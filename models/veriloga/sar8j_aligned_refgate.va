`include "constants.vams"
`include "disciplines.vams"

// Shared IDEAL timing notification. Observes actual native requests only.
// No native logic/MOS is replaced, no Vin/code/comparator oracle is used.
module sar8j_refcommit(SAMPLE, VDD, VSS,
    H0,L0,H1,L1,H2,L2,H3,L3,H4,L4,H5,L5,H6,L6,H7,L7,
    H8,L8,H9,L9,H10,L10,H11,L11,H12,L12,H13,L13,H14,L14,H15,L15, COMMIT);
    input SAMPLE,VDD,VSS;
    input H0,L0,H1,L1,H2,L2,H3,L3,H4,L4,H5,L5,H6,L6,H7,L7;
    input H8,L8,H9,L9,H10,L10,H11,L11,H12,L12,H13,L13,H14,L14,H15,L15;
    output COMMIT;
    electrical SAMPLE,VDD,VSS,COMMIT;
    electrical H0,L0,H1,L1,H2,L2,H3,L3,H4,L4,H5,L5,H6,L6,H7,L7;
    electrical H8,L8,H9,L9,H10,L10,H11,L11,H12,L12,H13,L13,H14,L14,H15,L15;
    parameter real settle_s=200p from (0:inf);
    integer toggle, valid;
    real capture_at, threshold;
    analog begin
        @(initial_step) begin toggle=0; capture_at=1e30; end
        @(cross(V(SAMPLE,VSS)-0.5*V(VDD,VSS),0) or
          cross(V(H0,VSS)-0.5*V(VDD,VSS),0) or cross(V(L0,VSS)-0.5*V(VDD,VSS),0) or
          cross(V(H1,VSS)-0.5*V(VDD,VSS),0) or cross(V(L1,VSS)-0.5*V(VDD,VSS),0) or
          cross(V(H2,VSS)-0.5*V(VDD,VSS),0) or cross(V(L2,VSS)-0.5*V(VDD,VSS),0) or
          cross(V(H3,VSS)-0.5*V(VDD,VSS),0) or cross(V(L3,VSS)-0.5*V(VDD,VSS),0) or
          cross(V(H4,VSS)-0.5*V(VDD,VSS),0) or cross(V(L4,VSS)-0.5*V(VDD,VSS),0) or
          cross(V(H5,VSS)-0.5*V(VDD,VSS),0) or cross(V(L5,VSS)-0.5*V(VDD,VSS),0) or
          cross(V(H6,VSS)-0.5*V(VDD,VSS),0) or cross(V(L6,VSS)-0.5*V(VDD,VSS),0) or
          cross(V(H7,VSS)-0.5*V(VDD,VSS),0) or cross(V(L7,VSS)-0.5*V(VDD,VSS),0) or
          cross(V(H8,VSS)-0.5*V(VDD,VSS),0) or cross(V(L8,VSS)-0.5*V(VDD,VSS),0) or
          cross(V(H9,VSS)-0.5*V(VDD,VSS),0) or cross(V(L9,VSS)-0.5*V(VDD,VSS),0) or
          cross(V(H10,VSS)-0.5*V(VDD,VSS),0) or cross(V(L10,VSS)-0.5*V(VDD,VSS),0) or
          cross(V(H11,VSS)-0.5*V(VDD,VSS),0) or cross(V(L11,VSS)-0.5*V(VDD,VSS),0) or
          cross(V(H12,VSS)-0.5*V(VDD,VSS),0) or cross(V(L12,VSS)-0.5*V(VDD,VSS),0) or
          cross(V(H13,VSS)-0.5*V(VDD,VSS),0) or cross(V(L13,VSS)-0.5*V(VDD,VSS),0) or
          cross(V(H14,VSS)-0.5*V(VDD,VSS),0) or cross(V(L14,VSS)-0.5*V(VDD,VSS),0) or
          cross(V(H15,VSS)-0.5*V(VDD,VSS),0) or cross(V(L15,VSS)-0.5*V(VDD,VSS),0)) begin
            if (V(SAMPLE,VSS)>0.5*V(VDD,VSS)) capture_at=1e30;
            else capture_at=$abstime+settle_s;
        end
        @(timer(capture_at)) begin
            threshold=0.5*V(VDD,VSS);
            valid = ((V(H0,VSS)>threshold)!=(V(L0,VSS)>threshold)) &&
                    ((V(H1,VSS)>threshold)!=(V(L1,VSS)>threshold)) &&
                    ((V(H2,VSS)>threshold)!=(V(L2,VSS)>threshold)) &&
                    ((V(H3,VSS)>threshold)!=(V(L3,VSS)>threshold)) &&
                    ((V(H4,VSS)>threshold)!=(V(L4,VSS)>threshold)) &&
                    ((V(H5,VSS)>threshold)!=(V(L5,VSS)>threshold)) &&
                    ((V(H6,VSS)>threshold)!=(V(L6,VSS)>threshold)) &&
                    ((V(H7,VSS)>threshold)!=(V(L7,VSS)>threshold)) &&
                    ((V(H8,VSS)>threshold)!=(V(L8,VSS)>threshold)) &&
                    ((V(H9,VSS)>threshold)!=(V(L9,VSS)>threshold)) &&
                    ((V(H10,VSS)>threshold)!=(V(L10,VSS)>threshold)) &&
                    ((V(H11,VSS)>threshold)!=(V(L11,VSS)>threshold)) &&
                    ((V(H12,VSS)>threshold)!=(V(L12,VSS)>threshold)) &&
                    ((V(H13,VSS)>threshold)!=(V(L13,VSS)>threshold)) &&
                    ((V(H14,VSS)>threshold)!=(V(L14,VSS)>threshold)) &&
                    ((V(H15,VSS)>threshold)!=(V(L15,VSS)>threshold));
            if (valid && V(SAMPLE,VSS)<threshold) toggle=1-toggle;
            capture_at=1e30;
        end
        // One shared threshold crossing, not 16 independent request clocks.
        V(COMMIT,VSS)<+V(VDD,VSS)*transition(toggle,0,1p,1p);
    end
endmodule

module sar8j_aligned_refgate(SAMPLE,EH,EL,VDD,VSS,GP,GN,COMMIT);
    input SAMPLE,EH,EL,VDD,VSS,COMMIT;
    output GP,GN;
    electrical SAMPLE,EH,EL,VDD,VSS,GP,GN,COMMIT;
    parameter integer initial_high=0 from [0:1];
    parameter real restore_guard_s=2n from (0:inf);
    parameter real dead_time_s=100p from (0:inf);
    parameter real edge_s=20p from (0:inf);
    integer sampling,restored,overridden;
    integer on_h,on_l,target_h,target_l,want_h,want_l;
    integer raw_h,raw_l,sample_now,commit_now,last_commit,commit_changed;
    real restore_at,turnon_at,off_at;
    analog begin
        @(initial_step) begin
            sampling=0; restored=0; overridden=1; last_commit=0;
            on_h=initial_high; on_l=1-initial_high;
            target_h=on_h; target_l=on_l;
            restore_at=1e30; turnon_at=1e30; off_at=-1;
        end
        @(cross(V(SAMPLE,VSS)-0.5*V(VDD,VSS),0) or
          cross(V(EH,VSS)-0.5*V(VDD,VSS),0) or
          cross(V(EL,VSS)-0.5*V(VDD,VSS),0) or
          cross(V(COMMIT,VSS)-0.5*V(VDD,VSS),0) or
          timer(restore_at) or timer(turnon_at)) begin
            sample_now=V(SAMPLE,VSS)>0.5*V(VDD,VSS);
            raw_h=V(EH,VSS)>0.5*V(VDD,VSS);
            raw_l=V(EL,VSS)>0.5*V(VDD,VSS);
            commit_now=V(COMMIT,VSS)>0.5*V(VDD,VSS);
            commit_changed=commit_now!=last_commit; last_commit=commit_now;
            if (sample_now && !sampling) begin
                sampling=1; restored=0; overridden=1;
                restore_at=$abstime+restore_guard_s; turnon_at=1e30;
                target_h=on_h; target_l=on_l;
            end else if (!sample_now && sampling) begin
                sampling=0; restore_at=1e30;
            end
            if (sampling && $abstime>=restore_at-1e-18) begin
                restored=1; restore_at=1e30;
            end
            if (!sampling && overridden && raw_h==initial_high && raw_l==1-initial_high)
                overridden=0;
            want_h=target_h; want_l=target_l;
            if (sampling && !restored) begin
                want_h=on_h; want_l=on_l;
            end else if (sampling || overridden) begin
                want_h=initial_high; want_l=1-initial_high;
            end else if (commit_changed) begin
                // All banks see the same event; unchanged banks remain on.
                want_h=raw_h && !raw_l; want_l=raw_l && !raw_h;
            end
            if (want_h!=target_h || want_l!=target_l) begin
                if (on_h || on_l) off_at=$abstime;
                on_h=0; on_l=0; target_h=want_h; target_l=want_l;
                turnon_at=1e30;
                if (target_h || target_l) turnon_at=max($abstime,off_at+dead_time_s);
            end
            if ($abstime>=turnon_at-1e-18) begin
                on_h=target_h; on_l=target_l; turnon_at=1e30;
            end
        end
        V(GP,VSS)<+V(VDD,VSS)*(1-transition(on_h,0,edge_s,edge_s));
        V(GN,VSS)<+V(VDD,VSS)*transition(on_l,0,edge_s,edge_s);
    end
endmodule
