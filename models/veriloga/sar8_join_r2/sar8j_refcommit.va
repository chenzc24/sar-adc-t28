`include "constants.vams"
`include "disciplines.vams"

// Shared IDEAL timing notification. Observes actual native requests only.
// No native logic/MOS is replaced, no Vin/code/comparator oracle is used.
module sar8j_refcommit(SAMPLE, VDD, VSS,
    H0,L0,H1,L1,H2,L2,H3,L3,H4,L4,H5,L5,H6,L6,H7,L7,
    H8,L8,H9,L9,H10,L10,H11,L11,H12,L12,H13,L13,H14,L14,H15,L15, COMMIT);
    input SAMPLE,VDD,VSS;
    input H0,L0,H1,L1,H2,L2,H3,L3,H4,L4,H5,L5,H6,L6,H7,L7;
    input H8,L8,H9,L9,H10,L10,H11,L11,H12,L12,H13,L13,H14,L14,H15,L15;
    output COMMIT;
    electrical SAMPLE,VDD,VSS,COMMIT;
    electrical H0,L0,H1,L1,H2,L2,H3,L3,H4,L4,H5,L5,H6,L6,H7,L7;
    electrical H8,L8,H9,L9,H10,L10,H11,L11,H12,L12,H13,L13,H14,L14,H15,L15;
    parameter real settle_s=200p from (0:inf);
    integer toggle, valid;
    real capture_at, threshold;
    analog begin
        @(initial_step) begin toggle=0; capture_at=1e30; end
        @(cross(V(SAMPLE,VSS)-0.5*V(VDD,VSS),0) or
          cross(V(H0,VSS)-0.5*V(VDD,VSS),0) or cross(V(L0,VSS)-0.5*V(VDD,VSS),0) or
          cross(V(H1,VSS)-0.5*V(VDD,VSS),0) or cross(V(L1,VSS)-0.5*V(VDD,VSS),0) or
          cross(V(H2,VSS)-0.5*V(VDD,VSS),0) or cross(V(L2,VSS)-0.5*V(VDD,VSS),0) or
          cross(V(H3,VSS)-0.5*V(VDD,VSS),0) or cross(V(L3,VSS)-0.5*V(VDD,VSS),0) or
          cross(V(H4,VSS)-0.5*V(VDD,VSS),0) or cross(V(L4,VSS)-0.5*V(VDD,VSS),0) or
          cross(V(H5,VSS)-0.5*V(VDD,VSS),0) or cross(V(L5,VSS)-0.5*V(VDD,VSS),0) or
          cross(V(H6,VSS)-0.5*V(VDD,VSS),0) or cross(V(L6,VSS)-0.5*V(VDD,VSS),0) or
          cross(V(H7,VSS)-0.5*V(VDD,VSS),0) or cross(V(L7,VSS)-0.5*V(VDD,VSS),0) or
          cross(V(H8,VSS)-0.5*V(VDD,VSS),0) or cross(V(L8,VSS)-0.5*V(VDD,VSS),0) or
          cross(V(H9,VSS)-0.5*V(VDD,VSS),0) or cross(V(L9,VSS)-0.5*V(VDD,VSS),0) or
          cross(V(H10,VSS)-0.5*V(VDD,VSS),0) or cross(V(L10,VSS)-0.5*V(VDD,VSS),0) or
          cross(V(H11,VSS)-0.5*V(VDD,VSS),0) or cross(V(L11,VSS)-0.5*V(VDD,VSS),0) or
          cross(V(H12,VSS)-0.5*V(VDD,VSS),0) or cross(V(L12,VSS)-0.5*V(VDD,VSS),0) or
          cross(V(H13,VSS)-0.5*V(VDD,VSS),0) or cross(V(L13,VSS)-0.5*V(VDD,VSS),0) or
          cross(V(H14,VSS)-0.5*V(VDD,VSS),0) or cross(V(L14,VSS)-0.5*V(VDD,VSS),0) or
          cross(V(H15,VSS)-0.5*V(VDD,VSS),0) or cross(V(L15,VSS)-0.5*V(VDD,VSS),0)) begin
            if (V(SAMPLE,VSS)>0.5*V(VDD,VSS)) capture_at=1e30;
            else capture_at=$abstime+settle_s;
        end
        @(timer(capture_at)) begin
            threshold=0.5*V(VDD,VSS);
            valid = ((V(H0,VSS)>threshold)!=(V(L0,VSS)>threshold)) &&
                    ((V(H1,VSS)>threshold)!=(V(L1,VSS)>threshold)) &&
                    ((V(H2,VSS)>threshold)!=(V(L2,VSS)>threshold)) &&
                    ((V(H3,VSS)>threshold)!=(V(L3,VSS)>threshold)) &&
                    ((V(H4,VSS)>threshold)!=(V(L4,VSS)>threshold)) &&
                    ((V(H5,VSS)>threshold)!=(V(L5,VSS)>threshold)) &&
                    ((V(H6,VSS)>threshold)!=(V(L6,VSS)>threshold)) &&
                    ((V(H7,VSS)>threshold)!=(V(L7,VSS)>threshold)) &&
                    ((V(H8,VSS)>threshold)!=(V(L8,VSS)>threshold)) &&
                    ((V(H9,VSS)>threshold)!=(V(L9,VSS)>threshold)) &&
                    ((V(H10,VSS)>threshold)!=(V(L10,VSS)>threshold)) &&
                    ((V(H11,VSS)>threshold)!=(V(L11,VSS)>threshold)) &&
                    ((V(H12,VSS)>threshold)!=(V(L12,VSS)>threshold)) &&
                    ((V(H13,VSS)>threshold)!=(V(L13,VSS)>threshold)) &&
                    ((V(H14,VSS)>threshold)!=(V(L14,VSS)>threshold)) &&
                    ((V(H15,VSS)>threshold)!=(V(L15,VSS)>threshold));
            if (valid && V(SAMPLE,VSS)<threshold) toggle=1-toggle;
            capture_at=1e30;
        end
        // One shared threshold crossing, not 16 independent request clocks.
        V(COMMIT,VSS)<+V(VDD,VSS)*transition(toggle,0,1p,1p);
    end
endmodule
