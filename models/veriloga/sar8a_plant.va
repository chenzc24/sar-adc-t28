`include "constants.vams"
`include "disciplines.vams"
// Explicit TESTBENCH plant, not part of the native gate-controller DUT.
// Ideal sampled input + ideal binary DAC + variable-time comparator rails.
module sar8a_plant(VDD,VSS,VIN,SAMPLE,CMP_CLK,C7,C6,C5,C4,C3,C2,C1,C0,P,N,TOPP,TOPN);
    input VDD,VSS,VIN,SAMPLE,CMP_CLK,C7,C6,C5,C4,C3,C2,C1,C0;
    output P,N,TOPP,TOPN;
    electrical VDD,VSS,VIN,SAMPLE,CMP_CLK,C7,C6,C5,C4,C3,C2,C1,C0,P,N,TOPP,TOPN;
    parameter real span_v=1.8;
    parameter real min_delay_s=0.15e-9;
    parameter real tau_s=0.035e-9;
    parameter real reset_delay_s=0.05e-9;
    parameter real tedge_s=10e-12;
    parameter integer pattern_mode=0;
    parameter integer pattern_word=165 from [0:255];
    parameter integer fault_bit=-1 from [-1:7];
    parameter integer fault_mode=0 from [0:2]; // 1 stuck, 2 illegal 00
    parameter integer fault_frame=-1 from [-1:255]; // -1 every frame
    parameter real delay_spread_s=0.0;
    real held,vdiff,threshold,tnext,decision,latency;
    integer code,pp,nn,phase,index,frame,word,inject;
    analog begin
        @(initial_step) begin held=0;pp=1;nn=1;phase=0;index=0;frame=-1;tnext=1.0;end
        threshold=V(VDD,VSS)/2;
        code=(V(C7,VSS)>threshold?128:0)+(V(C6,VSS)>threshold?64:0)
            +(V(C5,VSS)>threshold?32:0)+(V(C4,VSS)>threshold?16:0)
            +(V(C3,VSS)>threshold?8:0)+(V(C2,VSS)>threshold?4:0)
            +(V(C1,VSS)>threshold?2:0)+(V(C0,VSS)>threshold?1:0);
        vdiff=held+span_v/2-code*span_v/256;
        @(cross(V(SAMPLE,VSS)-V(VDD,VSS)/2,+1)) begin
            index=0;frame=frame+1;pp=1;nn=1;phase=0;tnext=1.0;
        end
        @(cross(V(SAMPLE,VSS)-V(VDD,VSS)/2,-1)) held=V(VIN,VSS);
        @(cross(V(CMP_CLK,VSS)-V(VDD,VSS)/2,+1)) begin
            word=pattern_mode==2 ? (frame%256):pattern_word;
            inject=(fault_frame<0 || fault_frame==frame) && (7-index)==fault_bit;
            decision=pattern_mode!=0 ? ((word & (1<<(7-index)))!=0 ? 1.0:-1.0) : vdiff;
            latency=min_delay_s+tau_s*max(0.0,ln(span_v/max(abs(decision),1e-9)))
                    +delay_spread_s*((index*5+3)%7);
            phase=(fault_mode==2 && inject!=0)?2:1;
            tnext=(fault_mode==1 && inject!=0)?1.0:$abstime+latency;
            index=index+1;
        end
        @(cross(V(CMP_CLK,VSS)-V(VDD,VSS)/2,-1)) begin
            phase=3;tnext=$abstime+reset_delay_s;
        end
        @(timer(tnext)) begin
            if(phase==1 && V(CMP_CLK,VSS)>V(VDD,VSS)/2) begin pp=decision>=0;nn=decision<0;end
            else if(phase==2 && V(CMP_CLK,VSS)>V(VDD,VSS)/2) begin pp=0;nn=0;end
            else if(phase==3 && V(CMP_CLK,VSS)<V(VDD,VSS)/2) begin pp=1;nn=1;end
            tnext=1.0;
        end
        V(P,VSS)<+V(VDD,VSS)*transition(pp,0,tedge_s,tedge_s);
        V(N,VSS)<+V(VDD,VSS)*transition(nn,0,tedge_s,tedge_s);
        V(TOPP,VSS)<+V(VDD,VSS)/2+transition(vdiff/2,0,tedge_s,tedge_s);
        V(TOPN,VSS)<+V(VDD,VSS)/2-transition(vdiff/2,0,tedge_s,tedge_s);
    end
endmodule
