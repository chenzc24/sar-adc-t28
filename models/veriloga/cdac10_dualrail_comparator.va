`include "constants.vams"
`include "disciplines.vams"

// Ideal sign decision for CDAC isolation. No CM limit, noise, offset or regeneration.
// Native StrongARM is tested separately, never equated to this abstraction.
module cdac10_dualrail_comparator(VINP,VINN,CLK,VDD,VSS,OUTP,OUTN);
    input VINP,VINN,CLK,VDD,VSS;
    output OUTP,OUTN;
    electrical VINP,VINN,CLK,VDD,VSS,OUTP,OUTN;
    parameter real delay_s=100p;
    parameter real edge_s=20p;
    integer state;
    analog begin
        @(initial_step) state=2;
        @(cross(V(CLK,VSS)-0.5*V(VDD,VSS),+1)) state=V(VINP,VINN)>=0?1:0;
        @(cross(V(CLK,VSS)-0.5*V(VDD,VSS),-1)) state=2;
        V(OUTP,VSS)<+V(VDD,VSS)*transition(state!=0?1.0:0.0,delay_s,edge_s,edge_s);
        V(OUTN,VSS)<+V(VDD,VSS)*transition(state!=1?1.0:0.0,delay_s,edge_s,edge_s);
    end
endmodule
