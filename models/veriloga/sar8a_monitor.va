`include "constants.vams"
`include "disciplines.vams"
// Measurement-only observer, never drives the native controller or rails.
module sar8a_monitor(VDD,VSS,SAMPLE,CMP_CLK,CAPTURE,ADVANCE,VALID,FAULT,D7,D6,D5,D4,D3,D2,D1,D0);
    input VDD,VSS,SAMPLE,CMP_CLK,CAPTURE,ADVANCE,VALID,FAULT,D7,D6,D5,D4,D3,D2,D1,D0;
    electrical VDD,VSS,SAMPLE,CMP_CLK,CAPTURE,ADVANCE,VALID,FAULT,D7,D6,D5,D4,D3,D2,D1,D0;
    integer frame,caps,evals,advs,code;
    real th;
    analog begin
        @(initial_step) begin frame=-1;caps=0;evals=0;advs=0;end
        th=V(VDD,VSS)/2;
        @(cross(V(SAMPLE,VSS)-V(VDD,VSS)/2,+1)) begin frame=frame+1;caps=0;evals=0;advs=0;end
        @(cross(V(CMP_CLK,VSS)-V(VDD,VSS)/2,+1)) evals=evals+1;
        @(cross(V(CAPTURE,VSS)-V(VDD,VSS)/2,+1)) caps=caps+1;
        @(cross(V(ADVANCE,VSS)-V(VDD,VSS)/2,+1)) advs=advs+1;
        @(timer(95e-9,100e-9)) begin
            code=(V(D7,VSS)>th?128:0)+(V(D6,VSS)>th?64:0)+(V(D5,VSS)>th?32:0)+(V(D4,VSS)>th?16:0)
                +(V(D3,VSS)>th?8:0)+(V(D2,VSS)>th?4:0)+(V(D1,VSS)>th?2:0)+(V(D0,VSS)>th?1:0);
            $strobe("SAR8A_FRAME %d CODE %d CAP %d EVAL %d ADV %d VALID %d FAULT %d",frame,code,caps,evals,advs,V(VALID,VSS)>th,V(FAULT,VSS)>th);
        end
    end
endmodule
