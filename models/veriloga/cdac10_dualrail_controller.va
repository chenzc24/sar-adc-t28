`include "constants.vams"
`include "disciplines.vams"

// Behavioral SAR/clock control only. Reads actual comparator outputs, never Vin.
// No CDAC VCM phase; a high-to-low move occurs once per selected bank.
module cdac10_dualrail_controller(COMP_P, COMP_N, PHI, PREPARE, HOLD_START,
    CLK_LATCH, CLK_COMPARE, VDD, VSS, PH, PL, NH, NL, DOUT,
    BUSY, VALID, CMP_CLK, CMP_RESET);
    input COMP_P, COMP_N, PHI, PREPARE, HOLD_START, CLK_LATCH, CLK_COMPARE, VDD, VSS;
    output [8:0] PH, PL, NH, NL;
    output [9:0] DOUT;
    output BUSY, VALID, CMP_CLK, CMP_RESET;
    electrical COMP_P, COMP_N, PHI, PREPARE, HOLD_START, CLK_LATCH, CLK_COMPARE, VDD, VSS;
    electrical [8:0] PH, PL, NH, NL;
    electrical [9:0] DOUT;
    electrical BUSY, VALID, CMP_CLK, CMP_RESET;
    parameter real dead_time_s=100p from (0:inf);
    parameter real edge_s=20p from (0:inf);
    integer low_command[0:17], high_drive[0:17], low_drive[0:17];
    real ready_time[0:17];
    integer bit_index, work_code, out_code, busy_state, valid_state;
    integer j, selected, positive;
    real threshold;
    genvar k;
    analog begin
        threshold=0.5*V(VDD,VSS);
        @(initial_step) begin
            bit_index=9; work_code=0; out_code=0; busy_state=0; valid_state=0;
            for(j=0;j<18;j=j+1) begin
                low_command[j]=0; high_drive[j]=1; low_drive[j]=0; ready_time[j]=1e9;
            end
        end
        @(cross(V(PHI,VSS)-threshold,+1)) begin
            bit_index=9; work_code=0; busy_state=0; valid_state=0;
        end
        @(cross(V(HOLD_START,VSS)-threshold,+1)) begin
            bit_index=9; work_code=0; busy_state=1; valid_state=0;
        end
        @(cross(V(CLK_LATCH,VSS)-threshold,+1)) begin
            if(busy_state!=0) begin
                positive=V(COMP_P,COMP_N)>=0.0 ? 1:0;
                if(positive!=0) work_code=work_code+(1<<bit_index);
                if(bit_index==0) begin
                    out_code=work_code; busy_state=0; valid_state=1;
                end else begin
                    selected=bit_index-1+(positive!=0 ? 0:9);
                    low_command[selected]=1;
                    high_drive[selected]=0; low_drive[selected]=0;
                    ready_time[selected]=$abstime+dead_time_s;
                    bit_index=bit_index-1;
                end
            end
        end
        @(cross(V(PREPARE,VSS)-threshold,+1)) begin
            busy_state=0;
            for(j=0;j<18;j=j+1) begin
                if(low_command[j]!=0) begin
                    low_command[j]=0; high_drive[j]=0; low_drive[j]=0;
                    ready_time[j]=$abstime+dead_time_s;
                end
            end
        end
        for(k=0;k<18;k=k+1) begin
            @(timer(ready_time[k])) begin
                high_drive[k]=1-low_command[k]; low_drive[k]=low_command[k];
            end
        end
        for(k=0;k<9;k=k+1) begin
            V(PH[k],VSS)<+transition(high_drive[k]!=0?V(VDD,VSS):0.0,0,edge_s,edge_s);
            V(PL[k],VSS)<+transition(low_drive[k]!=0?V(VDD,VSS):0.0,0,edge_s,edge_s);
            V(NH[k],VSS)<+transition(high_drive[k+9]!=0?V(VDD,VSS):0.0,0,edge_s,edge_s);
            V(NL[k],VSS)<+transition(low_drive[k+9]!=0?V(VDD,VSS):0.0,0,edge_s,edge_s);
        end
        for(k=0;k<10;k=k+1) begin
            V(DOUT[k],VSS)<+transition((out_code & (1<<k))!=0?V(VDD,VSS):0.0,0,edge_s,edge_s);
        end
        V(BUSY,VSS)<+transition(busy_state!=0?V(VDD,VSS):0.0,0,edge_s,edge_s);
        V(VALID,VSS)<+transition(valid_state!=0?V(VDD,VSS):0.0,0,edge_s,edge_s);
        V(CMP_CLK,VSS)<+V(CLK_COMPARE,VSS)*transition(busy_state!=0?1.0:0.0,0,edge_s,edge_s);
        V(CMP_RESET,VSS)<+V(VDD,VSS)-V(CMP_CLK,VSS);
    end
endmodule
