`include "constants.vams"
`include "disciplines.vams"

// Closed-loop phase controller for the topology-aware SAR electrical macro.
//
// During sampling, SEL0_*/SEL1_*/BASE are low so each CDAC bottom plate is
// held at VCM by the electrical network's sample-controlled relays. The sample
// falling edge establishes the code-zero reference state. Each CLK_TRIAL edge
// flips one capacitor pair, and each CLK_LATCH edge retains or rejects that
// trial from the sign of the electrical comparator macro.

module sar_macro_controller_10b (
    input  electrical       COMP_P,
    input  electrical       COMP_N,
    input  electrical       CLK_SAMPLE,
    input  electrical       CLK_TRIAL,
    input  electrical       CLK_LATCH,
    input  electrical       VDD,
    input  electrical       VSS,
    output electrical       SEL0_9,
    output electrical       SEL0_8,
    output electrical       SEL0_7,
    output electrical       SEL0_6,
    output electrical       SEL0_5,
    output electrical       SEL0_4,
    output electrical       SEL0_3,
    output electrical       SEL0_2,
    output electrical       SEL0_1,
    output electrical       SEL0_0,
    output electrical       SEL1_9,
    output electrical       SEL1_8,
    output electrical       SEL1_7,
    output electrical       SEL1_6,
    output electrical       SEL1_5,
    output electrical       SEL1_4,
    output electrical       SEL1_3,
    output electrical       SEL1_2,
    output electrical       SEL1_1,
    output electrical       SEL1_0,
    output electrical       BASE,
    output electrical       D9,
    output electrical       D8,
    output electrical       D7,
    output electrical       D6,
    output electrical       D5,
    output electrical       D4,
    output electrical       D3,
    output electrical       D2,
    output electrical       D1,
    output electrical       D0,
    output electrical       BUSY,
    output electrical       VALID
);

    parameter real logic_threshold_fraction = 0.5 from (0.0:1.0);
    parameter real logic_high_v = 0.9 from (0.0:inf);
    parameter real output_transition_s = 20p from (0.0:inf);

    integer code_work;
    integer code_out;
    integer bit_index;
    integer trial_mask;
    integer hold_state;
    integer busy_state;
    integer valid_state;
    integer trial_active;
    real logic_threshold_v;

    analog begin
        @(initial_step) begin
            code_work = 0;
            code_out = 0;
            bit_index = 9;
            trial_mask = 0;
            hold_state = 0;
            busy_state = 0;
            valid_state = 0;
            trial_active = 0;
        end

        logic_threshold_v = logic_threshold_fraction * V(VDD, VSS);

        // Enter acquisition and tri-state every reference-selection relay.
        @(cross(V(CLK_SAMPLE, VSS) - logic_threshold_v, +1)) begin
            code_work = 0;
            bit_index = 9;
            trial_mask = 0;
            hold_state = 0;
            busy_state = 0;
            valid_state = 0;
            trial_active = 0;
        end

        // End acquisition, establish the code-zero differential reference
        // state, and apply the MSB trial in the same electrical transition.
        // This avoids an artificial full-scale intermediate top-plate step.
        @(cross(V(CLK_SAMPLE, VSS) - logic_threshold_v, -1)) begin
            code_work = 0;
            bit_index = 9;
            trial_mask = 512;
            hold_state = 1;
            busy_state = 1;
            valid_state = 0;
            trial_active = 1;
        end

        @(cross(V(CLK_TRIAL, VSS) - logic_threshold_v, +1)) begin
            if (busy_state != 0 && trial_active == 0) begin
                trial_mask = 1 << bit_index;
                trial_active = 1;
            end
        end

        @(cross(V(CLK_LATCH, VSS) - logic_threshold_v, +1)) begin
            if (busy_state != 0 && trial_active != 0) begin
                if (V(COMP_P, COMP_N) >= 0.0)
                    code_work = code_work + trial_mask;
                trial_active = 0;
                trial_mask = 0;
                if (bit_index == 0) begin
                    code_out = code_work;
                    busy_state = 0;
                    valid_state = 1;
                end else begin
                    bit_index = bit_index - 1;
                end
            end
        end

        V(BASE, VSS) <+ transition(hold_state != 0 ? logic_high_v : 0.0,
            0.0, output_transition_s, output_transition_s);
        V(BUSY, VSS) <+ transition(busy_state != 0 ? logic_high_v : 0.0,
            0.0, output_transition_s, output_transition_s);
        V(VALID, VSS) <+ transition(valid_state != 0 ? logic_high_v : 0.0,
            0.0, output_transition_s, output_transition_s);

        // Explicit scalar contributions keep the OA symbol and Spectre
        // positional port contract unambiguous.
        V(SEL1_9, VSS) <+ transition(hold_state != 0 && (((code_work & 512) != 0) || (trial_active != 0 && bit_index == 9)) ? logic_high_v : 0.0, 0.0, output_transition_s, output_transition_s);
        V(SEL1_8, VSS) <+ transition(hold_state != 0 && (((code_work & 256) != 0) || (trial_active != 0 && bit_index == 8)) ? logic_high_v : 0.0, 0.0, output_transition_s, output_transition_s);
        V(SEL1_7, VSS) <+ transition(hold_state != 0 && (((code_work & 128) != 0) || (trial_active != 0 && bit_index == 7)) ? logic_high_v : 0.0, 0.0, output_transition_s, output_transition_s);
        V(SEL1_6, VSS) <+ transition(hold_state != 0 && (((code_work & 64) != 0) || (trial_active != 0 && bit_index == 6)) ? logic_high_v : 0.0, 0.0, output_transition_s, output_transition_s);
        V(SEL1_5, VSS) <+ transition(hold_state != 0 && (((code_work & 32) != 0) || (trial_active != 0 && bit_index == 5)) ? logic_high_v : 0.0, 0.0, output_transition_s, output_transition_s);
        V(SEL1_4, VSS) <+ transition(hold_state != 0 && (((code_work & 16) != 0) || (trial_active != 0 && bit_index == 4)) ? logic_high_v : 0.0, 0.0, output_transition_s, output_transition_s);
        V(SEL1_3, VSS) <+ transition(hold_state != 0 && (((code_work & 8) != 0) || (trial_active != 0 && bit_index == 3)) ? logic_high_v : 0.0, 0.0, output_transition_s, output_transition_s);
        V(SEL1_2, VSS) <+ transition(hold_state != 0 && (((code_work & 4) != 0) || (trial_active != 0 && bit_index == 2)) ? logic_high_v : 0.0, 0.0, output_transition_s, output_transition_s);
        V(SEL1_1, VSS) <+ transition(hold_state != 0 && (((code_work & 2) != 0) || (trial_active != 0 && bit_index == 1)) ? logic_high_v : 0.0, 0.0, output_transition_s, output_transition_s);
        V(SEL1_0, VSS) <+ transition(hold_state != 0 && (((code_work & 1) != 0) || (trial_active != 0 && bit_index == 0)) ? logic_high_v : 0.0, 0.0, output_transition_s, output_transition_s);

        V(SEL0_9, VSS) <+ transition(hold_state != 0 && !(((code_work & 512) != 0) || (trial_active != 0 && bit_index == 9)) ? logic_high_v : 0.0, 0.0, output_transition_s, output_transition_s);
        V(SEL0_8, VSS) <+ transition(hold_state != 0 && !(((code_work & 256) != 0) || (trial_active != 0 && bit_index == 8)) ? logic_high_v : 0.0, 0.0, output_transition_s, output_transition_s);
        V(SEL0_7, VSS) <+ transition(hold_state != 0 && !(((code_work & 128) != 0) || (trial_active != 0 && bit_index == 7)) ? logic_high_v : 0.0, 0.0, output_transition_s, output_transition_s);
        V(SEL0_6, VSS) <+ transition(hold_state != 0 && !(((code_work & 64) != 0) || (trial_active != 0 && bit_index == 6)) ? logic_high_v : 0.0, 0.0, output_transition_s, output_transition_s);
        V(SEL0_5, VSS) <+ transition(hold_state != 0 && !(((code_work & 32) != 0) || (trial_active != 0 && bit_index == 5)) ? logic_high_v : 0.0, 0.0, output_transition_s, output_transition_s);
        V(SEL0_4, VSS) <+ transition(hold_state != 0 && !(((code_work & 16) != 0) || (trial_active != 0 && bit_index == 4)) ? logic_high_v : 0.0, 0.0, output_transition_s, output_transition_s);
        V(SEL0_3, VSS) <+ transition(hold_state != 0 && !(((code_work & 8) != 0) || (trial_active != 0 && bit_index == 3)) ? logic_high_v : 0.0, 0.0, output_transition_s, output_transition_s);
        V(SEL0_2, VSS) <+ transition(hold_state != 0 && !(((code_work & 4) != 0) || (trial_active != 0 && bit_index == 2)) ? logic_high_v : 0.0, 0.0, output_transition_s, output_transition_s);
        V(SEL0_1, VSS) <+ transition(hold_state != 0 && !(((code_work & 2) != 0) || (trial_active != 0 && bit_index == 1)) ? logic_high_v : 0.0, 0.0, output_transition_s, output_transition_s);
        V(SEL0_0, VSS) <+ transition(hold_state != 0 && !(((code_work & 1) != 0) || (trial_active != 0 && bit_index == 0)) ? logic_high_v : 0.0, 0.0, output_transition_s, output_transition_s);

        V(D9, VSS) <+ transition((code_out & 512) != 0 ? logic_high_v : 0.0, 0.0, output_transition_s, output_transition_s);
        V(D8, VSS) <+ transition((code_out & 256) != 0 ? logic_high_v : 0.0, 0.0, output_transition_s, output_transition_s);
        V(D7, VSS) <+ transition((code_out & 128) != 0 ? logic_high_v : 0.0, 0.0, output_transition_s, output_transition_s);
        V(D6, VSS) <+ transition((code_out & 64) != 0 ? logic_high_v : 0.0, 0.0, output_transition_s, output_transition_s);
        V(D5, VSS) <+ transition((code_out & 32) != 0 ? logic_high_v : 0.0, 0.0, output_transition_s, output_transition_s);
        V(D4, VSS) <+ transition((code_out & 16) != 0 ? logic_high_v : 0.0, 0.0, output_transition_s, output_transition_s);
        V(D3, VSS) <+ transition((code_out & 8) != 0 ? logic_high_v : 0.0, 0.0, output_transition_s, output_transition_s);
        V(D2, VSS) <+ transition((code_out & 4) != 0 ? logic_high_v : 0.0, 0.0, output_transition_s, output_transition_s);
        V(D1, VSS) <+ transition((code_out & 2) != 0 ? logic_high_v : 0.0, 0.0, output_transition_s, output_transition_s);
        V(D0, VSS) <+ transition((code_out & 1) != 0 ? logic_high_v : 0.0, 0.0, output_transition_s, output_transition_s);
    end
endmodule
