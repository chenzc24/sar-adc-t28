`include "constants.vams"
`include "disciplines.vams"

// Clocked 10-bit fully differential SAR ADC behavioral core.
//
// CLK_SAMPLE is high during acquisition. Its falling edge captures
// V(VINP,VINN), clears VALID, and starts a conversion. Each subsequent rising
// edge of CLK_SAR resolves exactly one bit, MSB first. VALID rises when the
// tenth decision is complete and stays high until the next sample is taken.
//
// The ideal differential transfer range is
// [-V(VREFP,VREFN), +V(VREFP,VREFN)]. Nonideality parameters are zero by
// default so the model is exactly correlated with the Python golden model.

module sar_adc_ideal_10b (
    input  electrical       VINP,
    input  electrical       VINN,
    input  electrical       VREFP,
    input  electrical       VREFN,
    input  electrical       CLK_SAMPLE,
    input  electrical       CLK_SAR,
    input  electrical       RST_N,
    input  electrical       VDD,
    input  electrical       VSS,
    output electrical [9:0] DOUT,
    output electrical       BUSY,
    output electrical       VALID
);

    parameter real logic_threshold_fraction = 0.5 from (0.0:1.0);
    parameter real logic_high_v = 0.9 from (0.0:inf);
    parameter real output_delay_s = 0.0 from [0.0:inf);
    parameter real output_transition_s = 20p from (0.0:inf);

    // Input-referred nonidealities. Positive comparator_offset_v raises the
    // decision threshold. Noise values are one-sigma RMS quantities.
    parameter real comparator_offset_v = 0.0;
    parameter real sampling_noise_rms_v = 0.0 from [0.0:inf);
    parameter real comparator_noise_rms_v = 0.0 from [0.0:inf);
    parameter real reference_noise_rms_v = 0.0 from [0.0:inf);
    parameter real cdac_settling_residual = 0.0 from [0.0:1.0);

    // Relative effective CDAC bit-weight errors, MSB through LSB.
    parameter real cdac_w9_rel = 0.0;
    parameter real cdac_w8_rel = 0.0;
    parameter real cdac_w7_rel = 0.0;
    parameter real cdac_w6_rel = 0.0;
    parameter real cdac_w5_rel = 0.0;
    parameter real cdac_w4_rel = 0.0;
    parameter real cdac_w3_rel = 0.0;
    parameter real cdac_w2_rel = 0.0;
    parameter real cdac_w1_rel = 0.0;
    parameter real cdac_w0_rel = 0.0;

    parameter integer sampling_noise_seed = 271828;
    parameter integer comparator_noise_seed = 314159;
    parameter integer reference_noise_seed = 161803;

    integer code_work;
    integer code_out;
    integer bit_index;
    integer trial_code;
    integer busy_state;
    integer valid_state;
    integer sample_seed_state;
    integer comparator_seed_state;
    integer reference_seed_state;

    real sampled_diff_v;
    real sample_noise_v;
    real comparator_noise_v;
    real reference_noise_v;
    real logic_threshold_v;
    real vref_span_v;
    real cdac_weight_total;
    real trial_weight;
    real vdac_target_v;
    real vdac_previous_v;
    real vdac_effective_v;
    real decision_threshold_v;
    analog begin
        @(initial_step) begin
            code_work = 0;
            code_out = 0;
            bit_index = 9;
            trial_code = 0;
            busy_state = 0;
            valid_state = 0;
            sampled_diff_v = 0.0;
            vdac_previous_v = 0.0;
            sample_seed_state = sampling_noise_seed;
            comparator_seed_state = comparator_noise_seed;
            reference_seed_state = reference_noise_seed;

            // The ideal array includes one unit dummy capacitor, so the
            // nominal normalization is 1024 rather than the 1023 code sum.
            cdac_weight_total = 1.0
                + 512.0 * (1.0 + cdac_w9_rel)
                + 256.0 * (1.0 + cdac_w8_rel)
                + 128.0 * (1.0 + cdac_w7_rel)
                +  64.0 * (1.0 + cdac_w6_rel)
                +  32.0 * (1.0 + cdac_w5_rel)
                +  16.0 * (1.0 + cdac_w4_rel)
                +   8.0 * (1.0 + cdac_w3_rel)
                +   4.0 * (1.0 + cdac_w2_rel)
                +   2.0 * (1.0 + cdac_w1_rel)
                +   1.0 * (1.0 + cdac_w0_rel);
        end

        logic_threshold_v = logic_threshold_fraction * V(VDD, VSS);
        vref_span_v = V(VREFP, VREFN);

        // Asynchronous active-low reset.
        @(cross(V(RST_N, VSS) - logic_threshold_v, -1)) begin
            code_work = 0;
            code_out = 0;
            bit_index = 9;
            busy_state = 0;
            valid_state = 0;
            sampled_diff_v = 0.0;
            vdac_previous_v = 0.0;
        end

        // End of acquisition: hold the differential input and launch a new
        // conversion. Noise is sampled once per conversion.
        @(cross(V(CLK_SAMPLE, VSS) - logic_threshold_v, -1)) begin
            if (V(RST_N, VSS) < logic_threshold_v) begin
                code_work = 0;
                code_out = 0;
                bit_index = 9;
                busy_state = 0;
                valid_state = 0;
            end else begin
                sample_noise_v = 0.0;
                if (sampling_noise_rms_v > 0.0)
                    sample_noise_v = sampling_noise_rms_v
                        * $rdist_normal(sample_seed_state, 0, 1000000)
                        / 1000000.0;

                sampled_diff_v = V(VINP, VINN) + sample_noise_v;
                code_work = 0;
                bit_index = 9;
                busy_state = 1;
                valid_state = 0;
                vdac_previous_v = -vref_span_v;
            end
        end

        // One SAR decision per rising bit-clock edge.
        @(cross(V(CLK_SAR, VSS) - logic_threshold_v, +1)) begin
            if (V(RST_N, VSS) < logic_threshold_v) begin
                code_work = 0;
                code_out = 0;
                bit_index = 9;
                busy_state = 0;
                valid_state = 0;
            end else if (busy_state != 0) begin
                trial_code = code_work + (1 << bit_index);
                trial_weight = 0.0;
                if ((trial_code & 512) != 0)
                    trial_weight = trial_weight + 512.0 * (1.0 + cdac_w9_rel);
                if ((trial_code & 256) != 0)
                    trial_weight = trial_weight + 256.0 * (1.0 + cdac_w8_rel);
                if ((trial_code & 128) != 0)
                    trial_weight = trial_weight + 128.0 * (1.0 + cdac_w7_rel);
                if ((trial_code & 64) != 0)
                    trial_weight = trial_weight + 64.0 * (1.0 + cdac_w6_rel);
                if ((trial_code & 32) != 0)
                    trial_weight = trial_weight + 32.0 * (1.0 + cdac_w5_rel);
                if ((trial_code & 16) != 0)
                    trial_weight = trial_weight + 16.0 * (1.0 + cdac_w4_rel);
                if ((trial_code & 8) != 0)
                    trial_weight = trial_weight + 8.0 * (1.0 + cdac_w3_rel);
                if ((trial_code & 4) != 0)
                    trial_weight = trial_weight + 4.0 * (1.0 + cdac_w2_rel);
                if ((trial_code & 2) != 0)
                    trial_weight = trial_weight + 2.0 * (1.0 + cdac_w1_rel);
                if ((trial_code & 1) != 0)
                    trial_weight = trial_weight + 1.0 * (1.0 + cdac_w0_rel);

                vdac_target_v = -vref_span_v
                    + 2.0 * vref_span_v * trial_weight / cdac_weight_total;
                vdac_effective_v = vdac_target_v
                    + cdac_settling_residual * (vdac_previous_v - vdac_target_v);

                comparator_noise_v = 0.0;
                reference_noise_v = 0.0;
                if (comparator_noise_rms_v > 0.0)
                    comparator_noise_v = comparator_noise_rms_v
                        * $rdist_normal(comparator_seed_state, 0, 1000000)
                        / 1000000.0;
                if (reference_noise_rms_v > 0.0)
                    reference_noise_v = reference_noise_rms_v
                        * $rdist_normal(reference_seed_state, 0, 1000000)
                        / 1000000.0;

                decision_threshold_v = vdac_effective_v
                    + comparator_offset_v
                    + comparator_noise_v
                    + reference_noise_v;
                if (sampled_diff_v >= decision_threshold_v)
                    code_work = trial_code;

                vdac_previous_v = vdac_target_v;
                if (bit_index == 0) begin
                    code_out = code_work;
                    busy_state = 0;
                    valid_state = 1;
                end else begin
                    bit_index = bit_index - 1;
                end
            end
        end

        // Explicit bit contributions avoid runtime bus access and make the
        // intended Spectre elaboration unambiguous.
        V(DOUT[9], VSS) <+ transition(((code_out >> 9) & 1) != 0 ? logic_high_v : 0.0,
            output_delay_s, output_transition_s, output_transition_s);
        V(DOUT[8], VSS) <+ transition(((code_out >> 8) & 1) != 0 ? logic_high_v : 0.0,
            output_delay_s, output_transition_s, output_transition_s);
        V(DOUT[7], VSS) <+ transition(((code_out >> 7) & 1) != 0 ? logic_high_v : 0.0,
            output_delay_s, output_transition_s, output_transition_s);
        V(DOUT[6], VSS) <+ transition(((code_out >> 6) & 1) != 0 ? logic_high_v : 0.0,
            output_delay_s, output_transition_s, output_transition_s);
        V(DOUT[5], VSS) <+ transition(((code_out >> 5) & 1) != 0 ? logic_high_v : 0.0,
            output_delay_s, output_transition_s, output_transition_s);
        V(DOUT[4], VSS) <+ transition(((code_out >> 4) & 1) != 0 ? logic_high_v : 0.0,
            output_delay_s, output_transition_s, output_transition_s);
        V(DOUT[3], VSS) <+ transition(((code_out >> 3) & 1) != 0 ? logic_high_v : 0.0,
            output_delay_s, output_transition_s, output_transition_s);
        V(DOUT[2], VSS) <+ transition(((code_out >> 2) & 1) != 0 ? logic_high_v : 0.0,
            output_delay_s, output_transition_s, output_transition_s);
        V(DOUT[1], VSS) <+ transition(((code_out >> 1) & 1) != 0 ? logic_high_v : 0.0,
            output_delay_s, output_transition_s, output_transition_s);
        V(DOUT[0], VSS) <+ transition((code_out & 1) != 0 ? logic_high_v : 0.0,
            output_delay_s, output_transition_s, output_transition_s);
        V(BUSY, VSS) <+ transition(
            busy_state != 0 ? logic_high_v : 0.0,
            output_delay_s,
            output_transition_s,
            output_transition_s
        );
        V(VALID, VSS) <+ transition(
            valid_state != 0 ? logic_high_v : 0.0,
            output_delay_s,
            output_transition_s,
            output_transition_s
        );
    end

endmodule
