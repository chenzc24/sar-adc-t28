`include "constants.vams"
`include "disciplines.vams"

// Ideal diagnostic helper only; not a transistor keeper or clock implementation.
module ref_hold_diag(gate, rail, preset, sample, reset, highcmd, vss, enable);
  inout gate, rail;
  input preset, sample, reset, highcmd, vss;
  output enable;
  electrical gate, rail, preset, sample, reset, highcmd, vss, enable;
  parameter real conductance=0 from [0:inf);
  integer on;
  real gain;
  analog begin
    @(initial_step or cross(V(preset,vss)-0.495,0)
      or cross(V(sample,vss)-0.495,0) or cross(V(reset,vss)-0.495,0)
      or cross(V(highcmd,vss)-0.495,0)) begin
      on=(V(preset,vss)>0.495 && V(sample,vss)<0.495
         && V(reset,vss)<0.495 && V(highcmd,vss)>0.495);
    end
    gain=transition(on,0,5p,5p);
    I(gate,rail) <+ conductance*gain*V(gate,rail);
    V(enable,vss) <+ gain;
  end
endmodule

module ref_slew_diag(a,b,preset,sample,vss,enable);
  inout a,b;
  input preset,sample,vss;
  output enable;
  electrical a,b,preset,sample,vss,enable;
  parameter real extra_r=0 from [0:inf);
  integer on;
  real gain;
  analog begin
    @(initial_step or cross(V(preset,vss)-0.495,0)
      or cross(V(sample,vss)-0.495,0)) begin
      on=(V(preset,vss)>0.495 && V(sample,vss)<0.495);
    end
    gain=transition(on,0,5p,5p);
    V(a,b) <+ extra_r*gain*I(a,b);
    V(enable,vss) <+ gain;
  end
endmodule
