`include "constants.vams"
`include "disciplines.vams"

// External source search only. TIP/TIN are observed physical held top plates.
module sar8_phys_search(SIP,SIN,TIP,TIN,OP,ON,PR,NR,CLK,SUP,VSS);
  output SIP,SIN;
  input TIP,TIN,OP,ON,PR,NR,CLK,SUP,VSS;
  electrical SIP,SIN,TIP,TIN,OP,ON,PR,NR,CLK,SUP,VSS;
  parameter real cm=0.449;
  parameter real range_v=0.064;
  parameter real period_s=100n;
  parameter real first_report_s=103.504608487447n;
  parameter real first_update_s=159.85n;
  parameter real first_pre_s=102.669109398796n;
  parameter integer steps=10;
  integer cycle,report_cycle,polarity,guard_bad,unresolved,armed;
  real lower,upper,probe,pending,offset,clk_time,raw_delay,rx_delay;
  real reset_min,held_pre,cm_pre,held_lower,held_upper;
  analog begin
    @(initial_step) begin
      lower=-range_v;upper=range_v;probe=-range_v;pending=probe;
      held_lower=-range_v;held_upper=range_v;
      cycle=0;guard_bad=0;unresolved=0;armed=0;offset=0;
      raw_delay=-1;rx_delay=-1;clk_time=0;reset_min=0;held_pre=0;cm_pre=cm;
    end
    @(timer(first_pre_s,period_s)) begin
      held_pre=V(TIP,TIN);cm_pre=(V(TIP,VSS)+V(TIN,VSS))/2;
    end
    @(cross(V(CLK,VSS)-0.5*V(SUP,VSS),+1)) begin
      clk_time=$abstime;armed=1;raw_delay=-1;rx_delay=-1;
      reset_min=min(V(OP,VSS),V(ON,VSS));
    end
    @(cross(abs(V(OP,ON))-0.45,+1)) begin
      if(armed==1 && raw_delay<0) raw_delay=$abstime-clk_time;
    end
    @(cross(abs(V(PR,NR))-0.45,+1)) begin
      if(armed==1 && rx_delay<0) rx_delay=$abstime-clk_time;
    end
    @(timer(first_report_s,period_s)) begin
      polarity=V(PR,NR)>0.45 ? 1 : V(PR,NR)<-0.45 ? -1 : 0;
      if(cycle==0) begin
        if(polarity!=-1) guard_bad=1;
        pending=range_v;
      end else if(cycle==1) begin
        if(polarity!=1) guard_bad=1;
        pending=(lower+upper)/2;
      end else if(cycle<steps+2) begin
        if(polarity==1) begin upper=probe;held_upper=held_pre;end
        else if(polarity==-1) begin lower=probe;held_lower=held_pre;end
        else unresolved=unresolved+1;
        offset=(lower+upper)/2;
        if(cycle==steps+1) pending=offset-0.00703125;
        else pending=offset;
      end else begin
        case(cycle-(steps+2))
          0: pending=offset-0.0017578125;
          1: pending=offset-0.000703125;
          2: pending=offset+0.000703125;
          3: pending=offset+0.0017578125;
          4: pending=offset+0.00703125;
          5: pending=offset+0.0017578125;
          6: pending=offset+0.0017578125;
          7: pending=offset-0.0017578125;
          8: pending=offset+0.0017578125;
          default: pending=offset-0.0017578125;
        endcase
      end
      report_cycle=cycle;
      $strobe("PHYSMC,%d,%.15g,%d,%.15g,%.15g,%.15g,%.15g,%.15g,%.15g,%.15g,%.15g,%.15g,%d,%d,%.15g",
        report_cycle,probe,polarity,lower,upper,held_pre,cm_pre,held_lower,held_upper,
        raw_delay,rx_delay,reset_min,guard_bad,unresolved,$abstime);
      armed=0;cycle=cycle+1;
    end
    @(timer(first_update_s,period_s)) probe=pending;
    V(SIP,VSS)<+cm+transition(probe,0,20p,20p)/2;
    V(SIN,VSS)<+cm-transition(probe,0,20p,20p)/2;
  end
endmodule
