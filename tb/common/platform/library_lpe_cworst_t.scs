simulator lang=spice
.include "/home/process/tsmc28n/STD_CELL/tcbn28hpcplusbwp12t30p140_190a/tcbn28hpcplusbwp12t30p140_170a_lpe/TSMCHOME/digital/Back_End/lpe_spice/tcbn28hpcplusbwp12t30p140_170a/tcbn28hpcplusbwp12t30p140_170a_lpe_cworst_T.spi"
simulator lang=spectre
