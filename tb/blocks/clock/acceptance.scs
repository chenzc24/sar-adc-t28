// Every exported delay/edge helper, loaded by a native standard-cell input.
VTCLOCK (t_clock 0) vsource type=pulse val0=0 val1=0.9 delay=60n rise=100p fall=100p width=39.9n period=100n
XT0 (t_clock VDD! 0 t_out0) @sar8p_delay_valid@
XTL0 (t_out0 VDD! 0 t_unused0) sar8p_inv
XT1 (t_clock VDD! 0 t_out1) @sar8p_delay_write@
XTL1 (t_out1 VDD! 0 t_unused1) sar8p_inv
XT2 (t_clock VDD! 0 t_out2) @sar8p_delay_quiet@
XTL2 (t_out2 VDD! 0 t_unused2) sar8p_inv
XT3 (t_clock VDD! 0 t_out3) @sar8p_delay_capture@
XTL3 (t_out3 VDD! 0 t_unused3) sar8p_inv
XT4 (t_clock VDD! 0 t_out4) @sar8p_delay_bbm@
XTL4 (t_out4 VDD! 0 t_unused4) sar8p_inv
XT5 (t_clock VDD! 0 t_out5) @sar8r_delay@
XTL5 (t_out5 VDD! 0 t_unused5) sar8p_inv
XT6 (t_clock VDD! 0 t_out6) @sar8s_step@
XTL6 (t_out6 VDD! 0 t_unused6) sar8p_inv
XT7 (t_clock VDD! 0 t_out7) @sar8i_guard@
XTL7 (t_out7 VDD! 0 t_unused7) sar8p_inv
XT8 (t_clock VDD! 0 t_out8) @sar8r_edge@
XTL8 (t_out8 VDD! 0 t_unused8) sar8p_inv
XT9 (t_clock VDD! 0 t_out9) @sar8p_clkbuf@
XTL9 (t_out9 VDD! 0 t_unused9) sar8p_inv
