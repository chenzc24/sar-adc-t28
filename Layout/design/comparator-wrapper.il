procedure(saWrap()
 let((cv core inst owner net term shape master)
  unless(equal(ddGetObj("SAR_ADC_T28_LAYOUT")~>readPath "/home/chenzc_intern25/TSMC28/llm_IO/SAR_ADC_T28_LAYOUT")
   error("Wrong layout library"))
  core=dbOpenCellViewByType("SAR_ADC_T28_LAYOUT" "sar_strongarm_t28_core" "layout" "" "r")
  unless(core && length(core~>terminals)==7 error("Missing comparator core"))
  cv=dbOpenCellViewByType("SAR_ADC_T28_LAYOUT" "sar_strongarm_t28" "layout" "maskLayout" "a")
  unless(cv error("Cannot open wrapper"))
  owner=dbFindProp(cv "generatorOwner")
  unless((!cv~>instances && !cv~>shapes) || (owner && equal(owner~>value "Layout/design/comparator-wrapper.il"))
   error("Existing wrapper has different owner"))
  foreach(obj cv~>instances dbDeleteObject(obj))
  foreach(obj cv~>shapes dbDeleteObject(obj))
  foreach(obj cv~>nets dbDeleteObject(obj))
  dbReplaceProp(cv "generatorOwner" "string" "Layout/design/comparator-wrapper.il")
  inst=dbCreateInst(cv core "XCORE" 0:0 "R0")
  foreach(ct core~>terminals
   net=dbCreateNet(cv ct~>name)
   term=dbCreateTerm(net ct~>name ct~>direction)
   dbCreateInstTerm(net inst ct)
   foreach(pin ct~>pins foreach(fig pin~>figs
    unless(equal(fig~>objType "rect") error("Expected rectangular port"))
    shape=dbCreateRect(cv fig~>lpp fig~>bBox)
    dbCreatePin(net shape ct~>name term)
    dbCreateLabel(cv list(fig~>layerName "pin")
     list((caar(fig~>bBox)+caadr(fig~>bBox))/2.0 (cadar(fig~>bBox)+cadadr(fig~>bBox))/2.0)
     ct~>name "centerCenter" "R0" "roman" 0.1))))
  foreach(pair list(list("FILL_ODPO" "sar8_comp_fill_odpo") list("FILL_METAL" "sar8_comp_fill_metal"))
   master=dbOpenCellViewByType("SAR_ADC_T28_LAYOUT" cadr(pair) "layout" "" "r")
   unless(master && dbCreateInst(cv master car(pair) 0:0 "R0") error("Missing fill"))
   dbClose(master))
  unless(dbSave(cv) error("Cannot save wrapper"))
  dbClose(cv)
  dbClose(core)
  cv=dbOpenCellViewByType("SAR_ADC_T28_LAYOUT" "sar_strongarm_t28" "layout" "" "r")
  unless(length(cv~>instances)==3 && length(cv~>terminals)==7 error("Wrapper readback failed"))
  printf("COMPARATOR_WRAPPER_OK ports=7 instances=3 bbox=%L\n" cv~>bBox)
  dbClose(cv)
  t
 ))
if(errset(saWrap() t) then exit(0) else exit(1))
