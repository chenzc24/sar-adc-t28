; Native placement and integration helpers for the CDAC gate driver.
load("sar_timing.il")

procedure(refOpen(cell view)
  let((cv)
    stNeed(!ddGetObj("SAR_ADC_T28_LAYOUT" cell view) "Reference driver target already exists")
    cv=dbOpenCellViewByType("SAR_ADC_T28_LAYOUT" cell view "maskLayout" "a")
    stNeed(cv "Cannot create the reference driver view")
    cv))

procedure(refPinBox(cv name layer box direction)
  let((net tm fig)
    net=dbFindNetByName(cv name)
    tm=dbCreateTerm(net name direction)
    fig=dbCreateRect(cv list(layer "drawing") box)
    stNeed(tm && fig && dbCreatePin(net fig name tm) sprintf(nil "Cannot make terminal %s" name))
    dbCreateLabel(cv list(layer "pin")
      stPt((caar(box)+caadr(box))/2 (cadar(box)+cadadr(box))/2)
      name "centerCenter" "R0" "roman" .05)))

procedure(refPin(cv name layer x y w h direction)
  refPinBox(cv name layer list(stPt(x-w/2 y-h/2) stPt(x+w/2 y+h/2)) direction))

procedure(refChild(cv cell view name wiring)
  let((master inst tm)
    master=dbOpenCellViewByType("SAR_ADC_T28_LAYOUT" cell view "" "r")
    stNeed(master && length(master~>terminals)==length(wiring) sprintf(nil "Interface changed on %s" cell))
    inst=dbCreateInst(cv master name 0:0 "R0")
    foreach(pair wiring
      tm=dbFindTermByName(master car(pair))
      stNeed(tm && dbCreateInstTerm(dbFindNetByName(cv cadr(pair)) inst tm)
        sprintf(nil "Cannot bind %s.%s" name car(pair))))
    dbClose(master)
    inst))

procedure(refCopyPin(cv instName name direction)
  let((inst tm figs)
    inst=dbFindAnyInstByName(cv instName)
    tm=dbFindTermByName(inst~>master name)
    figs=nil
    foreach(pin tm~>pins figs=append(figs pin~>figs))
    stNeed(length(figs)==1 sprintf(nil "Expected one landing for %s.%s" instName name))
    refPinBox(cv name car(car(figs)~>lpp) dbTransformBBox(car(figs)~>bBox inst~>transform) direction)))

procedure(refUpperVia(cv lower name x y)
  let((def via)
    def=techFindViaDefByName(techGetTechFile(cv) sprintf(nil "M%d_M%d" round(lower)+1 round(lower)))
    stNeed(def "Missing upper-metal via definition")
    via=dbCreateVia(cv def stPt(x y) "R0")
    stNeed(via "Cannot create upper-metal via")
    via~>net=dbFindNetByName(cv name)))

procedure(refSave(cv)
  dbReplaceProp(cv "generatorOwner" "string" "Layout/design/reference_driver.py")
  stNeed(dbSave(cv) "Cannot save reference driver layout")
  dbClose(cv))
