; Single-channel Bootstrap prefill core, with physical VDD/VSS for schematic VDD!/0.
unless(boundp('bsLib) bsLib="SAR_ADC_T28_LAYOUT")
procedure(bsRequire(ok message) unless(ok error("%s\n" message)))
procedure(bsPoint(x y) list(0.005*round(x/0.005) 0.005*round(y/0.005)))
; Evaluate the installed CDF callbacks just as the instance form does. The 1.8 V
; MOS generator uses the resulting contact/via enclosures to build its routes.
procedure(bsMosParams(cv model fingers gateSide sdRoute left right)
 let((seed master cdfgData cdfgForm baseline field actual values)
  seed=dbCreateInstByMasterName(cv "tsmcN28" model "symbol" "__cdf_seed" 0:0 "R0")
  master=dbOpenCellViewByType("tsmcN28" model "layout" "" "r")
  cdfgData=cdfGetInstCDF(seed)
  baseline=mapcar(lambda((p) list(p~>name p~>value)) cdfgData~>parameters)
  foreach(option list(list("Wfg" "1u") list("fingers" sprintf(nil "%d" fingers)) list("custom_style" "ON")
                      list("polyContacts" t) list("polyContactsEnh" gateSide)
                      list("routePolydir" gateSide) list("routeSD" sdRoute))
   field=cdfFindParamByName(cdfgData car(option))
   field~>value=cadr(option)
   bsRequire(errset(evalstring(field~>callback) t) strcat("CDF callback failed: " car(option))))
  foreach(p master~>parameters~>value
   field=cdfFindParamByName(cdfgData p~>name)
   when(field && !equal(cadr(assoc(p~>name baseline)) field~>value)
    actual=cond((field~>value==t "TRUE") (!field~>value "FALSE") (t field~>value))
    values=cons(list(p~>name "string" actual) values)))
  dbDeleteObject(seed)
  dbClose(master)
  append(values list(list("leftShape" "string" left) list("rightShape" "string" right)))))

procedure(bsRect(cv layer net x0 y0 x1 y1)
 let((shape)
  shape=dbCreateRect(cv list(layer "drawing") list(bsPoint(min(x0 x1) min(y0 y1)) bsPoint(max(x0 x1) max(y0 y1))))
  when(net shape~>net=dbFindNetByName(cv net))
  shape))
procedure(bsH(cv layer net y x0 x1 w)
 bsRect(cv layer net min(x0 x1)-w/2 y-w/2 max(x0 x1)+w/2 y+w/2))
procedure(bsV(cv layer net x y0 y1 w)
 bsRect(cv layer net x-w/2 min(y0 y1)-w/2 x+w/2 max(y0 y1)+w/2))
procedure(bsVia(cv lower x y @optional (enc1 '(0.025 0.025)) (enc2 '(0.025 0.025)))
 let((def)
  def=techFindViaDefByName(techGetTechFile(cv) sprintf(nil "M%d_M%d" lower+1 lower))
  bsRequire(dbCreateVia(cv def bsPoint(x y) "R0" list(list("layer1Enc" enc1) list("layer2Enc" enc2))) "Missing via")))
procedure(bsStack(cv net x y lo hi)
 for(k lo hi-1
  bsVia(cv k x y if(k==1 then '(0.0 0.03) else '(0.025 0.025)) '(0.025 0.025)))
 for(k lo+1 hi-1 bsRect(cv sprintf(nil "M%d" k) net x-0.070 y-0.080 x+0.070 y+0.080)))
procedure(bsPin(cv name layer x y)
 let((net term fig)
  net=dbFindNetByName(cv name)
  term=dbCreateTerm(net name "inputOutput")
  fig=bsRect(cv layer name x-0.060 y-0.060 x+0.060 y+0.060)
  bsRequire(dbCreatePin(net fig name term) "Cannot create core terminal")
  dbCreateLabel(cv list(layer "pin") bsPoint(x y) name "centerCenter" "R0" "roman" 0.05)))
procedure(bsPins(inst name layer)
 let((boxes)
  foreach(tm inst~>master~>terminals when(equal(name tm~>name)
   foreach(p tm~>pins foreach(f p~>figs when(equal(f~>lpp list(layer "drawing"))
    boxes=cons(dbTransformBBox(f~>bBox inst~>transform) boxes))))))
  boxes))
procedure(bsBind(cv inst wiring)
 foreach(tm inst~>master~>terminals
  let((entry)
   entry=assoc(tm~>name wiring)
   bsRequire(entry sprintf(nil "%s.%s has no mapping" inst~>name tm~>name))
   bsRequire(dbCreateInstTerm(dbFindNetByName(cv cadr(entry)) inst tm) "Cannot bind native terminal")))
 bsRequire(length(inst~>instTerms)==length(wiring) sprintf(nil "Terminal count changed: %s" inst~>name)))
procedure(bsMos(cv name model gx y nf orientation left right side sd wiring)
 let((inst x gateBox gateNet gxPin cy)
  x=gx+if(equal(orientation "MY") 0.075 -0.075)
  inst=dbCreateParamInstByMasterName(cv "tsmcN28" model "layout" name bsPoint(x y) orientation 1
       bsMosParams(cv model nf side sd if(equal(orientation "MY") right left) if(equal(orientation "MY") left right)))
  bsRequire(inst && caadr(inst~>bBox)-caar(inst~>bBox)<2.3 sprintf(nil "Invalid native MOS %s" name))
  bsBind(cv inst wiring)
  gateBox=car(bsPins(inst "G" "M2"))
  bsRequire(gateBox && abs((cadar(gateBox)+cadadr(gateBox))/2-y-if(side=="Top" 1.115 -0.115))<0.002
    sprintf(nil "%s native gate strap has moved" name))
  gateNet=cadr(assoc("G" wiring))
  foreach(b bsPins(inst "G" "M1")
   gxPin=(caar(b)+caadr(b))/2 cy=(cadar(b)+cadadr(b))/2
   bsRect(cv "M1" gateNet gxPin-0.085 cy-0.055 gxPin+0.085 cy+0.055))
  printf("BS_MOS %s model=%s fingers=%d body=%s gate=%L\n" name model nf cadr(assoc("B" wiring)) gateBox)
  inst))
; Contact a shared S/D seam on the same nine rows as the 1 um PCell end.
procedure(bsSeam(cv net x y)
 foreach(dy '(0.05 0.165 0.28 0.395 0.51 0.62 0.73 0.84 0.95)
  bsRect(cv "CO" nil x-0.02 y+dy-0.02 x+0.02 y+dy+0.02))
 bsRect(cv "M1" net x-0.025 y x+0.025 y+1.0))
procedure(bsRing(cv net implant x0 y0 x1 y1)
 let((a b c n p)
  foreach(seg list(list(x0 y0 x1 y0) list(x1 y0 x1 y1) list(x0 y1 x1 y1) list(x0 y0 x0 y1))
   foreach(l list(list("OD" 0.050) list(implant 0.115) list("M1" 0.035))
    let((half)
     half=cadr(l)
     bsRect(cv car(l) if(car(l)=="M1" net nil) car(seg)-half cadr(seg)-half caddr(seg)+half nth(3 seg)+half))))
  foreach(s list(list(x0 x1 y0 t) list(x0 x1 y1 t) list(y0+0.14 y1-0.14 x0 nil) list(y0+0.14 y1-0.14 x1 nil))
   a=car(s) b=cadr(s) c=caddr(s) n=ceiling((b-a)/0.17)
   for(k 0 n
    p=if(nth(3 s) bsPoint(a+k*(b-a)/n c) bsPoint(c a+k*(b-a)/n))
    bsRect(cv "CO" nil car(p)-0.02 cadr(p)-0.02 car(p)+0.02 cadr(p)+0.02)))))

; Each unit is the electrical 2.5 um, eight-finger, M1..M3 MOM. The
; lower two rows leave eight central sites each for the switches (27*8-16).
; Rows face like terminals across the inter-row gap. Their M3 landings are
; collinear. Metal is added only in the gaps. M4 spines feed the array.
procedure(bsArray(cv)
 let((inst x y origin orient plus minus pY mY prevLeft count)
  count=0
  for(r 0 7
   y=0.0+3.14*r
   orient=if(evenp(r) "R0" "MX")
   origin=if(evenp(r) y y+2.92)
   pY=if(evenp(r) y+2.865 y+0.055) mY=if(evenp(r) y+0.055 y+2.865)
   prevLeft=nil
   for(c 0 26
    if(r<2 && c>=10 && c<=17 then prevLeft=nil
    else
     x=(c-13)*0.92-0.38
     inst=dbCreateParamInstByMasterName(cv "tsmcN28" "cfmom_2t" "layout" sprintf(nil "Cboot_%02d_%02d" r c)
       bsPoint(x origin) orient 1 list(list("Nfinger" "string" "8") list("Lfinger" "string" "2.5u")
       list("Wfinger" "string" "50n") list("Sfinger" "string" "50n") list("StartMn" "string" "1") list("StopMn" "string" "3")))
     bsBind(cv inst '(("PLUS" "BTOP") ("MINUS" "BBOT")))
     plus=car(bsPins(inst "PLUS" "M3")) minus=car(bsPins(inst "MINUS" "M3"))
     bsRequire(plus && minus && abs((cadar(plus)+cadadr(plus))/2-pY)<0.002
        && abs((cadar(minus)+cadadr(minus))/2-mY)<0.002 "MOM pin geometry changed")
     when(prevLeft
      bsRect(cv "M3" "BTOP" prevLeft-0.01 cadar(plus) caar(plus)+0.01 cadadr(plus))
      bsRect(cv "M3" "BBOT" prevLeft-0.01 cadar(minus) caar(minus)+0.01 cadadr(minus)))
     prevLeft=caadr(plus)
     count=count+1))
   foreach(item list(list("BTOP" pY -1.01 -3.89 4.39) list("BBOT" mY -0.515 -3.47 4.81))
    foreach(bx if(r<2 list(nth(3 item) nth(4 item)) if(r==2 cddr(item) list(nth(2 item))))
     foreach(dx '(-0.070 0.070) bsVia(cv 3 bx+dx cadr(item) '(0.03 0.005) '(0.005 0.03))))))
  ; Edge spines on the two notched rows tie into the first continuous row.
  foreach(x '(-3.89 4.39) bsV(cv "M4" "BTOP" x 2.865 9.145 0.20))
  foreach(x '(-3.47 4.81) bsV(cv "M4" "BBOT" x 0.055 6.335 0.20))
  bsV(cv "M4" "BTOP" -1.01 5.31 22.035 0.20)
  bsV(cv "M4" "BBOT" -0.515 1.64 24.845 0.20)
  bsRequire(count==200 "Invalid Cboot unit count")))

procedure(bsSwitches(cv)
 let((ny py main vin)
  ny=0.80 py=3.80
  ; Native S-only strap joins the two VIN diffusions. The D and D_1
  ; terminals stay distinct. From left: VIN | VOUT | VIN | BBOT.
  main=bsMos(cv "Mmain_Mmain_U1_Msin" "nch_18_mac" -2.00 ny 3 "R0" "normal" "same" "Top" "Source"
        '(("D" "VOUT") ("D_1" "BBOT") ("S" "VIN") ("G" "G") ("B" "VSS")))
  vin=setof(b bsPins(main "S" "M1") caadr(b)-caar(b)>0.65)
  bsRequire(length(vin)==1 && abs(caar(car(vin))+2.19)<0.002 "Native VIN strap missing")
  foreach(d '(("M4A" -1.01 "R0" "same" "same" "Top" "CTRL" "G" "BBOT")
              ("M4C" -0.68 "MY" "same" "same" "Bottom" "CTRL" "CLKS" "BBOT")
              ("M8" -0.35 "MY" "same" "normal" "Top" "BBOT" "CLKSB" "VSS")
              ("Maux" 1.80 "MY" "normal" "same" "Bottom" "G" "VDD" "GRESET")
              ("MRSTG" 2.13 "MY" "same" "same" "Top" "GRESET" "CLKSB" "VSS")
              ("MNCLK" 2.46 "R0" "same" "normal" "Bottom" "CLKSB" "CLKS" "VSS"))
   bsMos(cv car(d) "nch_18_mac" cadr(d) ny 1 nth(2 d) nth(3 d) nth(4 d) nth(5 d) "None"
    list(list("D" nth(6 d)) list("G" nth(7 d)) list("S" nth(8 d)) list("B" "VSS"))))
  foreach(d '(("M2" -1.175 "R0" "normal" "same" "Bottom" "BTOP" "G" "VDD" "BTOP")
              ("M4" -0.845 "R0" "same" "normal" "Top" "G" "CTRL" "BTOP" "BTOP")
              ("M4B" 2.13 "MY" "normal" "same" "Bottom" "CTRL" "CLKS" "VDD" "VDD")
              ("MPCLK" 2.46 "R0" "same" "normal" "Bottom" "CLKSB" "CLKS" "VDD" "VDD"))
   bsMos(cv car(d) "pch_18_mac" cadr(d) py 1 nth(2 d) nth(3 d) nth(4 d) nth(5 d) "None"
    list(list("D" nth(6 d)) list("G" nth(7 d)) list("S" nth(8 d)) list("B" nth(9 d)))))
  ; GRESET connects only Maux and MRSTG, by diffusion alone.
  foreach(s '(("BBOT" -1.175) ("CTRL" -0.845) ("BBOT" -0.515) ("VSS" 2.295))
   bsSeam(cv car(s) cadr(s) ny))
  foreach(s '(("BTOP" -1.01) ("VDD" 2.295)) bsSeam(cv car(s) cadr(s) py))
  ; Substrate guard; boosted and static PMOS each have a contacted well.
  bsRing(cv "VSS" "PP" -2.86 0.36 3.32 2.37)
  bsRect(cv "NP" nil -2.745 0.475 3.205 2.255)
  foreach(w '(("BTOP" -1.98 -0.04) ("VDD" 1.30 3.31))
   bsRect(cv "NW" nil cadr(w)-0.16 3.13 caddr(w)+0.16 5.47)
   bsRect(cv "PP" nil cadr(w)+0.115 3.405 caddr(w)-0.115 5.195)
   bsRing(cv car(w) "NP" cadr(w) 3.29 caddr(w) 5.31))
  bsV(cv "M1" "BTOP" -1.01 py+0.97 5.31 0.05)
  bsV(cv "M1" "VDD" 2.295 3.29 py+0.03 0.05)
  foreach(x '(-0.185 2.295) bsV(cv "M1" "VSS" x 0.36 ny+0.03 0.05))
  ; Analogue input and held output leave at their actual diffusion columns.
  foreach(s '(("VIN" -2.165) ("VOUT" -1.835))
   bsStack(cv car(s) cadr(s) 0.88 1 2)
   bsV(cv "M2" car(s) cadr(s) 0.07 0.88 0.09) bsPin(cv car(s) "M2" cadr(s) 0.07))
  ; BBOT feed from the two diffusion seams. BTOP leaves its well contact.
  foreach(x '(-1.175 -0.515) bsStack(cv "BBOT" x 1.64 1 2))
  bsH(cv "M2" "BBOT" 1.64 -1.175 -0.515 0.09)
  bsVia(cv 2 -0.515 1.64)
  bsStack(cv "BTOP" -1.01 5.31 1 3)
  bsRect(cv "M3" "BTOP" -1.15 5.245 -0.87 5.375)
  bsRect(cv "M3" "BBOT" -0.57 1.50 -0.46 1.78)
  foreach(delta '(-0.070 0.070)
   bsVia(cv 3 -1.01+delta 5.31 '(0.03 0.005) '(0.005 0.03))
   bsVia(cv 3 -0.515 1.64+delta '(0.005 0.03) '(0.03 0.005)))
  ; The boosted gate and CTRL rise beside their actual device terminals.
  bsH(cv "M2" "G" 1.915 -1.34 -0.68 0.11)
  bsVia(cv 2 -0.68 1.915)
  bsV(cv "M3" "G" -0.68 1.18 4.08 0.08)
  bsH(cv "M2" "G" 1.18 -0.68 1.635 0.10)
  bsVia(cv 2 -0.68 1.18) bsStack(cv "G" 1.635 1.18 1 2)
  bsH(cv "M2" "G" 3.685 -1.175 -0.68 0.11) bsVia(cv 2 -0.68 3.685)
  bsStack(cv "G" -0.68 4.08 1 3)
  bsStack(cv "CTRL" -0.845 1.38 1 3)
  bsV(cv "M3" "CTRL" -0.845 1.38 4.915 0.08)
  bsRect(cv "M2" "CTRL" -0.935 4.86 -0.755 4.97) bsVia(cv 2 -0.845 4.915)
  bsH(cv "M2" "CTRL" 4.32 -0.845 1.965 0.10)
  bsVia(cv 2 -0.845 4.32) bsStack(cv "CTRL" 1.965 4.32 1 2)
  ; Power and clock are on the outside of the switch chain.
  bsH(cv "M2" "VDD" 4.55 -1.34 1.30 0.10)
  bsStack(cv "VDD" -1.34 4.55 1 2) bsVia(cv 1 1.30 4.55)
  bsV(cv "M3" "VDD" 1.80 0.07 3.29 0.12)
  bsRect(cv "M2" "VDD" 1.71 0.63 1.89 0.74)
  bsStack(cv "VDD" 1.80 3.29 1 3) bsVia(cv 2 1.80 0.685) bsPin(cv "VDD" "M3" 1.80 0.07)
  bsVia(cv 1 3.15 0.36) bsV(cv "M2" "VSS" 3.15 0.07 0.36 0.12) bsPin(cv "VSS" "M2" 3.15 0.07)
  bsH(cv "M2" "CLKS" 0.49 -0.68 2.46 0.11)
  bsV(cv "M2" "CLKS" -0.68 0.49 0.685 0.11)
  bsV(cv "M2" "CLKS" 2.46 0.07 0.685 0.11) bsPin(cv "CLKS" "M2" 2.46 0.07)
  bsVia(cv 2 2.46 0.685) bsV(cv "M3" "CLKS" 2.46 0.685 3.685 0.08)
  bsVia(cv 2 2.46 3.685) bsH(cv "M2" "CLKS" 3.685 2.13 2.46 0.11)
  bsH(cv "M2" "CLKSB" 1.915 -0.35 2.625 0.11)
  bsVia(cv 2 2.625 1.915) bsStack(cv "CLKSB" 2.625 1.54 1 3)
  bsV(cv "M3" "CLKSB" 2.625 1.54 4.08 0.08) bsStack(cv "CLKSB" 2.625 4.08 1 3)))

procedure(bsBuild()
 let((lib cv owner cell)
  cell="sar_bootstrap_flat_8b_p_core"
  lib=ddGetObj(bsLib)
  bsRequire(lib && techGetTechFile(lib)~>libName=="tsmcN28" "Missing T28 technology")
  cv=dbOpenCellViewByType(bsLib cell "layout" "maskLayout" "a")
  bsRequire(cv "Cannot open Bootstrap core")
  owner=dbFindProp(cv "generatorOwner")
  bsRequire((!cv~>instances && !cv~>shapes && !cv~>nets && !cv~>vias) ||
     (owner && owner~>value=="Layout/design/bootstrap.il") "Existing view has a different owner")
  foreach(obj cv~>instances dbDeleteObject(obj))
  foreach(obj cv~>vias dbDeleteObject(obj))
  foreach(obj cv~>shapes dbDeleteObject(obj))
  foreach(obj cv~>nets dbDeleteObject(obj))
  dbReplaceProp(cv "generatorOwner" "string" "Layout/design/bootstrap.il")
  foreach(net '("CLKS" "VIN" "VOUT" "VDD" "VSS" "G" "BBOT" "BTOP" "CTRL" "GRESET" "CLKSB") dbCreateNet(cv net))
  bsArray(cv) bsSwitches(cv)
  bsRequire(dbSave(cv) "Cannot save")
  dbClose(cv)
  cv=dbOpenCellViewByType(bsLib cell "layout" "" "r")
  bsRequire(cv && length(cv~>instances)==211 && length(cv~>terminals)==5 "Saved placement or ports differ")
  bsRequire(forall(i cv~>instances length(i~>instTerms)==length(i~>master~>terminals)) "Unbound device terminal")
  foreach(port cv~>terminals
   let((fig) fig=car(car(port~>pins)~>figs) printf("BS_PORT %s %s %L\n" port~>name car(fig~>lpp) fig~>bBox)))
  printf("PILOT_OA_OK %s instances=%d ports=%d bbox=%L\n" cell length(cv~>instances) length(cv~>terminals) cv~>bBox)
  dbClose(cv) printf("BS_DONE\n") t))
if(errset(bsBuild() t) then exit(0) else exit(1))
