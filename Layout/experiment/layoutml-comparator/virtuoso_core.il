; Native T28 MOS parameter evaluation. The callback chain supplies the gate,
; contact and enclosure settings which raw CDF toggles alone do not materialize.
procedure(saParams(cv model width side gateRoute sdRoute left right)
  let((seed mast cdfgData cdfgForm initial f val pars)
    seed=dbCreateInstByMasterName(cv "tsmcN28" model "symbol" "__sa_cdf" 0:0 "R0")
    unless(seed error("Cannot evaluate T28 MOS CDF"))
    mast=dbOpenCellViewByType("tsmcN28" model "layout" "" "r")
    cdfgData=cdfGetInstCDF(seed)
    initial=mapcar(lambda((p) list(p~>name p~>value)) cdfgData~>parameters)
    foreach(opt list(list("Wfg" width) list("fingers" "1") list("custom_style" "ON")
                     list("polyContacts" t) list("polyContactsEnh" side)
                     list("routePolydir" gateRoute) list("routeSD" sdRoute))
      f=cdfFindParamByName(cdfgData car(opt))
      unless(f error("CDF lacks %L" car(opt)))
      f~>value=cadr(opt)
      when(f~>callback && !equal(f~>callback "")
        unless(errset(evalstring(f~>callback) t) error("Failed CDF callback %L" car(opt)))))
    foreach(p mast~>parameters~>value
      f=cdfFindParamByName(cdfgData p~>name)
      when(f && !equal(cadr(assoc(p~>name initial)) f~>value)
        val=cond((f~>value==t "TRUE") (!f~>value "FALSE") (t f~>value))
        pars=cons(list(p~>name "string" val) pars)))
    dbDeleteObject(seed)
    dbClose(mast)
    append(pars list(list("leftShape" "string" left) list("rightShape" "string" right)))))

; Coordinates below are integer nanometres on the 5 nm OA grid.
procedure(saPt(x y) list(x/1000.0 y/1000.0))
procedure(saRect(cv lay purpose net x1 y1 x2 y2)
  let((f)
    unless(x1<x2 && y1<y2 error("Bad %s box %L" lay list(x1 y1 x2 y2)))
    f=dbCreateRect(cv list(lay purpose) list(saPt(x1 y1) saPt(x2 y2)))
    unless(f error("Failed to create %s" lay))
    when(net f~>net=dbFindNetByName(cv net)) f))
procedure(saVia(cv name x y pars)
  let((v) v=dbCreateVia(cv techFindViaDefByName(techGetTechFile(cv) name) saPt(x y) "R0" pars)
    unless(v error("Missing via %s" name)) v))
procedure(saMos(cv name model width gx y orient left right side nets)
  let((inst orig par term net)
    orig=gx+if(orient=="MY" 15 -15)
    par=saParams(cv model sprintf(nil "%dn" width) side "None" "None"
                 if(orient=="MY" right left) if(orient=="MY" left right))
    inst=dbCreateParamInstByMasterName(cv "tsmcN28" model "layout" name saPt(orig y) orient 1 par)
    unless(inst && length(inst~>master~>terminals)==4 error("Invalid native MOS %s" name))
    foreach(pin '("D" "G" "S" "B")
      term=dbFindTermByName(inst~>master pin)
      net=dbFindNetByName(cv car(nets))
      unless(term && net && dbCreateInstTerm(net inst term) error("%s.%s failed binding" name pin))
      nets=cdr(nets))
    inst))
procedure(saPin(cv name lay x y w h direction)
  let((net f term)
    net=dbFindNetByName(cv name)
    term=dbCreateTerm(net name direction)
    f=saRect(cv lay "drawing" name x-w/2 y-h/2 x+w/2 y+h/2)
    unless(term && dbCreatePin(net f name term) error("Missing pin %s" name))
    dbCreateLabel(cv list(lay "pin") saPt(x y) name "centerCenter" "R0" "roman" 0.06)))
