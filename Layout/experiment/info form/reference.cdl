* Electrical source SHA256 c7fcfed4f2e49a1d569af2babe307cba4bbbdac1e400c7325f32b954e70c54b3
.SUBCKT sar_strongarm_t28_core CLK OUTN OUTP VDD VINN VINP VSS
MNLATN OUTN OUTP Y VSS nch_mac L=30n W=500n
MNLATP OUTP OUTN X VSS nch_mac L=30n W=500n
MNINN X VINN TAIL VSS nch_mac L=30n W=1u
MNINP Y VINP TAIL VSS nch_mac L=30n W=1u
MNTAIL TAIL CLK VSS VSS nch_mac L=30n W=1u
MPRSTN OUTN CLK VDD VDD pch_mac L=30n W=500n
MPRSTP OUTP CLK VDD VDD pch_mac L=30n W=500n
MPRSTY Y CLK VDD VDD pch_mac L=30n W=500n
MPRSTX X CLK VDD VDD pch_mac L=30n W=500n
MPLATN OUTN OUTP VDD VDD pch_mac L=30n W=500n
MPLATP OUTP OUTN VDD VDD pch_mac L=30n W=500n
.ENDS sar_strongarm_t28_core
