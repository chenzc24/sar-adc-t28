// OA-derived full-parameter nominal test. Foundry models are not distributed.
simulator lang=spectre
global 0 VDD!
parameters SUP=0.9 VDIFF=0.123
include "/home/process/tsmc28n/PDK_mmWave/iPDK_CRN28HPC+ULL_v1.8_2p2a_20190531/tsmcN28/../models/spectre/crn28ull_1d8_elk_v1d8_2p2_shrink0d9_embedded_usage.scs" section=pre_simu
include "/home/process/tsmc28n/PDK_mmWave/iPDK_CRN28HPC+ULL_v1.8_2p2a_20190531/tsmcN28/../models/spectre/crn28ull_1d8_elk_v1d8_2p2_shrink0d9_embedded_usage.scs" section=noise_worst
include "/home/process/tsmc28n/PDK_mmWave/iPDK_CRN28HPC+ULL_v1.8_2p2a_20190531/tsmcN28/../models/spectre/crn28ull_1d8_elk_v1d8_2p2_shrink0d9_embedded_usage.scs" section=TTGlobalCorner_LocalMC_MOS_MOSCAP
include "/home/process/tsmc28n/PDK_mmWave/iPDK_CRN28HPC+ULL_v1.8_2p2a_20190531/tsmcN28/../models/spectre/crn28ull_1d8_elk_v1d8_2p2_shrink0d9_embedded_usage.scs" section=tt_res_bip_dio_disres
include "/home/process/tsmc28n/PDK_mmWave/iPDK_CRN28HPC+ULL_v1.8_2p2a_20190531/tsmcN28/../models/spectre/crn28ull_1d8_elk_v1d8_2p2_shrink0d9_embedded_usage.scs" section=TTGlobalCorner_LocalMC_MOM
include "/home/process/tsmc28n/PDK_mmWave/iPDK_CRN28HPC+ULL_v1.8_2p2a_20190531/tsmcN28/../models/spectre/crn28ull_1d8_elk_v1d8_2p2_shrink0d9_embedded_usage.scs" section=tt_ind_jvar
include "/home/process/tsmc28n/PDK_mmWave/iPDK_CRN28HPC+ULL_v1.8_2p2a_20190531/tsmcN28/../models/spectre/crn28ull_1d8_elk_v1d8_2p2_shrink0d9_embedded_usage.scs" section=tt_r_metal

simulatorOptions options temp=27 tnom=27 reltol=1e-6 vabstol=1e-8 iabstol=1e-13 method=trap maxwarns=5 maxnotes=5 preserve_inst=all
saveOptions options save=selected
VCMOMN8 (CMOMN8 0) vsource dc=0.45 mag=1
CMOMN8 (CMOMN8 0) cfmom_2t nr=8 lr=2u w=50n s=50n stm=1 spm=3  multi=1 mismatchflag=1
VCMOMN7 (CMOMN7 0) vsource dc=0.45 mag=1
CMOMN7 (CMOMN7 0) cfmom_2t nr=8 lr=2u w=50n s=50n stm=1 spm=3  multi=128 mismatchflag=1
VCMOMN6 (CMOMN6 0) vsource dc=0.45 mag=1
CMOMN6 (CMOMN6 0) cfmom_2t nr=8 lr=2u w=50n s=50n stm=1 spm=3 multi=64  mismatchflag=1
VCMOMN5 (CMOMN5 0) vsource dc=0.45 mag=1
CMOMN5 (CMOMN5 0) cfmom_2t nr=8 lr=2u w=50n s=50n stm=1 spm=3 multi=32  mismatchflag=1
VCMOMN4 (CMOMN4 0) vsource dc=0.45 mag=1
CMOMN4 (CMOMN4 0) cfmom_2t nr=8 lr=2u w=50n s=50n stm=1 spm=3 multi=16  mismatchflag=1
VCMOMN3 (CMOMN3 0) vsource dc=0.45 mag=1
CMOMN3 (CMOMN3 0) cfmom_2t nr=8 lr=2u w=50n s=50n stm=1 spm=3 multi=8  mismatchflag=1
VCMOMN2 (CMOMN2 0) vsource dc=0.45 mag=1
CMOMN2 (CMOMN2 0) cfmom_2t nr=8 lr=2u w=50n s=50n stm=1 spm=3 multi=4  mismatchflag=1
VCMOMN1 (CMOMN1 0) vsource dc=0.45 mag=1
CMOMN1 (CMOMN1 0) cfmom_2t nr=8 lr=2u w=50n s=50n stm=1 spm=3 multi=2  mismatchflag=1
VCMOMN0 (CMOMN0 0) vsource dc=0.45 mag=1
CMOMN0 (CMOMN0 0) cfmom_2t nr=8 lr=2u w=50n s=50n stm=1 spm=3 multi=1  mismatchflag=1
VCMOMP8 (CMOMP8 0) vsource dc=0.45 mag=1
CMOMP8 (CMOMP8 0) cfmom_2t nr=8 lr=2u w=50n s=50n stm=1 spm=3  multi=1 mismatchflag=1
VCMOMP7 (CMOMP7 0) vsource dc=0.45 mag=1
CMOMP7 (CMOMP7 0) cfmom_2t nr=8 lr=2u w=50n s=50n stm=1 spm=3  multi=128 mismatchflag=1
VCMOMP6 (CMOMP6 0) vsource dc=0.45 mag=1
CMOMP6 (CMOMP6 0) cfmom_2t nr=8 lr=2u w=50n s=50n stm=1 spm=3 multi=64  mismatchflag=1
VCMOMP5 (CMOMP5 0) vsource dc=0.45 mag=1
CMOMP5 (CMOMP5 0) cfmom_2t nr=8 lr=2u w=50n s=50n stm=1 spm=3 multi=32  mismatchflag=1
VCMOMP4 (CMOMP4 0) vsource dc=0.45 mag=1
CMOMP4 (CMOMP4 0) cfmom_2t nr=8 lr=2u w=50n s=50n stm=1 spm=3 multi=16  mismatchflag=1
VCMOMP3 (CMOMP3 0) vsource dc=0.45 mag=1
CMOMP3 (CMOMP3 0) cfmom_2t nr=8 lr=2u w=50n s=50n stm=1 spm=3 multi=8  mismatchflag=1
VCMOMP2 (CMOMP2 0) vsource dc=0.45 mag=1
CMOMP2 (CMOMP2 0) cfmom_2t nr=8 lr=2u w=50n s=50n stm=1 spm=3 multi=4  mismatchflag=1
VCMOMP1 (CMOMP1 0) vsource dc=0.45 mag=1
CMOMP1 (CMOMP1 0) cfmom_2t nr=8 lr=2u w=50n s=50n stm=1 spm=3 multi=2  mismatchflag=1
VCMOMP0 (CMOMP0 0) vsource dc=0.45 mag=1
CMOMP0 (CMOMP0 0) cfmom_2t nr=8 lr=2u w=50n s=50n stm=1 spm=3 multi=1  mismatchflag=1
mc montecarlo numruns=1 seed=4147 variations=mismatch sampling=standard donominal=no savemismatchparams=yes mismatchparamfile="mismatch.params" mismatchscalarfile="mismatch.values" savefamilyplots=yes savedatainseparatedir=yes {
cap_ac ac start=1Meg stop=2Meg lin=2
}
save VCMOMN8:p VCMOMN7:p VCMOMN6:p VCMOMN5:p VCMOMN4:p VCMOMN3:p VCMOMN2:p VCMOMN1:p VCMOMN0:p VCMOMP8:p VCMOMP7:p VCMOMP6:p VCMOMP5:p VCMOMP4:p VCMOMP3:p VCMOMP2:p VCMOMP1:p VCMOMP0:p
