// OA-derived full-parameter nominal test. Foundry models are not distributed.
simulator lang=spectre
global 0 VDD!
parameters SUP=0.9 VDIFF=0.123
include "/home/process/tsmc28n/PDK_mmWave/iPDK_CRN28HPC+ULL_v1.8_2p2a_20190531/tsmcN28/../models/spectre/crn28ull_1d8_elk_v1d8_2p2_shrink0d9_embedded_usage.scs" section=pre_simu
include "/home/process/tsmc28n/PDK_mmWave/iPDK_CRN28HPC+ULL_v1.8_2p2a_20190531/tsmcN28/../models/spectre/crn28ull_1d8_elk_v1d8_2p2_shrink0d9_embedded_usage.scs" section=noise_worst
include "/home/process/tsmc28n/PDK_mmWave/iPDK_CRN28HPC+ULL_v1.8_2p2a_20190531/tsmcN28/../models/spectre/crn28ull_1d8_elk_v1d8_2p2_shrink0d9_embedded_usage.scs" section=TTGlobalCorner_LocalMC_MOS_MOSCAP
include "/home/process/tsmc28n/PDK_mmWave/iPDK_CRN28HPC+ULL_v1.8_2p2a_20190531/tsmcN28/../models/spectre/crn28ull_1d8_elk_v1d8_2p2_shrink0d9_embedded_usage.scs" section=TTGlobalCorner_LocalMC_RES_BIP_DIO_DISRES
include "/home/process/tsmc28n/PDK_mmWave/iPDK_CRN28HPC+ULL_v1.8_2p2a_20190531/tsmcN28/../models/spectre/crn28ull_1d8_elk_v1d8_2p2_shrink0d9_embedded_usage.scs" section=TTGlobalCorner_LocalMC_MOM
include "/home/process/tsmc28n/PDK_mmWave/iPDK_CRN28HPC+ULL_v1.8_2p2a_20190531/tsmcN28/../models/spectre/crn28ull_1d8_elk_v1d8_2p2_shrink0d9_embedded_usage.scs" section=TTGlobalCorner_LocalMC_IND_JVAR
include "/home/process/tsmc28n/PDK_mmWave/iPDK_CRN28HPC+ULL_v1.8_2p2a_20190531/tsmcN28/../models/spectre/crn28ull_1d8_elk_v1d8_2p2_shrink0d9_embedded_usage.scs" section=tt_r_metal

include "library_include.scs"
include "dut.scs"
include "tb.scs"
simulatorOptions options psfversion="1.4.0" method=gear2only reltol=1e-6 vabstol=1e-8 \
    iabstol=1e-13 temp=27 tnom=27 scalem=1.0 scale=1.0 gmin=1e-12 rforce=1 \
    maxnotes=5 maxwarns=5 digits=5 cols=80 pivrel=1e-3 \
    checklimitdest=psf
saveOptions options save=selected

XMEASURE (XDUT.SAMPLE_INT XDUT.CMP_CLK XDUT.XCTRL.PHI_W XDUT.PHI_U XDUT.XREF.CAP_CLK VDD! VINP_SRC VINN_SRC XDUT.TOPP XDUT.TOPN D0 D1 D2 D3 D4 D5 D6 D7) r4_perf_monitor time_origin=59n
ahdl_include "r4_perf_monitor.va"
mc montecarlo numruns=1 seed=3106 variations=mismatch sampling=standard donominal=no savemismatchparams=yes mismatchparamfile="mismatch.params" mismatchscalarfile="mismatch.values" savefamilyplots=yes savedatainseparatedir=yes {
tran_ab tran stop=1059n maxstep=10p errpreset=moderate lteratio=10
}
save D0 D1 D2 D3 D4 D5 D6 D7 SAMPLE VDD! VINP_SRC VINN_SRC VINP VINN VREFP VREFN XDUT.SAMPLE_INT XDUT.SEQ_SAMPLE XDUT.CMP_CLK XDUT.XCTRL.PHI_W XDUT.PHI_U XDUT.XREF.CAP_CLK XDUT.TOPP XDUT.TOPN XDUT.XBOOTP.G XDUT.XBOOTN.G XDUT.ACTIVE XDUT.COMP_P XDUT.COMP_N xdut.xbootp.btop xdut.xbootp.bbot xdut.xbootn.btop xdut.xbootn.bbot
