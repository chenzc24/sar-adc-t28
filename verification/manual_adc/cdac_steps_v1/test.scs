simulator lang=spectre
include "models.scs"
include "dut.scs"
VVDD (VDD 0) vsource dc=.9
VCLK (CLKS 0) vsource type=pulse val0=0 val1=.9 delay=10n rise=50p fall=50p width=39.9n period=1000n
VP (INP 0) vsource dc=.5
VN (INN 0) vsource dc=.4
VREF (REF 0) vsource dc=.9
VP1 (P1 0) vsource type=pwl wave=[0n 0 85n 0 85.05n 0.9]
VP2 (P2 0) vsource type=pwl wave=[0n 0 80n 0 80.05n 0.9]
VP3 (P3 0) vsource type=pwl wave=[0n 0 75n 0 75.05n 0.9]
VP4 (P4 0) vsource type=pwl wave=[0n 0]
VP5 (P5 0) vsource type=pwl wave=[0n 0]
VP6 (P6 0) vsource type=pwl wave=[0n 0]
VP7 (P7 0) vsource type=pwl wave=[0n 0.9]
VN1 (N1 0) vsource type=pwl wave=[0n 0]
VN2 (N2 0) vsource type=pwl wave=[0n 0]
VN3 (N3 0) vsource type=pwl wave=[0n 0]
VN4 (N4 0) vsource type=pwl wave=[0n 0 70n 0 70.05n 0.9]
VN5 (N5 0) vsource type=pwl wave=[0n 0 65n 0 65.05n 0.9]
VN6 (N6 0) vsource type=pwl wave=[0n 0 60n 0 60.05n 0.9]
VN7 (N7 0) vsource type=pwl wave=[0n 0.9 55n 0.9 55.05n 0]
XP (CLKS 0 VDD INP TOPP REF 0 P7 P6 P5 P4 P3 P2 P1) manual_cdac
XN (CLKS 0 VDD INN TOPN REF 0 N7 N6 N5 N4 N3 N2 N1) manual_cdac
simulatorOptions options reltol=1e-5 vabstol=1e-7 iabstol=1e-13 temp=27 tnom=27 gmin=1e-12 checklimitdest=psf
saveOptions options save=selected currents=selected
tran_test tran stop=110n maxstep=20p errpreset=conservative
save CLKS INN INP N1 N2 N3 N4 N5 N6 N7 P1 P2 P3 P4 P5 P6 P7 REF TOPN TOPP VDD VREF:1 VVDD:1 XN.net1 XN.net2 XN.net3 XN.net4 XN.net5 XN.net6 XN.net7 XP.net1 XP.net2 XP.net3 XP.net4 XP.net5 XP.net6 XP.net7
