simulator lang=spectre
global 0
include "models.scs"
include "dut.scs"
VVDD (VDD 0) vsource dc=.9
VCLK (CLKS 0) vsource type=pulse val0=0 val1=.9 delay=10n rise=50p fall=50p width=39.9n period=100n
XDUT (CLKS 0 VDD DCMPP DCMPN CMPCK DO_7 DO_6 DO_5 DO_4 DO_3 DO_2 DO_1 DO_0 DCTRLP_7 DCTRLP_6 DCTRLP_5 DCTRLP_4 DCTRLP_3 DCTRLP_2 DCTRLP_1 DCTRLP_0 DCTRLN_7 DCTRLN_6 DCTRLN_5 DCTRLN_4 DCTRLN_3 DCTRLN_2 DCTRLN_1 DCTRLN_0) manual_sar tloop=2n tgate=100p
ahdl_include "logic_delay.va"
ahdl_include "manual8_sample.va"
ahdl_include "manual8_cdac.va"
ahdl_include "manual8_cmp.va"
VINP (VINP 0) vsource type=pwl wave=[0 0.0017578125 1e-07 0.0017578125 1.0005e-07 0.8982421875 2e-07 0.8982421875 2.0005e-07 0.3005859375 3e-07 0.3005859375 3.0005e-07 0.5994140625 4e-07 0.5994140625 4.0005e-07 0.4517578125 5e-07 0.4517578125 5.0005e-07 0.4482421875 6e-07 0.4482421875 6.0005e-07 0.0052734375 7e-07 0.0052734375 7.0005e-07 0.8947265625 8e-07 0.8947265625 8.0005e-07 0.0017578125 9e-07 0.0017578125 9.0005e-07 0.8982421875 1e-06 0.8982421875 1.00005e-06 0.3005859375 1.1e-06 0.3005859375 1.10005e-06 0.5994140625 1.2e-06 0.5994140625 1.20005e-06 0.4517578125 1.3e-06 0.4517578125 1.30005e-06 0.4482421875 1.4e-06 0.4482421875 1.40005e-06 0.0052734375 1.5e-06 0.0052734375 1.50005e-06 0.8947265625]
XSP (CLKS 0 VDD VINP TOPP) manual8_sample ron=1 roff=1T trf=10p cin=0 qclk=0
XCP (0 VDD TOPP REF 0 DCTRLN_7 DCTRLP_6 DCTRLP_5 DCTRLP_4 DCTRLP_3 DCTRLP_2 DCTRLP_1) manual8_cdac cunit=10f ronunit=10 ctop=0
VINN (VINN 0) vsource type=pwl wave=[0 0.8982421875 1e-07 0.8982421875 1.0005e-07 0.0017578125 2e-07 0.0017578125 2.0005e-07 0.5994140625 3e-07 0.5994140625 3.0005e-07 0.3005859375 4e-07 0.3005859375 4.0005e-07 0.4482421875 5e-07 0.4482421875 5.0005e-07 0.4517578125 6e-07 0.4517578125 6.0005e-07 0.8947265625 7e-07 0.8947265625 7.0005e-07 0.0052734375 8e-07 0.0052734375 8.0005e-07 0.8982421875 9e-07 0.8982421875 9.0005e-07 0.0017578125 1e-06 0.0017578125 1.00005e-06 0.5994140625 1.1e-06 0.5994140625 1.10005e-06 0.3005859375 1.2e-06 0.3005859375 1.20005e-06 0.4482421875 1.3e-06 0.4482421875 1.30005e-06 0.4517578125 1.4e-06 0.4517578125 1.40005e-06 0.8947265625 1.5e-06 0.8947265625 1.50005e-06 0.0052734375]
XSN (CLKS 0 VDD VINN TOPN) manual8_sample ron=1 roff=1T trf=10p cin=0 qclk=0
XCN (0 VDD TOPN REF 0 DCTRLP_7 DCTRLN_6 DCTRLN_5 DCTRLN_4 DCTRLN_3 DCTRLN_2 DCTRLN_1) manual8_cdac cunit=10f ronunit=10 ctop=0
VREF (REF 0) vsource dc=.9
XCMP (CMPCK TOPP TOPN VDD 0 DCMPP DCMPN) manual8_cmp td=200p trf=50p rout=1 vos=0 cin=0 treg=0 qkickp=0 qkickn=0
LOADPM12 (VDD DCTRLP_1 VDD VDD) pch_mac l=100n w=3u multi=2 nf=10          sd=120.0n ad=1.8e-13 as=2.01e-13 pd=4.2u ps=4.94u nrd=0.065737          nrs=0.065737 sa=551.022n sb=551.022n sa1=212.829n sa2=458.86n          sa3=727.268n sa4=476.12n sb1=212.829n sb2=458.86n sb3=727.268n          spa=120.0n spa1=120.0n spa2=120.0n spa3=120.0n sap=191.293n          sapb=215.014n spba=162.129n spba1=166.371n dfm_flag=0          spmt=1.11111e+15 spomt=0 spomt1=1.11111e+60 spmb=1.11111e+15          spomb=0 spomb1=1.11111e+60
LOADPM9 (VDD DCTRLP_2 VDD VDD) pch_mac l=100n w=3u multi=4 nf=10 sd=120.0n          ad=1.8e-13 as=2.01e-13 pd=4.2u ps=4.94u nrd=0.065737 nrs=0.065737          sa=551.022n sb=551.022n sa1=212.829n sa2=458.86n sa3=727.268n          sa4=476.12n sb1=212.829n sb2=458.86n sb3=727.268n spa=120.0n          spa1=120.0n spa2=120.0n spa3=120.0n sap=191.293n sapb=215.014n          spba=162.129n spba1=166.371n dfm_flag=0 spmt=1.11111e+15 spomt=0          spomt1=1.11111e+60 spmb=1.11111e+15 spomb=0 spomb1=1.11111e+60
LOADPM8 (VDD DCTRLP_3 VDD VDD) pch_mac l=100n w=3u multi=8 nf=10 sd=120.0n          ad=1.8e-13 as=2.01e-13 pd=4.2u ps=4.94u nrd=0.065737 nrs=0.065737          sa=551.022n sb=551.022n sa1=212.829n sa2=458.86n sa3=727.268n          sa4=476.12n sb1=212.829n sb2=458.86n sb3=727.268n spa=120.0n          spa1=120.0n spa2=120.0n spa3=120.0n sap=191.293n sapb=215.014n          spba=162.129n spba1=166.371n dfm_flag=0 spmt=1.11111e+15 spomt=0          spomt1=1.11111e+60 spmb=1.11111e+15 spomb=0 spomb1=1.11111e+60
LOADPM6 (VDD DCTRLP_4 VDD VDD) pch_mac l=100n w=3u multi=16 nf=10          sd=120.0n ad=1.8e-13 as=2.01e-13 pd=4.2u ps=4.94u nrd=0.065737          nrs=0.065737 sa=551.022n sb=551.022n sa1=212.829n sa2=458.86n          sa3=727.268n sa4=476.12n sb1=212.829n sb2=458.86n sb3=727.268n          spa=120.0n spa1=120.0n spa2=120.0n spa3=120.0n sap=191.293n          sapb=215.014n spba=162.129n spba1=166.371n dfm_flag=0          spmt=1.11111e+15 spomt=0 spomt1=1.11111e+60 spmb=1.11111e+15          spomb=0 spomb1=1.11111e+60
LOADPM5 (VDD DCTRLP_5 VDD VDD) pch_mac l=100n w=3u multi=32 nf=10          sd=120.0n ad=1.8e-13 as=2.01e-13 pd=4.2u ps=4.94u nrd=0.065737          nrs=0.065737 sa=551.022n sb=551.022n sa1=212.829n sa2=458.86n          sa3=727.268n sa4=476.12n sb1=212.829n sb2=458.86n sb3=727.268n          spa=120.0n spa1=120.0n spa2=120.0n spa3=120.0n sap=191.293n          sapb=215.014n spba=162.129n spba1=166.371n dfm_flag=0          spmt=1.11111e+15 spomt=0 spomt1=1.11111e+60 spmb=1.11111e+15          spomb=0 spomb1=1.11111e+60
LOADPM4 (VDD DCTRLP_6 VDD VDD) pch_mac l=100n w=3u multi=64 nf=10          sd=120.0n ad=1.8e-13 as=2.01e-13 pd=4.2u ps=4.94u nrd=0.065737          nrs=0.065737 sa=551.022n sb=551.022n sa1=212.829n sa2=458.86n          sa3=727.268n sa4=476.12n sb1=212.829n sb2=458.86n sb3=727.268n          spa=120.0n spa1=120.0n spa2=120.0n spa3=120.0n sap=191.293n          sapb=215.014n spba=162.129n spba1=166.371n dfm_flag=0          spmt=1.11111e+15 spomt=0 spomt1=1.11111e+60 spmb=1.11111e+15          spomb=0 spomb1=1.11111e+60
LOADPM0 (VDD DCTRLP_7 VDD VDD) pch_mac l=100n w=3u multi=128 nf=10          sd=120.0n ad=1.8e-13 as=2.01e-13 pd=4.2u ps=4.94u nrd=0.065737          nrs=0.065737 sa=551.022n sb=551.022n sa1=212.829n sa2=458.86n          sa3=727.268n sa4=476.12n sb1=212.829n sb2=458.86n sb3=727.268n          spa=120.0n spa1=120.0n spa2=120.0n spa3=120.0n sap=191.293n          sapb=215.014n spba=162.129n spba1=166.371n dfm_flag=0          spmt=1.11111e+15 spomt=0 spomt1=1.11111e+60 spmb=1.11111e+15          spomb=0 spomb1=1.11111e+60
LOADPM14 (0 DCTRLP_1 0 0) nch_mac l=30n w=1u multi=2 nf=10 sd=100n          ad=5e-14 as=5.5e-14 pd=2u ps=2.3u nrd=0.427491 nrs=0.427491          sa=349.754n sb=349.754n sa1=161.047n sa2=316.499n sa3=575.493n          sa4=331.707n sb1=161.047n sb2=316.499n sb3=575.493n spa=100n          spa1=100n spa2=100n spa3=100n sap=150.407n sapb=165.494n          spba=115.715n spba1=117.043n dfm_flag=0 spmt=1.11111e+15 spomt=0          spomt1=1.11111e+60 spmb=1.11111e+15 spomb=0 spomb1=1.11111e+60
LOADPM11 (0 DCTRLP_2 0 0) nch_mac l=30n w=1u multi=4 nf=10 sd=100n          ad=5e-14 as=5.5e-14 pd=2u ps=2.3u nrd=0.427491 nrs=0.427491          sa=349.754n sb=349.754n sa1=161.047n sa2=316.499n sa3=575.493n          sa4=331.707n sb1=161.047n sb2=316.499n sb3=575.493n spa=100n          spa1=100n spa2=100n spa3=100n sap=150.407n sapb=165.494n          spba=115.715n spba1=117.043n dfm_flag=0 spmt=1.11111e+15 spomt=0          spomt1=1.11111e+60 spmb=1.11111e+15 spomb=0 spomb1=1.11111e+60
LOADPM10 (0 DCTRLP_3 0 0) nch_mac l=30n w=1u multi=8 nf=10 sd=100n          ad=5e-14 as=5.5e-14 pd=2u ps=2.3u nrd=0.427491 nrs=0.427491          sa=349.754n sb=349.754n sa1=161.047n sa2=316.499n sa3=575.493n          sa4=331.707n sb1=161.047n sb2=316.499n sb3=575.493n spa=100n          spa1=100n spa2=100n spa3=100n sap=150.407n sapb=165.494n          spba=115.715n spba1=117.043n dfm_flag=0 spmt=1.11111e+15 spomt=0          spomt1=1.11111e+60 spmb=1.11111e+15 spomb=0 spomb1=1.11111e+60
LOADPM7 (0 DCTRLP_4 0 0) nch_mac l=30n w=1u multi=16 nf=10 sd=100n          ad=5e-14 as=5.5e-14 pd=2u ps=2.3u nrd=0.427491 nrs=0.427491          sa=349.754n sb=349.754n sa1=161.047n sa2=316.499n sa3=575.493n          sa4=331.707n sb1=161.047n sb2=316.499n sb3=575.493n spa=100n          spa1=100n spa2=100n spa3=100n sap=150.407n sapb=165.494n          spba=115.715n spba1=117.043n dfm_flag=0 spmt=1.11111e+15 spomt=0          spomt1=1.11111e+60 spmb=1.11111e+15 spomb=0 spomb1=1.11111e+60
LOADPM3 (0 DCTRLP_5 0 0) nch_mac l=30n w=1u multi=32 nf=10 sd=100n          ad=5e-14 as=5.5e-14 pd=2u ps=2.3u nrd=0.427491 nrs=0.427491          sa=349.754n sb=349.754n sa1=161.047n sa2=316.499n sa3=575.493n          sa4=331.707n sb1=161.047n sb2=316.499n sb3=575.493n spa=100n          spa1=100n spa2=100n spa3=100n sap=150.407n sapb=165.494n          spba=115.715n spba1=117.043n dfm_flag=0 spmt=1.11111e+15 spomt=0          spomt1=1.11111e+60 spmb=1.11111e+15 spomb=0 spomb1=1.11111e+60
LOADPM2 (0 DCTRLP_6 0 0) nch_mac l=30n w=1u multi=64 nf=10 sd=100n          ad=5e-14 as=5.5e-14 pd=2u ps=2.3u nrd=0.427491 nrs=0.427491          sa=349.754n sb=349.754n sa1=161.047n sa2=316.499n sa3=575.493n          sa4=331.707n sb1=161.047n sb2=316.499n sb3=575.493n spa=100n          spa1=100n spa2=100n spa3=100n sap=150.407n sapb=165.494n          spba=115.715n spba1=117.043n dfm_flag=0 spmt=1.11111e+15 spomt=0          spomt1=1.11111e+60 spmb=1.11111e+15 spomb=0 spomb1=1.11111e+60
LOADPM1 (0 DCTRLP_7 0 0) nch_mac l=30n w=1u multi=128 nf=10 sd=100n          ad=5e-14 as=5.5e-14 pd=2u ps=2.3u nrd=0.427491 nrs=0.427491          sa=349.754n sb=349.754n sa1=161.047n sa2=316.499n sa3=575.493n          sa4=331.707n sb1=161.047n sb2=316.499n sb3=575.493n spa=100n          spa1=100n spa2=100n spa3=100n sap=150.407n sapb=165.494n          spba=115.715n spba1=117.043n dfm_flag=0 spmt=1.11111e+15 spomt=0          spomt1=1.11111e+60 spmb=1.11111e+15 spomb=0 spomb1=1.11111e+60
LOADNM12 (VDD DCTRLN_1 VDD VDD) pch_mac l=100n w=3u multi=2 nf=10          sd=120.0n ad=1.8e-13 as=2.01e-13 pd=4.2u ps=4.94u nrd=0.065737          nrs=0.065737 sa=551.022n sb=551.022n sa1=212.829n sa2=458.86n          sa3=727.268n sa4=476.12n sb1=212.829n sb2=458.86n sb3=727.268n          spa=120.0n spa1=120.0n spa2=120.0n spa3=120.0n sap=191.293n          sapb=215.014n spba=162.129n spba1=166.371n dfm_flag=0          spmt=1.11111e+15 spomt=0 spomt1=1.11111e+60 spmb=1.11111e+15          spomb=0 spomb1=1.11111e+60
LOADNM9 (VDD DCTRLN_2 VDD VDD) pch_mac l=100n w=3u multi=4 nf=10 sd=120.0n          ad=1.8e-13 as=2.01e-13 pd=4.2u ps=4.94u nrd=0.065737 nrs=0.065737          sa=551.022n sb=551.022n sa1=212.829n sa2=458.86n sa3=727.268n          sa4=476.12n sb1=212.829n sb2=458.86n sb3=727.268n spa=120.0n          spa1=120.0n spa2=120.0n spa3=120.0n sap=191.293n sapb=215.014n          spba=162.129n spba1=166.371n dfm_flag=0 spmt=1.11111e+15 spomt=0          spomt1=1.11111e+60 spmb=1.11111e+15 spomb=0 spomb1=1.11111e+60
LOADNM8 (VDD DCTRLN_3 VDD VDD) pch_mac l=100n w=3u multi=8 nf=10 sd=120.0n          ad=1.8e-13 as=2.01e-13 pd=4.2u ps=4.94u nrd=0.065737 nrs=0.065737          sa=551.022n sb=551.022n sa1=212.829n sa2=458.86n sa3=727.268n          sa4=476.12n sb1=212.829n sb2=458.86n sb3=727.268n spa=120.0n          spa1=120.0n spa2=120.0n spa3=120.0n sap=191.293n sapb=215.014n          spba=162.129n spba1=166.371n dfm_flag=0 spmt=1.11111e+15 spomt=0          spomt1=1.11111e+60 spmb=1.11111e+15 spomb=0 spomb1=1.11111e+60
LOADNM6 (VDD DCTRLN_4 VDD VDD) pch_mac l=100n w=3u multi=16 nf=10          sd=120.0n ad=1.8e-13 as=2.01e-13 pd=4.2u ps=4.94u nrd=0.065737          nrs=0.065737 sa=551.022n sb=551.022n sa1=212.829n sa2=458.86n          sa3=727.268n sa4=476.12n sb1=212.829n sb2=458.86n sb3=727.268n          spa=120.0n spa1=120.0n spa2=120.0n spa3=120.0n sap=191.293n          sapb=215.014n spba=162.129n spba1=166.371n dfm_flag=0          spmt=1.11111e+15 spomt=0 spomt1=1.11111e+60 spmb=1.11111e+15          spomb=0 spomb1=1.11111e+60
LOADNM5 (VDD DCTRLN_5 VDD VDD) pch_mac l=100n w=3u multi=32 nf=10          sd=120.0n ad=1.8e-13 as=2.01e-13 pd=4.2u ps=4.94u nrd=0.065737          nrs=0.065737 sa=551.022n sb=551.022n sa1=212.829n sa2=458.86n          sa3=727.268n sa4=476.12n sb1=212.829n sb2=458.86n sb3=727.268n          spa=120.0n spa1=120.0n spa2=120.0n spa3=120.0n sap=191.293n          sapb=215.014n spba=162.129n spba1=166.371n dfm_flag=0          spmt=1.11111e+15 spomt=0 spomt1=1.11111e+60 spmb=1.11111e+15          spomb=0 spomb1=1.11111e+60
LOADNM4 (VDD DCTRLN_6 VDD VDD) pch_mac l=100n w=3u multi=64 nf=10          sd=120.0n ad=1.8e-13 as=2.01e-13 pd=4.2u ps=4.94u nrd=0.065737          nrs=0.065737 sa=551.022n sb=551.022n sa1=212.829n sa2=458.86n          sa3=727.268n sa4=476.12n sb1=212.829n sb2=458.86n sb3=727.268n          spa=120.0n spa1=120.0n spa2=120.0n spa3=120.0n sap=191.293n          sapb=215.014n spba=162.129n spba1=166.371n dfm_flag=0          spmt=1.11111e+15 spomt=0 spomt1=1.11111e+60 spmb=1.11111e+15          spomb=0 spomb1=1.11111e+60
LOADNM0 (VDD DCTRLN_7 VDD VDD) pch_mac l=100n w=3u multi=128 nf=10          sd=120.0n ad=1.8e-13 as=2.01e-13 pd=4.2u ps=4.94u nrd=0.065737          nrs=0.065737 sa=551.022n sb=551.022n sa1=212.829n sa2=458.86n          sa3=727.268n sa4=476.12n sb1=212.829n sb2=458.86n sb3=727.268n          spa=120.0n spa1=120.0n spa2=120.0n spa3=120.0n sap=191.293n          sapb=215.014n spba=162.129n spba1=166.371n dfm_flag=0          spmt=1.11111e+15 spomt=0 spomt1=1.11111e+60 spmb=1.11111e+15          spomb=0 spomb1=1.11111e+60
LOADNM14 (0 DCTRLN_1 0 0) nch_mac l=30n w=1u multi=2 nf=10 sd=100n          ad=5e-14 as=5.5e-14 pd=2u ps=2.3u nrd=0.427491 nrs=0.427491          sa=349.754n sb=349.754n sa1=161.047n sa2=316.499n sa3=575.493n          sa4=331.707n sb1=161.047n sb2=316.499n sb3=575.493n spa=100n          spa1=100n spa2=100n spa3=100n sap=150.407n sapb=165.494n          spba=115.715n spba1=117.043n dfm_flag=0 spmt=1.11111e+15 spomt=0          spomt1=1.11111e+60 spmb=1.11111e+15 spomb=0 spomb1=1.11111e+60
LOADNM11 (0 DCTRLN_2 0 0) nch_mac l=30n w=1u multi=4 nf=10 sd=100n          ad=5e-14 as=5.5e-14 pd=2u ps=2.3u nrd=0.427491 nrs=0.427491          sa=349.754n sb=349.754n sa1=161.047n sa2=316.499n sa3=575.493n          sa4=331.707n sb1=161.047n sb2=316.499n sb3=575.493n spa=100n          spa1=100n spa2=100n spa3=100n sap=150.407n sapb=165.494n          spba=115.715n spba1=117.043n dfm_flag=0 spmt=1.11111e+15 spomt=0          spomt1=1.11111e+60 spmb=1.11111e+15 spomb=0 spomb1=1.11111e+60
LOADNM10 (0 DCTRLN_3 0 0) nch_mac l=30n w=1u multi=8 nf=10 sd=100n          ad=5e-14 as=5.5e-14 pd=2u ps=2.3u nrd=0.427491 nrs=0.427491          sa=349.754n sb=349.754n sa1=161.047n sa2=316.499n sa3=575.493n          sa4=331.707n sb1=161.047n sb2=316.499n sb3=575.493n spa=100n          spa1=100n spa2=100n spa3=100n sap=150.407n sapb=165.494n          spba=115.715n spba1=117.043n dfm_flag=0 spmt=1.11111e+15 spomt=0          spomt1=1.11111e+60 spmb=1.11111e+15 spomb=0 spomb1=1.11111e+60
LOADNM7 (0 DCTRLN_4 0 0) nch_mac l=30n w=1u multi=16 nf=10 sd=100n          ad=5e-14 as=5.5e-14 pd=2u ps=2.3u nrd=0.427491 nrs=0.427491          sa=349.754n sb=349.754n sa1=161.047n sa2=316.499n sa3=575.493n          sa4=331.707n sb1=161.047n sb2=316.499n sb3=575.493n spa=100n          spa1=100n spa2=100n spa3=100n sap=150.407n sapb=165.494n          spba=115.715n spba1=117.043n dfm_flag=0 spmt=1.11111e+15 spomt=0          spomt1=1.11111e+60 spmb=1.11111e+15 spomb=0 spomb1=1.11111e+60
LOADNM3 (0 DCTRLN_5 0 0) nch_mac l=30n w=1u multi=32 nf=10 sd=100n          ad=5e-14 as=5.5e-14 pd=2u ps=2.3u nrd=0.427491 nrs=0.427491          sa=349.754n sb=349.754n sa1=161.047n sa2=316.499n sa3=575.493n          sa4=331.707n sb1=161.047n sb2=316.499n sb3=575.493n spa=100n          spa1=100n spa2=100n spa3=100n sap=150.407n sapb=165.494n          spba=115.715n spba1=117.043n dfm_flag=0 spmt=1.11111e+15 spomt=0          spomt1=1.11111e+60 spmb=1.11111e+15 spomb=0 spomb1=1.11111e+60
LOADNM2 (0 DCTRLN_6 0 0) nch_mac l=30n w=1u multi=64 nf=10 sd=100n          ad=5e-14 as=5.5e-14 pd=2u ps=2.3u nrd=0.427491 nrs=0.427491          sa=349.754n sb=349.754n sa1=161.047n sa2=316.499n sa3=575.493n          sa4=331.707n sb1=161.047n sb2=316.499n sb3=575.493n spa=100n          spa1=100n spa2=100n spa3=100n sap=150.407n sapb=165.494n          spba=115.715n spba1=117.043n dfm_flag=0 spmt=1.11111e+15 spomt=0          spomt1=1.11111e+60 spmb=1.11111e+15 spomb=0 spomb1=1.11111e+60
LOADNM1 (0 DCTRLN_7 0 0) nch_mac l=30n w=1u multi=128 nf=10 sd=100n          ad=5e-14 as=5.5e-14 pd=2u ps=2.3u nrd=0.427491 nrs=0.427491          sa=349.754n sb=349.754n sa1=161.047n sa2=316.499n sa3=575.493n          sa4=331.707n sb1=161.047n sb2=316.499n sb3=575.493n spa=100n          spa1=100n spa2=100n spa3=100n sap=150.407n sapb=165.494n          spba=115.715n spba1=117.043n dfm_flag=0 spmt=1.11111e+15 spomt=0          spomt1=1.11111e+60 spmb=1.11111e+15 spomb=0 spomb1=1.11111e+60
COUT0 (DO_0 0) capacitor c=5f
COUT1 (DO_1 0) capacitor c=5f
COUT2 (DO_2 0) capacitor c=5f
COUT3 (DO_3 0) capacitor c=5f
COUT4 (DO_4 0) capacitor c=5f
COUT5 (DO_5 0) capacitor c=5f
COUT6 (DO_6 0) capacitor c=5f
COUT7 (DO_7 0) capacitor c=5f
simulatorOptions options reltol=1e-6 vabstol=1e-8 iabstol=1e-14 temp=27 tnom=27
saveOptions options save=selected currents=selected
tran_test tran stop=1620n maxstep=100p errpreset=conservative
save CLKS CMPCK DCMPN DCMPP DCTRLN_0 DCTRLN_1 DCTRLN_2 DCTRLN_3 DCTRLN_4 DCTRLN_5 DCTRLN_6 DCTRLN_7 DCTRLP_0 DCTRLP_1 DCTRLP_2 DCTRLP_3 DCTRLP_4 DCTRLP_5 DCTRLP_6 DCTRLP_7 DO_0 DO_1 DO_2 DO_3 DO_4 DO_5 DO_6 DO_7 REF TOPN TOPP VDD VINN VINP VVDD:1 XDUT.CLKSN XDUT.CLK_0 XDUT.CLK_1 XDUT.CLK_2 XDUT.CLK_3 XDUT.CLK_4 XDUT.CLK_5 XDUT.CLK_6 XDUT.CLK_7 XDUT.CMPCKe XDUT.I12.clkb XDUT.I12.clkbb XDUT.I12.mq XDUT.I12.mq_x XDUT.I12.net0138 XDUT.I12.net0152 XDUT.I12.net093 XDUT.I12.net103 XDUT.I12.net176 XDUT.I12.net184 XDUT.I12.net208 XDUT.I12.net212 XDUT.I12.qf XDUT.I12.qf_x XDUT.I14.clkb XDUT.I14.clkbb XDUT.I14.mq XDUT.I14.mq_x XDUT.I14.net0118 XDUT.I14.net0136 XDUT.I14.net086 XDUT.I14.net103 XDUT.I14.net176 XDUT.I14.net212 XDUT.I14.qf XDUT.I14.qf_x XDUT.I22.clkb XDUT.I22.clkbb XDUT.I22.mq XDUT.I22.mq_x XDUT.I22.net0118 XDUT.I22.net0136 XDUT.I22.net086 XDUT.I22.net103 XDUT.I22.net176 XDUT.I22.net212 XDUT.I22.qf XDUT.I22.qf_x XDUT.I28.clkb XDUT.I28.clkbb XDUT.I28.mq XDUT.I28.mq_x XDUT.I28.net0118 XDUT.I28.net0136 XDUT.I28.net086 XDUT.I28.net103 XDUT.I28.net176 XDUT.I28.net212 XDUT.I28.qf XDUT.I28.qf_x XDUT.I30.clkb XDUT.I30.clkbb XDUT.I30.mq XDUT.I30.mq_x XDUT.I30.net0118 XDUT.I30.net0136 XDUT.I30.net086 XDUT.I30.net103 XDUT.I30.net176 XDUT.I30.net212 XDUT.I30.qf XDUT.I30.qf_x XDUT.I38.clkb XDUT.I38.clkbb XDUT.I38.mq XDUT.I38.mq_x XDUT.I38.net0118 XDUT.I38.net0136 XDUT.I38.net086 XDUT.I38.net103 XDUT.I38.net176 XDUT.I38.net212 XDUT.I38.qf XDUT.I38.qf_x XDUT.I44.clkb XDUT.I44.clkbb XDUT.I44.mq XDUT.I44.mq_x XDUT.I44.net0118 XDUT.I44.net0136 XDUT.I44.net086 XDUT.I44.net103 XDUT.I44.net176 XDUT.I44.net212 XDUT.I44.qf XDUT.I44.qf_x XDUT.I46_3.clkb XDUT.I46_3.clkbb XDUT.I46_3.mq XDUT.I46_3.mq_x XDUT.I46_3.net0118 XDUT.I46_3.net0136 XDUT.I46_3.net086 XDUT.I46_3.net103 XDUT.I46_3.net176 XDUT.I46_3.net212 XDUT.I46_3.qf XDUT.I46_3.qf_x XDUT.I46_7.clkb XDUT.I46_7.clkbb XDUT.I46_7.mq XDUT.I46_7.mq_x XDUT.I46_7.net0118 XDUT.I46_7.net0136 XDUT.I46_7.net086 XDUT.I46_7.net103 XDUT.I46_7.net176 XDUT.I46_7.net212 XDUT.I46_7.qf XDUT.I46_7.qf_x XDUT.I5.clkb XDUT.I5.clkbb XDUT.I5.mq XDUT.I5.mq_x XDUT.I5.net0138 XDUT.I5.net0152 XDUT.I5.net093 XDUT.I5.net103 XDUT.I5.net176 XDUT.I5.net184 XDUT.I5.net208 XDUT.I5.net212 XDUT.I5.qf XDUT.I5.qf_x XDUT.VALID XDUT.net10 XDUT.net11 XDUT.net12 XDUT.net13 XDUT.net14 XDUT.net15 XDUT.net16 XDUT.net17 XDUT.net18 XDUT.net19 XDUT.net2 XDUT.net20 XDUT.net21 XDUT.net22 XDUT.net23 XDUT.net24 XDUT.net25 XDUT.net26 XDUT.net27 XDUT.net28 XDUT.net29 XDUT.net3 XDUT.net30 XDUT.net31 XDUT.net32 XDUT.net33 XDUT.net35 XDUT.net4 XDUT.net5 XDUT.net6 XDUT.net7 XDUT.net8 XDUT.net9
