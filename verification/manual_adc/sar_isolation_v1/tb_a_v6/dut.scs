subckt manual_sar CLKS GND VDD DCMPP DCMPN CMPCK DO_7 DO_6 DO_5 DO_4 DO_3 DO_2 DO_1 DO_0 DCTRLP_7 DCTRLP_6 DCTRLP_5 DCTRLP_4 DCTRLP_3 DCTRLP_2 DCTRLP_1 DCTRLP_0 DCTRLN_7 DCTRLN_6 DCTRLN_5 DCTRLN_4 DCTRLN_3 DCTRLN_2 DCTRLN_1 DCTRLN_0
parameters tloop=2n tgate=100p
IRESET (CLKS CLKSN VDD GND) INVD4BWP12T30P140
I3 (CLKS CLK_0 net34 VDD GND) OR2D1BWP12T30P140
I2 (VALID net34 net35 VDD GND) NR2D1BWP12T30P140
I0 (DCMPP DCMPN VALID VDD GND) OR2D4BWP12T30P140
DELAY16 (net3 GND CLK_0 VDD) sar_logic_delay td=tgate trf=50p
DELAY15 (net7 GND CLK_1 VDD) sar_logic_delay td=tgate trf=50p
DELAY14 (net6 GND CLK_2 VDD) sar_logic_delay td=tgate trf=50p
DELAY13 (net5 GND CLK_3 VDD) sar_logic_delay td=tgate trf=50p
DELAY12 (net4 GND CLK_4 VDD) sar_logic_delay td=tgate trf=50p
DELAY11 (net11 GND CLK_5 VDD) sar_logic_delay td=tgate trf=50p
DELAY10 (net9 GND CLK_6 VDD) sar_logic_delay td=tgate trf=50p
DELAY9 (net21 GND CLK_7 VDD) sar_logic_delay td=tgate trf=50p
DELAY8 (net15 GND CLK_0 VDD) sar_logic_delay td=tgate trf=50p
DELAY7 (net19 GND CLK_1 VDD) sar_logic_delay td=tgate trf=50p
DELAY6 (net18 GND CLK_2 VDD) sar_logic_delay td=tgate trf=50p
DELAY5 (net17 GND CLK_3 VDD) sar_logic_delay td=tgate trf=50p
DELAY4 (net16 GND CLK_4 VDD) sar_logic_delay td=tgate trf=50p
DELAY3 (net26 GND CLK_5 VDD) sar_logic_delay td=tgate trf=50p
DELAY2 (net25 GND CLK_6 VDD) sar_logic_delay td=tgate trf=50p
DELAY1 (net32 GND CLK_7 VDD) sar_logic_delay td=tgate trf=50p
DELAY0 (CMPCKe GND net35 VDD) sar_logic_delay td=tloop trf=50p
I4 (CMPCKe CMPCK VDD GND) BUFFD4BWP12T30P140
I12 (CLK_1 VALID CLKSN CLK_0 VDD GND) DFCNQD1BWP12T30P140
I11 (CLK_2 VALID CLKSN CLK_1 VDD GND) DFCNQD1BWP12T30P140
I10 (CLK_3 VALID CLKSN CLK_2 VDD GND) DFCNQD1BWP12T30P140
I9 (CLK_4 VALID CLKSN CLK_3 VDD GND) DFCNQD1BWP12T30P140
I8 (CLK_5 VALID CLKSN CLK_4 VDD GND) DFCNQD1BWP12T30P140
I7 (CLK_6 VALID CLKSN CLK_5 VDD GND) DFCNQD1BWP12T30P140
I6 (CLK_7 VALID CLKSN CLK_6 VDD GND) DFCNQD1BWP12T30P140
I5 (VDD VALID CLKSN CLK_7 VDD GND) DFCNQD1BWP12T30P140
I46_7 (net31 CLKS DO_7 VDD GND) DFQD1BWP12T30P140
I46_6 (net33 CLKS DO_6 VDD GND) DFQD1BWP12T30P140
I46_5 (net24 CLKS DO_5 VDD GND) DFQD1BWP12T30P140
I46_4 (net27 CLKS DO_4 VDD GND) DFQD1BWP12T30P140
I46_3 (net28 CLKS DO_3 VDD GND) DFQD1BWP12T30P140
I46_2 (net29 CLKS DO_2 VDD GND) DFQD1BWP12T30P140
I46_1 (net30 CLKS DO_1 VDD GND) DFQD1BWP12T30P140
I46_0 (net14 CLKS DO_0 VDD GND) DFQD1BWP12T30P140
I44 (DCMPN CLK_0 net2 VDD GND) DFQD1BWP12T30P140
I42 (DCMPN CLK_1 net13 VDD GND) DFQD1BWP12T30P140
I40 (DCMPN CLK_2 net12 VDD GND) DFQD1BWP12T30P140
I38 (DCMPN CLK_3 net10 VDD GND) DFQD1BWP12T30P140
I36 (DCMPN CLK_4 net8 VDD GND) DFQD1BWP12T30P140
I34 (DCMPN CLK_5 net23 VDD GND) DFQD1BWP12T30P140
I32 (DCMPN CLK_6 net22 VDD GND) DFQD1BWP12T30P140
I30 (DCMPN CLK_7 net20 VDD GND) DFQD1BWP12T30P140
I28 (DCMPP CLK_0 net14 VDD GND) DFQD1BWP12T30P140
I26 (DCMPP CLK_1 net30 VDD GND) DFQD1BWP12T30P140
I24 (DCMPP CLK_2 net29 VDD GND) DFQD1BWP12T30P140
I22 (DCMPP CLK_3 net28 VDD GND) DFQD1BWP12T30P140
I20 (DCMPP CLK_4 net27 VDD GND) DFQD1BWP12T30P140
I18 (DCMPP CLK_5 net24 VDD GND) DFQD1BWP12T30P140
I16 (DCMPP CLK_6 net33 VDD GND) DFQD1BWP12T30P140
I14 (DCMPP CLK_7 net31 VDD GND) DFQD1BWP12T30P140
I45 (net2 net3 DCTRLN_0 VDD GND) AN2D0BWP12T30P140
I43 (net13 net7 DCTRLN_1 VDD GND) AN2D0BWP12T30P140
I41 (net12 net6 DCTRLN_2 VDD GND) AN2D0BWP12T30P140
I29 (net14 net15 DCTRLP_0 VDD GND) AN2D0BWP12T30P140
I27 (net30 net19 DCTRLP_1 VDD GND) AN2D0BWP12T30P140
I25 (net29 net18 DCTRLP_2 VDD GND) AN2D0BWP12T30P140
I31 (net20 net21 net1 VDD GND) AN2D16BWP12T30P140
I15 (net31 net32 net36 VDD GND) AN2D16BWP12T30P140
I33 (net22 net9 DCTRLN_6 VDD GND) AN2D8BWP12T30P140
I17 (net33 net25 DCTRLP_6 VDD GND) AN2D8BWP12T30P140
I35 (net23 net11 DCTRLN_5 VDD GND) AN2D4BWP12T30P140
I19 (net24 net26 DCTRLP_5 VDD GND) AN2D4BWP12T30P140
I37 (net8 net4 DCTRLN_4 VDD GND) AN2D2BWP12T30P140
I21 (net27 net16 DCTRLP_4 VDD GND) AN2D2BWP12T30P140
I39 (net10 net5 DCTRLN_3 VDD GND) AN2D1BWP12T30P140
I23 (net28 net17 DCTRLP_3 VDD GND) AN2D1BWP12T30P140
I48 (net1 DCTRLN_7 VDD GND) INVD16BWP12T30P140
I47 (net36 DCTRLP_7 VDD GND) INVD16BWP12T30P140
ends manual_sar
