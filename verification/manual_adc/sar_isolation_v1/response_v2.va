`include "constants.vams"
`include "disciplines.vams"
// TB-only response source. Actual OR/VALID and SAR shift/capture remain native.
module sar_test_response(CLKS, CLK, VDD, GND, P, N);
 input CLKS, CLK, VDD; inout GND; output P,N;
 electrical CLKS, CLK, VDD, GND, P,N;
 parameter real td=200p, trf=50p, rout=1;
 integer frame, bitno, code, decision, pending, op, on;
 real due;
 analog begin
  @(initial_step) begin
   frame=-1; bitno=7; code=0; decision=0; pending=0; op=0; on=0; due=1e9;
  end
  @(cross(V(CLKS,GND)-0.5*V(VDD,GND),+1)) begin
   pending=0; op=0; on=0; due=1e9;
  end
  @(cross(V(CLKS,GND)-0.5*V(VDD,GND),-1)) begin
   frame=frame+1; bitno=7;
   case (frame%8)
    0:code=0; 1:code=255; 2:code=85; 3:code=170;
    4:code=128; 5:code=127; 6:code=1; 7:code=254;
   endcase
  end
  @(cross(V(CLK,GND)-0.5*V(VDD,GND),+1)) begin
   if (frame>=0 && bitno>=0 && V(CLKS,GND)<0.5*V(VDD,GND)) begin
    decision=(code>>bitno)&1; bitno=bitno-1;
    pending=1; due=$abstime+td;
   end
  end
  @(cross(V(CLK,GND)-0.5*V(VDD,GND),-1)) begin
   pending=0; op=0; on=0; due=1e9;
  end
  @(timer(due)) begin
   if (pending && V(CLK,GND)>0.5*V(VDD,GND) && V(CLKS,GND)<0.5*V(VDD,GND)) begin
    op=decision; on=1-decision; pending=0;
   end
   due=1e9;
  end
  I(P,GND)<+(V(P,GND)-V(VDD,GND)*transition(op,0,trf,trf))/rout;
  I(N,GND)<+(V(N,GND)-V(VDD,GND)*transition(on,0,trf,trf))/rout;
 end
endmodule
