simulator lang=spectre
global 0
include "models.scs"
VVDD (VDD 0) vsource dc=0.9
VCDN (CDN 0) vsource type=pwl wave=[ 0 0 9.75e-10 0 1.025e-09 0.9 4.981013574224731e-09 0.9 4.986327650354735e-09 0.882626411394 4.991649380494732e-09 0.802696111027 4.996785623884749e-09 0.6161153231449999 5.001888800994741e-09 0.352388900257 5.00569185976475e-09 0.161771342693 5.00623803651474e-09 0.141310016998 5.006817393344742e-09 0.121584006955 5.007369962054751e-09 0.105075386008 5.007882581604749e-09 0.0921596666259 5.008382713694733e-09 0.0819511860708 5.008909355834754e-09 0.0732183897278 5.009480519414743e-09 0.0648340852818 5.010035349064745e-09 0.0568679295928 5.010565020714743e-09 0.0493023189672 5.011093448834744e-09 0.0420476870038 5.011612369064732e-09 0.0354441905314 5.012184626184743e-09 0.0289515703407 5.012722004534735e-09 0.0237110300814 5.017734529854745e-09 0.00219061158243 5.022781207904739e-09 -0.00149683789206 5.025348548254748e-09 -0.00179436848489 5.025864054024753e-09 -0.00156846516216 5.026372778254748e-09 -0.00131101505232 5.026890959884737e-09 -0.00105226412568 5.027425600444753e-09 -0.000823640519696 5.028026374804741e-09 -0.000631230896557 5.028563282564748e-09 -0.000511087434809 5.029150361994745e-09 -0.000419854766893 5.02970408406473e-09 -0.000359097571974 5.030279217434748e-09 -0.000312454744144 5.030834419154746e-09 -0.000277617184521 5.031426052444752e-09 -0.000247923690218 5.031984761364754e-09 -0.000224950702783 5.032526800964743e-09 -0.000206090538817 5.033039262084746e-09 -0.000190442455756 5.033558239934732e-09 -0.00017615044906 5.034113129404742e-09 -0.000162449619571 5.034696480784738e-09 -0.000149968729451 5.035206222914739e-09 -0.000140630552066 5.035720573904743e-09 -0.000132439869493 5.036222113814731e-09 -0.000125623854271 5.036745508154749e-09 -0.000120192098579 5.037281420104733e-09 -0.0001138857787 5.037814539864738e-09 -0.000104869663518 5.038319167504745e-09 -9.49284874141e-05 5.03886231784474e-09 0 6.975e-09 0 7.025e-09 0.9 9e-09 0.9 ]
VCP (CP 0) vsource type=pwl wave=[ 0 0 1.975e-09 0 2.025e-09 0.9 2.975e-09 0.9 3.025e-09 0 7.975e-09 0 8.025000000000001e-09 0.9 9e-09 0.9 ]
VDA (DA 0) vsource dc=0.9
VDB (DB 0) vsource type=pwl wave=[ 0 0.9 4.986327650354735e-09 0.9 4.991649380494732e-09 0.8998546973180001 4.996785623884749e-09 0.899841153229 5.001888800994741e-09 0.905064277918 5.00569185976475e-09 0.920828513849 5.00623803651474e-09 0.92078048162 5.006817393344742e-09 0.915659655203 5.007369962054751e-09 0.902267138836 5.007882581604749e-09 0.878711150448 5.008382713694733e-09 0.8432255330839999 5.008909355834754e-09 0.792799934286 5.009480519414743e-09 0.724324480174 5.010035349064745e-09 0.646437437536 5.010565020714743e-09 0.565567469177 5.011093448834744e-09 0.484931580225 5.011612369064732e-09 0.408507517298 5.012184626184743e-09 0.328356153484 5.012722004534735e-09 0.25866672092 5.017734529854745e-09 0.0294154175517 5.022781207904739e-09 0.0107285254867 5.025348548254748e-09 0.00593776969145 5.025864054024753e-09 0.00521693026816 5.026372778254748e-09 0.00455435173991 5.026890959884737e-09 0.00393703130796 5.027425600444753e-09 0.00336627978794 5.028026374804741e-09 0.0027885352701 5.028563282564748e-09 0.00231027246786 5.029150361994745e-09 0.00182682222845 5.02970408406473e-09 0.00141494154278 5.030279217434748e-09 0.00103796748745 5.030834419154746e-09 0.000734686686591 5.031426052444752e-09 0.000483100668719 5.031984761364754e-09 0.000311106709021 5.032526800964743e-09 0.000203726250787 5.033039262084746e-09 0.000162077399663 5.033558239934732e-09 0.000187659808997 5.034113129404742e-09 0.000285482287595 5.034696480784738e-09 0.000434601004093 5.035206222914739e-09 0.000567696209538 5.035720573904743e-09 0.00067242009255 5.036222113814731e-09 0.000706729566313 5.036745508154749e-09 0.000592540935121 5.037281420104733e-09 0.000358147806842 5.037814539864738e-09 0.000143137385835 5.038319167504745e-09 2.00706467283e-05 5.03886231784474e-09 0 9e-09 0 ]
CQA (QA 0) capacitor c=5f
CQB (QB 0) capacitor c=5f
simulatorOptions options reltol=1e-5 vabstol=1e-8 iabstol=1e-14 temp=27 tnom=27
tran_test tran stop=9n maxstep=1p errpreset=conservative method=gear2only
saveOptions options save=selected currents=selected
XA (DA CP CDN QA VDD 0) GDFCNQMCOD1BWP12T30P140
XB (DB CP CDN QB VDD 0) GDFCNQMCOD1BWP12T30P140
save CDN CP DA DB QA QB VDD XA.clkb
save XA.mq XA.mq_x XA.net0100 XA.net0102 XA.net0138 XA.net103 XA.net176 XA.net184
save XA.net208 XA.net212 XA.qf XA.qf_x XB.clkb XB.mq XB.mq_x XB.net0100
save XB.net0102 XB.net0138 XB.net103 XB.net176 XB.net184 XB.net208 XB.net212 XB.qf
save XB.qf_x VVDD:1 VCDN:1 VCP:1 VDA:1 VDB:1 XA.MM64:1 XA.MM64:2
save XA.MM64:3 XA.MM64:4 XA.MM65:1 XA.MM65:2 XA.MM65:3 XA.MM65:4 XA.MM66:1 XA.MM66:2
save XA.MM66:3 XA.MM66:4 XA.MM75:1 XA.MM75:2 XA.MM75:3 XA.MM75:4 XA.MM76:1 XA.MM76:2
save XA.MM76:3 XA.MM76:4 XA.MM78:1 XA.MM78:2 XA.MM78:3 XA.MM78:4 XB.MM64:1 XB.MM64:2
save XB.MM64:3 XB.MM64:4 XB.MM65:1 XB.MM65:2 XB.MM65:3 XB.MM65:4 XB.MM66:1 XB.MM66:2
save XB.MM66:3 XB.MM66:4 XB.MM75:1 XB.MM75:2 XB.MM75:3 XB.MM75:4 XB.MM76:1 XB.MM76:2
save XB.MM76:3 XB.MM76:4 XB.MM78:1 XB.MM78:2 XB.MM78:3 XB.MM78:4
