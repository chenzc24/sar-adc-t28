simulator lang=spectre
global 0
include "wrappers_hybrid.scs"
VVDD (VDD 0) vsource type=pwl wave=[0 0 1n 0.99]
VVDDH (VDDH 0) vsource type=pwl wave=[0 0 1n 0.99]
VREF (REF 0) vsource type=pwl wave=[0 0 1n .9]
VCLK (CLKS 0) vsource type=pulse val0=0 val1=0.99 delay=110n rise=50p fall=50p width=39.9n period=100n
VCLKH (CLKH 0) vsource type=pulse val0=0 val1=0.99 delay=110n rise=50p fall=50p width=39.9n period=100n
VINP (VINP 0) vsource type=pwl wave=[0n 0 1n 0.0263671875 200n 0.0263671875 200.05n 0.8736328125 300n 0.8736328125 300.05n 0.4517578125 400n 0.4517578125 400.05n 0.2267578125 500n 0.2267578125 500.05n 0.6767578125 600n 0.6767578125 600.05n 0.0052734375 700n 0.0052734375 700.05n 0.8947265625 800n 0.8947265625 800.05n 0.4482421875]
VINN (VINN 0) vsource type=pwl wave=[0n 0 1n 0.8736328125 200n 0.8736328125 200.05n 0.0263671875 300n 0.0263671875 300.05n 0.4482421875 400n 0.4482421875 400.05n 0.6732421875 500n 0.6732421875 500.05n 0.2232421875 600n 0.2232421875 600.05n 0.8947265625 700n 0.8947265625 700.05n 0.0052734375 800n 0.0052734375 800.05n 0.4517578125]
VSENP (VINP INP) vsource dc=0
VSENN (VINN INN) vsource dc=0
XADC (CLKS 0 VDD INP INN REF 0 DO_7 DO_6 DO_5 DO_4 DO_3 DO_2 DO_1 DO_0 BUSY EOC FAULT) manual_adc_boot ref_ron=.01
XIDEAL (CLKS 0 VDD VINP VINN REF 0 IDO_7 IDO_6 IDO_5 IDO_4 IDO_3 IDO_2 IDO_1 IDO_0 IBUSY IEOC IFAULT) manual_adc_beh ref_ron=.01
// Companion fixture isolates turnoff/hold from intentional DAC redistribution.
XHP (CLKH 0 VDDH VINP HP) manual_boot main_mult=6
XHN (CLKH 0 VDDH VINN HN) manual_boot main_mult=6
CHP (HP 0) capacitor c=1.28p
CHN (HN 0) capacitor c=1.28p
simulatorOptions options reltol=1e-6 vabstol=1e-8 iabstol=1e-14 temp=125 tnom=27
saveOptions options save=selected currents=selected
tran_test tran stop=9.2e-07 maxstep=50p errpreset=conservative
save BUSY CLKH CLKS DO_0 DO_1 DO_2 DO_3 DO_4 DO_5 DO_6 DO_7 EOC FAULT HN HP IDO_0 IDO_1 IDO_2 IDO_3 IDO_4 IDO_5 IDO_6 IDO_7 IEOC IFAULT INN INP REF VCLK:1 VCLKH:1 VDD VDDH VINN VINP VSENN:1 VSENP:1 VVDD:1 VVDDH:1 XADC.CMPCK XADC.DN_0 XADC.DN_1 XADC.DN_2 XADC.DN_3 XADC.DN_4 XADC.DN_5 XADC.DN_6 XADC.DN_7 XADC.DP_0 XADC.DP_1 XADC.DP_2 XADC.DP_3 XADC.DP_4 XADC.DP_5 XADC.DP_6 XADC.DP_7 XADC.TOPN XADC.TOPP XADC.XN.XS.CLKSB XADC.XN.XS.net1 XADC.XN.XS.net2 XADC.XN.XS.net3 XADC.XN.XS.net4 XADC.XN.XS.net7 XADC.XP.XS.CLKSB XADC.XP.XS.net1 XADC.XP.XS.net2 XADC.XP.XS.net3 XADC.XP.XS.net4 XADC.XP.XS.net7 XHN.CLKSB XHN.net1 XHN.net2 XHN.net3 XHN.net4 XHN.net7 XHP.CLKSB XHP.net1 XHP.net2 XHP.net3 XHP.net4 XHP.net7 XIDEAL.CMPCK XIDEAL.TOPN XIDEAL.TOPP
