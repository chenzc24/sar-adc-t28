simulator lang=spectre
include "models.scs"
include "dut.scs"
VVDD (VDD 0) vsource dc=.9
VCLK (CLKS 0) vsource type=pulse val0=0 val1=.9 delay=10n rise=50p fall=50p width=39.9n period=100n
VRESPP (DCMPP 0) vsource type=pwl wave=[0n 0 189n 0 189.05n 0.9 190.5n 0.9 190.55n 0 284n 0 284.05n 0.9 285.5n 0.9 285.55n 0 384n 0 384.05n 0.9 385.5n 0.9 385.55n 0 389n 0 389.05n 0.9 390.5n 0.9 390.55n 0 479n 0 479.05n 0.9 480.5n 0.9 480.55n 0 579n 0 579.05n 0.9 580.5n 0.9 580.55n 0 589n 0 589.05n 0.9 590.5n 0.9 590.55n 0 679n 0 679.05n 0.9 680.5n 0.9 680.55n 0 684n 0 684.05n 0.9 685.5n 0.9 685.55n 0 779n 0 779.05n 0.9 780.5n 0.9 780.55n 0 784n 0 784.05n 0.9 785.5n 0.9 785.55n 0 789n 0 789.05n 0.9 790.5n 0.9 790.55n 0 874n 0 874.05n 0.9 875.5n 0.9 875.55n 0 974n 0 974.05n 0.9 975.5n 0.9 975.55n 0 989n 0 989.05n 0.9 990.5n 0.9 990.55n 0 1074n 0 1074.05n 0.9 1075.5n 0.9 1075.55n 0 1084n 0 1084.05n 0.9 1085.5n 0.9 1085.55n 0 1174n 0 1174.05n 0.9 1175.5n 0.9 1175.55n 0 1184n 0 1184.05n 0.9 1185.5n 0.9 1185.55n 0 1189n 0 1189.05n 0.9 1190.5n 0.9 1190.55n 0 1274n 0 1274.05n 0.9 1275.5n 0.9 1275.55n 0 1279n 0 1279.05n 0.9 1280.5n 0.9 1280.55n 0 1374n 0 1374.05n 0.9 1375.5n 0.9 1375.55n 0 1379n 0 1379.05n 0.9 1380.5n 0.9 1380.55n 0 1389n 0 1389.05n 0.9 1390.5n 0.9 1390.55n 0 1474n 0 1474.05n 0.9 1475.5n 0.9 1475.55n 0 1479n 0 1479.05n 0.9 1480.5n 0.9 1480.55n 0 1484n 0 1484.05n 0.9 1485.5n 0.9 1485.55n 0 1574n 0 1574.05n 0.9 1575.5n 0.9 1575.55n 0 1579n 0 1579.05n 0.9 1580.5n 0.9 1580.55n 0 1584n 0 1584.05n 0.9 1585.5n 0.9 1585.55n 0 1589n 0 1589.05n 0.9 1590.5n 0.9 1590.55n 0 1669n 0 1669.05n 0.9 1670.5n 0.9 1670.55n 0 1769n 0 1769.05n 0.9 1770.5n 0.9 1770.55n 0 1789n 0 1789.05n 0.9 1790.5n 0.9 1790.55n 0 1869n 0 1869.05n 0.9 1870.5n 0.9 1870.55n 0 1884n 0 1884.05n 0.9 1885.5n 0.9 1885.55n 0 1969n 0 1969.05n 0.9 1970.5n 0.9 1970.55n 0 1984n 0 1984.05n 0.9 1985.5n 0.9 1985.55n 0 1989n 0 1989.05n 0.9 1990.5n 0.9 1990.55n 0 2069n 0 2069.05n 0.9 2070.5n 0.9 2070.55n 0 2079n 0 2079.05n 0.9 2080.5n 0.9 2080.55n 0 2169n 0 2169.05n 0.9 2170.5n 0.9 2170.55n 0 2179n 0 2179.05n 0.9 2180.5n 0.9 2180.55n 0 2189n 0 2189.05n 0.9 2190.5n 0.9 2190.55n 0 2269n 0 2269.05n 0.9 2270.5n 0.9 2270.55n 0 2279n 0 2279.05n 0.9 2280.5n 0.9 2280.55n 0 2284n 0 2284.05n 0.9 2285.5n 0.9 2285.55n 0 2369n 0 2369.05n 0.9 2370.5n 0.9 2370.55n 0 2379n 0 2379.05n 0.9 2380.5n 0.9 2380.55n 0 2384n 0 2384.05n 0.9 2385.5n 0.9 2385.55n 0 2389n 0 2389.05n 0.9 2390.5n 0.9 2390.55n 0 2469n 0 2469.05n 0.9 2470.5n 0.9 2470.55n 0 2474n 0 2474.05n 0.9 2475.5n 0.9 2475.55n 0 2569n 0 2569.05n 0.9 2570.5n 0.9 2570.55n 0 2574n 0 2574.05n 0.9 2575.5n 0.9 2575.55n 0 2589n 0 2589.05n 0.9 2590.5n 0.9 2590.55n 0 2669n 0 2669.05n 0.9 2670.5n 0.9 2670.55n 0 2674n 0 2674.05n 0.9 2675.5n 0.9 2675.55n 0 2684n 0 2684.05n 0.9 2685.5n 0.9 2685.55n 0 2769n 0 2769.05n 0.9 2770.5n 0.9 2770.55n 0 2774n 0 2774.05n 0.9 2775.5n 0.9 2775.55n 0 2784n 0 2784.05n 0.9 2785.5n 0.9 2785.55n 0 2789n 0 2789.05n 0.9 2790.5n 0.9 2790.55n 0 2869n 0 2869.05n 0.9 2870.5n 0.9 2870.55n 0 2874n 0 2874.05n 0.9 2875.5n 0.9 2875.55n 0 2879n 0 2879.05n 0.9 2880.5n 0.9 2880.55n 0 2969n 0 2969.05n 0.9 2970.5n 0.9 2970.55n 0 2974n 0 2974.05n 0.9 2975.5n 0.9 2975.55n 0 2979n 0 2979.05n 0.9 2980.5n 0.9 2980.55n 0 2989n 0 2989.05n 0.9 2990.5n 0.9 2990.55n 0 3069n 0 3069.05n 0.9 3070.5n 0.9 3070.55n 0 3074n 0 3074.05n 0.9 3075.5n 0.9 3075.55n 0 3079n 0 3079.05n 0.9 3080.5n 0.9 3080.55n 0 3084n 0 3084.05n 0.9 3085.5n 0.9 3085.55n 0 3169n 0 3169.05n 0.9 3170.5n 0.9 3170.55n 0 3174n 0 3174.05n 0.9 3175.5n 0.9 3175.55n 0 3179n 0 3179.05n 0.9 3180.5n 0.9 3180.55n 0 3184n 0 3184.05n 0.9 3185.5n 0.9 3185.55n 0 3189n 0 3189.05n 0.9 3190.5n 0.9 3190.55n 0 3264n 0 3264.05n 0.9 3265.5n 0.9 3265.55n 0 3364n 0 3364.05n 0.9 3365.5n 0.9 3365.55n 0 3389n 0 3389.05n 0.9 3390.5n 0.9 3390.55n 0 3464n 0 3464.05n 0.9 3465.5n 0.9 3465.55n 0 3484n 0 3484.05n 0.9 3485.5n 0.9 3485.55n 0 3564n 0 3564.05n 0.9 3565.5n 0.9 3565.55n 0 3584n 0 3584.05n 0.9 3585.5n 0.9 3585.55n 0 3589n 0 3589.05n 0.9 3590.5n 0.9 3590.55n 0 3664n 0 3664.05n 0.9 3665.5n 0.9 3665.55n 0 3679n 0 3679.05n 0.9 3680.5n 0.9 3680.55n 0 3764n 0 3764.05n 0.9 3765.5n 0.9 3765.55n 0 3779n 0 3779.05n 0.9 3780.5n 0.9 3780.55n 0 3789n 0 3789.05n 0.9 3790.5n 0.9 3790.55n 0 3864n 0 3864.05n 0.9 3865.5n 0.9 3865.55n 0 3879n 0 3879.05n 0.9 3880.5n 0.9 3880.55n 0 3884n 0 3884.05n 0.9 3885.5n 0.9 3885.55n 0 3964n 0 3964.05n 0.9 3965.5n 0.9 3965.55n 0 3979n 0 3979.05n 0.9 3980.5n 0.9 3980.55n 0 3984n 0 3984.05n 0.9 3985.5n 0.9 3985.55n 0 3989n 0 3989.05n 0.9 3990.5n 0.9 3990.55n 0 4064n 0 4064.05n 0.9 4065.5n 0.9 4065.55n 0 4074n 0 4074.05n 0.9 4075.5n 0.9 4075.55n 0 4164n 0 4164.05n 0.9 4165.5n 0.9 4165.55n 0 4174n 0 4174.05n 0.9 4175.5n 0.9 4175.55n 0 4189n 0 4189.05n 0.9 4190.5n 0.9 4190.55n 0 4264n 0 4264.05n 0.9 4265.5n 0.9 4265.55n 0 4274n 0 4274.05n 0.9 4275.5n 0.9 4275.55n 0 4284n 0 4284.05n 0.9 4285.5n 0.9 4285.55n 0 4364n 0 4364.05n 0.9 4365.5n 0.9 4365.55n 0 4374n 0 4374.05n 0.9 4375.5n 0.9 4375.55n 0 4384n 0 4384.05n 0.9 4385.5n 0.9 4385.55n 0 4389n 0 4389.05n 0.9 4390.5n 0.9 4390.55n 0 4464n 0 4464.05n 0.9 4465.5n 0.9 4465.55n 0 4474n 0 4474.05n 0.9 4475.5n 0.9 4475.55n 0 4479n 0 4479.05n 0.9 4480.5n 0.9 4480.55n 0 4564n 0 4564.05n 0.9 4565.5n 0.9 4565.55n 0 4574n 0 4574.05n 0.9 4575.5n 0.9 4575.55n 0 4579n 0 4579.05n 0.9 4580.5n 0.9 4580.55n 0 4589n 0 4589.05n 0.9 4590.5n 0.9 4590.55n 0 4664n 0 4664.05n 0.9 4665.5n 0.9 4665.55n 0 4674n 0 4674.05n 0.9 4675.5n 0.9 4675.55n 0 4679n 0 4679.05n 0.9 4680.5n 0.9 4680.55n 0 4684n 0 4684.05n 0.9 4685.5n 0.9 4685.55n 0 4764n 0 4764.05n 0.9 4765.5n 0.9 4765.55n 0 4774n 0 4774.05n 0.9 4775.5n 0.9 4775.55n 0 4779n 0 4779.05n 0.9 4780.5n 0.9 4780.55n 0 4784n 0 4784.05n 0.9 4785.5n 0.9 4785.55n 0 4789n 0 4789.05n 0.9 4790.5n 0.9 4790.55n 0 4864n 0 4864.05n 0.9 4865.5n 0.9 4865.55n 0 4869n 0 4869.05n 0.9 4870.5n 0.9 4870.55n 0 4964n 0 4964.05n 0.9 4965.5n 0.9 4965.55n 0 4969n 0 4969.05n 0.9 4970.5n 0.9 4970.55n 0 4989n 0 4989.05n 0.9 4990.5n 0.9 4990.55n 0 5064n 0 5064.05n 0.9 5065.5n 0.9 5065.55n 0 5069n 0 5069.05n 0.9 5070.5n 0.9 5070.55n 0 5084n 0 5084.05n 0.9 5085.5n 0.9 5085.55n 0 5164n 0 5164.05n 0.9 5165.5n 0.9 5165.55n 0 5169n 0 5169.05n 0.9 5170.5n 0.9 5170.55n 0 5184n 0 5184.05n 0.9 5185.5n 0.9 5185.55n 0 5189n 0 5189.05n 0.9 5190.5n 0.9 5190.55n 0 5264n 0 5264.05n 0.9 5265.5n 0.9 5265.55n 0 5269n 0 5269.05n 0.9 5270.5n 0.9 5270.55n 0 5279n 0 5279.05n 0.9 5280.5n 0.9 5280.55n 0 5364n 0 5364.05n 0.9 5365.5n 0.9 5365.55n 0 5369n 0 5369.05n 0.9 5370.5n 0.9 5370.55n 0 5379n 0 5379.05n 0.9 5380.5n 0.9 5380.55n 0 5389n 0 5389.05n 0.9 5390.5n 0.9 5390.55n 0 5464n 0 5464.05n 0.9 5465.5n 0.9 5465.55n 0 5469n 0 5469.05n 0.9 5470.5n 0.9 5470.55n 0 5479n 0 5479.05n 0.9 5480.5n 0.9 5480.55n 0 5484n 0 5484.05n 0.9 5485.5n 0.9 5485.55n 0 5564n 0 5564.05n 0.9 5565.5n 0.9 5565.55n 0 5569n 0 5569.05n 0.9 5570.5n 0.9 5570.55n 0 5579n 0 5579.05n 0.9 5580.5n 0.9 5580.55n 0 5584n 0 5584.05n 0.9 5585.5n 0.9 5585.55n 0 5589n 0 5589.05n 0.9 5590.5n 0.9 5590.55n 0 5664n 0 5664.05n 0.9 5665.5n 0.9 5665.55n 0 5669n 0 5669.05n 0.9 5670.5n 0.9 5670.55n 0 5674n 0 5674.05n 0.9 5675.5n 0.9 5675.55n 0 5764n 0 5764.05n 0.9 5765.5n 0.9 5765.55n 0 5769n 0 5769.05n 0.9 5770.5n 0.9 5770.55n 0 5774n 0 5774.05n 0.9 5775.5n 0.9 5775.55n 0 5789n 0 5789.05n 0.9 5790.5n 0.9 5790.55n 0 5864n 0 5864.05n 0.9 5865.5n 0.9 5865.55n 0 5869n 0 5869.05n 0.9 5870.5n 0.9 5870.55n 0 5874n 0 5874.05n 0.9 5875.5n 0.9 5875.55n 0 5884n 0 5884.05n 0.9 5885.5n 0.9 5885.55n 0 5964n 0 5964.05n 0.9 5965.5n 0.9 5965.55n 0 5969n 0 5969.05n 0.9 5970.5n 0.9 5970.55n 0 5974n 0 5974.05n 0.9 5975.5n 0.9 5975.55n 0 5984n 0 5984.05n 0.9 5985.5n 0.9 5985.55n 0 5989n 0 5989.05n 0.9 5990.5n 0.9 5990.55n 0 6064n 0 6064.05n 0.9 6065.5n 0.9 6065.55n 0 6069n 0 6069.05n 0.9 6070.5n 0.9 6070.55n 0 6074n 0 6074.05n 0.9 6075.5n 0.9 6075.55n 0 6079n 0 6079.05n 0.9 6080.5n 0.9 6080.55n 0 6164n 0 6164.05n 0.9 6165.5n 0.9 6165.55n 0 6169n 0 6169.05n 0.9 6170.5n 0.9 6170.55n 0 6174n 0 6174.05n 0.9 6175.5n 0.9 6175.55n 0 6179n 0 6179.05n 0.9 6180.5n 0.9 6180.55n 0 6189n 0 6189.05n 0.9 6190.5n 0.9 6190.55n 0 6264n 0 6264.05n 0.9 6265.5n 0.9 6265.55n 0 6269n 0 6269.05n 0.9 6270.5n 0.9 6270.55n 0 6274n 0 6274.05n 0.9 6275.5n 0.9 6275.55n 0 6279n 0 6279.05n 0.9 6280.5n 0.9 6280.55n 0 6284n 0 6284.05n 0.9 6285.5n 0.9 6285.55n 0 6364n 0 6364.05n 0.9 6365.5n 0.9 6365.55n 0 6369n 0 6369.05n 0.9 6370.5n 0.9 6370.55n 0 6374n 0 6374.05n 0.9 6375.5n 0.9 6375.55n 0 6379n 0 6379.05n 0.9 6380.5n 0.9 6380.55n 0 6384n 0 6384.05n 0.9 6385.5n 0.9 6385.55n 0 6389n 0 6389.05n 0.9 6390.5n 0.9 6390.55n 0 6459n 0 6459.05n 0.9 6460.5n 0.9 6460.55n 0 6559n 0 6559.05n 0.9 6560.5n 0.9 6560.55n 0 6589n 0 6589.05n 0.9 6590.5n 0.9 6590.55n 0 6659n 0 6659.05n 0.9 6660.5n 0.9 6660.55n 0 6684n 0 6684.05n 0.9 6685.5n 0.9 6685.55n 0 6759n 0 6759.05n 0.9 6760.5n 0.9 6760.55n 0 6784n 0 6784.05n 0.9 6785.5n 0.9 6785.55n 0 6789n 0 6789.05n 0.9 6790.5n 0.9 6790.55n 0 6859n 0 6859.05n 0.9 6860.5n 0.9 6860.55n 0 6879n 0 6879.05n 0.9 6880.5n 0.9 6880.55n 0 6959n 0 6959.05n 0.9 6960.5n 0.9 6960.55n 0 6979n 0 6979.05n 0.9 6980.5n 0.9 6980.55n 0 6989n 0 6989.05n 0.9 6990.5n 0.9 6990.55n 0 7059n 0 7059.05n 0.9 7060.5n 0.9 7060.55n 0 7079n 0 7079.05n 0.9 7080.5n 0.9 7080.55n 0 7084n 0 7084.05n 0.9 7085.5n 0.9 7085.55n 0 7159n 0 7159.05n 0.9 7160.5n 0.9 7160.55n 0 7179n 0 7179.05n 0.9 7180.5n 0.9 7180.55n 0 7184n 0 7184.05n 0.9 7185.5n 0.9 7185.55n 0 7189n 0 7189.05n 0.9 7190.5n 0.9 7190.55n 0 7259n 0 7259.05n 0.9 7260.5n 0.9 7260.55n 0 7274n 0 7274.05n 0.9 7275.5n 0.9 7275.55n 0 7359n 0 7359.05n 0.9 7360.5n 0.9 7360.55n 0 7374n 0 7374.05n 0.9 7375.5n 0.9 7375.55n 0 7389n 0 7389.05n 0.9 7390.5n 0.9 7390.55n 0 7459n 0 7459.05n 0.9 7460.5n 0.9 7460.55n 0 7474n 0 7474.05n 0.9 7475.5n 0.9 7475.55n 0 7484n 0 7484.05n 0.9 7485.5n 0.9 7485.55n 0 7559n 0 7559.05n 0.9 7560.5n 0.9 7560.55n 0 7574n 0 7574.05n 0.9 7575.5n 0.9 7575.55n 0 7584n 0 7584.05n 0.9 7585.5n 0.9 7585.55n 0 7589n 0 7589.05n 0.9 7590.5n 0.9 7590.55n 0 7659n 0 7659.05n 0.9 7660.5n 0.9 7660.55n 0 7674n 0 7674.05n 0.9 7675.5n 0.9 7675.55n 0 7679n 0 7679.05n 0.9 7680.5n 0.9 7680.55n 0 7759n 0 7759.05n 0.9 7760.5n 0.9 7760.55n 0 7774n 0 7774.05n 0.9 7775.5n 0.9 7775.55n 0 7779n 0 7779.05n 0.9 7780.5n 0.9 7780.55n 0 7789n 0 7789.05n 0.9 7790.5n 0.9 7790.55n 0 7859n 0 7859.05n 0.9 7860.5n 0.9 7860.55n 0 7874n 0 7874.05n 0.9 7875.5n 0.9 7875.55n 0 7879n 0 7879.05n 0.9 7880.5n 0.9 7880.55n 0 7884n 0 7884.05n 0.9 7885.5n 0.9 7885.55n 0 7959n 0 7959.05n 0.9 7960.5n 0.9 7960.55n 0 7974n 0 7974.05n 0.9 7975.5n 0.9 7975.55n 0 7979n 0 7979.05n 0.9 7980.5n 0.9 7980.55n 0 7984n 0 7984.05n 0.9 7985.5n 0.9 7985.55n 0 7989n 0 7989.05n 0.9 7990.5n 0.9 7990.55n 0 8059n 0 8059.05n 0.9 8060.5n 0.9 8060.55n 0 8069n 0 8069.05n 0.9 8070.5n 0.9 8070.55n 0 8159n 0 8159.05n 0.9 8160.5n 0.9 8160.55n 0 8169n 0 8169.05n 0.9 8170.5n 0.9 8170.55n 0 8189n 0 8189.05n 0.9 8190.5n 0.9 8190.55n 0 8259n 0 8259.05n 0.9 8260.5n 0.9 8260.55n 0 8269n 0 8269.05n 0.9 8270.5n 0.9 8270.55n 0 8284n 0 8284.05n 0.9 8285.5n 0.9 8285.55n 0 8359n 0 8359.05n 0.9 8360.5n 0.9 8360.55n 0 8369n 0 8369.05n 0.9 8370.5n 0.9 8370.55n 0 8384n 0 8384.05n 0.9 8385.5n 0.9 8385.55n 0 8389n 0 8389.05n 0.9 8390.5n 0.9 8390.55n 0 8459n 0 8459.05n 0.9 8460.5n 0.9 8460.55n 0 8469n 0 8469.05n 0.9 8470.5n 0.9 8470.55n 0 8479n 0 8479.05n 0.9 8480.5n 0.9 8480.55n 0 8559n 0 8559.05n 0.9 8560.5n 0.9 8560.55n 0 8569n 0 8569.05n 0.9 8570.5n 0.9 8570.55n 0 8579n 0 8579.05n 0.9 8580.5n 0.9 8580.55n 0 8589n 0 8589.05n 0.9 8590.5n 0.9 8590.55n 0 8659n 0 8659.05n 0.9 8660.5n 0.9 8660.55n 0 8669n 0 8669.05n 0.9 8670.5n 0.9 8670.55n 0 8679n 0 8679.05n 0.9 8680.5n 0.9 8680.55n 0 8684n 0 8684.05n 0.9 8685.5n 0.9 8685.55n 0 8759n 0 8759.05n 0.9 8760.5n 0.9 8760.55n 0 8769n 0 8769.05n 0.9 8770.5n 0.9 8770.55n 0 8779n 0 8779.05n 0.9 8780.5n 0.9 8780.55n 0 8784n 0 8784.05n 0.9 8785.5n 0.9 8785.55n 0 8789n 0 8789.05n 0.9 8790.5n 0.9 8790.55n 0 8859n 0 8859.05n 0.9 8860.5n 0.9 8860.55n 0 8869n 0 8869.05n 0.9 8870.5n 0.9 8870.55n 0 8874n 0 8874.05n 0.9 8875.5n 0.9 8875.55n 0 8959n 0 8959.05n 0.9 8960.5n 0.9 8960.55n 0 8969n 0 8969.05n 0.9 8970.5n 0.9 8970.55n 0 8974n 0 8974.05n 0.9 8975.5n 0.9 8975.55n 0 8989n 0 8989.05n 0.9 8990.5n 0.9 8990.55n 0 9059n 0 9059.05n 0.9 9060.5n 0.9 9060.55n 0 9069n 0 9069.05n 0.9 9070.5n 0.9 9070.55n 0 9074n 0 9074.05n 0.9 9075.5n 0.9 9075.55n 0 9084n 0 9084.05n 0.9 9085.5n 0.9 9085.55n 0 9159n 0 9159.05n 0.9 9160.5n 0.9 9160.55n 0 9169n 0 9169.05n 0.9 9170.5n 0.9 9170.55n 0 9174n 0 9174.05n 0.9 9175.5n 0.9 9175.55n 0 9184n 0 9184.05n 0.9 9185.5n 0.9 9185.55n 0 9189n 0 9189.05n 0.9 9190.5n 0.9 9190.55n 0 9259n 0 9259.05n 0.9 9260.5n 0.9 9260.55n 0 9269n 0 9269.05n 0.9 9270.5n 0.9 9270.55n 0 9274n 0 9274.05n 0.9 9275.5n 0.9 9275.55n 0 9279n 0 9279.05n 0.9 9280.5n 0.9 9280.55n 0 9359n 0 9359.05n 0.9 9360.5n 0.9 9360.55n 0 9369n 0 9369.05n 0.9 9370.5n 0.9 9370.55n 0 9374n 0 9374.05n 0.9 9375.5n 0.9 9375.55n 0 9379n 0 9379.05n 0.9 9380.5n 0.9 9380.55n 0 9389n 0 9389.05n 0.9 9390.5n 0.9 9390.55n 0 9459n 0 9459.05n 0.9 9460.5n 0.9 9460.55n 0 9469n 0 9469.05n 0.9 9470.5n 0.9 9470.55n 0 9474n 0 9474.05n 0.9 9475.5n 0.9 9475.55n 0 9479n 0 9479.05n 0.9 9480.5n 0.9 9480.55n 0 9484n 0 9484.05n 0.9 9485.5n 0.9 9485.55n 0 9559n 0 9559.05n 0.9 9560.5n 0.9 9560.55n 0 9569n 0 9569.05n 0.9 9570.5n 0.9 9570.55n 0 9574n 0 9574.05n 0.9 9575.5n 0.9 9575.55n 0 9579n 0 9579.05n 0.9 9580.5n 0.9 9580.55n 0 9584n 0 9584.05n 0.9 9585.5n 0.9 9585.55n 0 9589n 0 9589.05n 0.9 9590.5n 0.9 9590.55n 0 9659n 0 9659.05n 0.9 9660.5n 0.9 9660.55n 0 9664n 0 9664.05n 0.9 9665.5n 0.9 9665.55n 0 9759n 0 9759.05n 0.9 9760.5n 0.9 9760.55n 0 9764n 0 9764.05n 0.9 9765.5n 0.9 9765.55n 0 9789n 0 9789.05n 0.9 9790.5n 0.9 9790.55n 0 9859n 0 9859.05n 0.9 9860.5n 0.9 9860.55n 0 9864n 0 9864.05n 0.9 9865.5n 0.9 9865.55n 0 9884n 0 9884.05n 0.9 9885.5n 0.9 9885.55n 0 9959n 0 9959.05n 0.9 9960.5n 0.9 9960.55n 0 9964n 0 9964.05n 0.9 9965.5n 0.9 9965.55n 0 9984n 0 9984.05n 0.9 9985.5n 0.9 9985.55n 0 9989n 0 9989.05n 0.9 9990.5n 0.9 9990.55n 0 10059n 0 10059.05n 0.9 10060.5n 0.9 10060.55n 0 10064n 0 10064.05n 0.9 10065.5n 0.9 10065.55n 0 10079n 0 10079.05n 0.9 10080.5n 0.9 10080.55n 0 10159n 0 10159.05n 0.9 10160.5n 0.9 10160.55n 0 10164n 0 10164.05n 0.9 10165.5n 0.9 10165.55n 0 10179n 0 10179.05n 0.9 10180.5n 0.9 10180.55n 0 10189n 0 10189.05n 0.9 10190.5n 0.9 10190.55n 0 10259n 0 10259.05n 0.9 10260.5n 0.9 10260.55n 0 10264n 0 10264.05n 0.9 10265.5n 0.9 10265.55n 0 10279n 0 10279.05n 0.9 10280.5n 0.9 10280.55n 0 10284n 0 10284.05n 0.9 10285.5n 0.9 10285.55n 0 10359n 0 10359.05n 0.9 10360.5n 0.9 10360.55n 0 10364n 0 10364.05n 0.9 10365.5n 0.9 10365.55n 0 10379n 0 10379.05n 0.9 10380.5n 0.9 10380.55n 0 10384n 0 10384.05n 0.9 10385.5n 0.9 10385.55n 0 10389n 0 10389.05n 0.9 10390.5n 0.9 10390.55n 0 10459n 0 10459.05n 0.9 10460.5n 0.9 10460.55n 0 10464n 0 10464.05n 0.9 10465.5n 0.9 10465.55n 0 10474n 0 10474.05n 0.9 10475.5n 0.9 10475.55n 0 10559n 0 10559.05n 0.9 10560.5n 0.9 10560.55n 0 10564n 0 10564.05n 0.9 10565.5n 0.9 10565.55n 0 10574n 0 10574.05n 0.9 10575.5n 0.9 10575.55n 0 10589n 0 10589.05n 0.9 10590.5n 0.9 10590.55n 0 10659n 0 10659.05n 0.9 10660.5n 0.9 10660.55n 0 10664n 0 10664.05n 0.9 10665.5n 0.9 10665.55n 0 10674n 0 10674.05n 0.9 10675.5n 0.9 10675.55n 0 10684n 0 10684.05n 0.9 10685.5n 0.9 10685.55n 0 10759n 0 10759.05n 0.9 10760.5n 0.9 10760.55n 0 10764n 0 10764.05n 0.9 10765.5n 0.9 10765.55n 0 10774n 0 10774.05n 0.9 10775.5n 0.9 10775.55n 0 10784n 0 10784.05n 0.9 10785.5n 0.9 10785.55n 0 10789n 0 10789.05n 0.9 10790.5n 0.9 10790.55n 0 10859n 0 10859.05n 0.9 10860.5n 0.9 10860.55n 0 10864n 0 10864.05n 0.9 10865.5n 0.9 10865.55n 0 10874n 0 10874.05n 0.9 10875.5n 0.9 10875.55n 0 10879n 0 10879.05n 0.9 10880.5n 0.9 10880.55n 0 10959n 0 10959.05n 0.9 10960.5n 0.9 10960.55n 0 10964n 0 10964.05n 0.9 10965.5n 0.9 10965.55n 0 10974n 0 10974.05n 0.9 10975.5n 0.9 10975.55n 0 10979n 0 10979.05n 0.9 10980.5n 0.9 10980.55n 0 10989n 0 10989.05n 0.9 10990.5n 0.9 10990.55n 0 11059n 0 11059.05n 0.9 11060.5n 0.9 11060.55n 0 11064n 0 11064.05n 0.9 11065.5n 0.9 11065.55n 0 11074n 0 11074.05n 0.9 11075.5n 0.9 11075.55n 0 11079n 0 11079.05n 0.9 11080.5n 0.9 11080.55n 0 11084n 0 11084.05n 0.9 11085.5n 0.9 11085.55n 0 11159n 0 11159.05n 0.9 11160.5n 0.9 11160.55n 0 11164n 0 11164.05n 0.9 11165.5n 0.9 11165.55n 0 11174n 0 11174.05n 0.9 11175.5n 0.9 11175.55n 0 11179n 0 11179.05n 0.9 11180.5n 0.9 11180.55n 0 11184n 0 11184.05n 0.9 11185.5n 0.9 11185.55n 0 11189n 0 11189.05n 0.9 11190.5n 0.9 11190.55n 0 11259n 0 11259.05n 0.9 11260.5n 0.9 11260.55n 0 11264n 0 11264.05n 0.9 11265.5n 0.9 11265.55n 0 11269n 0 11269.05n 0.9 11270.5n 0.9 11270.55n 0 11359n 0 11359.05n 0.9 11360.5n 0.9 11360.55n 0 11364n 0 11364.05n 0.9 11365.5n 0.9 11365.55n 0 11369n 0 11369.05n 0.9 11370.5n 0.9 11370.55n 0 11389n 0 11389.05n 0.9 11390.5n 0.9 11390.55n 0 11459n 0 11459.05n 0.9 11460.5n 0.9 11460.55n 0 11464n 0 11464.05n 0.9 11465.5n 0.9 11465.55n 0 11469n 0 11469.05n 0.9 11470.5n 0.9 11470.55n 0 11484n 0 11484.05n 0.9 11485.5n 0.9 11485.55n 0 11559n 0 11559.05n 0.9 11560.5n 0.9 11560.55n 0 11564n 0 11564.05n 0.9 11565.5n 0.9 11565.55n 0 11569n 0 11569.05n 0.9 11570.5n 0.9 11570.55n 0 11584n 0 11584.05n 0.9 11585.5n 0.9 11585.55n 0 11589n 0 11589.05n 0.9 11590.5n 0.9 11590.55n 0 11659n 0 11659.05n 0.9 11660.5n 0.9 11660.55n 0 11664n 0 11664.05n 0.9 11665.5n 0.9 11665.55n 0 11669n 0 11669.05n 0.9 11670.5n 0.9 11670.55n 0 11679n 0 11679.05n 0.9 11680.5n 0.9 11680.55n 0 11759n 0 11759.05n 0.9 11760.5n 0.9 11760.55n 0 11764n 0 11764.05n 0.9 11765.5n 0.9 11765.55n 0 11769n 0 11769.05n 0.9 11770.5n 0.9 11770.55n 0 11779n 0 11779.05n 0.9 11780.5n 0.9 11780.55n 0 11789n 0 11789.05n 0.9 11790.5n 0.9 11790.55n 0 11859n 0 11859.05n 0.9 11860.5n 0.9 11860.55n 0 11864n 0 11864.05n 0.9 11865.5n 0.9 11865.55n 0 11869n 0 11869.05n 0.9 11870.5n 0.9 11870.55n 0 11879n 0 11879.05n 0.9 11880.5n 0.9 11880.55n 0 11884n 0 11884.05n 0.9 11885.5n 0.9 11885.55n 0 11959n 0 11959.05n 0.9 11960.5n 0.9 11960.55n 0 11964n 0 11964.05n 0.9 11965.5n 0.9 11965.55n 0 11969n 0 11969.05n 0.9 11970.5n 0.9 11970.55n 0 11979n 0 11979.05n 0.9 11980.5n 0.9 11980.55n 0 11984n 0 11984.05n 0.9 11985.5n 0.9 11985.55n 0 11989n 0 11989.05n 0.9 11990.5n 0.9 11990.55n 0 12059n 0 12059.05n 0.9 12060.5n 0.9 12060.55n 0 12064n 0 12064.05n 0.9 12065.5n 0.9 12065.55n 0 12069n 0 12069.05n 0.9 12070.5n 0.9 12070.55n 0 12074n 0 12074.05n 0.9 12075.5n 0.9 12075.55n 0 12159n 0 12159.05n 0.9 12160.5n 0.9 12160.55n 0 12164n 0 12164.05n 0.9 12165.5n 0.9 12165.55n 0 12169n 0 12169.05n 0.9 12170.5n 0.9 12170.55n 0 12174n 0 12174.05n 0.9 12175.5n 0.9 12175.55n 0 12189n 0 12189.05n 0.9 12190.5n 0.9 12190.55n 0 12259n 0 12259.05n 0.9 12260.5n 0.9 12260.55n 0 12264n 0 12264.05n 0.9 12265.5n 0.9 12265.55n 0 12269n 0 12269.05n 0.9 12270.5n 0.9 12270.55n 0 12274n 0 12274.05n 0.9 12275.5n 0.9 12275.55n 0 12284n 0 12284.05n 0.9 12285.5n 0.9 12285.55n 0 12359n 0 12359.05n 0.9 12360.5n 0.9 12360.55n 0 12364n 0 12364.05n 0.9 12365.5n 0.9 12365.55n 0 12369n 0 12369.05n 0.9 12370.5n 0.9 12370.55n 0 12374n 0 12374.05n 0.9 12375.5n 0.9 12375.55n 0 12384n 0 12384.05n 0.9 12385.5n 0.9 12385.55n 0 12389n 0 12389.05n 0.9 12390.5n 0.9 12390.55n 0 12459n 0 12459.05n 0.9 12460.5n 0.9 12460.55n 0 12464n 0 12464.05n 0.9 12465.5n 0.9 12465.55n 0 12469n 0 12469.05n 0.9 12470.5n 0.9 12470.55n 0 12474n 0 12474.05n 0.9 12475.5n 0.9 12475.55n 0 12479n 0 12479.05n 0.9 12480.5n 0.9 12480.55n 0 12559n 0 12559.05n 0.9 12560.5n 0.9 12560.55n 0 12564n 0 12564.05n 0.9 12565.5n 0.9 12565.55n 0 12569n 0 12569.05n 0.9 12570.5n 0.9 12570.55n 0 12574n 0 12574.05n 0.9 12575.5n 0.9 12575.55n 0 12579n 0 12579.05n 0.9 12580.5n 0.9 12580.55n 0 12589n 0 12589.05n 0.9 12590.5n 0.9 12590.55n 0 12659n 0 12659.05n 0.9 12660.5n 0.9 12660.55n 0 12664n 0 12664.05n 0.9 12665.5n 0.9 12665.55n 0 12669n 0 12669.05n 0.9 12670.5n 0.9 12670.55n 0 12674n 0 12674.05n 0.9 12675.5n 0.9 12675.55n 0 12679n 0 12679.05n 0.9 12680.5n 0.9 12680.55n 0 12684n 0 12684.05n 0.9 12685.5n 0.9 12685.55n 0 12759n 0 12759.05n 0.9 12760.5n 0.9 12760.55n 0 12764n 0 12764.05n 0.9 12765.5n 0.9 12765.55n 0 12769n 0 12769.05n 0.9 12770.5n 0.9 12770.55n 0 12774n 0 12774.05n 0.9 12775.5n 0.9 12775.55n 0 12779n 0 12779.05n 0.9 12780.5n 0.9 12780.55n 0 12784n 0 12784.05n 0.9 12785.5n 0.9 12785.55n 0 12789n 0 12789.05n 0.9 12790.5n 0.9 12790.55n 0 12854n 0 12854.05n 0.9 12855.5n 0.9 12855.55n 0 12954n 0 12954.05n 0.9 12955.5n 0.9 12955.55n 0 12989n 0 12989.05n 0.9 12990.5n 0.9 12990.55n 0 13054n 0 13054.05n 0.9 13055.5n 0.9 13055.55n 0 13084n 0 13084.05n 0.9 13085.5n 0.9 13085.55n 0 13154n 0 13154.05n 0.9 13155.5n 0.9 13155.55n 0 13184n 0 13184.05n 0.9 13185.5n 0.9 13185.55n 0 13189n 0 13189.05n 0.9 13190.5n 0.9 13190.55n 0 13254n 0 13254.05n 0.9 13255.5n 0.9 13255.55n 0 13279n 0 13279.05n 0.9 13280.5n 0.9 13280.55n 0 13354n 0 13354.05n 0.9 13355.5n 0.9 13355.55n 0 13379n 0 13379.05n 0.9 13380.5n 0.9 13380.55n 0 13389n 0 13389.05n 0.9 13390.5n 0.9 13390.55n 0 13454n 0 13454.05n 0.9 13455.5n 0.9 13455.55n 0 13479n 0 13479.05n 0.9 13480.5n 0.9 13480.55n 0 13484n 0 13484.05n 0.9 13485.5n 0.9 13485.55n 0 13554n 0 13554.05n 0.9 13555.5n 0.9 13555.55n 0 13579n 0 13579.05n 0.9 13580.5n 0.9 13580.55n 0 13584n 0 13584.05n 0.9 13585.5n 0.9 13585.55n 0 13589n 0 13589.05n 0.9 13590.5n 0.9 13590.55n 0 13654n 0 13654.05n 0.9 13655.5n 0.9 13655.55n 0 13674n 0 13674.05n 0.9 13675.5n 0.9 13675.55n 0 13754n 0 13754.05n 0.9 13755.5n 0.9 13755.55n 0 13774n 0 13774.05n 0.9 13775.5n 0.9 13775.55n 0 13789n 0 13789.05n 0.9 13790.5n 0.9 13790.55n 0 13854n 0 13854.05n 0.9 13855.5n 0.9 13855.55n 0 13874n 0 13874.05n 0.9 13875.5n 0.9 13875.55n 0 13884n 0 13884.05n 0.9 13885.5n 0.9 13885.55n 0 13954n 0 13954.05n 0.9 13955.5n 0.9 13955.55n 0 13974n 0 13974.05n 0.9 13975.5n 0.9 13975.55n 0 13984n 0 13984.05n 0.9 13985.5n 0.9 13985.55n 0 13989n 0 13989.05n 0.9 13990.5n 0.9 13990.55n 0 14054n 0 14054.05n 0.9 14055.5n 0.9 14055.55n 0 14074n 0 14074.05n 0.9 14075.5n 0.9 14075.55n 0 14079n 0 14079.05n 0.9 14080.5n 0.9 14080.55n 0 14154n 0 14154.05n 0.9 14155.5n 0.9 14155.55n 0 14174n 0 14174.05n 0.9 14175.5n 0.9 14175.55n 0 14179n 0 14179.05n 0.9 14180.5n 0.9 14180.55n 0 14189n 0 14189.05n 0.9 14190.5n 0.9 14190.55n 0 14254n 0 14254.05n 0.9 14255.5n 0.9 14255.55n 0 14274n 0 14274.05n 0.9 14275.5n 0.9 14275.55n 0 14279n 0 14279.05n 0.9 14280.5n 0.9 14280.55n 0 14284n 0 14284.05n 0.9 14285.5n 0.9 14285.55n 0 14354n 0 14354.05n 0.9 14355.5n 0.9 14355.55n 0 14374n 0 14374.05n 0.9 14375.5n 0.9 14375.55n 0 14379n 0 14379.05n 0.9 14380.5n 0.9 14380.55n 0 14384n 0 14384.05n 0.9 14385.5n 0.9 14385.55n 0 14389n 0 14389.05n 0.9 14390.5n 0.9 14390.55n 0 14454n 0 14454.05n 0.9 14455.5n 0.9 14455.55n 0 14469n 0 14469.05n 0.9 14470.5n 0.9 14470.55n 0 14554n 0 14554.05n 0.9 14555.5n 0.9 14555.55n 0 14569n 0 14569.05n 0.9 14570.5n 0.9 14570.55n 0 14589n 0 14589.05n 0.9 14590.5n 0.9 14590.55n 0 14654n 0 14654.05n 0.9 14655.5n 0.9 14655.55n 0 14669n 0 14669.05n 0.9 14670.5n 0.9 14670.55n 0 14684n 0 14684.05n 0.9 14685.5n 0.9 14685.55n 0 14754n 0 14754.05n 0.9 14755.5n 0.9 14755.55n 0 14769n 0 14769.05n 0.9 14770.5n 0.9 14770.55n 0 14784n 0 14784.05n 0.9 14785.5n 0.9 14785.55n 0 14789n 0 14789.05n 0.9 14790.5n 0.9 14790.55n 0 14854n 0 14854.05n 0.9 14855.5n 0.9 14855.55n 0 14869n 0 14869.05n 0.9 14870.5n 0.9 14870.55n 0 14879n 0 14879.05n 0.9 14880.5n 0.9 14880.55n 0 14954n 0 14954.05n 0.9 14955.5n 0.9 14955.55n 0 14969n 0 14969.05n 0.9 14970.5n 0.9 14970.55n 0 14979n 0 14979.05n 0.9 14980.5n 0.9 14980.55n 0 14989n 0 14989.05n 0.9 14990.5n 0.9 14990.55n 0 15054n 0 15054.05n 0.9 15055.5n 0.9 15055.55n 0 15069n 0 15069.05n 0.9 15070.5n 0.9 15070.55n 0 15079n 0 15079.05n 0.9 15080.5n 0.9 15080.55n 0 15084n 0 15084.05n 0.9 15085.5n 0.9 15085.55n 0 15154n 0 15154.05n 0.9 15155.5n 0.9 15155.55n 0 15169n 0 15169.05n 0.9 15170.5n 0.9 15170.55n 0 15179n 0 15179.05n 0.9 15180.5n 0.9 15180.55n 0 15184n 0 15184.05n 0.9 15185.5n 0.9 15185.55n 0 15189n 0 15189.05n 0.9 15190.5n 0.9 15190.55n 0 15254n 0 15254.05n 0.9 15255.5n 0.9 15255.55n 0 15269n 0 15269.05n 0.9 15270.5n 0.9 15270.55n 0 15274n 0 15274.05n 0.9 15275.5n 0.9 15275.55n 0 15354n 0 15354.05n 0.9 15355.5n 0.9 15355.55n 0 15369n 0 15369.05n 0.9 15370.5n 0.9 15370.55n 0 15374n 0 15374.05n 0.9 15375.5n 0.9 15375.55n 0 15389n 0 15389.05n 0.9 15390.5n 0.9 15390.55n 0 15454n 0 15454.05n 0.9 15455.5n 0.9 15455.55n 0 15469n 0 15469.05n 0.9 15470.5n 0.9 15470.55n 0 15474n 0 15474.05n 0.9 15475.5n 0.9 15475.55n 0 15484n 0 15484.05n 0.9 15485.5n 0.9 15485.55n 0 15554n 0 15554.05n 0.9 15555.5n 0.9 15555.55n 0 15569n 0 15569.05n 0.9 15570.5n 0.9 15570.55n 0 15574n 0 15574.05n 0.9 15575.5n 0.9 15575.55n 0 15584n 0 15584.05n 0.9 15585.5n 0.9 15585.55n 0 15589n 0 15589.05n 0.9 15590.5n 0.9 15590.55n 0 15654n 0 15654.05n 0.9 15655.5n 0.9 15655.55n 0 15669n 0 15669.05n 0.9 15670.5n 0.9 15670.55n 0 15674n 0 15674.05n 0.9 15675.5n 0.9 15675.55n 0 15679n 0 15679.05n 0.9 15680.5n 0.9 15680.55n 0 15754n 0 15754.05n 0.9 15755.5n 0.9 15755.55n 0 15769n 0 15769.05n 0.9 15770.5n 0.9 15770.55n 0 15774n 0 15774.05n 0.9 15775.5n 0.9 15775.55n 0 15779n 0 15779.05n 0.9 15780.5n 0.9 15780.55n 0 15789n 0 15789.05n 0.9 15790.5n 0.9 15790.55n 0 15854n 0 15854.05n 0.9 15855.5n 0.9 15855.55n 0 15869n 0 15869.05n 0.9 15870.5n 0.9 15870.55n 0 15874n 0 15874.05n 0.9 15875.5n 0.9 15875.55n 0 15879n 0 15879.05n 0.9 15880.5n 0.9 15880.55n 0 15884n 0 15884.05n 0.9 15885.5n 0.9 15885.55n 0 15954n 0 15954.05n 0.9 15955.5n 0.9 15955.55n 0 15969n 0 15969.05n 0.9 15970.5n 0.9 15970.55n 0 15974n 0 15974.05n 0.9 15975.5n 0.9 15975.55n 0 15979n 0 15979.05n 0.9 15980.5n 0.9 15980.55n 0 15984n 0 15984.05n 0.9 15985.5n 0.9 15985.55n 0 15989n 0 15989.05n 0.9 15990.5n 0.9 15990.55n 0 16054n 0 16054.05n 0.9 16055.5n 0.9 16055.55n 0 16064n 0 16064.05n 0.9 16065.5n 0.9 16065.55n 0 16154n 0 16154.05n 0.9 16155.5n 0.9 16155.55n 0 16164n 0 16164.05n 0.9 16165.5n 0.9 16165.55n 0 16189n 0 16189.05n 0.9 16190.5n 0.9 16190.55n 0 16254n 0 16254.05n 0.9 16255.5n 0.9 16255.55n 0 16264n 0 16264.05n 0.9 16265.5n 0.9 16265.55n 0 16284n 0 16284.05n 0.9 16285.5n 0.9 16285.55n 0 16354n 0 16354.05n 0.9 16355.5n 0.9 16355.55n 0 16364n 0 16364.05n 0.9 16365.5n 0.9 16365.55n 0 16384n 0 16384.05n 0.9 16385.5n 0.9 16385.55n 0 16389n 0 16389.05n 0.9 16390.5n 0.9 16390.55n 0 16454n 0 16454.05n 0.9 16455.5n 0.9 16455.55n 0 16464n 0 16464.05n 0.9 16465.5n 0.9 16465.55n 0 16479n 0 16479.05n 0.9 16480.5n 0.9 16480.55n 0 16554n 0 16554.05n 0.9 16555.5n 0.9 16555.55n 0 16564n 0 16564.05n 0.9 16565.5n 0.9 16565.55n 0 16579n 0 16579.05n 0.9 16580.5n 0.9 16580.55n 0 16589n 0 16589.05n 0.9 16590.5n 0.9 16590.55n 0 16654n 0 16654.05n 0.9 16655.5n 0.9 16655.55n 0 16664n 0 16664.05n 0.9 16665.5n 0.9 16665.55n 0 16679n 0 16679.05n 0.9 16680.5n 0.9 16680.55n 0 16684n 0 16684.05n 0.9 16685.5n 0.9 16685.55n 0 16754n 0 16754.05n 0.9 16755.5n 0.9 16755.55n 0 16764n 0 16764.05n 0.9 16765.5n 0.9 16765.55n 0 16779n 0 16779.05n 0.9 16780.5n 0.9 16780.55n 0 16784n 0 16784.05n 0.9 16785.5n 0.9 16785.55n 0 16789n 0 16789.05n 0.9 16790.5n 0.9 16790.55n 0 16854n 0 16854.05n 0.9 16855.5n 0.9 16855.55n 0 16864n 0 16864.05n 0.9 16865.5n 0.9 16865.55n 0 16874n 0 16874.05n 0.9 16875.5n 0.9 16875.55n 0 16954n 0 16954.05n 0.9 16955.5n 0.9 16955.55n 0 16964n 0 16964.05n 0.9 16965.5n 0.9 16965.55n 0 16974n 0 16974.05n 0.9 16975.5n 0.9 16975.55n 0 16989n 0 16989.05n 0.9 16990.5n 0.9 16990.55n 0 17054n 0 17054.05n 0.9 17055.5n 0.9 17055.55n 0 17064n 0 17064.05n 0.9 17065.5n 0.9 17065.55n 0 17074n 0 17074.05n 0.9 17075.5n 0.9 17075.55n 0 17084n 0 17084.05n 0.9 17085.5n 0.9 17085.55n 0 17154n 0 17154.05n 0.9 17155.5n 0.9 17155.55n 0 17164n 0 17164.05n 0.9 17165.5n 0.9 17165.55n 0 17174n 0 17174.05n 0.9 17175.5n 0.9 17175.55n 0 17184n 0 17184.05n 0.9 17185.5n 0.9 17185.55n 0 17189n 0 17189.05n 0.9 17190.5n 0.9 17190.55n 0 17254n 0 17254.05n 0.9 17255.5n 0.9 17255.55n 0 17264n 0 17264.05n 0.9 17265.5n 0.9 17265.55n 0 17274n 0 17274.05n 0.9 17275.5n 0.9 17275.55n 0 17279n 0 17279.05n 0.9 17280.5n 0.9 17280.55n 0 17354n 0 17354.05n 0.9 17355.5n 0.9 17355.55n 0 17364n 0 17364.05n 0.9 17365.5n 0.9 17365.55n 0 17374n 0 17374.05n 0.9 17375.5n 0.9 17375.55n 0 17379n 0 17379.05n 0.9 17380.5n 0.9 17380.55n 0 17389n 0 17389.05n 0.9 17390.5n 0.9 17390.55n 0 17454n 0 17454.05n 0.9 17455.5n 0.9 17455.55n 0 17464n 0 17464.05n 0.9 17465.5n 0.9 17465.55n 0 17474n 0 17474.05n 0.9 17475.5n 0.9 17475.55n 0 17479n 0 17479.05n 0.9 17480.5n 0.9 17480.55n 0 17484n 0 17484.05n 0.9 17485.5n 0.9 17485.55n 0 17554n 0 17554.05n 0.9 17555.5n 0.9 17555.55n 0 17564n 0 17564.05n 0.9 17565.5n 0.9 17565.55n 0 17574n 0 17574.05n 0.9 17575.5n 0.9 17575.55n 0 17579n 0 17579.05n 0.9 17580.5n 0.9 17580.55n 0 17584n 0 17584.05n 0.9 17585.5n 0.9 17585.55n 0 17589n 0 17589.05n 0.9 17590.5n 0.9 17590.55n 0 17654n 0 17654.05n 0.9 17655.5n 0.9 17655.55n 0 17664n 0 17664.05n 0.9 17665.5n 0.9 17665.55n 0 17669n 0 17669.05n 0.9 17670.5n 0.9 17670.55n 0 17754n 0 17754.05n 0.9 17755.5n 0.9 17755.55n 0 17764n 0 17764.05n 0.9 17765.5n 0.9 17765.55n 0 17769n 0 17769.05n 0.9 17770.5n 0.9 17770.55n 0 17789n 0 17789.05n 0.9 17790.5n 0.9 17790.55n 0 17854n 0 17854.05n 0.9 17855.5n 0.9 17855.55n 0 17864n 0 17864.05n 0.9 17865.5n 0.9 17865.55n 0 17869n 0 17869.05n 0.9 17870.5n 0.9 17870.55n 0 17884n 0 17884.05n 0.9 17885.5n 0.9 17885.55n 0 17954n 0 17954.05n 0.9 17955.5n 0.9 17955.55n 0 17964n 0 17964.05n 0.9 17965.5n 0.9 17965.55n 0 17969n 0 17969.05n 0.9 17970.5n 0.9 17970.55n 0 17984n 0 17984.05n 0.9 17985.5n 0.9 17985.55n 0 17989n 0 17989.05n 0.9 17990.5n 0.9 17990.55n 0 18054n 0 18054.05n 0.9 18055.5n 0.9 18055.55n 0 18064n 0 18064.05n 0.9 18065.5n 0.9 18065.55n 0 18069n 0 18069.05n 0.9 18070.5n 0.9 18070.55n 0 18079n 0 18079.05n 0.9 18080.5n 0.9 18080.55n 0 18154n 0 18154.05n 0.9 18155.5n 0.9 18155.55n 0 18164n 0 18164.05n 0.9 18165.5n 0.9 18165.55n 0 18169n 0 18169.05n 0.9 18170.5n 0.9 18170.55n 0 18179n 0 18179.05n 0.9 18180.5n 0.9 18180.55n 0 18189n 0 18189.05n 0.9 18190.5n 0.9 18190.55n 0 18254n 0 18254.05n 0.9 18255.5n 0.9 18255.55n 0 18264n 0 18264.05n 0.9 18265.5n 0.9 18265.55n 0 18269n 0 18269.05n 0.9 18270.5n 0.9 18270.55n 0 18279n 0 18279.05n 0.9 18280.5n 0.9 18280.55n 0 18284n 0 18284.05n 0.9 18285.5n 0.9 18285.55n 0 18354n 0 18354.05n 0.9 18355.5n 0.9 18355.55n 0 18364n 0 18364.05n 0.9 18365.5n 0.9 18365.55n 0 18369n 0 18369.05n 0.9 18370.5n 0.9 18370.55n 0 18379n 0 18379.05n 0.9 18380.5n 0.9 18380.55n 0 18384n 0 18384.05n 0.9 18385.5n 0.9 18385.55n 0 18389n 0 18389.05n 0.9 18390.5n 0.9 18390.55n 0 18454n 0 18454.05n 0.9 18455.5n 0.9 18455.55n 0 18464n 0 18464.05n 0.9 18465.5n 0.9 18465.55n 0 18469n 0 18469.05n 0.9 18470.5n 0.9 18470.55n 0 18474n 0 18474.05n 0.9 18475.5n 0.9 18475.55n 0 18554n 0 18554.05n 0.9 18555.5n 0.9 18555.55n 0 18564n 0 18564.05n 0.9 18565.5n 0.9 18565.55n 0 18569n 0 18569.05n 0.9 18570.5n 0.9 18570.55n 0 18574n 0 18574.05n 0.9 18575.5n 0.9 18575.55n 0 18589n 0 18589.05n 0.9 18590.5n 0.9 18590.55n 0 18654n 0 18654.05n 0.9 18655.5n 0.9 18655.55n 0 18664n 0 18664.05n 0.9 18665.5n 0.9 18665.55n 0 18669n 0 18669.05n 0.9 18670.5n 0.9 18670.55n 0 18674n 0 18674.05n 0.9 18675.5n 0.9 18675.55n 0 18684n 0 18684.05n 0.9 18685.5n 0.9 18685.55n 0 18754n 0 18754.05n 0.9 18755.5n 0.9 18755.55n 0 18764n 0 18764.05n 0.9 18765.5n 0.9 18765.55n 0 18769n 0 18769.05n 0.9 18770.5n 0.9 18770.55n 0 18774n 0 18774.05n 0.9 18775.5n 0.9 18775.55n 0 18784n 0 18784.05n 0.9 18785.5n 0.9 18785.55n 0 18789n 0 18789.05n 0.9 18790.5n 0.9 18790.55n 0 18854n 0 18854.05n 0.9 18855.5n 0.9 18855.55n 0 18864n 0 18864.05n 0.9 18865.5n 0.9 18865.55n 0 18869n 0 18869.05n 0.9 18870.5n 0.9 18870.55n 0 18874n 0 18874.05n 0.9 18875.5n 0.9 18875.55n 0 18879n 0 18879.05n 0.9 18880.5n 0.9 18880.55n 0 18954n 0 18954.05n 0.9 18955.5n 0.9 18955.55n 0 18964n 0 18964.05n 0.9 18965.5n 0.9 18965.55n 0 18969n 0 18969.05n 0.9 18970.5n 0.9 18970.55n 0 18974n 0 18974.05n 0.9 18975.5n 0.9 18975.55n 0 18979n 0 18979.05n 0.9 18980.5n 0.9 18980.55n 0 18989n 0 18989.05n 0.9 18990.5n 0.9 18990.55n 0 19054n 0 19054.05n 0.9 19055.5n 0.9 19055.55n 0 19064n 0 19064.05n 0.9 19065.5n 0.9 19065.55n 0 19069n 0 19069.05n 0.9 19070.5n 0.9 19070.55n 0 19074n 0 19074.05n 0.9 19075.5n 0.9 19075.55n 0 19079n 0 19079.05n 0.9 19080.5n 0.9 19080.55n 0 19084n 0 19084.05n 0.9 19085.5n 0.9 19085.55n 0 19154n 0 19154.05n 0.9 19155.5n 0.9 19155.55n 0 19164n 0 19164.05n 0.9 19165.5n 0.9 19165.55n 0 19169n 0 19169.05n 0.9 19170.5n 0.9 19170.55n 0 19174n 0 19174.05n 0.9 19175.5n 0.9 19175.55n 0 19179n 0 19179.05n 0.9 19180.5n 0.9 19180.55n 0 19184n 0 19184.05n 0.9 19185.5n 0.9 19185.55n 0 19189n 0 19189.05n 0.9 19190.5n 0.9 19190.55n 0 19254n 0 19254.05n 0.9 19255.5n 0.9 19255.55n 0 19259n 0 19259.05n 0.9 19260.5n 0.9 19260.55n 0 19354n 0 19354.05n 0.9 19355.5n 0.9 19355.55n 0 19359n 0 19359.05n 0.9 19360.5n 0.9 19360.55n 0 19389n 0 19389.05n 0.9 19390.5n 0.9 19390.55n 0 19454n 0 19454.05n 0.9 19455.5n 0.9 19455.55n 0 19459n 0 19459.05n 0.9 19460.5n 0.9 19460.55n 0 19484n 0 19484.05n 0.9 19485.5n 0.9 19485.55n 0 19554n 0 19554.05n 0.9 19555.5n 0.9 19555.55n 0 19559n 0 19559.05n 0.9 19560.5n 0.9 19560.55n 0 19584n 0 19584.05n 0.9 19585.5n 0.9 19585.55n 0 19589n 0 19589.05n 0.9 19590.5n 0.9 19590.55n 0 19654n 0 19654.05n 0.9 19655.5n 0.9 19655.55n 0 19659n 0 19659.05n 0.9 19660.5n 0.9 19660.55n 0 19679n 0 19679.05n 0.9 19680.5n 0.9 19680.55n 0 19754n 0 19754.05n 0.9 19755.5n 0.9 19755.55n 0 19759n 0 19759.05n 0.9 19760.5n 0.9 19760.55n 0 19779n 0 19779.05n 0.9 19780.5n 0.9 19780.55n 0 19789n 0 19789.05n 0.9 19790.5n 0.9 19790.55n 0 19854n 0 19854.05n 0.9 19855.5n 0.9 19855.55n 0 19859n 0 19859.05n 0.9 19860.5n 0.9 19860.55n 0 19879n 0 19879.05n 0.9 19880.5n 0.9 19880.55n 0 19884n 0 19884.05n 0.9 19885.5n 0.9 19885.55n 0 19954n 0 19954.05n 0.9 19955.5n 0.9 19955.55n 0 19959n 0 19959.05n 0.9 19960.5n 0.9 19960.55n 0 19979n 0 19979.05n 0.9 19980.5n 0.9 19980.55n 0 19984n 0 19984.05n 0.9 19985.5n 0.9 19985.55n 0 19989n 0 19989.05n 0.9 19990.5n 0.9 19990.55n 0 20054n 0 20054.05n 0.9 20055.5n 0.9 20055.55n 0 20059n 0 20059.05n 0.9 20060.5n 0.9 20060.55n 0 20074n 0 20074.05n 0.9 20075.5n 0.9 20075.55n 0 20154n 0 20154.05n 0.9 20155.5n 0.9 20155.55n 0 20159n 0 20159.05n 0.9 20160.5n 0.9 20160.55n 0 20174n 0 20174.05n 0.9 20175.5n 0.9 20175.55n 0 20189n 0 20189.05n 0.9 20190.5n 0.9 20190.55n 0 20254n 0 20254.05n 0.9 20255.5n 0.9 20255.55n 0 20259n 0 20259.05n 0.9 20260.5n 0.9 20260.55n 0 20274n 0 20274.05n 0.9 20275.5n 0.9 20275.55n 0 20284n 0 20284.05n 0.9 20285.5n 0.9 20285.55n 0 20354n 0 20354.05n 0.9 20355.5n 0.9 20355.55n 0 20359n 0 20359.05n 0.9 20360.5n 0.9 20360.55n 0 20374n 0 20374.05n 0.9 20375.5n 0.9 20375.55n 0 20384n 0 20384.05n 0.9 20385.5n 0.9 20385.55n 0 20389n 0 20389.05n 0.9 20390.5n 0.9 20390.55n 0 20454n 0 20454.05n 0.9 20455.5n 0.9 20455.55n 0 20459n 0 20459.05n 0.9 20460.5n 0.9 20460.55n 0 20474n 0 20474.05n 0.9 20475.5n 0.9 20475.55n 0 20479n 0 20479.05n 0.9 20480.5n 0.9 20480.55n 0 20554n 0 20554.05n 0.9 20555.5n 0.9 20555.55n 0 20559n 0 20559.05n 0.9 20560.5n 0.9 20560.55n 0 20574n 0 20574.05n 0.9 20575.5n 0.9 20575.55n 0 20579n 0 20579.05n 0.9 20580.5n 0.9 20580.55n 0 20589n 0 20589.05n 0.9 20590.5n 0.9 20590.55n 0 20654n 0 20654.05n 0.9 20655.5n 0.9 20655.55n 0 20659n 0 20659.05n 0.9 20660.5n 0.9 20660.55n 0 20674n 0 20674.05n 0.9 20675.5n 0.9 20675.55n 0 20679n 0 20679.05n 0.9 20680.5n 0.9 20680.55n 0 20684n 0 20684.05n 0.9 20685.5n 0.9 20685.55n 0 20754n 0 20754.05n 0.9 20755.5n 0.9 20755.55n 0 20759n 0 20759.05n 0.9 20760.5n 0.9 20760.55n 0 20774n 0 20774.05n 0.9 20775.5n 0.9 20775.55n 0 20779n 0 20779.05n 0.9 20780.5n 0.9 20780.55n 0 20784n 0 20784.05n 0.9 20785.5n 0.9 20785.55n 0 20789n 0 20789.05n 0.9 20790.5n 0.9 20790.55n 0 20854n 0 20854.05n 0.9 20855.5n 0.9 20855.55n 0 20859n 0 20859.05n 0.9 20860.5n 0.9 20860.55n 0 20869n 0 20869.05n 0.9 20870.5n 0.9 20870.55n 0 20954n 0 20954.05n 0.9 20955.5n 0.9 20955.55n 0 20959n 0 20959.05n 0.9 20960.5n 0.9 20960.55n 0 20969n 0 20969.05n 0.9 20970.5n 0.9 20970.55n 0 20989n 0 20989.05n 0.9 20990.5n 0.9 20990.55n 0 21054n 0 21054.05n 0.9 21055.5n 0.9 21055.55n 0 21059n 0 21059.05n 0.9 21060.5n 0.9 21060.55n 0 21069n 0 21069.05n 0.9 21070.5n 0.9 21070.55n 0 21084n 0 21084.05n 0.9 21085.5n 0.9 21085.55n 0 21154n 0 21154.05n 0.9 21155.5n 0.9 21155.55n 0 21159n 0 21159.05n 0.9 21160.5n 0.9 21160.55n 0 21169n 0 21169.05n 0.9 21170.5n 0.9 21170.55n 0 21184n 0 21184.05n 0.9 21185.5n 0.9 21185.55n 0 21189n 0 21189.05n 0.9 21190.5n 0.9 21190.55n 0 21254n 0 21254.05n 0.9 21255.5n 0.9 21255.55n 0 21259n 0 21259.05n 0.9 21260.5n 0.9 21260.55n 0 21269n 0 21269.05n 0.9 21270.5n 0.9 21270.55n 0 21279n 0 21279.05n 0.9 21280.5n 0.9 21280.55n 0 21354n 0 21354.05n 0.9 21355.5n 0.9 21355.55n 0 21359n 0 21359.05n 0.9 21360.5n 0.9 21360.55n 0 21369n 0 21369.05n 0.9 21370.5n 0.9 21370.55n 0 21379n 0 21379.05n 0.9 21380.5n 0.9 21380.55n 0 21389n 0 21389.05n 0.9 21390.5n 0.9 21390.55n 0 21454n 0 21454.05n 0.9 21455.5n 0.9 21455.55n 0 21459n 0 21459.05n 0.9 21460.5n 0.9 21460.55n 0 21469n 0 21469.05n 0.9 21470.5n 0.9 21470.55n 0 21479n 0 21479.05n 0.9 21480.5n 0.9 21480.55n 0 21484n 0 21484.05n 0.9 21485.5n 0.9 21485.55n 0 21554n 0 21554.05n 0.9 21555.5n 0.9 21555.55n 0 21559n 0 21559.05n 0.9 21560.5n 0.9 21560.55n 0 21569n 0 21569.05n 0.9 21570.5n 0.9 21570.55n 0 21579n 0 21579.05n 0.9 21580.5n 0.9 21580.55n 0 21584n 0 21584.05n 0.9 21585.5n 0.9 21585.55n 0 21589n 0 21589.05n 0.9 21590.5n 0.9 21590.55n 0 21654n 0 21654.05n 0.9 21655.5n 0.9 21655.55n 0 21659n 0 21659.05n 0.9 21660.5n 0.9 21660.55n 0 21669n 0 21669.05n 0.9 21670.5n 0.9 21670.55n 0 21674n 0 21674.05n 0.9 21675.5n 0.9 21675.55n 0 21754n 0 21754.05n 0.9 21755.5n 0.9 21755.55n 0 21759n 0 21759.05n 0.9 21760.5n 0.9 21760.55n 0 21769n 0 21769.05n 0.9 21770.5n 0.9 21770.55n 0 21774n 0 21774.05n 0.9 21775.5n 0.9 21775.55n 0 21789n 0 21789.05n 0.9 21790.5n 0.9 21790.55n 0 21854n 0 21854.05n 0.9 21855.5n 0.9 21855.55n 0 21859n 0 21859.05n 0.9 21860.5n 0.9 21860.55n 0 21869n 0 21869.05n 0.9 21870.5n 0.9 21870.55n 0 21874n 0 21874.05n 0.9 21875.5n 0.9 21875.55n 0 21884n 0 21884.05n 0.9 21885.5n 0.9 21885.55n 0 21954n 0 21954.05n 0.9 21955.5n 0.9 21955.55n 0 21959n 0 21959.05n 0.9 21960.5n 0.9 21960.55n 0 21969n 0 21969.05n 0.9 21970.5n 0.9 21970.55n 0 21974n 0 21974.05n 0.9 21975.5n 0.9 21975.55n 0 21984n 0 21984.05n 0.9 21985.5n 0.9 21985.55n 0 21989n 0 21989.05n 0.9 21990.5n 0.9 21990.55n 0 22054n 0 22054.05n 0.9 22055.5n 0.9 22055.55n 0 22059n 0 22059.05n 0.9 22060.5n 0.9 22060.55n 0 22069n 0 22069.05n 0.9 22070.5n 0.9 22070.55n 0 22074n 0 22074.05n 0.9 22075.5n 0.9 22075.55n 0 22079n 0 22079.05n 0.9 22080.5n 0.9 22080.55n 0 22154n 0 22154.05n 0.9 22155.5n 0.9 22155.55n 0 22159n 0 22159.05n 0.9 22160.5n 0.9 22160.55n 0 22169n 0 22169.05n 0.9 22170.5n 0.9 22170.55n 0 22174n 0 22174.05n 0.9 22175.5n 0.9 22175.55n 0 22179n 0 22179.05n 0.9 22180.5n 0.9 22180.55n 0 22189n 0 22189.05n 0.9 22190.5n 0.9 22190.55n 0 22254n 0 22254.05n 0.9 22255.5n 0.9 22255.55n 0 22259n 0 22259.05n 0.9 22260.5n 0.9 22260.55n 0 22269n 0 22269.05n 0.9 22270.5n 0.9 22270.55n 0 22274n 0 22274.05n 0.9 22275.5n 0.9 22275.55n 0 22279n 0 22279.05n 0.9 22280.5n 0.9 22280.55n 0 22284n 0 22284.05n 0.9 22285.5n 0.9 22285.55n 0 22354n 0 22354.05n 0.9 22355.5n 0.9 22355.55n 0 22359n 0 22359.05n 0.9 22360.5n 0.9 22360.55n 0 22369n 0 22369.05n 0.9 22370.5n 0.9 22370.55n 0 22374n 0 22374.05n 0.9 22375.5n 0.9 22375.55n 0 22379n 0 22379.05n 0.9 22380.5n 0.9 22380.55n 0 22384n 0 22384.05n 0.9 22385.5n 0.9 22385.55n 0 22389n 0 22389.05n 0.9 22390.5n 0.9 22390.55n 0 22454n 0 22454.05n 0.9 22455.5n 0.9 22455.55n 0 22459n 0 22459.05n 0.9 22460.5n 0.9 22460.55n 0 22464n 0 22464.05n 0.9 22465.5n 0.9 22465.55n 0 22554n 0 22554.05n 0.9 22555.5n 0.9 22555.55n 0 22559n 0 22559.05n 0.9 22560.5n 0.9 22560.55n 0 22564n 0 22564.05n 0.9 22565.5n 0.9 22565.55n 0 22589n 0 22589.05n 0.9 22590.5n 0.9 22590.55n 0 22654n 0 22654.05n 0.9 22655.5n 0.9 22655.55n 0 22659n 0 22659.05n 0.9 22660.5n 0.9 22660.55n 0 22664n 0 22664.05n 0.9 22665.5n 0.9 22665.55n 0 22684n 0 22684.05n 0.9 22685.5n 0.9 22685.55n 0 22754n 0 22754.05n 0.9 22755.5n 0.9 22755.55n 0 22759n 0 22759.05n 0.9 22760.5n 0.9 22760.55n 0 22764n 0 22764.05n 0.9 22765.5n 0.9 22765.55n 0 22784n 0 22784.05n 0.9 22785.5n 0.9 22785.55n 0 22789n 0 22789.05n 0.9 22790.5n 0.9 22790.55n 0 22854n 0 22854.05n 0.9 22855.5n 0.9 22855.55n 0 22859n 0 22859.05n 0.9 22860.5n 0.9 22860.55n 0 22864n 0 22864.05n 0.9 22865.5n 0.9 22865.55n 0 22879n 0 22879.05n 0.9 22880.5n 0.9 22880.55n 0 22954n 0 22954.05n 0.9 22955.5n 0.9 22955.55n 0 22959n 0 22959.05n 0.9 22960.5n 0.9 22960.55n 0 22964n 0 22964.05n 0.9 22965.5n 0.9 22965.55n 0 22979n 0 22979.05n 0.9 22980.5n 0.9 22980.55n 0 22989n 0 22989.05n 0.9 22990.5n 0.9 22990.55n 0 23054n 0 23054.05n 0.9 23055.5n 0.9 23055.55n 0 23059n 0 23059.05n 0.9 23060.5n 0.9 23060.55n 0 23064n 0 23064.05n 0.9 23065.5n 0.9 23065.55n 0 23079n 0 23079.05n 0.9 23080.5n 0.9 23080.55n 0 23084n 0 23084.05n 0.9 23085.5n 0.9 23085.55n 0 23154n 0 23154.05n 0.9 23155.5n 0.9 23155.55n 0 23159n 0 23159.05n 0.9 23160.5n 0.9 23160.55n 0 23164n 0 23164.05n 0.9 23165.5n 0.9 23165.55n 0 23179n 0 23179.05n 0.9 23180.5n 0.9 23180.55n 0 23184n 0 23184.05n 0.9 23185.5n 0.9 23185.55n 0 23189n 0 23189.05n 0.9 23190.5n 0.9 23190.55n 0 23254n 0 23254.05n 0.9 23255.5n 0.9 23255.55n 0 23259n 0 23259.05n 0.9 23260.5n 0.9 23260.55n 0 23264n 0 23264.05n 0.9 23265.5n 0.9 23265.55n 0 23274n 0 23274.05n 0.9 23275.5n 0.9 23275.55n 0 23354n 0 23354.05n 0.9 23355.5n 0.9 23355.55n 0 23359n 0 23359.05n 0.9 23360.5n 0.9 23360.55n 0 23364n 0 23364.05n 0.9 23365.5n 0.9 23365.55n 0 23374n 0 23374.05n 0.9 23375.5n 0.9 23375.55n 0 23389n 0 23389.05n 0.9 23390.5n 0.9 23390.55n 0 23454n 0 23454.05n 0.9 23455.5n 0.9 23455.55n 0 23459n 0 23459.05n 0.9 23460.5n 0.9 23460.55n 0 23464n 0 23464.05n 0.9 23465.5n 0.9 23465.55n 0 23474n 0 23474.05n 0.9 23475.5n 0.9 23475.55n 0 23484n 0 23484.05n 0.9 23485.5n 0.9 23485.55n 0 23554n 0 23554.05n 0.9 23555.5n 0.9 23555.55n 0 23559n 0 23559.05n 0.9 23560.5n 0.9 23560.55n 0 23564n 0 23564.05n 0.9 23565.5n 0.9 23565.55n 0 23574n 0 23574.05n 0.9 23575.5n 0.9 23575.55n 0 23584n 0 23584.05n 0.9 23585.5n 0.9 23585.55n 0 23589n 0 23589.05n 0.9 23590.5n 0.9 23590.55n 0 23654n 0 23654.05n 0.9 23655.5n 0.9 23655.55n 0 23659n 0 23659.05n 0.9 23660.5n 0.9 23660.55n 0 23664n 0 23664.05n 0.9 23665.5n 0.9 23665.55n 0 23674n 0 23674.05n 0.9 23675.5n 0.9 23675.55n 0 23679n 0 23679.05n 0.9 23680.5n 0.9 23680.55n 0 23754n 0 23754.05n 0.9 23755.5n 0.9 23755.55n 0 23759n 0 23759.05n 0.9 23760.5n 0.9 23760.55n 0 23764n 0 23764.05n 0.9 23765.5n 0.9 23765.55n 0 23774n 0 23774.05n 0.9 23775.5n 0.9 23775.55n 0 23779n 0 23779.05n 0.9 23780.5n 0.9 23780.55n 0 23789n 0 23789.05n 0.9 23790.5n 0.9 23790.55n 0 23854n 0 23854.05n 0.9 23855.5n 0.9 23855.55n 0 23859n 0 23859.05n 0.9 23860.5n 0.9 23860.55n 0 23864n 0 23864.05n 0.9 23865.5n 0.9 23865.55n 0 23874n 0 23874.05n 0.9 23875.5n 0.9 23875.55n 0 23879n 0 23879.05n 0.9 23880.5n 0.9 23880.55n 0 23884n 0 23884.05n 0.9 23885.5n 0.9 23885.55n 0 23954n 0 23954.05n 0.9 23955.5n 0.9 23955.55n 0 23959n 0 23959.05n 0.9 23960.5n 0.9 23960.55n 0 23964n 0 23964.05n 0.9 23965.5n 0.9 23965.55n 0 23974n 0 23974.05n 0.9 23975.5n 0.9 23975.55n 0 23979n 0 23979.05n 0.9 23980.5n 0.9 23980.55n 0 23984n 0 23984.05n 0.9 23985.5n 0.9 23985.55n 0 23989n 0 23989.05n 0.9 23990.5n 0.9 23990.55n 0 24054n 0 24054.05n 0.9 24055.5n 0.9 24055.55n 0 24059n 0 24059.05n 0.9 24060.5n 0.9 24060.55n 0 24064n 0 24064.05n 0.9 24065.5n 0.9 24065.55n 0 24069n 0 24069.05n 0.9 24070.5n 0.9 24070.55n 0 24154n 0 24154.05n 0.9 24155.5n 0.9 24155.55n 0 24159n 0 24159.05n 0.9 24160.5n 0.9 24160.55n 0 24164n 0 24164.05n 0.9 24165.5n 0.9 24165.55n 0 24169n 0 24169.05n 0.9 24170.5n 0.9 24170.55n 0 24189n 0 24189.05n 0.9 24190.5n 0.9 24190.55n 0 24254n 0 24254.05n 0.9 24255.5n 0.9 24255.55n 0 24259n 0 24259.05n 0.9 24260.5n 0.9 24260.55n 0 24264n 0 24264.05n 0.9 24265.5n 0.9 24265.55n 0 24269n 0 24269.05n 0.9 24270.5n 0.9 24270.55n 0 24284n 0 24284.05n 0.9 24285.5n 0.9 24285.55n 0 24354n 0 24354.05n 0.9 24355.5n 0.9 24355.55n 0 24359n 0 24359.05n 0.9 24360.5n 0.9 24360.55n 0 24364n 0 24364.05n 0.9 24365.5n 0.9 24365.55n 0 24369n 0 24369.05n 0.9 24370.5n 0.9 24370.55n 0 24384n 0 24384.05n 0.9 24385.5n 0.9 24385.55n 0 24389n 0 24389.05n 0.9 24390.5n 0.9 24390.55n 0 24454n 0 24454.05n 0.9 24455.5n 0.9 24455.55n 0 24459n 0 24459.05n 0.9 24460.5n 0.9 24460.55n 0 24464n 0 24464.05n 0.9 24465.5n 0.9 24465.55n 0 24469n 0 24469.05n 0.9 24470.5n 0.9 24470.55n 0 24479n 0 24479.05n 0.9 24480.5n 0.9 24480.55n 0 24554n 0 24554.05n 0.9 24555.5n 0.9 24555.55n 0 24559n 0 24559.05n 0.9 24560.5n 0.9 24560.55n 0 24564n 0 24564.05n 0.9 24565.5n 0.9 24565.55n 0 24569n 0 24569.05n 0.9 24570.5n 0.9 24570.55n 0 24579n 0 24579.05n 0.9 24580.5n 0.9 24580.55n 0 24589n 0 24589.05n 0.9 24590.5n 0.9 24590.55n 0 24654n 0 24654.05n 0.9 24655.5n 0.9 24655.55n 0 24659n 0 24659.05n 0.9 24660.5n 0.9 24660.55n 0 24664n 0 24664.05n 0.9 24665.5n 0.9 24665.55n 0 24669n 0 24669.05n 0.9 24670.5n 0.9 24670.55n 0 24679n 0 24679.05n 0.9 24680.5n 0.9 24680.55n 0 24684n 0 24684.05n 0.9 24685.5n 0.9 24685.55n 0 24754n 0 24754.05n 0.9 24755.5n 0.9 24755.55n 0 24759n 0 24759.05n 0.9 24760.5n 0.9 24760.55n 0 24764n 0 24764.05n 0.9 24765.5n 0.9 24765.55n 0 24769n 0 24769.05n 0.9 24770.5n 0.9 24770.55n 0 24779n 0 24779.05n 0.9 24780.5n 0.9 24780.55n 0 24784n 0 24784.05n 0.9 24785.5n 0.9 24785.55n 0 24789n 0 24789.05n 0.9 24790.5n 0.9 24790.55n 0 24854n 0 24854.05n 0.9 24855.5n 0.9 24855.55n 0 24859n 0 24859.05n 0.9 24860.5n 0.9 24860.55n 0 24864n 0 24864.05n 0.9 24865.5n 0.9 24865.55n 0 24869n 0 24869.05n 0.9 24870.5n 0.9 24870.55n 0 24874n 0 24874.05n 0.9 24875.5n 0.9 24875.55n 0 24954n 0 24954.05n 0.9 24955.5n 0.9 24955.55n 0 24959n 0 24959.05n 0.9 24960.5n 0.9 24960.55n 0 24964n 0 24964.05n 0.9 24965.5n 0.9 24965.55n 0 24969n 0 24969.05n 0.9 24970.5n 0.9 24970.55n 0 24974n 0 24974.05n 0.9 24975.5n 0.9 24975.55n 0 24989n 0 24989.05n 0.9 24990.5n 0.9 24990.55n 0 25054n 0 25054.05n 0.9 25055.5n 0.9 25055.55n 0 25059n 0 25059.05n 0.9 25060.5n 0.9 25060.55n 0 25064n 0 25064.05n 0.9 25065.5n 0.9 25065.55n 0 25069n 0 25069.05n 0.9 25070.5n 0.9 25070.55n 0 25074n 0 25074.05n 0.9 25075.5n 0.9 25075.55n 0 25084n 0 25084.05n 0.9 25085.5n 0.9 25085.55n 0 25154n 0 25154.05n 0.9 25155.5n 0.9 25155.55n 0 25159n 0 25159.05n 0.9 25160.5n 0.9 25160.55n 0 25164n 0 25164.05n 0.9 25165.5n 0.9 25165.55n 0 25169n 0 25169.05n 0.9 25170.5n 0.9 25170.55n 0 25174n 0 25174.05n 0.9 25175.5n 0.9 25175.55n 0 25184n 0 25184.05n 0.9 25185.5n 0.9 25185.55n 0 25189n 0 25189.05n 0.9 25190.5n 0.9 25190.55n 0 25254n 0 25254.05n 0.9 25255.5n 0.9 25255.55n 0 25259n 0 25259.05n 0.9 25260.5n 0.9 25260.55n 0 25264n 0 25264.05n 0.9 25265.5n 0.9 25265.55n 0 25269n 0 25269.05n 0.9 25270.5n 0.9 25270.55n 0 25274n 0 25274.05n 0.9 25275.5n 0.9 25275.55n 0 25279n 0 25279.05n 0.9 25280.5n 0.9 25280.55n 0 25354n 0 25354.05n 0.9 25355.5n 0.9 25355.55n 0 25359n 0 25359.05n 0.9 25360.5n 0.9 25360.55n 0 25364n 0 25364.05n 0.9 25365.5n 0.9 25365.55n 0 25369n 0 25369.05n 0.9 25370.5n 0.9 25370.55n 0 25374n 0 25374.05n 0.9 25375.5n 0.9 25375.55n 0 25379n 0 25379.05n 0.9 25380.5n 0.9 25380.55n 0 25389n 0 25389.05n 0.9 25390.5n 0.9 25390.55n 0 25454n 0 25454.05n 0.9 25455.5n 0.9 25455.55n 0 25459n 0 25459.05n 0.9 25460.5n 0.9 25460.55n 0 25464n 0 25464.05n 0.9 25465.5n 0.9 25465.55n 0 25469n 0 25469.05n 0.9 25470.5n 0.9 25470.55n 0 25474n 0 25474.05n 0.9 25475.5n 0.9 25475.55n 0 25479n 0 25479.05n 0.9 25480.5n 0.9 25480.55n 0 25484n 0 25484.05n 0.9 25485.5n 0.9 25485.55n 0 25554n 0 25554.05n 0.9 25555.5n 0.9 25555.55n 0 25559n 0 25559.05n 0.9 25560.5n 0.9 25560.55n 0 25564n 0 25564.05n 0.9 25565.5n 0.9 25565.55n 0 25569n 0 25569.05n 0.9 25570.5n 0.9 25570.55n 0 25574n 0 25574.05n 0.9 25575.5n 0.9 25575.55n 0 25579n 0 25579.05n 0.9 25580.5n 0.9 25580.55n 0 25584n 0 25584.05n 0.9 25585.5n 0.9 25585.55n 0 25589n 0 25589.05n 0.9 25590.5n 0.9 25590.55n 0]
VRESPN (DCMPN 0) vsource type=pwl wave=[0n 0 54n 0 54.05n 0.9 55.5n 0.9 55.55n 0 59n 0 59.05n 0.9 60.5n 0.9 60.55n 0 64n 0 64.05n 0.9 65.5n 0.9 65.55n 0 69n 0 69.05n 0.9 70.5n 0.9 70.55n 0 74n 0 74.05n 0.9 75.5n 0.9 75.55n 0 79n 0 79.05n 0.9 80.5n 0.9 80.55n 0 84n 0 84.05n 0.9 85.5n 0.9 85.55n 0 89n 0 89.05n 0.9 90.5n 0.9 90.55n 0 154n 0 154.05n 0.9 155.5n 0.9 155.55n 0 159n 0 159.05n 0.9 160.5n 0.9 160.55n 0 164n 0 164.05n 0.9 165.5n 0.9 165.55n 0 169n 0 169.05n 0.9 170.5n 0.9 170.55n 0 174n 0 174.05n 0.9 175.5n 0.9 175.55n 0 179n 0 179.05n 0.9 180.5n 0.9 180.55n 0 184n 0 184.05n 0.9 185.5n 0.9 185.55n 0 254n 0 254.05n 0.9 255.5n 0.9 255.55n 0 259n 0 259.05n 0.9 260.5n 0.9 260.55n 0 264n 0 264.05n 0.9 265.5n 0.9 265.55n 0 269n 0 269.05n 0.9 270.5n 0.9 270.55n 0 274n 0 274.05n 0.9 275.5n 0.9 275.55n 0 279n 0 279.05n 0.9 280.5n 0.9 280.55n 0 289n 0 289.05n 0.9 290.5n 0.9 290.55n 0 354n 0 354.05n 0.9 355.5n 0.9 355.55n 0 359n 0 359.05n 0.9 360.5n 0.9 360.55n 0 364n 0 364.05n 0.9 365.5n 0.9 365.55n 0 369n 0 369.05n 0.9 370.5n 0.9 370.55n 0 374n 0 374.05n 0.9 375.5n 0.9 375.55n 0 379n 0 379.05n 0.9 380.5n 0.9 380.55n 0 454n 0 454.05n 0.9 455.5n 0.9 455.55n 0 459n 0 459.05n 0.9 460.5n 0.9 460.55n 0 464n 0 464.05n 0.9 465.5n 0.9 465.55n 0 469n 0 469.05n 0.9 470.5n 0.9 470.55n 0 474n 0 474.05n 0.9 475.5n 0.9 475.55n 0 484n 0 484.05n 0.9 485.5n 0.9 485.55n 0 489n 0 489.05n 0.9 490.5n 0.9 490.55n 0 554n 0 554.05n 0.9 555.5n 0.9 555.55n 0 559n 0 559.05n 0.9 560.5n 0.9 560.55n 0 564n 0 564.05n 0.9 565.5n 0.9 565.55n 0 569n 0 569.05n 0.9 570.5n 0.9 570.55n 0 574n 0 574.05n 0.9 575.5n 0.9 575.55n 0 584n 0 584.05n 0.9 585.5n 0.9 585.55n 0 654n 0 654.05n 0.9 655.5n 0.9 655.55n 0 659n 0 659.05n 0.9 660.5n 0.9 660.55n 0 664n 0 664.05n 0.9 665.5n 0.9 665.55n 0 669n 0 669.05n 0.9 670.5n 0.9 670.55n 0 674n 0 674.05n 0.9 675.5n 0.9 675.55n 0 689n 0 689.05n 0.9 690.5n 0.9 690.55n 0 754n 0 754.05n 0.9 755.5n 0.9 755.55n 0 759n 0 759.05n 0.9 760.5n 0.9 760.55n 0 764n 0 764.05n 0.9 765.5n 0.9 765.55n 0 769n 0 769.05n 0.9 770.5n 0.9 770.55n 0 774n 0 774.05n 0.9 775.5n 0.9 775.55n 0 854n 0 854.05n 0.9 855.5n 0.9 855.55n 0 859n 0 859.05n 0.9 860.5n 0.9 860.55n 0 864n 0 864.05n 0.9 865.5n 0.9 865.55n 0 869n 0 869.05n 0.9 870.5n 0.9 870.55n 0 879n 0 879.05n 0.9 880.5n 0.9 880.55n 0 884n 0 884.05n 0.9 885.5n 0.9 885.55n 0 889n 0 889.05n 0.9 890.5n 0.9 890.55n 0 954n 0 954.05n 0.9 955.5n 0.9 955.55n 0 959n 0 959.05n 0.9 960.5n 0.9 960.55n 0 964n 0 964.05n 0.9 965.5n 0.9 965.55n 0 969n 0 969.05n 0.9 970.5n 0.9 970.55n 0 979n 0 979.05n 0.9 980.5n 0.9 980.55n 0 984n 0 984.05n 0.9 985.5n 0.9 985.55n 0 1054n 0 1054.05n 0.9 1055.5n 0.9 1055.55n 0 1059n 0 1059.05n 0.9 1060.5n 0.9 1060.55n 0 1064n 0 1064.05n 0.9 1065.5n 0.9 1065.55n 0 1069n 0 1069.05n 0.9 1070.5n 0.9 1070.55n 0 1079n 0 1079.05n 0.9 1080.5n 0.9 1080.55n 0 1089n 0 1089.05n 0.9 1090.5n 0.9 1090.55n 0 1154n 0 1154.05n 0.9 1155.5n 0.9 1155.55n 0 1159n 0 1159.05n 0.9 1160.5n 0.9 1160.55n 0 1164n 0 1164.05n 0.9 1165.5n 0.9 1165.55n 0 1169n 0 1169.05n 0.9 1170.5n 0.9 1170.55n 0 1179n 0 1179.05n 0.9 1180.5n 0.9 1180.55n 0 1254n 0 1254.05n 0.9 1255.5n 0.9 1255.55n 0 1259n 0 1259.05n 0.9 1260.5n 0.9 1260.55n 0 1264n 0 1264.05n 0.9 1265.5n 0.9 1265.55n 0 1269n 0 1269.05n 0.9 1270.5n 0.9 1270.55n 0 1284n 0 1284.05n 0.9 1285.5n 0.9 1285.55n 0 1289n 0 1289.05n 0.9 1290.5n 0.9 1290.55n 0 1354n 0 1354.05n 0.9 1355.5n 0.9 1355.55n 0 1359n 0 1359.05n 0.9 1360.5n 0.9 1360.55n 0 1364n 0 1364.05n 0.9 1365.5n 0.9 1365.55n 0 1369n 0 1369.05n 0.9 1370.5n 0.9 1370.55n 0 1384n 0 1384.05n 0.9 1385.5n 0.9 1385.55n 0 1454n 0 1454.05n 0.9 1455.5n 0.9 1455.55n 0 1459n 0 1459.05n 0.9 1460.5n 0.9 1460.55n 0 1464n 0 1464.05n 0.9 1465.5n 0.9 1465.55n 0 1469n 0 1469.05n 0.9 1470.5n 0.9 1470.55n 0 1489n 0 1489.05n 0.9 1490.5n 0.9 1490.55n 0 1554n 0 1554.05n 0.9 1555.5n 0.9 1555.55n 0 1559n 0 1559.05n 0.9 1560.5n 0.9 1560.55n 0 1564n 0 1564.05n 0.9 1565.5n 0.9 1565.55n 0 1569n 0 1569.05n 0.9 1570.5n 0.9 1570.55n 0 1654n 0 1654.05n 0.9 1655.5n 0.9 1655.55n 0 1659n 0 1659.05n 0.9 1660.5n 0.9 1660.55n 0 1664n 0 1664.05n 0.9 1665.5n 0.9 1665.55n 0 1674n 0 1674.05n 0.9 1675.5n 0.9 1675.55n 0 1679n 0 1679.05n 0.9 1680.5n 0.9 1680.55n 0 1684n 0 1684.05n 0.9 1685.5n 0.9 1685.55n 0 1689n 0 1689.05n 0.9 1690.5n 0.9 1690.55n 0 1754n 0 1754.05n 0.9 1755.5n 0.9 1755.55n 0 1759n 0 1759.05n 0.9 1760.5n 0.9 1760.55n 0 1764n 0 1764.05n 0.9 1765.5n 0.9 1765.55n 0 1774n 0 1774.05n 0.9 1775.5n 0.9 1775.55n 0 1779n 0 1779.05n 0.9 1780.5n 0.9 1780.55n 0 1784n 0 1784.05n 0.9 1785.5n 0.9 1785.55n 0 1854n 0 1854.05n 0.9 1855.5n 0.9 1855.55n 0 1859n 0 1859.05n 0.9 1860.5n 0.9 1860.55n 0 1864n 0 1864.05n 0.9 1865.5n 0.9 1865.55n 0 1874n 0 1874.05n 0.9 1875.5n 0.9 1875.55n 0 1879n 0 1879.05n 0.9 1880.5n 0.9 1880.55n 0 1889n 0 1889.05n 0.9 1890.5n 0.9 1890.55n 0 1954n 0 1954.05n 0.9 1955.5n 0.9 1955.55n 0 1959n 0 1959.05n 0.9 1960.5n 0.9 1960.55n 0 1964n 0 1964.05n 0.9 1965.5n 0.9 1965.55n 0 1974n 0 1974.05n 0.9 1975.5n 0.9 1975.55n 0 1979n 0 1979.05n 0.9 1980.5n 0.9 1980.55n 0 2054n 0 2054.05n 0.9 2055.5n 0.9 2055.55n 0 2059n 0 2059.05n 0.9 2060.5n 0.9 2060.55n 0 2064n 0 2064.05n 0.9 2065.5n 0.9 2065.55n 0 2074n 0 2074.05n 0.9 2075.5n 0.9 2075.55n 0 2084n 0 2084.05n 0.9 2085.5n 0.9 2085.55n 0 2089n 0 2089.05n 0.9 2090.5n 0.9 2090.55n 0 2154n 0 2154.05n 0.9 2155.5n 0.9 2155.55n 0 2159n 0 2159.05n 0.9 2160.5n 0.9 2160.55n 0 2164n 0 2164.05n 0.9 2165.5n 0.9 2165.55n 0 2174n 0 2174.05n 0.9 2175.5n 0.9 2175.55n 0 2184n 0 2184.05n 0.9 2185.5n 0.9 2185.55n 0 2254n 0 2254.05n 0.9 2255.5n 0.9 2255.55n 0 2259n 0 2259.05n 0.9 2260.5n 0.9 2260.55n 0 2264n 0 2264.05n 0.9 2265.5n 0.9 2265.55n 0 2274n 0 2274.05n 0.9 2275.5n 0.9 2275.55n 0 2289n 0 2289.05n 0.9 2290.5n 0.9 2290.55n 0 2354n 0 2354.05n 0.9 2355.5n 0.9 2355.55n 0 2359n 0 2359.05n 0.9 2360.5n 0.9 2360.55n 0 2364n 0 2364.05n 0.9 2365.5n 0.9 2365.55n 0 2374n 0 2374.05n 0.9 2375.5n 0.9 2375.55n 0 2454n 0 2454.05n 0.9 2455.5n 0.9 2455.55n 0 2459n 0 2459.05n 0.9 2460.5n 0.9 2460.55n 0 2464n 0 2464.05n 0.9 2465.5n 0.9 2465.55n 0 2479n 0 2479.05n 0.9 2480.5n 0.9 2480.55n 0 2484n 0 2484.05n 0.9 2485.5n 0.9 2485.55n 0 2489n 0 2489.05n 0.9 2490.5n 0.9 2490.55n 0 2554n 0 2554.05n 0.9 2555.5n 0.9 2555.55n 0 2559n 0 2559.05n 0.9 2560.5n 0.9 2560.55n 0 2564n 0 2564.05n 0.9 2565.5n 0.9 2565.55n 0 2579n 0 2579.05n 0.9 2580.5n 0.9 2580.55n 0 2584n 0 2584.05n 0.9 2585.5n 0.9 2585.55n 0 2654n 0 2654.05n 0.9 2655.5n 0.9 2655.55n 0 2659n 0 2659.05n 0.9 2660.5n 0.9 2660.55n 0 2664n 0 2664.05n 0.9 2665.5n 0.9 2665.55n 0 2679n 0 2679.05n 0.9 2680.5n 0.9 2680.55n 0 2689n 0 2689.05n 0.9 2690.5n 0.9 2690.55n 0 2754n 0 2754.05n 0.9 2755.5n 0.9 2755.55n 0 2759n 0 2759.05n 0.9 2760.5n 0.9 2760.55n 0 2764n 0 2764.05n 0.9 2765.5n 0.9 2765.55n 0 2779n 0 2779.05n 0.9 2780.5n 0.9 2780.55n 0 2854n 0 2854.05n 0.9 2855.5n 0.9 2855.55n 0 2859n 0 2859.05n 0.9 2860.5n 0.9 2860.55n 0 2864n 0 2864.05n 0.9 2865.5n 0.9 2865.55n 0 2884n 0 2884.05n 0.9 2885.5n 0.9 2885.55n 0 2889n 0 2889.05n 0.9 2890.5n 0.9 2890.55n 0 2954n 0 2954.05n 0.9 2955.5n 0.9 2955.55n 0 2959n 0 2959.05n 0.9 2960.5n 0.9 2960.55n 0 2964n 0 2964.05n 0.9 2965.5n 0.9 2965.55n 0 2984n 0 2984.05n 0.9 2985.5n 0.9 2985.55n 0 3054n 0 3054.05n 0.9 3055.5n 0.9 3055.55n 0 3059n 0 3059.05n 0.9 3060.5n 0.9 3060.55n 0 3064n 0 3064.05n 0.9 3065.5n 0.9 3065.55n 0 3089n 0 3089.05n 0.9 3090.5n 0.9 3090.55n 0 3154n 0 3154.05n 0.9 3155.5n 0.9 3155.55n 0 3159n 0 3159.05n 0.9 3160.5n 0.9 3160.55n 0 3164n 0 3164.05n 0.9 3165.5n 0.9 3165.55n 0 3254n 0 3254.05n 0.9 3255.5n 0.9 3255.55n 0 3259n 0 3259.05n 0.9 3260.5n 0.9 3260.55n 0 3269n 0 3269.05n 0.9 3270.5n 0.9 3270.55n 0 3274n 0 3274.05n 0.9 3275.5n 0.9 3275.55n 0 3279n 0 3279.05n 0.9 3280.5n 0.9 3280.55n 0 3284n 0 3284.05n 0.9 3285.5n 0.9 3285.55n 0 3289n 0 3289.05n 0.9 3290.5n 0.9 3290.55n 0 3354n 0 3354.05n 0.9 3355.5n 0.9 3355.55n 0 3359n 0 3359.05n 0.9 3360.5n 0.9 3360.55n 0 3369n 0 3369.05n 0.9 3370.5n 0.9 3370.55n 0 3374n 0 3374.05n 0.9 3375.5n 0.9 3375.55n 0 3379n 0 3379.05n 0.9 3380.5n 0.9 3380.55n 0 3384n 0 3384.05n 0.9 3385.5n 0.9 3385.55n 0 3454n 0 3454.05n 0.9 3455.5n 0.9 3455.55n 0 3459n 0 3459.05n 0.9 3460.5n 0.9 3460.55n 0 3469n 0 3469.05n 0.9 3470.5n 0.9 3470.55n 0 3474n 0 3474.05n 0.9 3475.5n 0.9 3475.55n 0 3479n 0 3479.05n 0.9 3480.5n 0.9 3480.55n 0 3489n 0 3489.05n 0.9 3490.5n 0.9 3490.55n 0 3554n 0 3554.05n 0.9 3555.5n 0.9 3555.55n 0 3559n 0 3559.05n 0.9 3560.5n 0.9 3560.55n 0 3569n 0 3569.05n 0.9 3570.5n 0.9 3570.55n 0 3574n 0 3574.05n 0.9 3575.5n 0.9 3575.55n 0 3579n 0 3579.05n 0.9 3580.5n 0.9 3580.55n 0 3654n 0 3654.05n 0.9 3655.5n 0.9 3655.55n 0 3659n 0 3659.05n 0.9 3660.5n 0.9 3660.55n 0 3669n 0 3669.05n 0.9 3670.5n 0.9 3670.55n 0 3674n 0 3674.05n 0.9 3675.5n 0.9 3675.55n 0 3684n 0 3684.05n 0.9 3685.5n 0.9 3685.55n 0 3689n 0 3689.05n 0.9 3690.5n 0.9 3690.55n 0 3754n 0 3754.05n 0.9 3755.5n 0.9 3755.55n 0 3759n 0 3759.05n 0.9 3760.5n 0.9 3760.55n 0 3769n 0 3769.05n 0.9 3770.5n 0.9 3770.55n 0 3774n 0 3774.05n 0.9 3775.5n 0.9 3775.55n 0 3784n 0 3784.05n 0.9 3785.5n 0.9 3785.55n 0 3854n 0 3854.05n 0.9 3855.5n 0.9 3855.55n 0 3859n 0 3859.05n 0.9 3860.5n 0.9 3860.55n 0 3869n 0 3869.05n 0.9 3870.5n 0.9 3870.55n 0 3874n 0 3874.05n 0.9 3875.5n 0.9 3875.55n 0 3889n 0 3889.05n 0.9 3890.5n 0.9 3890.55n 0 3954n 0 3954.05n 0.9 3955.5n 0.9 3955.55n 0 3959n 0 3959.05n 0.9 3960.5n 0.9 3960.55n 0 3969n 0 3969.05n 0.9 3970.5n 0.9 3970.55n 0 3974n 0 3974.05n 0.9 3975.5n 0.9 3975.55n 0 4054n 0 4054.05n 0.9 4055.5n 0.9 4055.55n 0 4059n 0 4059.05n 0.9 4060.5n 0.9 4060.55n 0 4069n 0 4069.05n 0.9 4070.5n 0.9 4070.55n 0 4079n 0 4079.05n 0.9 4080.5n 0.9 4080.55n 0 4084n 0 4084.05n 0.9 4085.5n 0.9 4085.55n 0 4089n 0 4089.05n 0.9 4090.5n 0.9 4090.55n 0 4154n 0 4154.05n 0.9 4155.5n 0.9 4155.55n 0 4159n 0 4159.05n 0.9 4160.5n 0.9 4160.55n 0 4169n 0 4169.05n 0.9 4170.5n 0.9 4170.55n 0 4179n 0 4179.05n 0.9 4180.5n 0.9 4180.55n 0 4184n 0 4184.05n 0.9 4185.5n 0.9 4185.55n 0 4254n 0 4254.05n 0.9 4255.5n 0.9 4255.55n 0 4259n 0 4259.05n 0.9 4260.5n 0.9 4260.55n 0 4269n 0 4269.05n 0.9 4270.5n 0.9 4270.55n 0 4279n 0 4279.05n 0.9 4280.5n 0.9 4280.55n 0 4289n 0 4289.05n 0.9 4290.5n 0.9 4290.55n 0 4354n 0 4354.05n 0.9 4355.5n 0.9 4355.55n 0 4359n 0 4359.05n 0.9 4360.5n 0.9 4360.55n 0 4369n 0 4369.05n 0.9 4370.5n 0.9 4370.55n 0 4379n 0 4379.05n 0.9 4380.5n 0.9 4380.55n 0 4454n 0 4454.05n 0.9 4455.5n 0.9 4455.55n 0 4459n 0 4459.05n 0.9 4460.5n 0.9 4460.55n 0 4469n 0 4469.05n 0.9 4470.5n 0.9 4470.55n 0 4484n 0 4484.05n 0.9 4485.5n 0.9 4485.55n 0 4489n 0 4489.05n 0.9 4490.5n 0.9 4490.55n 0 4554n 0 4554.05n 0.9 4555.5n 0.9 4555.55n 0 4559n 0 4559.05n 0.9 4560.5n 0.9 4560.55n 0 4569n 0 4569.05n 0.9 4570.5n 0.9 4570.55n 0 4584n 0 4584.05n 0.9 4585.5n 0.9 4585.55n 0 4654n 0 4654.05n 0.9 4655.5n 0.9 4655.55n 0 4659n 0 4659.05n 0.9 4660.5n 0.9 4660.55n 0 4669n 0 4669.05n 0.9 4670.5n 0.9 4670.55n 0 4689n 0 4689.05n 0.9 4690.5n 0.9 4690.55n 0 4754n 0 4754.05n 0.9 4755.5n 0.9 4755.55n 0 4759n 0 4759.05n 0.9 4760.5n 0.9 4760.55n 0 4769n 0 4769.05n 0.9 4770.5n 0.9 4770.55n 0 4854n 0 4854.05n 0.9 4855.5n 0.9 4855.55n 0 4859n 0 4859.05n 0.9 4860.5n 0.9 4860.55n 0 4874n 0 4874.05n 0.9 4875.5n 0.9 4875.55n 0 4879n 0 4879.05n 0.9 4880.5n 0.9 4880.55n 0 4884n 0 4884.05n 0.9 4885.5n 0.9 4885.55n 0 4889n 0 4889.05n 0.9 4890.5n 0.9 4890.55n 0 4954n 0 4954.05n 0.9 4955.5n 0.9 4955.55n 0 4959n 0 4959.05n 0.9 4960.5n 0.9 4960.55n 0 4974n 0 4974.05n 0.9 4975.5n 0.9 4975.55n 0 4979n 0 4979.05n 0.9 4980.5n 0.9 4980.55n 0 4984n 0 4984.05n 0.9 4985.5n 0.9 4985.55n 0 5054n 0 5054.05n 0.9 5055.5n 0.9 5055.55n 0 5059n 0 5059.05n 0.9 5060.5n 0.9 5060.55n 0 5074n 0 5074.05n 0.9 5075.5n 0.9 5075.55n 0 5079n 0 5079.05n 0.9 5080.5n 0.9 5080.55n 0 5089n 0 5089.05n 0.9 5090.5n 0.9 5090.55n 0 5154n 0 5154.05n 0.9 5155.5n 0.9 5155.55n 0 5159n 0 5159.05n 0.9 5160.5n 0.9 5160.55n 0 5174n 0 5174.05n 0.9 5175.5n 0.9 5175.55n 0 5179n 0 5179.05n 0.9 5180.5n 0.9 5180.55n 0 5254n 0 5254.05n 0.9 5255.5n 0.9 5255.55n 0 5259n 0 5259.05n 0.9 5260.5n 0.9 5260.55n 0 5274n 0 5274.05n 0.9 5275.5n 0.9 5275.55n 0 5284n 0 5284.05n 0.9 5285.5n 0.9 5285.55n 0 5289n 0 5289.05n 0.9 5290.5n 0.9 5290.55n 0 5354n 0 5354.05n 0.9 5355.5n 0.9 5355.55n 0 5359n 0 5359.05n 0.9 5360.5n 0.9 5360.55n 0 5374n 0 5374.05n 0.9 5375.5n 0.9 5375.55n 0 5384n 0 5384.05n 0.9 5385.5n 0.9 5385.55n 0 5454n 0 5454.05n 0.9 5455.5n 0.9 5455.55n 0 5459n 0 5459.05n 0.9 5460.5n 0.9 5460.55n 0 5474n 0 5474.05n 0.9 5475.5n 0.9 5475.55n 0 5489n 0 5489.05n 0.9 5490.5n 0.9 5490.55n 0 5554n 0 5554.05n 0.9 5555.5n 0.9 5555.55n 0 5559n 0 5559.05n 0.9 5560.5n 0.9 5560.55n 0 5574n 0 5574.05n 0.9 5575.5n 0.9 5575.55n 0 5654n 0 5654.05n 0.9 5655.5n 0.9 5655.55n 0 5659n 0 5659.05n 0.9 5660.5n 0.9 5660.55n 0 5679n 0 5679.05n 0.9 5680.5n 0.9 5680.55n 0 5684n 0 5684.05n 0.9 5685.5n 0.9 5685.55n 0 5689n 0 5689.05n 0.9 5690.5n 0.9 5690.55n 0 5754n 0 5754.05n 0.9 5755.5n 0.9 5755.55n 0 5759n 0 5759.05n 0.9 5760.5n 0.9 5760.55n 0 5779n 0 5779.05n 0.9 5780.5n 0.9 5780.55n 0 5784n 0 5784.05n 0.9 5785.5n 0.9 5785.55n 0 5854n 0 5854.05n 0.9 5855.5n 0.9 5855.55n 0 5859n 0 5859.05n 0.9 5860.5n 0.9 5860.55n 0 5879n 0 5879.05n 0.9 5880.5n 0.9 5880.55n 0 5889n 0 5889.05n 0.9 5890.5n 0.9 5890.55n 0 5954n 0 5954.05n 0.9 5955.5n 0.9 5955.55n 0 5959n 0 5959.05n 0.9 5960.5n 0.9 5960.55n 0 5979n 0 5979.05n 0.9 5980.5n 0.9 5980.55n 0 6054n 0 6054.05n 0.9 6055.5n 0.9 6055.55n 0 6059n 0 6059.05n 0.9 6060.5n 0.9 6060.55n 0 6084n 0 6084.05n 0.9 6085.5n 0.9 6085.55n 0 6089n 0 6089.05n 0.9 6090.5n 0.9 6090.55n 0 6154n 0 6154.05n 0.9 6155.5n 0.9 6155.55n 0 6159n 0 6159.05n 0.9 6160.5n 0.9 6160.55n 0 6184n 0 6184.05n 0.9 6185.5n 0.9 6185.55n 0 6254n 0 6254.05n 0.9 6255.5n 0.9 6255.55n 0 6259n 0 6259.05n 0.9 6260.5n 0.9 6260.55n 0 6289n 0 6289.05n 0.9 6290.5n 0.9 6290.55n 0 6354n 0 6354.05n 0.9 6355.5n 0.9 6355.55n 0 6359n 0 6359.05n 0.9 6360.5n 0.9 6360.55n 0 6454n 0 6454.05n 0.9 6455.5n 0.9 6455.55n 0 6464n 0 6464.05n 0.9 6465.5n 0.9 6465.55n 0 6469n 0 6469.05n 0.9 6470.5n 0.9 6470.55n 0 6474n 0 6474.05n 0.9 6475.5n 0.9 6475.55n 0 6479n 0 6479.05n 0.9 6480.5n 0.9 6480.55n 0 6484n 0 6484.05n 0.9 6485.5n 0.9 6485.55n 0 6489n 0 6489.05n 0.9 6490.5n 0.9 6490.55n 0 6554n 0 6554.05n 0.9 6555.5n 0.9 6555.55n 0 6564n 0 6564.05n 0.9 6565.5n 0.9 6565.55n 0 6569n 0 6569.05n 0.9 6570.5n 0.9 6570.55n 0 6574n 0 6574.05n 0.9 6575.5n 0.9 6575.55n 0 6579n 0 6579.05n 0.9 6580.5n 0.9 6580.55n 0 6584n 0 6584.05n 0.9 6585.5n 0.9 6585.55n 0 6654n 0 6654.05n 0.9 6655.5n 0.9 6655.55n 0 6664n 0 6664.05n 0.9 6665.5n 0.9 6665.55n 0 6669n 0 6669.05n 0.9 6670.5n 0.9 6670.55n 0 6674n 0 6674.05n 0.9 6675.5n 0.9 6675.55n 0 6679n 0 6679.05n 0.9 6680.5n 0.9 6680.55n 0 6689n 0 6689.05n 0.9 6690.5n 0.9 6690.55n 0 6754n 0 6754.05n 0.9 6755.5n 0.9 6755.55n 0 6764n 0 6764.05n 0.9 6765.5n 0.9 6765.55n 0 6769n 0 6769.05n 0.9 6770.5n 0.9 6770.55n 0 6774n 0 6774.05n 0.9 6775.5n 0.9 6775.55n 0 6779n 0 6779.05n 0.9 6780.5n 0.9 6780.55n 0 6854n 0 6854.05n 0.9 6855.5n 0.9 6855.55n 0 6864n 0 6864.05n 0.9 6865.5n 0.9 6865.55n 0 6869n 0 6869.05n 0.9 6870.5n 0.9 6870.55n 0 6874n 0 6874.05n 0.9 6875.5n 0.9 6875.55n 0 6884n 0 6884.05n 0.9 6885.5n 0.9 6885.55n 0 6889n 0 6889.05n 0.9 6890.5n 0.9 6890.55n 0 6954n 0 6954.05n 0.9 6955.5n 0.9 6955.55n 0 6964n 0 6964.05n 0.9 6965.5n 0.9 6965.55n 0 6969n 0 6969.05n 0.9 6970.5n 0.9 6970.55n 0 6974n 0 6974.05n 0.9 6975.5n 0.9 6975.55n 0 6984n 0 6984.05n 0.9 6985.5n 0.9 6985.55n 0 7054n 0 7054.05n 0.9 7055.5n 0.9 7055.55n 0 7064n 0 7064.05n 0.9 7065.5n 0.9 7065.55n 0 7069n 0 7069.05n 0.9 7070.5n 0.9 7070.55n 0 7074n 0 7074.05n 0.9 7075.5n 0.9 7075.55n 0 7089n 0 7089.05n 0.9 7090.5n 0.9 7090.55n 0 7154n 0 7154.05n 0.9 7155.5n 0.9 7155.55n 0 7164n 0 7164.05n 0.9 7165.5n 0.9 7165.55n 0 7169n 0 7169.05n 0.9 7170.5n 0.9 7170.55n 0 7174n 0 7174.05n 0.9 7175.5n 0.9 7175.55n 0 7254n 0 7254.05n 0.9 7255.5n 0.9 7255.55n 0 7264n 0 7264.05n 0.9 7265.5n 0.9 7265.55n 0 7269n 0 7269.05n 0.9 7270.5n 0.9 7270.55n 0 7279n 0 7279.05n 0.9 7280.5n 0.9 7280.55n 0 7284n 0 7284.05n 0.9 7285.5n 0.9 7285.55n 0 7289n 0 7289.05n 0.9 7290.5n 0.9 7290.55n 0 7354n 0 7354.05n 0.9 7355.5n 0.9 7355.55n 0 7364n 0 7364.05n 0.9 7365.5n 0.9 7365.55n 0 7369n 0 7369.05n 0.9 7370.5n 0.9 7370.55n 0 7379n 0 7379.05n 0.9 7380.5n 0.9 7380.55n 0 7384n 0 7384.05n 0.9 7385.5n 0.9 7385.55n 0 7454n 0 7454.05n 0.9 7455.5n 0.9 7455.55n 0 7464n 0 7464.05n 0.9 7465.5n 0.9 7465.55n 0 7469n 0 7469.05n 0.9 7470.5n 0.9 7470.55n 0 7479n 0 7479.05n 0.9 7480.5n 0.9 7480.55n 0 7489n 0 7489.05n 0.9 7490.5n 0.9 7490.55n 0 7554n 0 7554.05n 0.9 7555.5n 0.9 7555.55n 0 7564n 0 7564.05n 0.9 7565.5n 0.9 7565.55n 0 7569n 0 7569.05n 0.9 7570.5n 0.9 7570.55n 0 7579n 0 7579.05n 0.9 7580.5n 0.9 7580.55n 0 7654n 0 7654.05n 0.9 7655.5n 0.9 7655.55n 0 7664n 0 7664.05n 0.9 7665.5n 0.9 7665.55n 0 7669n 0 7669.05n 0.9 7670.5n 0.9 7670.55n 0 7684n 0 7684.05n 0.9 7685.5n 0.9 7685.55n 0 7689n 0 7689.05n 0.9 7690.5n 0.9 7690.55n 0 7754n 0 7754.05n 0.9 7755.5n 0.9 7755.55n 0 7764n 0 7764.05n 0.9 7765.5n 0.9 7765.55n 0 7769n 0 7769.05n 0.9 7770.5n 0.9 7770.55n 0 7784n 0 7784.05n 0.9 7785.5n 0.9 7785.55n 0 7854n 0 7854.05n 0.9 7855.5n 0.9 7855.55n 0 7864n 0 7864.05n 0.9 7865.5n 0.9 7865.55n 0 7869n 0 7869.05n 0.9 7870.5n 0.9 7870.55n 0 7889n 0 7889.05n 0.9 7890.5n 0.9 7890.55n 0 7954n 0 7954.05n 0.9 7955.5n 0.9 7955.55n 0 7964n 0 7964.05n 0.9 7965.5n 0.9 7965.55n 0 7969n 0 7969.05n 0.9 7970.5n 0.9 7970.55n 0 8054n 0 8054.05n 0.9 8055.5n 0.9 8055.55n 0 8064n 0 8064.05n 0.9 8065.5n 0.9 8065.55n 0 8074n 0 8074.05n 0.9 8075.5n 0.9 8075.55n 0 8079n 0 8079.05n 0.9 8080.5n 0.9 8080.55n 0 8084n 0 8084.05n 0.9 8085.5n 0.9 8085.55n 0 8089n 0 8089.05n 0.9 8090.5n 0.9 8090.55n 0 8154n 0 8154.05n 0.9 8155.5n 0.9 8155.55n 0 8164n 0 8164.05n 0.9 8165.5n 0.9 8165.55n 0 8174n 0 8174.05n 0.9 8175.5n 0.9 8175.55n 0 8179n 0 8179.05n 0.9 8180.5n 0.9 8180.55n 0 8184n 0 8184.05n 0.9 8185.5n 0.9 8185.55n 0 8254n 0 8254.05n 0.9 8255.5n 0.9 8255.55n 0 8264n 0 8264.05n 0.9 8265.5n 0.9 8265.55n 0 8274n 0 8274.05n 0.9 8275.5n 0.9 8275.55n 0 8279n 0 8279.05n 0.9 8280.5n 0.9 8280.55n 0 8289n 0 8289.05n 0.9 8290.5n 0.9 8290.55n 0 8354n 0 8354.05n 0.9 8355.5n 0.9 8355.55n 0 8364n 0 8364.05n 0.9 8365.5n 0.9 8365.55n 0 8374n 0 8374.05n 0.9 8375.5n 0.9 8375.55n 0 8379n 0 8379.05n 0.9 8380.5n 0.9 8380.55n 0 8454n 0 8454.05n 0.9 8455.5n 0.9 8455.55n 0 8464n 0 8464.05n 0.9 8465.5n 0.9 8465.55n 0 8474n 0 8474.05n 0.9 8475.5n 0.9 8475.55n 0 8484n 0 8484.05n 0.9 8485.5n 0.9 8485.55n 0 8489n 0 8489.05n 0.9 8490.5n 0.9 8490.55n 0 8554n 0 8554.05n 0.9 8555.5n 0.9 8555.55n 0 8564n 0 8564.05n 0.9 8565.5n 0.9 8565.55n 0 8574n 0 8574.05n 0.9 8575.5n 0.9 8575.55n 0 8584n 0 8584.05n 0.9 8585.5n 0.9 8585.55n 0 8654n 0 8654.05n 0.9 8655.5n 0.9 8655.55n 0 8664n 0 8664.05n 0.9 8665.5n 0.9 8665.55n 0 8674n 0 8674.05n 0.9 8675.5n 0.9 8675.55n 0 8689n 0 8689.05n 0.9 8690.5n 0.9 8690.55n 0 8754n 0 8754.05n 0.9 8755.5n 0.9 8755.55n 0 8764n 0 8764.05n 0.9 8765.5n 0.9 8765.55n 0 8774n 0 8774.05n 0.9 8775.5n 0.9 8775.55n 0 8854n 0 8854.05n 0.9 8855.5n 0.9 8855.55n 0 8864n 0 8864.05n 0.9 8865.5n 0.9 8865.55n 0 8879n 0 8879.05n 0.9 8880.5n 0.9 8880.55n 0 8884n 0 8884.05n 0.9 8885.5n 0.9 8885.55n 0 8889n 0 8889.05n 0.9 8890.5n 0.9 8890.55n 0 8954n 0 8954.05n 0.9 8955.5n 0.9 8955.55n 0 8964n 0 8964.05n 0.9 8965.5n 0.9 8965.55n 0 8979n 0 8979.05n 0.9 8980.5n 0.9 8980.55n 0 8984n 0 8984.05n 0.9 8985.5n 0.9 8985.55n 0 9054n 0 9054.05n 0.9 9055.5n 0.9 9055.55n 0 9064n 0 9064.05n 0.9 9065.5n 0.9 9065.55n 0 9079n 0 9079.05n 0.9 9080.5n 0.9 9080.55n 0 9089n 0 9089.05n 0.9 9090.5n 0.9 9090.55n 0 9154n 0 9154.05n 0.9 9155.5n 0.9 9155.55n 0 9164n 0 9164.05n 0.9 9165.5n 0.9 9165.55n 0 9179n 0 9179.05n 0.9 9180.5n 0.9 9180.55n 0 9254n 0 9254.05n 0.9 9255.5n 0.9 9255.55n 0 9264n 0 9264.05n 0.9 9265.5n 0.9 9265.55n 0 9284n 0 9284.05n 0.9 9285.5n 0.9 9285.55n 0 9289n 0 9289.05n 0.9 9290.5n 0.9 9290.55n 0 9354n 0 9354.05n 0.9 9355.5n 0.9 9355.55n 0 9364n 0 9364.05n 0.9 9365.5n 0.9 9365.55n 0 9384n 0 9384.05n 0.9 9385.5n 0.9 9385.55n 0 9454n 0 9454.05n 0.9 9455.5n 0.9 9455.55n 0 9464n 0 9464.05n 0.9 9465.5n 0.9 9465.55n 0 9489n 0 9489.05n 0.9 9490.5n 0.9 9490.55n 0 9554n 0 9554.05n 0.9 9555.5n 0.9 9555.55n 0 9564n 0 9564.05n 0.9 9565.5n 0.9 9565.55n 0 9654n 0 9654.05n 0.9 9655.5n 0.9 9655.55n 0 9669n 0 9669.05n 0.9 9670.5n 0.9 9670.55n 0 9674n 0 9674.05n 0.9 9675.5n 0.9 9675.55n 0 9679n 0 9679.05n 0.9 9680.5n 0.9 9680.55n 0 9684n 0 9684.05n 0.9 9685.5n 0.9 9685.55n 0 9689n 0 9689.05n 0.9 9690.5n 0.9 9690.55n 0 9754n 0 9754.05n 0.9 9755.5n 0.9 9755.55n 0 9769n 0 9769.05n 0.9 9770.5n 0.9 9770.55n 0 9774n 0 9774.05n 0.9 9775.5n 0.9 9775.55n 0 9779n 0 9779.05n 0.9 9780.5n 0.9 9780.55n 0 9784n 0 9784.05n 0.9 9785.5n 0.9 9785.55n 0 9854n 0 9854.05n 0.9 9855.5n 0.9 9855.55n 0 9869n 0 9869.05n 0.9 9870.5n 0.9 9870.55n 0 9874n 0 9874.05n 0.9 9875.5n 0.9 9875.55n 0 9879n 0 9879.05n 0.9 9880.5n 0.9 9880.55n 0 9889n 0 9889.05n 0.9 9890.5n 0.9 9890.55n 0 9954n 0 9954.05n 0.9 9955.5n 0.9 9955.55n 0 9969n 0 9969.05n 0.9 9970.5n 0.9 9970.55n 0 9974n 0 9974.05n 0.9 9975.5n 0.9 9975.55n 0 9979n 0 9979.05n 0.9 9980.5n 0.9 9980.55n 0 10054n 0 10054.05n 0.9 10055.5n 0.9 10055.55n 0 10069n 0 10069.05n 0.9 10070.5n 0.9 10070.55n 0 10074n 0 10074.05n 0.9 10075.5n 0.9 10075.55n 0 10084n 0 10084.05n 0.9 10085.5n 0.9 10085.55n 0 10089n 0 10089.05n 0.9 10090.5n 0.9 10090.55n 0 10154n 0 10154.05n 0.9 10155.5n 0.9 10155.55n 0 10169n 0 10169.05n 0.9 10170.5n 0.9 10170.55n 0 10174n 0 10174.05n 0.9 10175.5n 0.9 10175.55n 0 10184n 0 10184.05n 0.9 10185.5n 0.9 10185.55n 0 10254n 0 10254.05n 0.9 10255.5n 0.9 10255.55n 0 10269n 0 10269.05n 0.9 10270.5n 0.9 10270.55n 0 10274n 0 10274.05n 0.9 10275.5n 0.9 10275.55n 0 10289n 0 10289.05n 0.9 10290.5n 0.9 10290.55n 0 10354n 0 10354.05n 0.9 10355.5n 0.9 10355.55n 0 10369n 0 10369.05n 0.9 10370.5n 0.9 10370.55n 0 10374n 0 10374.05n 0.9 10375.5n 0.9 10375.55n 0 10454n 0 10454.05n 0.9 10455.5n 0.9 10455.55n 0 10469n 0 10469.05n 0.9 10470.5n 0.9 10470.55n 0 10479n 0 10479.05n 0.9 10480.5n 0.9 10480.55n 0 10484n 0 10484.05n 0.9 10485.5n 0.9 10485.55n 0 10489n 0 10489.05n 0.9 10490.5n 0.9 10490.55n 0 10554n 0 10554.05n 0.9 10555.5n 0.9 10555.55n 0 10569n 0 10569.05n 0.9 10570.5n 0.9 10570.55n 0 10579n 0 10579.05n 0.9 10580.5n 0.9 10580.55n 0 10584n 0 10584.05n 0.9 10585.5n 0.9 10585.55n 0 10654n 0 10654.05n 0.9 10655.5n 0.9 10655.55n 0 10669n 0 10669.05n 0.9 10670.5n 0.9 10670.55n 0 10679n 0 10679.05n 0.9 10680.5n 0.9 10680.55n 0 10689n 0 10689.05n 0.9 10690.5n 0.9 10690.55n 0 10754n 0 10754.05n 0.9 10755.5n 0.9 10755.55n 0 10769n 0 10769.05n 0.9 10770.5n 0.9 10770.55n 0 10779n 0 10779.05n 0.9 10780.5n 0.9 10780.55n 0 10854n 0 10854.05n 0.9 10855.5n 0.9 10855.55n 0 10869n 0 10869.05n 0.9 10870.5n 0.9 10870.55n 0 10884n 0 10884.05n 0.9 10885.5n 0.9 10885.55n 0 10889n 0 10889.05n 0.9 10890.5n 0.9 10890.55n 0 10954n 0 10954.05n 0.9 10955.5n 0.9 10955.55n 0 10969n 0 10969.05n 0.9 10970.5n 0.9 10970.55n 0 10984n 0 10984.05n 0.9 10985.5n 0.9 10985.55n 0 11054n 0 11054.05n 0.9 11055.5n 0.9 11055.55n 0 11069n 0 11069.05n 0.9 11070.5n 0.9 11070.55n 0 11089n 0 11089.05n 0.9 11090.5n 0.9 11090.55n 0 11154n 0 11154.05n 0.9 11155.5n 0.9 11155.55n 0 11169n 0 11169.05n 0.9 11170.5n 0.9 11170.55n 0 11254n 0 11254.05n 0.9 11255.5n 0.9 11255.55n 0 11274n 0 11274.05n 0.9 11275.5n 0.9 11275.55n 0 11279n 0 11279.05n 0.9 11280.5n 0.9 11280.55n 0 11284n 0 11284.05n 0.9 11285.5n 0.9 11285.55n 0 11289n 0 11289.05n 0.9 11290.5n 0.9 11290.55n 0 11354n 0 11354.05n 0.9 11355.5n 0.9 11355.55n 0 11374n 0 11374.05n 0.9 11375.5n 0.9 11375.55n 0 11379n 0 11379.05n 0.9 11380.5n 0.9 11380.55n 0 11384n 0 11384.05n 0.9 11385.5n 0.9 11385.55n 0 11454n 0 11454.05n 0.9 11455.5n 0.9 11455.55n 0 11474n 0 11474.05n 0.9 11475.5n 0.9 11475.55n 0 11479n 0 11479.05n 0.9 11480.5n 0.9 11480.55n 0 11489n 0 11489.05n 0.9 11490.5n 0.9 11490.55n 0 11554n 0 11554.05n 0.9 11555.5n 0.9 11555.55n 0 11574n 0 11574.05n 0.9 11575.5n 0.9 11575.55n 0 11579n 0 11579.05n 0.9 11580.5n 0.9 11580.55n 0 11654n 0 11654.05n 0.9 11655.5n 0.9 11655.55n 0 11674n 0 11674.05n 0.9 11675.5n 0.9 11675.55n 0 11684n 0 11684.05n 0.9 11685.5n 0.9 11685.55n 0 11689n 0 11689.05n 0.9 11690.5n 0.9 11690.55n 0 11754n 0 11754.05n 0.9 11755.5n 0.9 11755.55n 0 11774n 0 11774.05n 0.9 11775.5n 0.9 11775.55n 0 11784n 0 11784.05n 0.9 11785.5n 0.9 11785.55n 0 11854n 0 11854.05n 0.9 11855.5n 0.9 11855.55n 0 11874n 0 11874.05n 0.9 11875.5n 0.9 11875.55n 0 11889n 0 11889.05n 0.9 11890.5n 0.9 11890.55n 0 11954n 0 11954.05n 0.9 11955.5n 0.9 11955.55n 0 11974n 0 11974.05n 0.9 11975.5n 0.9 11975.55n 0 12054n 0 12054.05n 0.9 12055.5n 0.9 12055.55n 0 12079n 0 12079.05n 0.9 12080.5n 0.9 12080.55n 0 12084n 0 12084.05n 0.9 12085.5n 0.9 12085.55n 0 12089n 0 12089.05n 0.9 12090.5n 0.9 12090.55n 0 12154n 0 12154.05n 0.9 12155.5n 0.9 12155.55n 0 12179n 0 12179.05n 0.9 12180.5n 0.9 12180.55n 0 12184n 0 12184.05n 0.9 12185.5n 0.9 12185.55n 0 12254n 0 12254.05n 0.9 12255.5n 0.9 12255.55n 0 12279n 0 12279.05n 0.9 12280.5n 0.9 12280.55n 0 12289n 0 12289.05n 0.9 12290.5n 0.9 12290.55n 0 12354n 0 12354.05n 0.9 12355.5n 0.9 12355.55n 0 12379n 0 12379.05n 0.9 12380.5n 0.9 12380.55n 0 12454n 0 12454.05n 0.9 12455.5n 0.9 12455.55n 0 12484n 0 12484.05n 0.9 12485.5n 0.9 12485.55n 0 12489n 0 12489.05n 0.9 12490.5n 0.9 12490.55n 0 12554n 0 12554.05n 0.9 12555.5n 0.9 12555.55n 0 12584n 0 12584.05n 0.9 12585.5n 0.9 12585.55n 0 12654n 0 12654.05n 0.9 12655.5n 0.9 12655.55n 0 12689n 0 12689.05n 0.9 12690.5n 0.9 12690.55n 0 12754n 0 12754.05n 0.9 12755.5n 0.9 12755.55n 0 12859n 0 12859.05n 0.9 12860.5n 0.9 12860.55n 0 12864n 0 12864.05n 0.9 12865.5n 0.9 12865.55n 0 12869n 0 12869.05n 0.9 12870.5n 0.9 12870.55n 0 12874n 0 12874.05n 0.9 12875.5n 0.9 12875.55n 0 12879n 0 12879.05n 0.9 12880.5n 0.9 12880.55n 0 12884n 0 12884.05n 0.9 12885.5n 0.9 12885.55n 0 12889n 0 12889.05n 0.9 12890.5n 0.9 12890.55n 0 12959n 0 12959.05n 0.9 12960.5n 0.9 12960.55n 0 12964n 0 12964.05n 0.9 12965.5n 0.9 12965.55n 0 12969n 0 12969.05n 0.9 12970.5n 0.9 12970.55n 0 12974n 0 12974.05n 0.9 12975.5n 0.9 12975.55n 0 12979n 0 12979.05n 0.9 12980.5n 0.9 12980.55n 0 12984n 0 12984.05n 0.9 12985.5n 0.9 12985.55n 0 13059n 0 13059.05n 0.9 13060.5n 0.9 13060.55n 0 13064n 0 13064.05n 0.9 13065.5n 0.9 13065.55n 0 13069n 0 13069.05n 0.9 13070.5n 0.9 13070.55n 0 13074n 0 13074.05n 0.9 13075.5n 0.9 13075.55n 0 13079n 0 13079.05n 0.9 13080.5n 0.9 13080.55n 0 13089n 0 13089.05n 0.9 13090.5n 0.9 13090.55n 0 13159n 0 13159.05n 0.9 13160.5n 0.9 13160.55n 0 13164n 0 13164.05n 0.9 13165.5n 0.9 13165.55n 0 13169n 0 13169.05n 0.9 13170.5n 0.9 13170.55n 0 13174n 0 13174.05n 0.9 13175.5n 0.9 13175.55n 0 13179n 0 13179.05n 0.9 13180.5n 0.9 13180.55n 0 13259n 0 13259.05n 0.9 13260.5n 0.9 13260.55n 0 13264n 0 13264.05n 0.9 13265.5n 0.9 13265.55n 0 13269n 0 13269.05n 0.9 13270.5n 0.9 13270.55n 0 13274n 0 13274.05n 0.9 13275.5n 0.9 13275.55n 0 13284n 0 13284.05n 0.9 13285.5n 0.9 13285.55n 0 13289n 0 13289.05n 0.9 13290.5n 0.9 13290.55n 0 13359n 0 13359.05n 0.9 13360.5n 0.9 13360.55n 0 13364n 0 13364.05n 0.9 13365.5n 0.9 13365.55n 0 13369n 0 13369.05n 0.9 13370.5n 0.9 13370.55n 0 13374n 0 13374.05n 0.9 13375.5n 0.9 13375.55n 0 13384n 0 13384.05n 0.9 13385.5n 0.9 13385.55n 0 13459n 0 13459.05n 0.9 13460.5n 0.9 13460.55n 0 13464n 0 13464.05n 0.9 13465.5n 0.9 13465.55n 0 13469n 0 13469.05n 0.9 13470.5n 0.9 13470.55n 0 13474n 0 13474.05n 0.9 13475.5n 0.9 13475.55n 0 13489n 0 13489.05n 0.9 13490.5n 0.9 13490.55n 0 13559n 0 13559.05n 0.9 13560.5n 0.9 13560.55n 0 13564n 0 13564.05n 0.9 13565.5n 0.9 13565.55n 0 13569n 0 13569.05n 0.9 13570.5n 0.9 13570.55n 0 13574n 0 13574.05n 0.9 13575.5n 0.9 13575.55n 0 13659n 0 13659.05n 0.9 13660.5n 0.9 13660.55n 0 13664n 0 13664.05n 0.9 13665.5n 0.9 13665.55n 0 13669n 0 13669.05n 0.9 13670.5n 0.9 13670.55n 0 13679n 0 13679.05n 0.9 13680.5n 0.9 13680.55n 0 13684n 0 13684.05n 0.9 13685.5n 0.9 13685.55n 0 13689n 0 13689.05n 0.9 13690.5n 0.9 13690.55n 0 13759n 0 13759.05n 0.9 13760.5n 0.9 13760.55n 0 13764n 0 13764.05n 0.9 13765.5n 0.9 13765.55n 0 13769n 0 13769.05n 0.9 13770.5n 0.9 13770.55n 0 13779n 0 13779.05n 0.9 13780.5n 0.9 13780.55n 0 13784n 0 13784.05n 0.9 13785.5n 0.9 13785.55n 0 13859n 0 13859.05n 0.9 13860.5n 0.9 13860.55n 0 13864n 0 13864.05n 0.9 13865.5n 0.9 13865.55n 0 13869n 0 13869.05n 0.9 13870.5n 0.9 13870.55n 0 13879n 0 13879.05n 0.9 13880.5n 0.9 13880.55n 0 13889n 0 13889.05n 0.9 13890.5n 0.9 13890.55n 0 13959n 0 13959.05n 0.9 13960.5n 0.9 13960.55n 0 13964n 0 13964.05n 0.9 13965.5n 0.9 13965.55n 0 13969n 0 13969.05n 0.9 13970.5n 0.9 13970.55n 0 13979n 0 13979.05n 0.9 13980.5n 0.9 13980.55n 0 14059n 0 14059.05n 0.9 14060.5n 0.9 14060.55n 0 14064n 0 14064.05n 0.9 14065.5n 0.9 14065.55n 0 14069n 0 14069.05n 0.9 14070.5n 0.9 14070.55n 0 14084n 0 14084.05n 0.9 14085.5n 0.9 14085.55n 0 14089n 0 14089.05n 0.9 14090.5n 0.9 14090.55n 0 14159n 0 14159.05n 0.9 14160.5n 0.9 14160.55n 0 14164n 0 14164.05n 0.9 14165.5n 0.9 14165.55n 0 14169n 0 14169.05n 0.9 14170.5n 0.9 14170.55n 0 14184n 0 14184.05n 0.9 14185.5n 0.9 14185.55n 0 14259n 0 14259.05n 0.9 14260.5n 0.9 14260.55n 0 14264n 0 14264.05n 0.9 14265.5n 0.9 14265.55n 0 14269n 0 14269.05n 0.9 14270.5n 0.9 14270.55n 0 14289n 0 14289.05n 0.9 14290.5n 0.9 14290.55n 0 14359n 0 14359.05n 0.9 14360.5n 0.9 14360.55n 0 14364n 0 14364.05n 0.9 14365.5n 0.9 14365.55n 0 14369n 0 14369.05n 0.9 14370.5n 0.9 14370.55n 0 14459n 0 14459.05n 0.9 14460.5n 0.9 14460.55n 0 14464n 0 14464.05n 0.9 14465.5n 0.9 14465.55n 0 14474n 0 14474.05n 0.9 14475.5n 0.9 14475.55n 0 14479n 0 14479.05n 0.9 14480.5n 0.9 14480.55n 0 14484n 0 14484.05n 0.9 14485.5n 0.9 14485.55n 0 14489n 0 14489.05n 0.9 14490.5n 0.9 14490.55n 0 14559n 0 14559.05n 0.9 14560.5n 0.9 14560.55n 0 14564n 0 14564.05n 0.9 14565.5n 0.9 14565.55n 0 14574n 0 14574.05n 0.9 14575.5n 0.9 14575.55n 0 14579n 0 14579.05n 0.9 14580.5n 0.9 14580.55n 0 14584n 0 14584.05n 0.9 14585.5n 0.9 14585.55n 0 14659n 0 14659.05n 0.9 14660.5n 0.9 14660.55n 0 14664n 0 14664.05n 0.9 14665.5n 0.9 14665.55n 0 14674n 0 14674.05n 0.9 14675.5n 0.9 14675.55n 0 14679n 0 14679.05n 0.9 14680.5n 0.9 14680.55n 0 14689n 0 14689.05n 0.9 14690.5n 0.9 14690.55n 0 14759n 0 14759.05n 0.9 14760.5n 0.9 14760.55n 0 14764n 0 14764.05n 0.9 14765.5n 0.9 14765.55n 0 14774n 0 14774.05n 0.9 14775.5n 0.9 14775.55n 0 14779n 0 14779.05n 0.9 14780.5n 0.9 14780.55n 0 14859n 0 14859.05n 0.9 14860.5n 0.9 14860.55n 0 14864n 0 14864.05n 0.9 14865.5n 0.9 14865.55n 0 14874n 0 14874.05n 0.9 14875.5n 0.9 14875.55n 0 14884n 0 14884.05n 0.9 14885.5n 0.9 14885.55n 0 14889n 0 14889.05n 0.9 14890.5n 0.9 14890.55n 0 14959n 0 14959.05n 0.9 14960.5n 0.9 14960.55n 0 14964n 0 14964.05n 0.9 14965.5n 0.9 14965.55n 0 14974n 0 14974.05n 0.9 14975.5n 0.9 14975.55n 0 14984n 0 14984.05n 0.9 14985.5n 0.9 14985.55n 0 15059n 0 15059.05n 0.9 15060.5n 0.9 15060.55n 0 15064n 0 15064.05n 0.9 15065.5n 0.9 15065.55n 0 15074n 0 15074.05n 0.9 15075.5n 0.9 15075.55n 0 15089n 0 15089.05n 0.9 15090.5n 0.9 15090.55n 0 15159n 0 15159.05n 0.9 15160.5n 0.9 15160.55n 0 15164n 0 15164.05n 0.9 15165.5n 0.9 15165.55n 0 15174n 0 15174.05n 0.9 15175.5n 0.9 15175.55n 0 15259n 0 15259.05n 0.9 15260.5n 0.9 15260.55n 0 15264n 0 15264.05n 0.9 15265.5n 0.9 15265.55n 0 15279n 0 15279.05n 0.9 15280.5n 0.9 15280.55n 0 15284n 0 15284.05n 0.9 15285.5n 0.9 15285.55n 0 15289n 0 15289.05n 0.9 15290.5n 0.9 15290.55n 0 15359n 0 15359.05n 0.9 15360.5n 0.9 15360.55n 0 15364n 0 15364.05n 0.9 15365.5n 0.9 15365.55n 0 15379n 0 15379.05n 0.9 15380.5n 0.9 15380.55n 0 15384n 0 15384.05n 0.9 15385.5n 0.9 15385.55n 0 15459n 0 15459.05n 0.9 15460.5n 0.9 15460.55n 0 15464n 0 15464.05n 0.9 15465.5n 0.9 15465.55n 0 15479n 0 15479.05n 0.9 15480.5n 0.9 15480.55n 0 15489n 0 15489.05n 0.9 15490.5n 0.9 15490.55n 0 15559n 0 15559.05n 0.9 15560.5n 0.9 15560.55n 0 15564n 0 15564.05n 0.9 15565.5n 0.9 15565.55n 0 15579n 0 15579.05n 0.9 15580.5n 0.9 15580.55n 0 15659n 0 15659.05n 0.9 15660.5n 0.9 15660.55n 0 15664n 0 15664.05n 0.9 15665.5n 0.9 15665.55n 0 15684n 0 15684.05n 0.9 15685.5n 0.9 15685.55n 0 15689n 0 15689.05n 0.9 15690.5n 0.9 15690.55n 0 15759n 0 15759.05n 0.9 15760.5n 0.9 15760.55n 0 15764n 0 15764.05n 0.9 15765.5n 0.9 15765.55n 0 15784n 0 15784.05n 0.9 15785.5n 0.9 15785.55n 0 15859n 0 15859.05n 0.9 15860.5n 0.9 15860.55n 0 15864n 0 15864.05n 0.9 15865.5n 0.9 15865.55n 0 15889n 0 15889.05n 0.9 15890.5n 0.9 15890.55n 0 15959n 0 15959.05n 0.9 15960.5n 0.9 15960.55n 0 15964n 0 15964.05n 0.9 15965.5n 0.9 15965.55n 0 16059n 0 16059.05n 0.9 16060.5n 0.9 16060.55n 0 16069n 0 16069.05n 0.9 16070.5n 0.9 16070.55n 0 16074n 0 16074.05n 0.9 16075.5n 0.9 16075.55n 0 16079n 0 16079.05n 0.9 16080.5n 0.9 16080.55n 0 16084n 0 16084.05n 0.9 16085.5n 0.9 16085.55n 0 16089n 0 16089.05n 0.9 16090.5n 0.9 16090.55n 0 16159n 0 16159.05n 0.9 16160.5n 0.9 16160.55n 0 16169n 0 16169.05n 0.9 16170.5n 0.9 16170.55n 0 16174n 0 16174.05n 0.9 16175.5n 0.9 16175.55n 0 16179n 0 16179.05n 0.9 16180.5n 0.9 16180.55n 0 16184n 0 16184.05n 0.9 16185.5n 0.9 16185.55n 0 16259n 0 16259.05n 0.9 16260.5n 0.9 16260.55n 0 16269n 0 16269.05n 0.9 16270.5n 0.9 16270.55n 0 16274n 0 16274.05n 0.9 16275.5n 0.9 16275.55n 0 16279n 0 16279.05n 0.9 16280.5n 0.9 16280.55n 0 16289n 0 16289.05n 0.9 16290.5n 0.9 16290.55n 0 16359n 0 16359.05n 0.9 16360.5n 0.9 16360.55n 0 16369n 0 16369.05n 0.9 16370.5n 0.9 16370.55n 0 16374n 0 16374.05n 0.9 16375.5n 0.9 16375.55n 0 16379n 0 16379.05n 0.9 16380.5n 0.9 16380.55n 0 16459n 0 16459.05n 0.9 16460.5n 0.9 16460.55n 0 16469n 0 16469.05n 0.9 16470.5n 0.9 16470.55n 0 16474n 0 16474.05n 0.9 16475.5n 0.9 16475.55n 0 16484n 0 16484.05n 0.9 16485.5n 0.9 16485.55n 0 16489n 0 16489.05n 0.9 16490.5n 0.9 16490.55n 0 16559n 0 16559.05n 0.9 16560.5n 0.9 16560.55n 0 16569n 0 16569.05n 0.9 16570.5n 0.9 16570.55n 0 16574n 0 16574.05n 0.9 16575.5n 0.9 16575.55n 0 16584n 0 16584.05n 0.9 16585.5n 0.9 16585.55n 0 16659n 0 16659.05n 0.9 16660.5n 0.9 16660.55n 0 16669n 0 16669.05n 0.9 16670.5n 0.9 16670.55n 0 16674n 0 16674.05n 0.9 16675.5n 0.9 16675.55n 0 16689n 0 16689.05n 0.9 16690.5n 0.9 16690.55n 0 16759n 0 16759.05n 0.9 16760.5n 0.9 16760.55n 0 16769n 0 16769.05n 0.9 16770.5n 0.9 16770.55n 0 16774n 0 16774.05n 0.9 16775.5n 0.9 16775.55n 0 16859n 0 16859.05n 0.9 16860.5n 0.9 16860.55n 0 16869n 0 16869.05n 0.9 16870.5n 0.9 16870.55n 0 16879n 0 16879.05n 0.9 16880.5n 0.9 16880.55n 0 16884n 0 16884.05n 0.9 16885.5n 0.9 16885.55n 0 16889n 0 16889.05n 0.9 16890.5n 0.9 16890.55n 0 16959n 0 16959.05n 0.9 16960.5n 0.9 16960.55n 0 16969n 0 16969.05n 0.9 16970.5n 0.9 16970.55n 0 16979n 0 16979.05n 0.9 16980.5n 0.9 16980.55n 0 16984n 0 16984.05n 0.9 16985.5n 0.9 16985.55n 0 17059n 0 17059.05n 0.9 17060.5n 0.9 17060.55n 0 17069n 0 17069.05n 0.9 17070.5n 0.9 17070.55n 0 17079n 0 17079.05n 0.9 17080.5n 0.9 17080.55n 0 17089n 0 17089.05n 0.9 17090.5n 0.9 17090.55n 0 17159n 0 17159.05n 0.9 17160.5n 0.9 17160.55n 0 17169n 0 17169.05n 0.9 17170.5n 0.9 17170.55n 0 17179n 0 17179.05n 0.9 17180.5n 0.9 17180.55n 0 17259n 0 17259.05n 0.9 17260.5n 0.9 17260.55n 0 17269n 0 17269.05n 0.9 17270.5n 0.9 17270.55n 0 17284n 0 17284.05n 0.9 17285.5n 0.9 17285.55n 0 17289n 0 17289.05n 0.9 17290.5n 0.9 17290.55n 0 17359n 0 17359.05n 0.9 17360.5n 0.9 17360.55n 0 17369n 0 17369.05n 0.9 17370.5n 0.9 17370.55n 0 17384n 0 17384.05n 0.9 17385.5n 0.9 17385.55n 0 17459n 0 17459.05n 0.9 17460.5n 0.9 17460.55n 0 17469n 0 17469.05n 0.9 17470.5n 0.9 17470.55n 0 17489n 0 17489.05n 0.9 17490.5n 0.9 17490.55n 0 17559n 0 17559.05n 0.9 17560.5n 0.9 17560.55n 0 17569n 0 17569.05n 0.9 17570.5n 0.9 17570.55n 0 17659n 0 17659.05n 0.9 17660.5n 0.9 17660.55n 0 17674n 0 17674.05n 0.9 17675.5n 0.9 17675.55n 0 17679n 0 17679.05n 0.9 17680.5n 0.9 17680.55n 0 17684n 0 17684.05n 0.9 17685.5n 0.9 17685.55n 0 17689n 0 17689.05n 0.9 17690.5n 0.9 17690.55n 0 17759n 0 17759.05n 0.9 17760.5n 0.9 17760.55n 0 17774n 0 17774.05n 0.9 17775.5n 0.9 17775.55n 0 17779n 0 17779.05n 0.9 17780.5n 0.9 17780.55n 0 17784n 0 17784.05n 0.9 17785.5n 0.9 17785.55n 0 17859n 0 17859.05n 0.9 17860.5n 0.9 17860.55n 0 17874n 0 17874.05n 0.9 17875.5n 0.9 17875.55n 0 17879n 0 17879.05n 0.9 17880.5n 0.9 17880.55n 0 17889n 0 17889.05n 0.9 17890.5n 0.9 17890.55n 0 17959n 0 17959.05n 0.9 17960.5n 0.9 17960.55n 0 17974n 0 17974.05n 0.9 17975.5n 0.9 17975.55n 0 17979n 0 17979.05n 0.9 17980.5n 0.9 17980.55n 0 18059n 0 18059.05n 0.9 18060.5n 0.9 18060.55n 0 18074n 0 18074.05n 0.9 18075.5n 0.9 18075.55n 0 18084n 0 18084.05n 0.9 18085.5n 0.9 18085.55n 0 18089n 0 18089.05n 0.9 18090.5n 0.9 18090.55n 0 18159n 0 18159.05n 0.9 18160.5n 0.9 18160.55n 0 18174n 0 18174.05n 0.9 18175.5n 0.9 18175.55n 0 18184n 0 18184.05n 0.9 18185.5n 0.9 18185.55n 0 18259n 0 18259.05n 0.9 18260.5n 0.9 18260.55n 0 18274n 0 18274.05n 0.9 18275.5n 0.9 18275.55n 0 18289n 0 18289.05n 0.9 18290.5n 0.9 18290.55n 0 18359n 0 18359.05n 0.9 18360.5n 0.9 18360.55n 0 18374n 0 18374.05n 0.9 18375.5n 0.9 18375.55n 0 18459n 0 18459.05n 0.9 18460.5n 0.9 18460.55n 0 18479n 0 18479.05n 0.9 18480.5n 0.9 18480.55n 0 18484n 0 18484.05n 0.9 18485.5n 0.9 18485.55n 0 18489n 0 18489.05n 0.9 18490.5n 0.9 18490.55n 0 18559n 0 18559.05n 0.9 18560.5n 0.9 18560.55n 0 18579n 0 18579.05n 0.9 18580.5n 0.9 18580.55n 0 18584n 0 18584.05n 0.9 18585.5n 0.9 18585.55n 0 18659n 0 18659.05n 0.9 18660.5n 0.9 18660.55n 0 18679n 0 18679.05n 0.9 18680.5n 0.9 18680.55n 0 18689n 0 18689.05n 0.9 18690.5n 0.9 18690.55n 0 18759n 0 18759.05n 0.9 18760.5n 0.9 18760.55n 0 18779n 0 18779.05n 0.9 18780.5n 0.9 18780.55n 0 18859n 0 18859.05n 0.9 18860.5n 0.9 18860.55n 0 18884n 0 18884.05n 0.9 18885.5n 0.9 18885.55n 0 18889n 0 18889.05n 0.9 18890.5n 0.9 18890.55n 0 18959n 0 18959.05n 0.9 18960.5n 0.9 18960.55n 0 18984n 0 18984.05n 0.9 18985.5n 0.9 18985.55n 0 19059n 0 19059.05n 0.9 19060.5n 0.9 19060.55n 0 19089n 0 19089.05n 0.9 19090.5n 0.9 19090.55n 0 19159n 0 19159.05n 0.9 19160.5n 0.9 19160.55n 0 19264n 0 19264.05n 0.9 19265.5n 0.9 19265.55n 0 19269n 0 19269.05n 0.9 19270.5n 0.9 19270.55n 0 19274n 0 19274.05n 0.9 19275.5n 0.9 19275.55n 0 19279n 0 19279.05n 0.9 19280.5n 0.9 19280.55n 0 19284n 0 19284.05n 0.9 19285.5n 0.9 19285.55n 0 19289n 0 19289.05n 0.9 19290.5n 0.9 19290.55n 0 19364n 0 19364.05n 0.9 19365.5n 0.9 19365.55n 0 19369n 0 19369.05n 0.9 19370.5n 0.9 19370.55n 0 19374n 0 19374.05n 0.9 19375.5n 0.9 19375.55n 0 19379n 0 19379.05n 0.9 19380.5n 0.9 19380.55n 0 19384n 0 19384.05n 0.9 19385.5n 0.9 19385.55n 0 19464n 0 19464.05n 0.9 19465.5n 0.9 19465.55n 0 19469n 0 19469.05n 0.9 19470.5n 0.9 19470.55n 0 19474n 0 19474.05n 0.9 19475.5n 0.9 19475.55n 0 19479n 0 19479.05n 0.9 19480.5n 0.9 19480.55n 0 19489n 0 19489.05n 0.9 19490.5n 0.9 19490.55n 0 19564n 0 19564.05n 0.9 19565.5n 0.9 19565.55n 0 19569n 0 19569.05n 0.9 19570.5n 0.9 19570.55n 0 19574n 0 19574.05n 0.9 19575.5n 0.9 19575.55n 0 19579n 0 19579.05n 0.9 19580.5n 0.9 19580.55n 0 19664n 0 19664.05n 0.9 19665.5n 0.9 19665.55n 0 19669n 0 19669.05n 0.9 19670.5n 0.9 19670.55n 0 19674n 0 19674.05n 0.9 19675.5n 0.9 19675.55n 0 19684n 0 19684.05n 0.9 19685.5n 0.9 19685.55n 0 19689n 0 19689.05n 0.9 19690.5n 0.9 19690.55n 0 19764n 0 19764.05n 0.9 19765.5n 0.9 19765.55n 0 19769n 0 19769.05n 0.9 19770.5n 0.9 19770.55n 0 19774n 0 19774.05n 0.9 19775.5n 0.9 19775.55n 0 19784n 0 19784.05n 0.9 19785.5n 0.9 19785.55n 0 19864n 0 19864.05n 0.9 19865.5n 0.9 19865.55n 0 19869n 0 19869.05n 0.9 19870.5n 0.9 19870.55n 0 19874n 0 19874.05n 0.9 19875.5n 0.9 19875.55n 0 19889n 0 19889.05n 0.9 19890.5n 0.9 19890.55n 0 19964n 0 19964.05n 0.9 19965.5n 0.9 19965.55n 0 19969n 0 19969.05n 0.9 19970.5n 0.9 19970.55n 0 19974n 0 19974.05n 0.9 19975.5n 0.9 19975.55n 0 20064n 0 20064.05n 0.9 20065.5n 0.9 20065.55n 0 20069n 0 20069.05n 0.9 20070.5n 0.9 20070.55n 0 20079n 0 20079.05n 0.9 20080.5n 0.9 20080.55n 0 20084n 0 20084.05n 0.9 20085.5n 0.9 20085.55n 0 20089n 0 20089.05n 0.9 20090.5n 0.9 20090.55n 0 20164n 0 20164.05n 0.9 20165.5n 0.9 20165.55n 0 20169n 0 20169.05n 0.9 20170.5n 0.9 20170.55n 0 20179n 0 20179.05n 0.9 20180.5n 0.9 20180.55n 0 20184n 0 20184.05n 0.9 20185.5n 0.9 20185.55n 0 20264n 0 20264.05n 0.9 20265.5n 0.9 20265.55n 0 20269n 0 20269.05n 0.9 20270.5n 0.9 20270.55n 0 20279n 0 20279.05n 0.9 20280.5n 0.9 20280.55n 0 20289n 0 20289.05n 0.9 20290.5n 0.9 20290.55n 0 20364n 0 20364.05n 0.9 20365.5n 0.9 20365.55n 0 20369n 0 20369.05n 0.9 20370.5n 0.9 20370.55n 0 20379n 0 20379.05n 0.9 20380.5n 0.9 20380.55n 0 20464n 0 20464.05n 0.9 20465.5n 0.9 20465.55n 0 20469n 0 20469.05n 0.9 20470.5n 0.9 20470.55n 0 20484n 0 20484.05n 0.9 20485.5n 0.9 20485.55n 0 20489n 0 20489.05n 0.9 20490.5n 0.9 20490.55n 0 20564n 0 20564.05n 0.9 20565.5n 0.9 20565.55n 0 20569n 0 20569.05n 0.9 20570.5n 0.9 20570.55n 0 20584n 0 20584.05n 0.9 20585.5n 0.9 20585.55n 0 20664n 0 20664.05n 0.9 20665.5n 0.9 20665.55n 0 20669n 0 20669.05n 0.9 20670.5n 0.9 20670.55n 0 20689n 0 20689.05n 0.9 20690.5n 0.9 20690.55n 0 20764n 0 20764.05n 0.9 20765.5n 0.9 20765.55n 0 20769n 0 20769.05n 0.9 20770.5n 0.9 20770.55n 0 20864n 0 20864.05n 0.9 20865.5n 0.9 20865.55n 0 20874n 0 20874.05n 0.9 20875.5n 0.9 20875.55n 0 20879n 0 20879.05n 0.9 20880.5n 0.9 20880.55n 0 20884n 0 20884.05n 0.9 20885.5n 0.9 20885.55n 0 20889n 0 20889.05n 0.9 20890.5n 0.9 20890.55n 0 20964n 0 20964.05n 0.9 20965.5n 0.9 20965.55n 0 20974n 0 20974.05n 0.9 20975.5n 0.9 20975.55n 0 20979n 0 20979.05n 0.9 20980.5n 0.9 20980.55n 0 20984n 0 20984.05n 0.9 20985.5n 0.9 20985.55n 0 21064n 0 21064.05n 0.9 21065.5n 0.9 21065.55n 0 21074n 0 21074.05n 0.9 21075.5n 0.9 21075.55n 0 21079n 0 21079.05n 0.9 21080.5n 0.9 21080.55n 0 21089n 0 21089.05n 0.9 21090.5n 0.9 21090.55n 0 21164n 0 21164.05n 0.9 21165.5n 0.9 21165.55n 0 21174n 0 21174.05n 0.9 21175.5n 0.9 21175.55n 0 21179n 0 21179.05n 0.9 21180.5n 0.9 21180.55n 0 21264n 0 21264.05n 0.9 21265.5n 0.9 21265.55n 0 21274n 0 21274.05n 0.9 21275.5n 0.9 21275.55n 0 21284n 0 21284.05n 0.9 21285.5n 0.9 21285.55n 0 21289n 0 21289.05n 0.9 21290.5n 0.9 21290.55n 0 21364n 0 21364.05n 0.9 21365.5n 0.9 21365.55n 0 21374n 0 21374.05n 0.9 21375.5n 0.9 21375.55n 0 21384n 0 21384.05n 0.9 21385.5n 0.9 21385.55n 0 21464n 0 21464.05n 0.9 21465.5n 0.9 21465.55n 0 21474n 0 21474.05n 0.9 21475.5n 0.9 21475.55n 0 21489n 0 21489.05n 0.9 21490.5n 0.9 21490.55n 0 21564n 0 21564.05n 0.9 21565.5n 0.9 21565.55n 0 21574n 0 21574.05n 0.9 21575.5n 0.9 21575.55n 0 21664n 0 21664.05n 0.9 21665.5n 0.9 21665.55n 0 21679n 0 21679.05n 0.9 21680.5n 0.9 21680.55n 0 21684n 0 21684.05n 0.9 21685.5n 0.9 21685.55n 0 21689n 0 21689.05n 0.9 21690.5n 0.9 21690.55n 0 21764n 0 21764.05n 0.9 21765.5n 0.9 21765.55n 0 21779n 0 21779.05n 0.9 21780.5n 0.9 21780.55n 0 21784n 0 21784.05n 0.9 21785.5n 0.9 21785.55n 0 21864n 0 21864.05n 0.9 21865.5n 0.9 21865.55n 0 21879n 0 21879.05n 0.9 21880.5n 0.9 21880.55n 0 21889n 0 21889.05n 0.9 21890.5n 0.9 21890.55n 0 21964n 0 21964.05n 0.9 21965.5n 0.9 21965.55n 0 21979n 0 21979.05n 0.9 21980.5n 0.9 21980.55n 0 22064n 0 22064.05n 0.9 22065.5n 0.9 22065.55n 0 22084n 0 22084.05n 0.9 22085.5n 0.9 22085.55n 0 22089n 0 22089.05n 0.9 22090.5n 0.9 22090.55n 0 22164n 0 22164.05n 0.9 22165.5n 0.9 22165.55n 0 22184n 0 22184.05n 0.9 22185.5n 0.9 22185.55n 0 22264n 0 22264.05n 0.9 22265.5n 0.9 22265.55n 0 22289n 0 22289.05n 0.9 22290.5n 0.9 22290.55n 0 22364n 0 22364.05n 0.9 22365.5n 0.9 22365.55n 0 22469n 0 22469.05n 0.9 22470.5n 0.9 22470.55n 0 22474n 0 22474.05n 0.9 22475.5n 0.9 22475.55n 0 22479n 0 22479.05n 0.9 22480.5n 0.9 22480.55n 0 22484n 0 22484.05n 0.9 22485.5n 0.9 22485.55n 0 22489n 0 22489.05n 0.9 22490.5n 0.9 22490.55n 0 22569n 0 22569.05n 0.9 22570.5n 0.9 22570.55n 0 22574n 0 22574.05n 0.9 22575.5n 0.9 22575.55n 0 22579n 0 22579.05n 0.9 22580.5n 0.9 22580.55n 0 22584n 0 22584.05n 0.9 22585.5n 0.9 22585.55n 0 22669n 0 22669.05n 0.9 22670.5n 0.9 22670.55n 0 22674n 0 22674.05n 0.9 22675.5n 0.9 22675.55n 0 22679n 0 22679.05n 0.9 22680.5n 0.9 22680.55n 0 22689n 0 22689.05n 0.9 22690.5n 0.9 22690.55n 0 22769n 0 22769.05n 0.9 22770.5n 0.9 22770.55n 0 22774n 0 22774.05n 0.9 22775.5n 0.9 22775.55n 0 22779n 0 22779.05n 0.9 22780.5n 0.9 22780.55n 0 22869n 0 22869.05n 0.9 22870.5n 0.9 22870.55n 0 22874n 0 22874.05n 0.9 22875.5n 0.9 22875.55n 0 22884n 0 22884.05n 0.9 22885.5n 0.9 22885.55n 0 22889n 0 22889.05n 0.9 22890.5n 0.9 22890.55n 0 22969n 0 22969.05n 0.9 22970.5n 0.9 22970.55n 0 22974n 0 22974.05n 0.9 22975.5n 0.9 22975.55n 0 22984n 0 22984.05n 0.9 22985.5n 0.9 22985.55n 0 23069n 0 23069.05n 0.9 23070.5n 0.9 23070.55n 0 23074n 0 23074.05n 0.9 23075.5n 0.9 23075.55n 0 23089n 0 23089.05n 0.9 23090.5n 0.9 23090.55n 0 23169n 0 23169.05n 0.9 23170.5n 0.9 23170.55n 0 23174n 0 23174.05n 0.9 23175.5n 0.9 23175.55n 0 23269n 0 23269.05n 0.9 23270.5n 0.9 23270.55n 0 23279n 0 23279.05n 0.9 23280.5n 0.9 23280.55n 0 23284n 0 23284.05n 0.9 23285.5n 0.9 23285.55n 0 23289n 0 23289.05n 0.9 23290.5n 0.9 23290.55n 0 23369n 0 23369.05n 0.9 23370.5n 0.9 23370.55n 0 23379n 0 23379.05n 0.9 23380.5n 0.9 23380.55n 0 23384n 0 23384.05n 0.9 23385.5n 0.9 23385.55n 0 23469n 0 23469.05n 0.9 23470.5n 0.9 23470.55n 0 23479n 0 23479.05n 0.9 23480.5n 0.9 23480.55n 0 23489n 0 23489.05n 0.9 23490.5n 0.9 23490.55n 0 23569n 0 23569.05n 0.9 23570.5n 0.9 23570.55n 0 23579n 0 23579.05n 0.9 23580.5n 0.9 23580.55n 0 23669n 0 23669.05n 0.9 23670.5n 0.9 23670.55n 0 23684n 0 23684.05n 0.9 23685.5n 0.9 23685.55n 0 23689n 0 23689.05n 0.9 23690.5n 0.9 23690.55n 0 23769n 0 23769.05n 0.9 23770.5n 0.9 23770.55n 0 23784n 0 23784.05n 0.9 23785.5n 0.9 23785.55n 0 23869n 0 23869.05n 0.9 23870.5n 0.9 23870.55n 0 23889n 0 23889.05n 0.9 23890.5n 0.9 23890.55n 0 23969n 0 23969.05n 0.9 23970.5n 0.9 23970.55n 0 24074n 0 24074.05n 0.9 24075.5n 0.9 24075.55n 0 24079n 0 24079.05n 0.9 24080.5n 0.9 24080.55n 0 24084n 0 24084.05n 0.9 24085.5n 0.9 24085.55n 0 24089n 0 24089.05n 0.9 24090.5n 0.9 24090.55n 0 24174n 0 24174.05n 0.9 24175.5n 0.9 24175.55n 0 24179n 0 24179.05n 0.9 24180.5n 0.9 24180.55n 0 24184n 0 24184.05n 0.9 24185.5n 0.9 24185.55n 0 24274n 0 24274.05n 0.9 24275.5n 0.9 24275.55n 0 24279n 0 24279.05n 0.9 24280.5n 0.9 24280.55n 0 24289n 0 24289.05n 0.9 24290.5n 0.9 24290.55n 0 24374n 0 24374.05n 0.9 24375.5n 0.9 24375.55n 0 24379n 0 24379.05n 0.9 24380.5n 0.9 24380.55n 0 24474n 0 24474.05n 0.9 24475.5n 0.9 24475.55n 0 24484n 0 24484.05n 0.9 24485.5n 0.9 24485.55n 0 24489n 0 24489.05n 0.9 24490.5n 0.9 24490.55n 0 24574n 0 24574.05n 0.9 24575.5n 0.9 24575.55n 0 24584n 0 24584.05n 0.9 24585.5n 0.9 24585.55n 0 24674n 0 24674.05n 0.9 24675.5n 0.9 24675.55n 0 24689n 0 24689.05n 0.9 24690.5n 0.9 24690.55n 0 24774n 0 24774.05n 0.9 24775.5n 0.9 24775.55n 0 24879n 0 24879.05n 0.9 24880.5n 0.9 24880.55n 0 24884n 0 24884.05n 0.9 24885.5n 0.9 24885.55n 0 24889n 0 24889.05n 0.9 24890.5n 0.9 24890.55n 0 24979n 0 24979.05n 0.9 24980.5n 0.9 24980.55n 0 24984n 0 24984.05n 0.9 24985.5n 0.9 24985.55n 0 25079n 0 25079.05n 0.9 25080.5n 0.9 25080.55n 0 25089n 0 25089.05n 0.9 25090.5n 0.9 25090.55n 0 25179n 0 25179.05n 0.9 25180.5n 0.9 25180.55n 0 25284n 0 25284.05n 0.9 25285.5n 0.9 25285.55n 0 25289n 0 25289.05n 0.9 25290.5n 0.9 25290.55n 0 25384n 0 25384.05n 0.9 25385.5n 0.9 25385.55n 0 25489n 0 25489.05n 0.9 25490.5n 0.9 25490.55n 0]
XDUT (CLKS 0 VDD DCMPP DCMPN CMPCK DO_7 DO_6 DO_5 DO_4 DO_3 DO_2 DO_1 DO_0 DCTRLP_7 DCTRLP_6 DCTRLP_5 DCTRLP_4 DCTRLP_3 DCTRLP_2 DCTRLP_1 DCTRLP_0 DCTRLN_7 DCTRLN_6 DCTRLN_5 DCTRLN_4 DCTRLN_3 DCTRLN_2 DCTRLN_1 DCTRLN_0) manual_sar
LOADPM12 (VDD DCTRLP_1 VDD VDD) pch_mac l=100n w=3u multi=2 nf=10          sd=120.0n ad=1.8e-13 as=2.01e-13 pd=4.2u ps=4.94u nrd=0.065737          nrs=0.065737 sa=551.022n sb=551.022n sa1=212.829n sa2=458.86n          sa3=727.268n sa4=476.12n sb1=212.829n sb2=458.86n sb3=727.268n          spa=120.0n spa1=120.0n spa2=120.0n spa3=120.0n sap=191.293n          sapb=215.014n spba=162.129n spba1=166.371n dfm_flag=0          spmt=1.11111e+15 spomt=0 spomt1=1.11111e+60 spmb=1.11111e+15          spomb=0 spomb1=1.11111e+60
LOADPM9 (VDD DCTRLP_2 VDD VDD) pch_mac l=100n w=3u multi=4 nf=10 sd=120.0n          ad=1.8e-13 as=2.01e-13 pd=4.2u ps=4.94u nrd=0.065737 nrs=0.065737          sa=551.022n sb=551.022n sa1=212.829n sa2=458.86n sa3=727.268n          sa4=476.12n sb1=212.829n sb2=458.86n sb3=727.268n spa=120.0n          spa1=120.0n spa2=120.0n spa3=120.0n sap=191.293n sapb=215.014n          spba=162.129n spba1=166.371n dfm_flag=0 spmt=1.11111e+15 spomt=0          spomt1=1.11111e+60 spmb=1.11111e+15 spomb=0 spomb1=1.11111e+60
LOADPM8 (VDD DCTRLP_3 VDD VDD) pch_mac l=100n w=3u multi=8 nf=10 sd=120.0n          ad=1.8e-13 as=2.01e-13 pd=4.2u ps=4.94u nrd=0.065737 nrs=0.065737          sa=551.022n sb=551.022n sa1=212.829n sa2=458.86n sa3=727.268n          sa4=476.12n sb1=212.829n sb2=458.86n sb3=727.268n spa=120.0n          spa1=120.0n spa2=120.0n spa3=120.0n sap=191.293n sapb=215.014n          spba=162.129n spba1=166.371n dfm_flag=0 spmt=1.11111e+15 spomt=0          spomt1=1.11111e+60 spmb=1.11111e+15 spomb=0 spomb1=1.11111e+60
LOADPM6 (VDD DCTRLP_4 VDD VDD) pch_mac l=100n w=3u multi=16 nf=10          sd=120.0n ad=1.8e-13 as=2.01e-13 pd=4.2u ps=4.94u nrd=0.065737          nrs=0.065737 sa=551.022n sb=551.022n sa1=212.829n sa2=458.86n          sa3=727.268n sa4=476.12n sb1=212.829n sb2=458.86n sb3=727.268n          spa=120.0n spa1=120.0n spa2=120.0n spa3=120.0n sap=191.293n          sapb=215.014n spba=162.129n spba1=166.371n dfm_flag=0          spmt=1.11111e+15 spomt=0 spomt1=1.11111e+60 spmb=1.11111e+15          spomb=0 spomb1=1.11111e+60
LOADPM5 (VDD DCTRLP_5 VDD VDD) pch_mac l=100n w=3u multi=32 nf=10          sd=120.0n ad=1.8e-13 as=2.01e-13 pd=4.2u ps=4.94u nrd=0.065737          nrs=0.065737 sa=551.022n sb=551.022n sa1=212.829n sa2=458.86n          sa3=727.268n sa4=476.12n sb1=212.829n sb2=458.86n sb3=727.268n          spa=120.0n spa1=120.0n spa2=120.0n spa3=120.0n sap=191.293n          sapb=215.014n spba=162.129n spba1=166.371n dfm_flag=0          spmt=1.11111e+15 spomt=0 spomt1=1.11111e+60 spmb=1.11111e+15          spomb=0 spomb1=1.11111e+60
LOADPM4 (VDD DCTRLP_6 VDD VDD) pch_mac l=100n w=3u multi=64 nf=10          sd=120.0n ad=1.8e-13 as=2.01e-13 pd=4.2u ps=4.94u nrd=0.065737          nrs=0.065737 sa=551.022n sb=551.022n sa1=212.829n sa2=458.86n          sa3=727.268n sa4=476.12n sb1=212.829n sb2=458.86n sb3=727.268n          spa=120.0n spa1=120.0n spa2=120.0n spa3=120.0n sap=191.293n          sapb=215.014n spba=162.129n spba1=166.371n dfm_flag=0          spmt=1.11111e+15 spomt=0 spomt1=1.11111e+60 spmb=1.11111e+15          spomb=0 spomb1=1.11111e+60
LOADPM0 (VDD DCTRLP_7 VDD VDD) pch_mac l=100n w=3u multi=128 nf=10          sd=120.0n ad=1.8e-13 as=2.01e-13 pd=4.2u ps=4.94u nrd=0.065737          nrs=0.065737 sa=551.022n sb=551.022n sa1=212.829n sa2=458.86n          sa3=727.268n sa4=476.12n sb1=212.829n sb2=458.86n sb3=727.268n          spa=120.0n spa1=120.0n spa2=120.0n spa3=120.0n sap=191.293n          sapb=215.014n spba=162.129n spba1=166.371n dfm_flag=0          spmt=1.11111e+15 spomt=0 spomt1=1.11111e+60 spmb=1.11111e+15          spomb=0 spomb1=1.11111e+60
LOADPM14 (0 DCTRLP_1 0 0) nch_mac l=30n w=1u multi=2 nf=10 sd=100n          ad=5e-14 as=5.5e-14 pd=2u ps=2.3u nrd=0.427491 nrs=0.427491          sa=349.754n sb=349.754n sa1=161.047n sa2=316.499n sa3=575.493n          sa4=331.707n sb1=161.047n sb2=316.499n sb3=575.493n spa=100n          spa1=100n spa2=100n spa3=100n sap=150.407n sapb=165.494n          spba=115.715n spba1=117.043n dfm_flag=0 spmt=1.11111e+15 spomt=0          spomt1=1.11111e+60 spmb=1.11111e+15 spomb=0 spomb1=1.11111e+60
LOADPM11 (0 DCTRLP_2 0 0) nch_mac l=30n w=1u multi=4 nf=10 sd=100n          ad=5e-14 as=5.5e-14 pd=2u ps=2.3u nrd=0.427491 nrs=0.427491          sa=349.754n sb=349.754n sa1=161.047n sa2=316.499n sa3=575.493n          sa4=331.707n sb1=161.047n sb2=316.499n sb3=575.493n spa=100n          spa1=100n spa2=100n spa3=100n sap=150.407n sapb=165.494n          spba=115.715n spba1=117.043n dfm_flag=0 spmt=1.11111e+15 spomt=0          spomt1=1.11111e+60 spmb=1.11111e+15 spomb=0 spomb1=1.11111e+60
LOADPM10 (0 DCTRLP_3 0 0) nch_mac l=30n w=1u multi=8 nf=10 sd=100n          ad=5e-14 as=5.5e-14 pd=2u ps=2.3u nrd=0.427491 nrs=0.427491          sa=349.754n sb=349.754n sa1=161.047n sa2=316.499n sa3=575.493n          sa4=331.707n sb1=161.047n sb2=316.499n sb3=575.493n spa=100n          spa1=100n spa2=100n spa3=100n sap=150.407n sapb=165.494n          spba=115.715n spba1=117.043n dfm_flag=0 spmt=1.11111e+15 spomt=0          spomt1=1.11111e+60 spmb=1.11111e+15 spomb=0 spomb1=1.11111e+60
LOADPM7 (0 DCTRLP_4 0 0) nch_mac l=30n w=1u multi=16 nf=10 sd=100n          ad=5e-14 as=5.5e-14 pd=2u ps=2.3u nrd=0.427491 nrs=0.427491          sa=349.754n sb=349.754n sa1=161.047n sa2=316.499n sa3=575.493n          sa4=331.707n sb1=161.047n sb2=316.499n sb3=575.493n spa=100n          spa1=100n spa2=100n spa3=100n sap=150.407n sapb=165.494n          spba=115.715n spba1=117.043n dfm_flag=0 spmt=1.11111e+15 spomt=0          spomt1=1.11111e+60 spmb=1.11111e+15 spomb=0 spomb1=1.11111e+60
LOADPM3 (0 DCTRLP_5 0 0) nch_mac l=30n w=1u multi=32 nf=10 sd=100n          ad=5e-14 as=5.5e-14 pd=2u ps=2.3u nrd=0.427491 nrs=0.427491          sa=349.754n sb=349.754n sa1=161.047n sa2=316.499n sa3=575.493n          sa4=331.707n sb1=161.047n sb2=316.499n sb3=575.493n spa=100n          spa1=100n spa2=100n spa3=100n sap=150.407n sapb=165.494n          spba=115.715n spba1=117.043n dfm_flag=0 spmt=1.11111e+15 spomt=0          spomt1=1.11111e+60 spmb=1.11111e+15 spomb=0 spomb1=1.11111e+60
LOADPM2 (0 DCTRLP_6 0 0) nch_mac l=30n w=1u multi=64 nf=10 sd=100n          ad=5e-14 as=5.5e-14 pd=2u ps=2.3u nrd=0.427491 nrs=0.427491          sa=349.754n sb=349.754n sa1=161.047n sa2=316.499n sa3=575.493n          sa4=331.707n sb1=161.047n sb2=316.499n sb3=575.493n spa=100n          spa1=100n spa2=100n spa3=100n sap=150.407n sapb=165.494n          spba=115.715n spba1=117.043n dfm_flag=0 spmt=1.11111e+15 spomt=0          spomt1=1.11111e+60 spmb=1.11111e+15 spomb=0 spomb1=1.11111e+60
LOADPM1 (0 DCTRLP_7 0 0) nch_mac l=30n w=1u multi=128 nf=10 sd=100n          ad=5e-14 as=5.5e-14 pd=2u ps=2.3u nrd=0.427491 nrs=0.427491          sa=349.754n sb=349.754n sa1=161.047n sa2=316.499n sa3=575.493n          sa4=331.707n sb1=161.047n sb2=316.499n sb3=575.493n spa=100n          spa1=100n spa2=100n spa3=100n sap=150.407n sapb=165.494n          spba=115.715n spba1=117.043n dfm_flag=0 spmt=1.11111e+15 spomt=0          spomt1=1.11111e+60 spmb=1.11111e+15 spomb=0 spomb1=1.11111e+60
LOADNM12 (VDD DCTRLN_1 VDD VDD) pch_mac l=100n w=3u multi=2 nf=10          sd=120.0n ad=1.8e-13 as=2.01e-13 pd=4.2u ps=4.94u nrd=0.065737          nrs=0.065737 sa=551.022n sb=551.022n sa1=212.829n sa2=458.86n          sa3=727.268n sa4=476.12n sb1=212.829n sb2=458.86n sb3=727.268n          spa=120.0n spa1=120.0n spa2=120.0n spa3=120.0n sap=191.293n          sapb=215.014n spba=162.129n spba1=166.371n dfm_flag=0          spmt=1.11111e+15 spomt=0 spomt1=1.11111e+60 spmb=1.11111e+15          spomb=0 spomb1=1.11111e+60
LOADNM9 (VDD DCTRLN_2 VDD VDD) pch_mac l=100n w=3u multi=4 nf=10 sd=120.0n          ad=1.8e-13 as=2.01e-13 pd=4.2u ps=4.94u nrd=0.065737 nrs=0.065737          sa=551.022n sb=551.022n sa1=212.829n sa2=458.86n sa3=727.268n          sa4=476.12n sb1=212.829n sb2=458.86n sb3=727.268n spa=120.0n          spa1=120.0n spa2=120.0n spa3=120.0n sap=191.293n sapb=215.014n          spba=162.129n spba1=166.371n dfm_flag=0 spmt=1.11111e+15 spomt=0          spomt1=1.11111e+60 spmb=1.11111e+15 spomb=0 spomb1=1.11111e+60
LOADNM8 (VDD DCTRLN_3 VDD VDD) pch_mac l=100n w=3u multi=8 nf=10 sd=120.0n          ad=1.8e-13 as=2.01e-13 pd=4.2u ps=4.94u nrd=0.065737 nrs=0.065737          sa=551.022n sb=551.022n sa1=212.829n sa2=458.86n sa3=727.268n          sa4=476.12n sb1=212.829n sb2=458.86n sb3=727.268n spa=120.0n          spa1=120.0n spa2=120.0n spa3=120.0n sap=191.293n sapb=215.014n          spba=162.129n spba1=166.371n dfm_flag=0 spmt=1.11111e+15 spomt=0          spomt1=1.11111e+60 spmb=1.11111e+15 spomb=0 spomb1=1.11111e+60
LOADNM6 (VDD DCTRLN_4 VDD VDD) pch_mac l=100n w=3u multi=16 nf=10          sd=120.0n ad=1.8e-13 as=2.01e-13 pd=4.2u ps=4.94u nrd=0.065737          nrs=0.065737 sa=551.022n sb=551.022n sa1=212.829n sa2=458.86n          sa3=727.268n sa4=476.12n sb1=212.829n sb2=458.86n sb3=727.268n          spa=120.0n spa1=120.0n spa2=120.0n spa3=120.0n sap=191.293n          sapb=215.014n spba=162.129n spba1=166.371n dfm_flag=0          spmt=1.11111e+15 spomt=0 spomt1=1.11111e+60 spmb=1.11111e+15          spomb=0 spomb1=1.11111e+60
LOADNM5 (VDD DCTRLN_5 VDD VDD) pch_mac l=100n w=3u multi=32 nf=10          sd=120.0n ad=1.8e-13 as=2.01e-13 pd=4.2u ps=4.94u nrd=0.065737          nrs=0.065737 sa=551.022n sb=551.022n sa1=212.829n sa2=458.86n          sa3=727.268n sa4=476.12n sb1=212.829n sb2=458.86n sb3=727.268n          spa=120.0n spa1=120.0n spa2=120.0n spa3=120.0n sap=191.293n          sapb=215.014n spba=162.129n spba1=166.371n dfm_flag=0          spmt=1.11111e+15 spomt=0 spomt1=1.11111e+60 spmb=1.11111e+15          spomb=0 spomb1=1.11111e+60
LOADNM4 (VDD DCTRLN_6 VDD VDD) pch_mac l=100n w=3u multi=64 nf=10          sd=120.0n ad=1.8e-13 as=2.01e-13 pd=4.2u ps=4.94u nrd=0.065737          nrs=0.065737 sa=551.022n sb=551.022n sa1=212.829n sa2=458.86n          sa3=727.268n sa4=476.12n sb1=212.829n sb2=458.86n sb3=727.268n          spa=120.0n spa1=120.0n spa2=120.0n spa3=120.0n sap=191.293n          sapb=215.014n spba=162.129n spba1=166.371n dfm_flag=0          spmt=1.11111e+15 spomt=0 spomt1=1.11111e+60 spmb=1.11111e+15          spomb=0 spomb1=1.11111e+60
LOADNM0 (VDD DCTRLN_7 VDD VDD) pch_mac l=100n w=3u multi=128 nf=10          sd=120.0n ad=1.8e-13 as=2.01e-13 pd=4.2u ps=4.94u nrd=0.065737          nrs=0.065737 sa=551.022n sb=551.022n sa1=212.829n sa2=458.86n          sa3=727.268n sa4=476.12n sb1=212.829n sb2=458.86n sb3=727.268n          spa=120.0n spa1=120.0n spa2=120.0n spa3=120.0n sap=191.293n          sapb=215.014n spba=162.129n spba1=166.371n dfm_flag=0          spmt=1.11111e+15 spomt=0 spomt1=1.11111e+60 spmb=1.11111e+15          spomb=0 spomb1=1.11111e+60
LOADNM14 (0 DCTRLN_1 0 0) nch_mac l=30n w=1u multi=2 nf=10 sd=100n          ad=5e-14 as=5.5e-14 pd=2u ps=2.3u nrd=0.427491 nrs=0.427491          sa=349.754n sb=349.754n sa1=161.047n sa2=316.499n sa3=575.493n          sa4=331.707n sb1=161.047n sb2=316.499n sb3=575.493n spa=100n          spa1=100n spa2=100n spa3=100n sap=150.407n sapb=165.494n          spba=115.715n spba1=117.043n dfm_flag=0 spmt=1.11111e+15 spomt=0          spomt1=1.11111e+60 spmb=1.11111e+15 spomb=0 spomb1=1.11111e+60
LOADNM11 (0 DCTRLN_2 0 0) nch_mac l=30n w=1u multi=4 nf=10 sd=100n          ad=5e-14 as=5.5e-14 pd=2u ps=2.3u nrd=0.427491 nrs=0.427491          sa=349.754n sb=349.754n sa1=161.047n sa2=316.499n sa3=575.493n          sa4=331.707n sb1=161.047n sb2=316.499n sb3=575.493n spa=100n          spa1=100n spa2=100n spa3=100n sap=150.407n sapb=165.494n          spba=115.715n spba1=117.043n dfm_flag=0 spmt=1.11111e+15 spomt=0          spomt1=1.11111e+60 spmb=1.11111e+15 spomb=0 spomb1=1.11111e+60
LOADNM10 (0 DCTRLN_3 0 0) nch_mac l=30n w=1u multi=8 nf=10 sd=100n          ad=5e-14 as=5.5e-14 pd=2u ps=2.3u nrd=0.427491 nrs=0.427491          sa=349.754n sb=349.754n sa1=161.047n sa2=316.499n sa3=575.493n          sa4=331.707n sb1=161.047n sb2=316.499n sb3=575.493n spa=100n          spa1=100n spa2=100n spa3=100n sap=150.407n sapb=165.494n          spba=115.715n spba1=117.043n dfm_flag=0 spmt=1.11111e+15 spomt=0          spomt1=1.11111e+60 spmb=1.11111e+15 spomb=0 spomb1=1.11111e+60
LOADNM7 (0 DCTRLN_4 0 0) nch_mac l=30n w=1u multi=16 nf=10 sd=100n          ad=5e-14 as=5.5e-14 pd=2u ps=2.3u nrd=0.427491 nrs=0.427491          sa=349.754n sb=349.754n sa1=161.047n sa2=316.499n sa3=575.493n          sa4=331.707n sb1=161.047n sb2=316.499n sb3=575.493n spa=100n          spa1=100n spa2=100n spa3=100n sap=150.407n sapb=165.494n          spba=115.715n spba1=117.043n dfm_flag=0 spmt=1.11111e+15 spomt=0          spomt1=1.11111e+60 spmb=1.11111e+15 spomb=0 spomb1=1.11111e+60
LOADNM3 (0 DCTRLN_5 0 0) nch_mac l=30n w=1u multi=32 nf=10 sd=100n          ad=5e-14 as=5.5e-14 pd=2u ps=2.3u nrd=0.427491 nrs=0.427491          sa=349.754n sb=349.754n sa1=161.047n sa2=316.499n sa3=575.493n          sa4=331.707n sb1=161.047n sb2=316.499n sb3=575.493n spa=100n          spa1=100n spa2=100n spa3=100n sap=150.407n sapb=165.494n          spba=115.715n spba1=117.043n dfm_flag=0 spmt=1.11111e+15 spomt=0          spomt1=1.11111e+60 spmb=1.11111e+15 spomb=0 spomb1=1.11111e+60
LOADNM2 (0 DCTRLN_6 0 0) nch_mac l=30n w=1u multi=64 nf=10 sd=100n          ad=5e-14 as=5.5e-14 pd=2u ps=2.3u nrd=0.427491 nrs=0.427491          sa=349.754n sb=349.754n sa1=161.047n sa2=316.499n sa3=575.493n          sa4=331.707n sb1=161.047n sb2=316.499n sb3=575.493n spa=100n          spa1=100n spa2=100n spa3=100n sap=150.407n sapb=165.494n          spba=115.715n spba1=117.043n dfm_flag=0 spmt=1.11111e+15 spomt=0          spomt1=1.11111e+60 spmb=1.11111e+15 spomb=0 spomb1=1.11111e+60
LOADNM1 (0 DCTRLN_7 0 0) nch_mac l=30n w=1u multi=128 nf=10 sd=100n          ad=5e-14 as=5.5e-14 pd=2u ps=2.3u nrd=0.427491 nrs=0.427491          sa=349.754n sb=349.754n sa1=161.047n sa2=316.499n sa3=575.493n          sa4=331.707n sb1=161.047n sb2=316.499n sb3=575.493n spa=100n          spa1=100n spa2=100n spa3=100n sap=150.407n sapb=165.494n          spba=115.715n spba1=117.043n dfm_flag=0 spmt=1.11111e+15 spomt=0          spomt1=1.11111e+60 spmb=1.11111e+15 spomb=0 spomb1=1.11111e+60
simulatorOptions options reltol=1e-5 vabstol=1e-7 iabstol=1e-13 temp=27 tnom=27 gmin=1e-12 checklimitdest=psf
saveOptions options save=selected currents=selected
tran_test tran stop=25620n maxstep=200p errpreset=conservative
save CLKS CMPCK DCMPN DCMPP DCTRLN_0 DCTRLN_1 DCTRLN_2 DCTRLN_3 DCTRLN_4 DCTRLN_5 DCTRLN_6 DCTRLN_7 DCTRLP_0 DCTRLP_1 DCTRLP_2 DCTRLP_3 DCTRLP_4 DCTRLP_5 DCTRLP_6 DCTRLP_7 DO_0 DO_1 DO_2 DO_3 DO_4 DO_5 DO_6 DO_7 VDD VVDD:1 XDUT.CLK_0 XDUT.CLK_1 XDUT.CLK_2 XDUT.CLK_3 XDUT.CLK_4 XDUT.CLK_5 XDUT.CLK_6 XDUT.CLK_7
