`include "constants.vams"
`include "disciplines.vams"

// Functional SAR reference, not a gate-for-gate timing or device stress model.
// Native manual_sar pin sequence followed by three optional monitor outputs.
// First decision raises the lower side via inverted/crossed bit7 controls.
// Remaining decisions lower the higher side. No DAC update for final bit0.
module manual8_sar(CLKS, GND, VDD, DCMPP, DCMPN, CMPCK,
    DO_7, DO_6, DO_5, DO_4, DO_3, DO_2, DO_1, DO_0,
    DCTRLP_7, DCTRLP_6, DCTRLP_5, DCTRLP_4, DCTRLP_3, DCTRLP_2, DCTRLP_1, DCTRLP_0,
    DCTRLN_7, DCTRLN_6, DCTRLN_5, DCTRLN_4, DCTRLN_3, DCTRLN_2, DCTRLN_1, DCTRLN_0, BUSY, EOC, FAULT, REFRST);
    input CLKS, VDD, DCMPP, DCMPN, REFRST;
    electrical REFRST;
    inout GND;
    output CMPCK, BUSY, EOC, FAULT;
    output DO_7, DO_6, DO_5, DO_4, DO_3, DO_2, DO_1, DO_0;
    output DCTRLP_7, DCTRLP_6, DCTRLP_5, DCTRLP_4, DCTRLP_3, DCTRLP_2, DCTRLP_1, DCTRLP_0;
    output DCTRLN_7, DCTRLN_6, DCTRLN_5, DCTRLN_4, DCTRLN_3, DCTRLN_2, DCTRLN_1, DCTRLN_0;
    electrical CLKS, GND, VDD, DCMPP, DCMPN, CMPCK, BUSY, EOC, FAULT;
    electrical DO_7, DO_6, DO_5, DO_4, DO_3, DO_2, DO_1, DO_0;
    electrical DCTRLP_7, DCTRLP_6, DCTRLP_5, DCTRLP_4, DCTRLP_3, DCTRLP_2, DCTRLP_1, DCTRLP_0;
    electrical DCTRLN_7, DCTRLN_6, DCTRLN_5, DCTRLN_4, DCTRLN_3, DCTRLN_2, DCTRLN_1, DCTRLN_0;
    parameter real t_start = 4n from (0:inf);
    parameter real t_capture = 50p from (0:inf);
    parameter real t_update = 100p from (0:inf);
    parameter real t_settle = 2n from (0:inf);
    parameter real t_reset = 500p from (0:inf);
    parameter real t_timeout = 8n from (0:inf);
    parameter real trf = 50p from (0:inf);
    parameter real rout = 1 from (0:inf);
    // Optional receiver loading per comparator output; zero by default.
    parameter real cin_cmp = 0 from [0:inf);
    parameter real threshold = 0.5 from (0:1);
    // phases: 0 sample/idle,1 start,2 valid-wait,3 capture,4 DAC-update,
    // 5 settle,6 reset-wait,7 complete,-1 fault.
    integer phase, bitpos, raw_p, raw_n, gate_p, gate_n, out_code;
    integer ck, busy, done, fault, pv, nv;
    real next_action, deadline, reset_at;
    analog begin
        @(initial_step) begin
            phase=0; bitpos=7; raw_p=0; raw_n=0; gate_p=0; gate_n=0;
            out_code=0; ck=0; busy=0; done=0; fault=0;
            next_action=1e9; deadline=1e9; reset_at=0;
        end
        // Reset only the reference gate bank; preserve previous raw code until capture.
        @(cross(V(REFRST,GND)-threshold*V(VDD,GND), +1)) begin
            gate_p=0; gate_n=0;
        end
        // Sample wins over pending conversion events. Completed code is captured
        // BEFORE clearing the working decision bank. An incomplete frame is not published.
        @(cross(V(CLKS,GND)-threshold*V(VDD,GND), +1)) begin
            if (done) out_code=raw_p;
            fault=busy;
            phase=0; bitpos=7; raw_p=0; raw_n=0; gate_p=0; gate_n=0;
            ck=0; busy=0; done=0; next_action=1e9; deadline=1e9;
        end
        @(cross(V(CLKS,GND)-threshold*V(VDD,GND), -1)) begin
            phase=1; bitpos=7; raw_p=0; raw_n=0; gate_p=0; gate_n=0;
            ck=0; busy=1; done=0;
            next_action=$abstime+t_start;
            deadline=$abstime+t_start+t_timeout;
        end
        @(cross(V(DCMPP,GND)-threshold*V(VDD,GND), +1)
          or cross(V(DCMPN,GND)-threshold*V(VDD,GND), +1)) begin
            if (phase==2 && V(CLKS,GND)<threshold*V(VDD,GND)) begin
                phase=3; next_action=$abstime+t_capture;
            end
        end
        // Following settling, a real comparator may still be resetting.
        // Resume only after BOTH output rails are low.
        @(cross(V(DCMPP,GND)-threshold*V(VDD,GND), -1)
          or cross(V(DCMPN,GND)-threshold*V(VDD,GND), -1)) begin
            if (phase==6 && V(CLKS,GND)<threshold*V(VDD,GND)
                && V(DCMPP,GND)<=threshold*V(VDD,GND)
                && V(DCMPN,GND)<=threshold*V(VDD,GND)) begin
                phase=1; next_action=$abstime+t_capture;
            end
        end
        @(timer(next_action)) begin
            next_action=1e9;
            if (V(CLKS,GND)<threshold*V(VDD,GND)) begin
                case (phase)
                1: begin
                    if (V(DCMPP,GND)<threshold*V(VDD,GND)
                        && V(DCMPN,GND)<threshold*V(VDD,GND)) begin
                        ck=1; phase=2; deadline=$abstime+t_timeout;
                    end else phase=6;
                end
                3: begin
                    pv=(V(DCMPP,GND)>threshold*V(VDD,GND));
                    nv=(V(DCMPN,GND)>threshold*V(VDD,GND));
                    if (pv+nv!=1) begin
                        fault=1; busy=0; done=0; ck=0; phase=-1; deadline=1e9;
                    end else begin
                        if (pv) raw_p=raw_p+(1 << bitpos);
                        if (nv) raw_n=raw_n+(1 << bitpos);
                        ck=0; reset_at=$abstime;
                        phase=4; next_action=$abstime+t_update;
                        deadline=$abstime+t_update+t_settle+t_reset+t_timeout;
                    end
                end
                4: begin
                    gate_p=raw_p; gate_n=raw_n;
                    if (bitpos==0) begin
                        phase=7; busy=0; done=1; deadline=1e9;
                    end else begin
                        bitpos=bitpos-1;
                        phase=5;
                        next_action=max($abstime+t_settle,reset_at+t_reset);
                    end
                end
                5: begin
                    if (V(DCMPP,GND)<threshold*V(VDD,GND)
                        && V(DCMPN,GND)<threshold*V(VDD,GND)) begin
                        ck=1; phase=2; deadline=$abstime+t_timeout;
                    end else phase=6;
                end
                endcase
            end
        end
        // Explicit diagnostic, not an invented conversion result on timeout.
        @(timer(deadline)) begin
            deadline=1e9;
            if (busy && V(CLKS,GND)<threshold*V(VDD,GND)) begin
                fault=1; busy=0; done=0; ck=0; phase=-1; next_action=1e9;
            end
        end
        I(DCMPP,GND) <+ cin_cmp*ddt(V(DCMPP,GND));
        I(DCMPN,GND) <+ cin_cmp*ddt(V(DCMPN,GND));
        I(CMPCK,GND) <+ (V(CMPCK,GND)-V(VDD,GND)*transition(ck,0,trf,trf))/rout;
        I(BUSY,GND) <+ (V(BUSY,GND)-V(VDD,GND)*transition(busy,0,trf,trf))/rout;
        I(EOC,GND) <+ (V(EOC,GND)-V(VDD,GND)*transition(done,0,trf,trf))/rout;
        I(FAULT,GND) <+ (V(FAULT,GND)-V(VDD,GND)*transition(fault,0,trf,trf))/rout;
        I(DO_7,GND) <+ (V(DO_7,GND)-V(VDD,GND)*transition(((out_code >> 7) & 1),0,trf,trf))/rout;
        I(DO_6,GND) <+ (V(DO_6,GND)-V(VDD,GND)*transition(((out_code >> 6) & 1),0,trf,trf))/rout;
        I(DO_5,GND) <+ (V(DO_5,GND)-V(VDD,GND)*transition(((out_code >> 5) & 1),0,trf,trf))/rout;
        I(DO_4,GND) <+ (V(DO_4,GND)-V(VDD,GND)*transition(((out_code >> 4) & 1),0,trf,trf))/rout;
        I(DO_3,GND) <+ (V(DO_3,GND)-V(VDD,GND)*transition(((out_code >> 3) & 1),0,trf,trf))/rout;
        I(DO_2,GND) <+ (V(DO_2,GND)-V(VDD,GND)*transition(((out_code >> 2) & 1),0,trf,trf))/rout;
        I(DO_1,GND) <+ (V(DO_1,GND)-V(VDD,GND)*transition(((out_code >> 1) & 1),0,trf,trf))/rout;
        I(DO_0,GND) <+ (V(DO_0,GND)-V(VDD,GND)*transition(((out_code >> 0) & 1),0,trf,trf))/rout;
        I(DCTRLP_7,GND) <+ (V(DCTRLP_7,GND)-V(VDD,GND)*transition((1-((gate_p >> 7) & 1)),0,trf,trf))/rout;
        I(DCTRLP_6,GND) <+ (V(DCTRLP_6,GND)-V(VDD,GND)*transition(((gate_p >> 6) & 1),0,trf,trf))/rout;
        I(DCTRLP_5,GND) <+ (V(DCTRLP_5,GND)-V(VDD,GND)*transition(((gate_p >> 5) & 1),0,trf,trf))/rout;
        I(DCTRLP_4,GND) <+ (V(DCTRLP_4,GND)-V(VDD,GND)*transition(((gate_p >> 4) & 1),0,trf,trf))/rout;
        I(DCTRLP_3,GND) <+ (V(DCTRLP_3,GND)-V(VDD,GND)*transition(((gate_p >> 3) & 1),0,trf,trf))/rout;
        I(DCTRLP_2,GND) <+ (V(DCTRLP_2,GND)-V(VDD,GND)*transition(((gate_p >> 2) & 1),0,trf,trf))/rout;
        I(DCTRLP_1,GND) <+ (V(DCTRLP_1,GND)-V(VDD,GND)*transition(((gate_p >> 1) & 1),0,trf,trf))/rout;
        I(DCTRLP_0,GND) <+ (V(DCTRLP_0,GND)-V(VDD,GND)*transition(((gate_p >> 0) & 1),0,trf,trf))/rout;
        I(DCTRLN_7,GND) <+ (V(DCTRLN_7,GND)-V(VDD,GND)*transition((1-((gate_n >> 7) & 1)),0,trf,trf))/rout;
        I(DCTRLN_6,GND) <+ (V(DCTRLN_6,GND)-V(VDD,GND)*transition(((gate_n >> 6) & 1),0,trf,trf))/rout;
        I(DCTRLN_5,GND) <+ (V(DCTRLN_5,GND)-V(VDD,GND)*transition(((gate_n >> 5) & 1),0,trf,trf))/rout;
        I(DCTRLN_4,GND) <+ (V(DCTRLN_4,GND)-V(VDD,GND)*transition(((gate_n >> 4) & 1),0,trf,trf))/rout;
        I(DCTRLN_3,GND) <+ (V(DCTRLN_3,GND)-V(VDD,GND)*transition(((gate_n >> 3) & 1),0,trf,trf))/rout;
        I(DCTRLN_2,GND) <+ (V(DCTRLN_2,GND)-V(VDD,GND)*transition(((gate_n >> 2) & 1),0,trf,trf))/rout;
        I(DCTRLN_1,GND) <+ (V(DCTRLN_1,GND)-V(VDD,GND)*transition(((gate_n >> 1) & 1),0,trf,trf))/rout;
        I(DCTRLN_0,GND) <+ (V(DCTRLN_0,GND)-V(VDD,GND)*transition(((gate_n >> 0) & 1),0,trf,trf))/rout;
    end
endmodule
