simulator lang=spectre
include "models.scs"
include "dut.scs"
VVDD (VDD 0) vsource dc=.9
VCLK (CLKS 0) vsource type=pulse val0=0 val1=.9 delay=10n rise=50p fall=50p width=39.9n period=100n
VREF (REF 0) vsource dc=.9
VINP (VINP 0) vsource type=pwl wave=[0n 0.5 110n 0.5 110.05n 0.1 210n 0.1 210.05n 0.8 310n 0.8 310.05n 0.46]
VINN (VINN 0) vsource type=pwl wave=[0n 0.4 110n 0.4 110.05n 0.8 210n 0.8 210.05n 0.1 310n 0.1 310.05n 0.44]
XADC (CLKS 0 VDD VINP VINN REF 0 DO_7 DO_6 DO_5 DO_4 DO_3 DO_2 DO_1 DO_0) manual_adc main_mult=4
simulatorOptions options reltol=1e-5 vabstol=1e-7 iabstol=1e-13 temp=27 tnom=27 gmin=1e-12 checklimitdest=psf
saveOptions options save=selected currents=selected
tran_test tran stop=120n maxstep=20p errpreset=conservative
save CLKS DO_0 DO_1 DO_2 DO_3 DO_4 DO_5 DO_6 DO_7 REF VCLK:1 VDD VINN VINN:1 VINP VINP:1 VREF:1 VVDD:1 XADC.CMPCK XADC.DCMPN XADC.DCMPP XADC.DN_0 XADC.DN_1 XADC.DN_2 XADC.DN_3 XADC.DN_4 XADC.DN_5 XADC.DN_6 XADC.DN_7 XADC.DP_0 XADC.DP_1 XADC.DP_2 XADC.DP_3 XADC.DP_4 XADC.DP_5 XADC.DP_6 XADC.DP_7 XADC.TOPN XADC.TOPP XADC.XC.LN XADC.XC.LP XADC.XC.net1 XADC.XC.net2 XADC.XC.net3 XADC.XL.CLKS XADC.XL.CLKSN XADC.XL.CLK_0 XADC.XL.CLK_1 XADC.XL.CLK_2 XADC.XL.CLK_3 XADC.XL.CLK_4 XADC.XL.CLK_5 XADC.XL.CLK_6 XADC.XL.CLK_7 XADC.XL.CMPCK XADC.XL.CMPCKe XADC.XL.DCMPN XADC.XL.DCMPP XADC.XL.DO_0 XADC.XL.DO_1 XADC.XL.DO_2 XADC.XL.DO_3 XADC.XL.DO_4 XADC.XL.DO_5 XADC.XL.DO_6 XADC.XL.DO_7 XADC.XL.I10.clkb XADC.XL.I10.clkbb XADC.XL.I10.mq XADC.XL.I10.mq_x XADC.XL.I10.net0138 XADC.XL.I10.net0152 XADC.XL.I10.net093 XADC.XL.I10.net103 XADC.XL.I10.net176 XADC.XL.I10.net184 XADC.XL.I10.net208 XADC.XL.I10.net212 XADC.XL.I10.qf XADC.XL.I10.qf_x XADC.XL.I11.clkb XADC.XL.I11.clkbb XADC.XL.I11.mq XADC.XL.I11.mq_x XADC.XL.I11.net0138 XADC.XL.I11.net0152 XADC.XL.I11.net093 XADC.XL.I11.net103 XADC.XL.I11.net176 XADC.XL.I11.net184 XADC.XL.I11.net208 XADC.XL.I11.net212 XADC.XL.I11.qf XADC.XL.I11.qf_x XADC.XL.I12.MM0:1 XADC.XL.I12.MM0:2 XADC.XL.I12.MM0:3 XADC.XL.I12.MM0:4 XADC.XL.I12.MM1:1 XADC.XL.I12.MM1:2 XADC.XL.I12.MM1:3 XADC.XL.I12.MM1:4 XADC.XL.I12.MM2:1 XADC.XL.I12.MM2:2 XADC.XL.I12.MM2:3 XADC.XL.I12.MM2:4 XADC.XL.I12.MM3:1 XADC.XL.I12.MM3:2 XADC.XL.I12.MM3:3 XADC.XL.I12.MM3:4 XADC.XL.I12.MM4:1 XADC.XL.I12.MM4:2 XADC.XL.I12.MM4:3 XADC.XL.I12.MM4:4 XADC.XL.I12.MM5:1 XADC.XL.I12.MM5:2 XADC.XL.I12.MM5:3 XADC.XL.I12.MM5:4 XADC.XL.I12.MM61:1 XADC.XL.I12.MM61:2 XADC.XL.I12.MM61:3 XADC.XL.I12.MM61:4 XADC.XL.I12.MM64:1 XADC.XL.I12.MM64:2 XADC.XL.I12.MM64:3 XADC.XL.I12.MM64:4 XADC.XL.I12.MM65:1 XADC.XL.I12.MM65:2 XADC.XL.I12.MM65:3 XADC.XL.I12.MM65:4 XADC.XL.I12.MM76:1 XADC.XL.I12.MM76:2 XADC.XL.I12.MM76:3 XADC.XL.I12.MM76:4 XADC.XL.I12.MM77:1 XADC.XL.I12.MM77:2 XADC.XL.I12.MM77:3 XADC.XL.I12.MM77:4 XADC.XL.I12.MSLTn1:1 XADC.XL.I12.MSLTn1:2 XADC.XL.I12.MSLTn1:3 XADC.XL.I12.MSLTn1:4 XADC.XL.I12.MSLTp1:1 XADC.XL.I12.MSLTp1:2 XADC.XL.I12.MSLTp1:3 XADC.XL.I12.MSLTp1:4 XADC.XL.I12.clkb XADC.XL.I12.clkbb XADC.XL.I12.mq XADC.XL.I12.mq_x XADC.XL.I12.net0138 XADC.XL.I12.net0152 XADC.XL.I12.net093 XADC.XL.I12.net103 XADC.XL.I12.net176 XADC.XL.I12.net184 XADC.XL.I12.net208 XADC.XL.I12.net212 XADC.XL.I12.qf XADC.XL.I12.qf_x XADC.XL.I14.clkb XADC.XL.I14.clkbb XADC.XL.I14.mq XADC.XL.I14.mq_x XADC.XL.I14.net0118 XADC.XL.I14.net0136 XADC.XL.I14.net086 XADC.XL.I14.net103 XADC.XL.I14.net176 XADC.XL.I14.net212 XADC.XL.I14.qf XADC.XL.I14.qf_x XADC.XL.I16.clkb XADC.XL.I16.clkbb XADC.XL.I16.mq XADC.XL.I16.mq_x XADC.XL.I16.net0118 XADC.XL.I16.net0136 XADC.XL.I16.net086 XADC.XL.I16.net103 XADC.XL.I16.net176 XADC.XL.I16.net212 XADC.XL.I16.qf XADC.XL.I16.qf_x XADC.XL.I18.clkb XADC.XL.I18.clkbb XADC.XL.I18.mq XADC.XL.I18.mq_x XADC.XL.I18.net0118 XADC.XL.I18.net0136 XADC.XL.I18.net086 XADC.XL.I18.net103 XADC.XL.I18.net176 XADC.XL.I18.net212 XADC.XL.I18.qf XADC.XL.I18.qf_x XADC.XL.I20.clkb XADC.XL.I20.clkbb XADC.XL.I20.mq XADC.XL.I20.mq_x XADC.XL.I20.net0118 XADC.XL.I20.net0136 XADC.XL.I20.net086 XADC.XL.I20.net103 XADC.XL.I20.net176 XADC.XL.I20.net212 XADC.XL.I20.qf XADC.XL.I20.qf_x XADC.XL.I22.clkb XADC.XL.I22.clkbb XADC.XL.I22.mq XADC.XL.I22.mq_x XADC.XL.I22.net0118 XADC.XL.I22.net0136 XADC.XL.I22.net086 XADC.XL.I22.net103 XADC.XL.I22.net176 XADC.XL.I22.net212 XADC.XL.I22.qf XADC.XL.I22.qf_x XADC.XL.I24.clkb XADC.XL.I24.clkbb XADC.XL.I24.mq XADC.XL.I24.mq_x XADC.XL.I24.net0118 XADC.XL.I24.net0136 XADC.XL.I24.net086 XADC.XL.I24.net103 XADC.XL.I24.net176 XADC.XL.I24.net212 XADC.XL.I24.qf XADC.XL.I24.qf_x XADC.XL.I26.clkb XADC.XL.I26.clkbb XADC.XL.I26.mq XADC.XL.I26.mq_x XADC.XL.I26.net0118 XADC.XL.I26.net0136 XADC.XL.I26.net086 XADC.XL.I26.net103 XADC.XL.I26.net176 XADC.XL.I26.net212 XADC.XL.I26.qf XADC.XL.I26.qf_x XADC.XL.I28.clkb XADC.XL.I28.clkbb XADC.XL.I28.mq XADC.XL.I28.mq_x XADC.XL.I28.net0118 XADC.XL.I28.net0136 XADC.XL.I28.net086 XADC.XL.I28.net103 XADC.XL.I28.net176 XADC.XL.I28.net212 XADC.XL.I28.qf XADC.XL.I28.qf_x XADC.XL.I30.clkb XADC.XL.I30.clkbb XADC.XL.I30.mq XADC.XL.I30.mq_x XADC.XL.I30.net0118 XADC.XL.I30.net0136 XADC.XL.I30.net086 XADC.XL.I30.net103 XADC.XL.I30.net176 XADC.XL.I30.net212 XADC.XL.I30.qf XADC.XL.I30.qf_x XADC.XL.I32.clkb XADC.XL.I32.clkbb XADC.XL.I32.mq XADC.XL.I32.mq_x XADC.XL.I32.net0118 XADC.XL.I32.net0136 XADC.XL.I32.net086 XADC.XL.I32.net103 XADC.XL.I32.net176 XADC.XL.I32.net212 XADC.XL.I32.qf XADC.XL.I32.qf_x XADC.XL.I34.clkb XADC.XL.I34.clkbb XADC.XL.I34.mq XADC.XL.I34.mq_x XADC.XL.I34.net0118 XADC.XL.I34.net0136 XADC.XL.I34.net086 XADC.XL.I34.net103 XADC.XL.I34.net176 XADC.XL.I34.net212 XADC.XL.I34.qf XADC.XL.I34.qf_x XADC.XL.I36.clkb XADC.XL.I36.clkbb XADC.XL.I36.mq XADC.XL.I36.mq_x XADC.XL.I36.net0118 XADC.XL.I36.net0136 XADC.XL.I36.net086 XADC.XL.I36.net103 XADC.XL.I36.net176 XADC.XL.I36.net212 XADC.XL.I36.qf XADC.XL.I36.qf_x XADC.XL.I38.clkb XADC.XL.I38.clkbb XADC.XL.I38.mq XADC.XL.I38.mq_x XADC.XL.I38.net0118 XADC.XL.I38.net0136 XADC.XL.I38.net086 XADC.XL.I38.net103 XADC.XL.I38.net176 XADC.XL.I38.net212 XADC.XL.I38.qf XADC.XL.I38.qf_x XADC.XL.I4.net9 XADC.XL.I40.clkb XADC.XL.I40.clkbb XADC.XL.I40.mq XADC.XL.I40.mq_x XADC.XL.I40.net0118 XADC.XL.I40.net0136 XADC.XL.I40.net086 XADC.XL.I40.net103 XADC.XL.I40.net176 XADC.XL.I40.net212 XADC.XL.I40.qf XADC.XL.I40.qf_x XADC.XL.I42.clkb XADC.XL.I42.clkbb XADC.XL.I42.mq XADC.XL.I42.mq_x XADC.XL.I42.net0118 XADC.XL.I42.net0136 XADC.XL.I42.net086 XADC.XL.I42.net103 XADC.XL.I42.net176 XADC.XL.I42.net212 XADC.XL.I42.qf XADC.XL.I42.qf_x XADC.XL.I44.clkb XADC.XL.I44.clkbb XADC.XL.I44.mq XADC.XL.I44.mq_x XADC.XL.I44.net0118 XADC.XL.I44.net0136 XADC.XL.I44.net086 XADC.XL.I44.net103 XADC.XL.I44.net176 XADC.XL.I44.net212 XADC.XL.I44.qf XADC.XL.I44.qf_x XADC.XL.I46_0.clkb XADC.XL.I46_0.clkbb XADC.XL.I46_0.mq XADC.XL.I46_0.mq_x XADC.XL.I46_0.net0118 XADC.XL.I46_0.net0136 XADC.XL.I46_0.net086 XADC.XL.I46_0.net103 XADC.XL.I46_0.net176 XADC.XL.I46_0.net212 XADC.XL.I46_0.qf XADC.XL.I46_0.qf_x XADC.XL.I46_1.clkb XADC.XL.I46_1.clkbb XADC.XL.I46_1.mq XADC.XL.I46_1.mq_x XADC.XL.I46_1.net0118 XADC.XL.I46_1.net0136 XADC.XL.I46_1.net086 XADC.XL.I46_1.net103 XADC.XL.I46_1.net176 XADC.XL.I46_1.net212 XADC.XL.I46_1.qf XADC.XL.I46_1.qf_x XADC.XL.I46_2.clkb XADC.XL.I46_2.clkbb XADC.XL.I46_2.mq XADC.XL.I46_2.mq_x XADC.XL.I46_2.net0118 XADC.XL.I46_2.net0136 XADC.XL.I46_2.net086 XADC.XL.I46_2.net103 XADC.XL.I46_2.net176 XADC.XL.I46_2.net212 XADC.XL.I46_2.qf XADC.XL.I46_2.qf_x XADC.XL.I46_3.clkb XADC.XL.I46_3.clkbb XADC.XL.I46_3.mq XADC.XL.I46_3.mq_x XADC.XL.I46_3.net0118 XADC.XL.I46_3.net0136 XADC.XL.I46_3.net086 XADC.XL.I46_3.net103 XADC.XL.I46_3.net176 XADC.XL.I46_3.net212 XADC.XL.I46_3.qf XADC.XL.I46_3.qf_x XADC.XL.I46_4.clkb XADC.XL.I46_4.clkbb XADC.XL.I46_4.mq XADC.XL.I46_4.mq_x XADC.XL.I46_4.net0118 XADC.XL.I46_4.net0136 XADC.XL.I46_4.net086 XADC.XL.I46_4.net103 XADC.XL.I46_4.net176 XADC.XL.I46_4.net212 XADC.XL.I46_4.qf XADC.XL.I46_4.qf_x XADC.XL.I46_5.clkb XADC.XL.I46_5.clkbb XADC.XL.I46_5.mq XADC.XL.I46_5.mq_x XADC.XL.I46_5.net0118 XADC.XL.I46_5.net0136 XADC.XL.I46_5.net086 XADC.XL.I46_5.net103 XADC.XL.I46_5.net176 XADC.XL.I46_5.net212 XADC.XL.I46_5.qf XADC.XL.I46_5.qf_x XADC.XL.I46_6.clkb XADC.XL.I46_6.clkbb XADC.XL.I46_6.mq XADC.XL.I46_6.mq_x XADC.XL.I46_6.net0118 XADC.XL.I46_6.net0136 XADC.XL.I46_6.net086 XADC.XL.I46_6.net103 XADC.XL.I46_6.net176 XADC.XL.I46_6.net212 XADC.XL.I46_6.qf XADC.XL.I46_6.qf_x XADC.XL.I46_7.clkb XADC.XL.I46_7.clkbb XADC.XL.I46_7.mq XADC.XL.I46_7.mq_x XADC.XL.I46_7.net0118 XADC.XL.I46_7.net0136 XADC.XL.I46_7.net086 XADC.XL.I46_7.net103 XADC.XL.I46_7.net176 XADC.XL.I46_7.net212 XADC.XL.I46_7.qf XADC.XL.I46_7.qf_x XADC.XL.I5.MM0:1 XADC.XL.I5.MM0:2 XADC.XL.I5.MM0:3 XADC.XL.I5.MM0:4 XADC.XL.I5.MM1:1 XADC.XL.I5.MM1:2 XADC.XL.I5.MM1:3 XADC.XL.I5.MM1:4 XADC.XL.I5.MM2:1 XADC.XL.I5.MM2:2 XADC.XL.I5.MM2:3 XADC.XL.I5.MM2:4 XADC.XL.I5.MM3:1 XADC.XL.I5.MM3:2 XADC.XL.I5.MM3:3 XADC.XL.I5.MM3:4 XADC.XL.I5.MM4:1 XADC.XL.I5.MM4:2 XADC.XL.I5.MM4:3 XADC.XL.I5.MM4:4 XADC.XL.I5.MM5:1 XADC.XL.I5.MM5:2 XADC.XL.I5.MM5:3 XADC.XL.I5.MM5:4 XADC.XL.I5.MM61:1 XADC.XL.I5.MM61:2 XADC.XL.I5.MM61:3 XADC.XL.I5.MM61:4 XADC.XL.I5.MM64:1 XADC.XL.I5.MM64:2 XADC.XL.I5.MM64:3 XADC.XL.I5.MM64:4 XADC.XL.I5.MM65:1 XADC.XL.I5.MM65:2 XADC.XL.I5.MM65:3 XADC.XL.I5.MM65:4 XADC.XL.I5.MM76:1 XADC.XL.I5.MM76:2 XADC.XL.I5.MM76:3 XADC.XL.I5.MM76:4 XADC.XL.I5.MM77:1 XADC.XL.I5.MM77:2 XADC.XL.I5.MM77:3 XADC.XL.I5.MM77:4 XADC.XL.I5.MSLTn1:1 XADC.XL.I5.MSLTn1:2 XADC.XL.I5.MSLTn1:3 XADC.XL.I5.MSLTn1:4 XADC.XL.I5.MSLTp1:1 XADC.XL.I5.MSLTp1:2 XADC.XL.I5.MSLTp1:3 XADC.XL.I5.MSLTp1:4 XADC.XL.I5.clkb XADC.XL.I5.clkbb XADC.XL.I5.mq XADC.XL.I5.mq_x XADC.XL.I5.net0138 XADC.XL.I5.net0152 XADC.XL.I5.net093 XADC.XL.I5.net103 XADC.XL.I5.net176 XADC.XL.I5.net184 XADC.XL.I5.net208 XADC.XL.I5.net212 XADC.XL.I5.qf XADC.XL.I5.qf_x XADC.XL.I6.clkb XADC.XL.I6.clkbb XADC.XL.I6.mq XADC.XL.I6.mq_x XADC.XL.I6.net0138 XADC.XL.I6.net0152 XADC.XL.I6.net093 XADC.XL.I6.net103 XADC.XL.I6.net176 XADC.XL.I6.net184 XADC.XL.I6.net208 XADC.XL.I6.net212 XADC.XL.I6.qf XADC.XL.I6.qf_x XADC.XL.I7.clkb XADC.XL.I7.clkbb XADC.XL.I7.mq XADC.XL.I7.mq_x XADC.XL.I7.net0138 XADC.XL.I7.net0152 XADC.XL.I7.net093 XADC.XL.I7.net103 XADC.XL.I7.net176 XADC.XL.I7.net184 XADC.XL.I7.net208 XADC.XL.I7.net212 XADC.XL.I7.qf XADC.XL.I7.qf_x XADC.XL.I8.clkb XADC.XL.I8.clkbb XADC.XL.I8.mq XADC.XL.I8.mq_x XADC.XL.I8.net0138 XADC.XL.I8.net0152 XADC.XL.I8.net093 XADC.XL.I8.net103 XADC.XL.I8.net176 XADC.XL.I8.net184 XADC.XL.I8.net208 XADC.XL.I8.net212 XADC.XL.I8.qf XADC.XL.I8.qf_x XADC.XL.I9.clkb XADC.XL.I9.clkbb XADC.XL.I9.mq XADC.XL.I9.mq_x XADC.XL.I9.net0138 XADC.XL.I9.net0152 XADC.XL.I9.net093 XADC.XL.I9.net103 XADC.XL.I9.net176 XADC.XL.I9.net184 XADC.XL.I9.net208 XADC.XL.I9.net212 XADC.XL.I9.qf XADC.XL.I9.qf_x XADC.XL.VALID XADC.XL.net10 XADC.XL.net12 XADC.XL.net13 XADC.XL.net14 XADC.XL.net2 XADC.XL.net20 XADC.XL.net22 XADC.XL.net23 XADC.XL.net24 XADC.XL.net27 XADC.XL.net28 XADC.XL.net29 XADC.XL.net30 XADC.XL.net31 XADC.XL.net33 XADC.XL.net8 XADC.XN.I1.CLKSB XADC.XN.I1.net1 XADC.XN.I1.net2 XADC.XN.I1.net3 XADC.XN.I1.net4 XADC.XN.I1.net7 XADC.XN.net1 XADC.XN.net2 XADC.XN.net3 XADC.XN.net4 XADC.XN.net5 XADC.XN.net6 XADC.XN.net7 XADC.XP.I1.CLKSB XADC.XP.I1.net1 XADC.XP.I1.net2 XADC.XP.I1.net3 XADC.XP.I1.net4 XADC.XP.I1.net7 XADC.XP.net1 XADC.XP.net2 XADC.XP.net3 XADC.XP.net4 XADC.XP.net5 XADC.XP.net6 XADC.XP.net7
