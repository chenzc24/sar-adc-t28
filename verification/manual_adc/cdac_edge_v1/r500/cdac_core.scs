simulator lang=spectre
// Original MOS and capacitor lines retained verbatim; Bootstrap excluded.
subckt manual_cdac_core GND VDD VTOP VREFP VREFN DCTRL_7 DCTRL_6 DCTRL_5 DCTRL_4 DCTRL_3 DCTRL_2 DCTRL_1
parameters cunit=10f
C7 (VTOP net4) capacitor c=4*cunit
C6 (VTOP 0) capacitor c=cunit
C5 (VTOP net1) capacitor c=cunit
C4 (VTOP net2) capacitor c=2*cunit
C3 (VTOP net5) capacitor c=16*cunit
C2 (VTOP net3) capacitor c=8*cunit
C1 (VTOP net6) capacitor c=32*cunit
C0 (VTOP net7) capacitor c=64*cunit
M12 (net1 DCTRL_1 VREFP VDD) pch_mac l=100n w=3u multi=2 nf=10          sd=120.0n ad=1.8e-13 as=2.01e-13 pd=4.2u ps=4.94u nrd=0.065737          nrs=0.065737 sa=551.022n sb=551.022n sa1=212.829n sa2=458.86n          sa3=727.268n sa4=476.12n sb1=212.829n sb2=458.86n sb3=727.268n          spa=120.0n spa1=120.0n spa2=120.0n spa3=120.0n sap=191.293n          sapb=215.014n spba=162.129n spba1=166.371n dfm_flag=0          spmt=1.11111e+15 spomt=0 spomt1=1.11111e+60 spmb=1.11111e+15          spomb=0 spomb1=1.11111e+60
M9 (net2 DCTRL_2 VREFP VDD) pch_mac l=100n w=3u multi=4 nf=10 sd=120.0n          ad=1.8e-13 as=2.01e-13 pd=4.2u ps=4.94u nrd=0.065737 nrs=0.065737          sa=551.022n sb=551.022n sa1=212.829n sa2=458.86n sa3=727.268n          sa4=476.12n sb1=212.829n sb2=458.86n sb3=727.268n spa=120.0n          spa1=120.0n spa2=120.0n spa3=120.0n sap=191.293n sapb=215.014n          spba=162.129n spba1=166.371n dfm_flag=0 spmt=1.11111e+15 spomt=0          spomt1=1.11111e+60 spmb=1.11111e+15 spomb=0 spomb1=1.11111e+60
M8 (net4 DCTRL_3 VREFP VDD) pch_mac l=100n w=3u multi=8 nf=10 sd=120.0n          ad=1.8e-13 as=2.01e-13 pd=4.2u ps=4.94u nrd=0.065737 nrs=0.065737          sa=551.022n sb=551.022n sa1=212.829n sa2=458.86n sa3=727.268n          sa4=476.12n sb1=212.829n sb2=458.86n sb3=727.268n spa=120.0n          spa1=120.0n spa2=120.0n spa3=120.0n sap=191.293n sapb=215.014n          spba=162.129n spba1=166.371n dfm_flag=0 spmt=1.11111e+15 spomt=0          spomt1=1.11111e+60 spmb=1.11111e+15 spomb=0 spomb1=1.11111e+60
M6 (net3 DCTRL_4 VREFP VDD) pch_mac l=100n w=3u multi=16 nf=10          sd=120.0n ad=1.8e-13 as=2.01e-13 pd=4.2u ps=4.94u nrd=0.065737          nrs=0.065737 sa=551.022n sb=551.022n sa1=212.829n sa2=458.86n          sa3=727.268n sa4=476.12n sb1=212.829n sb2=458.86n sb3=727.268n          spa=120.0n spa1=120.0n spa2=120.0n spa3=120.0n sap=191.293n          sapb=215.014n spba=162.129n spba1=166.371n dfm_flag=0          spmt=1.11111e+15 spomt=0 spomt1=1.11111e+60 spmb=1.11111e+15          spomb=0 spomb1=1.11111e+60
M5 (net5 DCTRL_5 VREFP VDD) pch_mac l=100n w=3u multi=32 nf=10          sd=120.0n ad=1.8e-13 as=2.01e-13 pd=4.2u ps=4.94u nrd=0.065737          nrs=0.065737 sa=551.022n sb=551.022n sa1=212.829n sa2=458.86n          sa3=727.268n sa4=476.12n sb1=212.829n sb2=458.86n sb3=727.268n          spa=120.0n spa1=120.0n spa2=120.0n spa3=120.0n sap=191.293n          sapb=215.014n spba=162.129n spba1=166.371n dfm_flag=0          spmt=1.11111e+15 spomt=0 spomt1=1.11111e+60 spmb=1.11111e+15          spomb=0 spomb1=1.11111e+60
M4 (net6 DCTRL_6 VREFP VDD) pch_mac l=100n w=3u multi=64 nf=10          sd=120.0n ad=1.8e-13 as=2.01e-13 pd=4.2u ps=4.94u nrd=0.065737          nrs=0.065737 sa=551.022n sb=551.022n sa1=212.829n sa2=458.86n          sa3=727.268n sa4=476.12n sb1=212.829n sb2=458.86n sb3=727.268n          spa=120.0n spa1=120.0n spa2=120.0n spa3=120.0n sap=191.293n          sapb=215.014n spba=162.129n spba1=166.371n dfm_flag=0          spmt=1.11111e+15 spomt=0 spomt1=1.11111e+60 spmb=1.11111e+15          spomb=0 spomb1=1.11111e+60
M0 (net7 DCTRL_7 VREFP VDD) pch_mac l=100n w=3u multi=128 nf=10          sd=120.0n ad=1.8e-13 as=2.01e-13 pd=4.2u ps=4.94u nrd=0.065737          nrs=0.065737 sa=551.022n sb=551.022n sa1=212.829n sa2=458.86n          sa3=727.268n sa4=476.12n sb1=212.829n sb2=458.86n sb3=727.268n          spa=120.0n spa1=120.0n spa2=120.0n spa3=120.0n sap=191.293n          sapb=215.014n spba=162.129n spba1=166.371n dfm_flag=0          spmt=1.11111e+15 spomt=0 spomt1=1.11111e+60 spmb=1.11111e+15          spomb=0 spomb1=1.11111e+60
M14 (net1 DCTRL_1 VREFN GND) nch_mac l=30n w=1u multi=2 nf=10 sd=100n          ad=5e-14 as=5.5e-14 pd=2u ps=2.3u nrd=0.427491 nrs=0.427491          sa=349.754n sb=349.754n sa1=161.047n sa2=316.499n sa3=575.493n          sa4=331.707n sb1=161.047n sb2=316.499n sb3=575.493n spa=100n          spa1=100n spa2=100n spa3=100n sap=150.407n sapb=165.494n          spba=115.715n spba1=117.043n dfm_flag=0 spmt=1.11111e+15 spomt=0          spomt1=1.11111e+60 spmb=1.11111e+15 spomb=0 spomb1=1.11111e+60
M11 (net2 DCTRL_2 VREFN GND) nch_mac l=30n w=1u multi=4 nf=10 sd=100n          ad=5e-14 as=5.5e-14 pd=2u ps=2.3u nrd=0.427491 nrs=0.427491          sa=349.754n sb=349.754n sa1=161.047n sa2=316.499n sa3=575.493n          sa4=331.707n sb1=161.047n sb2=316.499n sb3=575.493n spa=100n          spa1=100n spa2=100n spa3=100n sap=150.407n sapb=165.494n          spba=115.715n spba1=117.043n dfm_flag=0 spmt=1.11111e+15 spomt=0          spomt1=1.11111e+60 spmb=1.11111e+15 spomb=0 spomb1=1.11111e+60
M10 (net4 DCTRL_3 VREFN GND) nch_mac l=30n w=1u multi=8 nf=10 sd=100n          ad=5e-14 as=5.5e-14 pd=2u ps=2.3u nrd=0.427491 nrs=0.427491          sa=349.754n sb=349.754n sa1=161.047n sa2=316.499n sa3=575.493n          sa4=331.707n sb1=161.047n sb2=316.499n sb3=575.493n spa=100n          spa1=100n spa2=100n spa3=100n sap=150.407n sapb=165.494n          spba=115.715n spba1=117.043n dfm_flag=0 spmt=1.11111e+15 spomt=0          spomt1=1.11111e+60 spmb=1.11111e+15 spomb=0 spomb1=1.11111e+60
M7 (net3 DCTRL_4 VREFN GND) nch_mac l=30n w=1u multi=16 nf=10 sd=100n          ad=5e-14 as=5.5e-14 pd=2u ps=2.3u nrd=0.427491 nrs=0.427491          sa=349.754n sb=349.754n sa1=161.047n sa2=316.499n sa3=575.493n          sa4=331.707n sb1=161.047n sb2=316.499n sb3=575.493n spa=100n          spa1=100n spa2=100n spa3=100n sap=150.407n sapb=165.494n          spba=115.715n spba1=117.043n dfm_flag=0 spmt=1.11111e+15 spomt=0          spomt1=1.11111e+60 spmb=1.11111e+15 spomb=0 spomb1=1.11111e+60
M3 (net5 DCTRL_5 VREFN GND) nch_mac l=30n w=1u multi=32 nf=10 sd=100n          ad=5e-14 as=5.5e-14 pd=2u ps=2.3u nrd=0.427491 nrs=0.427491          sa=349.754n sb=349.754n sa1=161.047n sa2=316.499n sa3=575.493n          sa4=331.707n sb1=161.047n sb2=316.499n sb3=575.493n spa=100n          spa1=100n spa2=100n spa3=100n sap=150.407n sapb=165.494n          spba=115.715n spba1=117.043n dfm_flag=0 spmt=1.11111e+15 spomt=0          spomt1=1.11111e+60 spmb=1.11111e+15 spomb=0 spomb1=1.11111e+60
M2 (net6 DCTRL_6 VREFN GND) nch_mac l=30n w=1u multi=64 nf=10 sd=100n          ad=5e-14 as=5.5e-14 pd=2u ps=2.3u nrd=0.427491 nrs=0.427491          sa=349.754n sb=349.754n sa1=161.047n sa2=316.499n sa3=575.493n          sa4=331.707n sb1=161.047n sb2=316.499n sb3=575.493n spa=100n          spa1=100n spa2=100n spa3=100n sap=150.407n sapb=165.494n          spba=115.715n spba1=117.043n dfm_flag=0 spmt=1.11111e+15 spomt=0          spomt1=1.11111e+60 spmb=1.11111e+15 spomb=0 spomb1=1.11111e+60
M1 (net7 DCTRL_7 VREFN GND) nch_mac l=30n w=1u multi=128 nf=10 sd=100n          ad=5e-14 as=5.5e-14 pd=2u ps=2.3u nrd=0.427491 nrs=0.427491          sa=349.754n sb=349.754n sa1=161.047n sa2=316.499n sa3=575.493n          sa4=331.707n sb1=161.047n sb2=316.499n sb3=575.493n spa=100n          spa1=100n spa2=100n spa3=100n sap=150.407n sapb=165.494n          spba=115.715n spba1=117.043n dfm_flag=0 spmt=1.11111e+15 spomt=0          spomt1=1.11111e+60 spmb=1.11111e+15 spomb=0 spomb1=1.11111e+60
ends manual_cdac_core
