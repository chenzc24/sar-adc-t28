simulator lang=spectre
include "models.scs"
include "dut.scs"
VVDD (VDD 0) vsource dc=.9
VCLK (CLKS 0) vsource type=pulse val0=0 val1=.9 delay=10n rise=50p fall=50p width=39.9n period=100n
VREF (REF 0) vsource dc=.9
VINP (VINP 0) vsource type=pwl wave=[0n 0.5 110n 0.5 110.05n 0.1 210n 0.1 210.05n 0.8 310n 0.8 310.05n 0.46]
VINN (VINN 0) vsource type=pwl wave=[0n 0.4 110n 0.4 110.05n 0.8 210n 0.8 210.05n 0.1 310n 0.1 310.05n 0.44]
XADC (CLKS 0 VDD VINP VINN REF 0 DO_7 DO_6 DO_5 DO_4 DO_3 DO_2 DO_1 DO_0) manual_adc main_mult=4
simulatorOptions options reltol=1e-5 vabstol=1e-7 iabstol=1e-13 temp=27 tnom=27 gmin=1e-12 checklimitdest=psf
saveOptions options save=selected currents=selected
tran_test tran stop=420n maxstep=20p errpreset=conservative
save CLKS DO_0 DO_1 DO_2 DO_3 DO_4 DO_5 DO_6 DO_7 REF VCLK:1 VDD VINN VINN:1 VINP VINP:1 VREF:1 VVDD:1 XADC.CMPCK XADC.DCMPN XADC.DCMPP XADC.DN_0 XADC.DN_1 XADC.DN_2 XADC.DN_3 XADC.DN_4 XADC.DN_5 XADC.DN_6 XADC.DN_7 XADC.DP_0 XADC.DP_1 XADC.DP_2 XADC.DP_3 XADC.DP_4 XADC.DP_5 XADC.DP_6 XADC.DP_7 XADC.TOPN XADC.TOPP XADC.XC.LN XADC.XC.LP XADC.XC.net1 XADC.XC.net2 XADC.XC.net3 XADC.XL.CLK_0 XADC.XL.CLK_1 XADC.XL.CLK_2 XADC.XL.CLK_3 XADC.XL.CLK_4 XADC.XL.CLK_5 XADC.XL.CLK_6 XADC.XL.CLK_7 XADC.XN.I1.CLKSB XADC.XN.I1.net1 XADC.XN.I1.net2 XADC.XN.I1.net3 XADC.XN.I1.net4 XADC.XN.I1.net7 XADC.XN.net1 XADC.XN.net2 XADC.XN.net3 XADC.XN.net4 XADC.XN.net5 XADC.XN.net6 XADC.XN.net7 XADC.XP.I1.CLKSB XADC.XP.I1.net1 XADC.XP.I1.net2 XADC.XP.I1.net3 XADC.XP.I1.net4 XADC.XP.I1.net7 XADC.XP.net1 XADC.XP.net2 XADC.XP.net3 XADC.XP.net4 XADC.XP.net5 XADC.XP.net6 XADC.XP.net7
