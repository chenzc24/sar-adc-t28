// Native-derived candidate, external standard library unchanged.

subckt manual_boot CLKS GND VDD VIN VOUT
parameters main_mult=1
M11 (CLKSB CLKS GND GND) nch_mac l=30n w=100n multi=1 nf=1 sd=100n          ad=7.5e-15 as=7.5e-15 pd=350.0n ps=350.0n nrd=2.576626          nrs=2.576626 sa=75.0n sb=75.0n sa1=75.0n sa2=75.0n sa3=75.0n          sa4=75.0n sb1=75.0n sb2=75.0n sb3=75.0n spa=100n spa1=100n          spa2=100n spa3=100n sap=91.9776n sapb=114.444n spba=115.715n          spba1=117.043n dfm_flag=0 spmt=1.11111e+15 spomt=0          spomt1=1.11111e+60 spmb=1.11111e+15 spomb=0 spomb1=1.11111e+60
M9 (net7 CLKSB GND GND) nch_mac l=30n w=100n multi=1 nf=1 sd=100n          ad=7.5e-15 as=7.5e-15 pd=350.0n ps=350.0n nrd=2.576626          nrs=2.576626 sa=75.0n sb=75.0n sa1=75.0n sa2=75.0n sa3=75.0n          sa4=75.0n sb1=75.0n sb2=75.0n sb3=75.0n spa=100n spa1=100n          spa2=100n spa3=100n sap=91.9776n sapb=114.444n spba=115.715n          spba1=117.043n dfm_flag=0 spmt=1.11111e+15 spomt=0          spomt1=1.11111e+60 spmb=1.11111e+15 spomb=0 spomb1=1.11111e+60
M8 (net1 VDD net7 GND) nch_mac l=30n w=100n multi=1 nf=1 sd=100n          ad=7.5e-15 as=7.5e-15 pd=350.0n ps=350.0n nrd=2.576626          nrs=2.576626 sa=75.0n sb=75.0n sa1=75.0n sa2=75.0n sa3=75.0n          sa4=75.0n sb1=75.0n sb2=75.0n sb3=75.0n spa=100n spa1=100n          spa2=100n spa3=100n sap=91.9776n sapb=114.444n spba=115.715n          spba1=117.043n dfm_flag=0 spmt=1.11111e+15 spomt=0          spomt1=1.11111e+60 spmb=1.11111e+15 spomb=0 spomb1=1.11111e+60
M7 (net4 CLKS net3 GND) nch_mac l=30n w=100n multi=1 nf=1 sd=100n          ad=7.5e-15 as=7.5e-15 pd=350.0n ps=350.0n nrd=2.576626          nrs=2.576626 sa=75.0n sb=75.0n sa1=75.0n sa2=75.0n sa3=75.0n          sa4=75.0n sb1=75.0n sb2=75.0n sb3=75.0n spa=100n spa1=100n          spa2=100n spa3=100n sap=91.9776n sapb=114.444n spba=115.715n          spba1=117.043n dfm_flag=0 spmt=1.11111e+15 spomt=0          spomt1=1.11111e+60 spmb=1.11111e+15 spomb=0 spomb1=1.11111e+60
M5 (net4 net1 net3 GND) nch_mac l=30n w=100n multi=1 nf=1 sd=100n          ad=7.5e-15 as=7.5e-15 pd=350.0n ps=350.0n nrd=2.576626          nrs=2.576626 sa=75.0n sb=75.0n sa1=75.0n sa2=75.0n sa3=75.0n          sa4=75.0n sb1=75.0n sb2=75.0n sb3=75.0n spa=100n spa1=100n          spa2=100n spa3=100n sap=91.9776n sapb=114.444n spba=115.715n          spba1=117.043n dfm_flag=0 spmt=1.11111e+15 spomt=0          spomt1=1.11111e+60 spmb=1.11111e+15 spomb=0 spomb1=1.11111e+60
M4 (net3 CLKSB GND GND) nch_mac l=30n w=100n multi=1 nf=1 sd=100n          ad=7.5e-15 as=7.5e-15 pd=350.0n ps=350.0n nrd=2.576626          nrs=2.576626 sa=75.0n sb=75.0n sa1=75.0n sa2=75.0n sa3=75.0n          sa4=75.0n sb1=75.0n sb2=75.0n sb3=75.0n spa=100n spa1=100n          spa2=100n spa3=100n sap=91.9776n sapb=114.444n spba=115.715n          spba1=117.043n dfm_flag=0 spmt=1.11111e+15 spomt=0          spomt1=1.11111e+60 spmb=1.11111e+15 spomb=0 spomb1=1.11111e+60
M2 (net3 net1 VIN GND) nch_mac l=30n w=100n multi=1 nf=1 sd=100n          ad=7.5e-15 as=7.5e-15 pd=350.0n ps=350.0n nrd=2.576626          nrs=2.576626 sa=75.0n sb=75.0n sa1=75.0n sa2=75.0n sa3=75.0n          sa4=75.0n sb1=75.0n sb2=75.0n sb3=75.0n spa=100n spa1=100n          spa2=100n spa3=100n sap=91.9776n sapb=114.444n spba=115.715n          spba1=117.043n dfm_flag=0 spmt=1.11111e+15 spomt=0          spomt1=1.11111e+60 spmb=1.11111e+15 spomb=0 spomb1=1.11111e+60
M0 (VOUT net1 VIN GND) nch_mac l=30n w=100n multi=main_mult nf=1 sd=100n          ad=7.5e-15 as=7.5e-15 pd=350.0n ps=350.0n nrd=2.576626          nrs=2.576626 sa=75.0n sb=75.0n sa1=75.0n sa2=75.0n sa3=75.0n          sa4=75.0n sb1=75.0n sb2=75.0n sb3=75.0n spa=100n spa1=100n          spa2=100n spa3=100n sap=91.9776n sapb=114.444n spba=115.715n          spba1=117.043n dfm_flag=0 spmt=1.11111e+15 spomt=0          spomt1=1.11111e+60 spmb=1.11111e+15 spomb=0 spomb1=1.11111e+60
C0 (net2 net3) capacitor c=1p
M10 (CLKSB CLKS VDD VDD) pch_mac l=30n w=100n multi=1 nf=1 sd=100n          ad=7.5e-15 as=7.5e-15 pd=350.0n ps=350.0n nrd=1.466664          nrs=1.466664 sa=75.0n sb=75.0n sa1=75.0n sa2=75.0n sa3=75.0n          sa4=75.0n sb1=75.0n sb2=75.0n sb3=75.0n spa=100n spa1=100n          spa2=100n spa3=100n sap=91.9776n sapb=114.444n spba=115.715n          spba1=117.043n dfm_flag=0 spmt=1.11111e+15 spomt=0          spomt1=1.11111e+60 spmb=1.11111e+15 spomb=0 spomb1=1.11111e+60
M6 (net4 CLKS VDD VDD) pch_mac l=30n w=100n multi=1 nf=1 sd=100n          ad=7.5e-15 as=7.5e-15 pd=350.0n ps=350.0n nrd=1.466664          nrs=1.466664 sa=75.0n sb=75.0n sa1=75.0n sa2=75.0n sa3=75.0n          sa4=75.0n sb1=75.0n sb2=75.0n sb3=75.0n spa=100n spa1=100n          spa2=100n spa3=100n sap=91.9776n sapb=114.444n spba=115.715n          spba1=117.043n dfm_flag=0 spmt=1.11111e+15 spomt=0          spomt1=1.11111e+60 spmb=1.11111e+15 spomb=0 spomb1=1.11111e+60
M3 (net1 net4 net2 net2) pch_mac l=30n w=100n multi=1 nf=1 sd=100n          ad=7.5e-15 as=7.5e-15 pd=350.0n ps=350.0n nrd=1.466664          nrs=1.466664 sa=75.0n sb=75.0n sa1=75.0n sa2=75.0n sa3=75.0n          sa4=75.0n sb1=75.0n sb2=75.0n sb3=75.0n spa=100n spa1=100n          spa2=100n spa3=100n sap=91.9776n sapb=114.444n spba=115.715n          spba1=117.043n dfm_flag=0 spmt=1.11111e+15 spomt=0          spomt1=1.11111e+60 spmb=1.11111e+15 spomb=0 spomb1=1.11111e+60
M1 (net2 net1 VDD net2) pch_mac l=30n w=100n multi=1 nf=1 sd=100n          ad=7.5e-15 as=7.5e-15 pd=350.0n ps=350.0n nrd=1.466664          nrs=1.466664 sa=75.0n sb=75.0n sa1=75.0n sa2=75.0n sa3=75.0n          sa4=75.0n sb1=75.0n sb2=75.0n sb3=75.0n spa=100n spa1=100n          spa2=100n spa3=100n sap=91.9776n sapb=114.444n spba=115.715n          spba1=117.043n dfm_flag=0 spmt=1.11111e+15 spomt=0          spomt1=1.11111e+60 spmb=1.11111e+15 spomb=0 spomb1=1.11111e+60
ends manual_boot

subckt manual_cmp CLK VINP VINN VDD GND DCMPP DCMPN
parameters cmp_mult=1
M13 (DCMPN LN VDD VDD) pch_mac l=30n w=100n multi=cmp_mult nf=1 sd=100n          ad=7.5e-15 as=7.5e-15 pd=350.0n ps=350.0n nrd=1.466664          nrs=1.466664 sa=75.0n sb=75.0n sa1=75.0n sa2=75.0n sa3=75.0n          sa4=75.0n sb1=75.0n sb2=75.0n sb3=75.0n spa=100n spa1=100n          spa2=100n spa3=100n sap=91.9776n sapb=114.444n spba=115.715n          spba1=117.043n dfm_flag=0 spmt=1.11111e+15 spomt=0          spomt1=1.11111e+60 spmb=1.11111e+15 spomb=0 spomb1=1.11111e+60
M11 (DCMPP LP VDD VDD) pch_mac l=30n w=100n multi=cmp_mult nf=1 sd=100n          ad=7.5e-15 as=7.5e-15 pd=350.0n ps=350.0n nrd=1.466664          nrs=1.466664 sa=75.0n sb=75.0n sa1=75.0n sa2=75.0n sa3=75.0n          sa4=75.0n sb1=75.0n sb2=75.0n sb3=75.0n spa=100n spa1=100n          spa2=100n spa3=100n sap=91.9776n sapb=114.444n spba=115.715n          spba1=117.043n dfm_flag=0 spmt=1.11111e+15 spomt=0          spomt1=1.11111e+60 spmb=1.11111e+15 spomb=0 spomb1=1.11111e+60
M5 (net2 CLK VDD VDD) pch_mac l=30n w=100n multi=cmp_mult nf=1 sd=100n ad=7.5e-15          as=7.5e-15 pd=350.0n ps=350.0n nrd=1.466664 nrs=1.466664 sa=75.0n          sb=75.0n sa1=75.0n sa2=75.0n sa3=75.0n sa4=75.0n sb1=75.0n          sb2=75.0n sb3=75.0n spa=100n spa1=100n spa2=100n spa3=100n          sap=91.9776n sapb=114.444n spba=115.715n spba1=117.043n dfm_flag=0          spmt=1.11111e+15 spomt=0 spomt1=1.11111e+60 spmb=1.11111e+15          spomb=0 spomb1=1.11111e+60
M4 (LN CLK VDD VDD) pch_mac l=30n w=100n multi=cmp_mult nf=1 sd=100n ad=7.5e-15          as=7.5e-15 pd=350.0n ps=350.0n nrd=1.466664 nrs=1.466664 sa=75.0n          sb=75.0n sa1=75.0n sa2=75.0n sa3=75.0n sa4=75.0n sb1=75.0n          sb2=75.0n sb3=75.0n spa=100n spa1=100n spa2=100n spa3=100n          sap=91.9776n sapb=114.444n spba=115.715n spba1=117.043n dfm_flag=0          spmt=1.11111e+15 spomt=0 spomt1=1.11111e+60 spmb=1.11111e+15          spomb=0 spomb1=1.11111e+60
M3 (net1 CLK VDD VDD) pch_mac l=30n w=100n multi=cmp_mult nf=1 sd=100n ad=7.5e-15          as=7.5e-15 pd=350.0n ps=350.0n nrd=1.466664 nrs=1.466664 sa=75.0n          sb=75.0n sa1=75.0n sa2=75.0n sa3=75.0n sa4=75.0n sb1=75.0n          sb2=75.0n sb3=75.0n spa=100n spa1=100n spa2=100n spa3=100n          sap=91.9776n sapb=114.444n spba=115.715n spba1=117.043n dfm_flag=0          spmt=1.11111e+15 spomt=0 spomt1=1.11111e+60 spmb=1.11111e+15          spomb=0 spomb1=1.11111e+60
M2 (LP CLK VDD VDD) pch_mac l=30n w=100n multi=cmp_mult nf=1 sd=100n ad=7.5e-15          as=7.5e-15 pd=350.0n ps=350.0n nrd=1.466664 nrs=1.466664 sa=75.0n          sb=75.0n sa1=75.0n sa2=75.0n sa3=75.0n sa4=75.0n sb1=75.0n          sb2=75.0n sb3=75.0n spa=100n spa1=100n spa2=100n spa3=100n          sap=91.9776n sapb=114.444n spba=115.715n spba1=117.043n dfm_flag=0          spmt=1.11111e+15 spomt=0 spomt1=1.11111e+60 spmb=1.11111e+15          spomb=0 spomb1=1.11111e+60
M0 (LP LN VDD VDD) pch_mac l=30n w=100n multi=cmp_mult nf=1 sd=100n ad=7.5e-15          as=7.5e-15 pd=350.0n ps=350.0n nrd=1.466664 nrs=1.466664 sa=75.0n          sb=75.0n sa1=75.0n sa2=75.0n sa3=75.0n sa4=75.0n sb1=75.0n          sb2=75.0n sb3=75.0n spa=100n spa1=100n spa2=100n spa3=100n          sap=91.9776n sapb=114.444n spba=115.715n spba1=117.043n dfm_flag=0          spmt=1.11111e+15 spomt=0 spomt1=1.11111e+60 spmb=1.11111e+15          spomb=0 spomb1=1.11111e+60
M1 (LN LP VDD VDD) pch_mac l=30n w=100n multi=cmp_mult nf=1 sd=100n ad=7.5e-15          as=7.5e-15 pd=350.0n ps=350.0n nrd=1.466664 nrs=1.466664 sa=75.0n          sb=75.0n sa1=75.0n sa2=75.0n sa3=75.0n sa4=75.0n sb1=75.0n          sb2=75.0n sb3=75.0n spa=100n spa1=100n spa2=100n spa3=100n          sap=91.9776n sapb=114.444n spba=115.715n spba1=117.043n dfm_flag=0          spmt=1.11111e+15 spomt=0 spomt1=1.11111e+60 spmb=1.11111e+15          spomb=0 spomb1=1.11111e+60
M14 (DCMPN LN GND GND) nch_mac l=30n w=100n multi=cmp_mult nf=1 sd=100n          ad=7.5e-15 as=7.5e-15 pd=350.0n ps=350.0n nrd=2.576626          nrs=2.576626 sa=75.0n sb=75.0n sa1=75.0n sa2=75.0n sa3=75.0n          sa4=75.0n sb1=75.0n sb2=75.0n sb3=75.0n spa=100n spa1=100n          spa2=100n spa3=100n sap=91.9776n sapb=114.444n spba=115.715n          spba1=117.043n dfm_flag=0 spmt=1.11111e+15 spomt=0          spomt1=1.11111e+60 spmb=1.11111e+15 spomb=0 spomb1=1.11111e+60
M12 (DCMPP LP GND GND) nch_mac l=30n w=100n multi=cmp_mult nf=1 sd=100n          ad=7.5e-15 as=7.5e-15 pd=350.0n ps=350.0n nrd=2.576626          nrs=2.576626 sa=75.0n sb=75.0n sa1=75.0n sa2=75.0n sa3=75.0n          sa4=75.0n sb1=75.0n sb2=75.0n sb3=75.0n spa=100n spa1=100n          spa2=100n spa3=100n sap=91.9776n sapb=114.444n spba=115.715n          spba1=117.043n dfm_flag=0 spmt=1.11111e+15 spomt=0          spomt1=1.11111e+60 spmb=1.11111e+15 spomb=0 spomb1=1.11111e+60
M10 (net3 CLK GND GND) nch_mac l=30n w=100n multi=cmp_mult nf=1 sd=100n          ad=7.5e-15 as=7.5e-15 pd=350.0n ps=350.0n nrd=2.576626          nrs=2.576626 sa=75.0n sb=75.0n sa1=75.0n sa2=75.0n sa3=75.0n          sa4=75.0n sb1=75.0n sb2=75.0n sb3=75.0n spa=100n spa1=100n          spa2=100n spa3=100n sap=91.9776n sapb=114.444n spba=115.715n          spba1=117.043n dfm_flag=0 spmt=1.11111e+15 spomt=0          spomt1=1.11111e+60 spmb=1.11111e+15 spomb=0 spomb1=1.11111e+60
M9 (net2 VINN net3 GND) nch_mac l=30n w=100n multi=cmp_mult nf=1 sd=100n          ad=7.5e-15 as=7.5e-15 pd=350.0n ps=350.0n nrd=2.576626          nrs=2.576626 sa=75.0n sb=75.0n sa1=75.0n sa2=75.0n sa3=75.0n          sa4=75.0n sb1=75.0n sb2=75.0n sb3=75.0n spa=100n spa1=100n          spa2=100n spa3=100n sap=91.9776n sapb=114.444n spba=115.715n          spba1=117.043n dfm_flag=0 spmt=1.11111e+15 spomt=0          spomt1=1.11111e+60 spmb=1.11111e+15 spomb=0 spomb1=1.11111e+60
M8 (net1 VINP net3 GND) nch_mac l=30n w=100n multi=cmp_mult nf=1 sd=100n          ad=7.5e-15 as=7.5e-15 pd=350.0n ps=350.0n nrd=2.576626          nrs=2.576626 sa=75.0n sb=75.0n sa1=75.0n sa2=75.0n sa3=75.0n          sa4=75.0n sb1=75.0n sb2=75.0n sb3=75.0n spa=100n spa1=100n          spa2=100n spa3=100n sap=91.9776n sapb=114.444n spba=115.715n          spba1=117.043n dfm_flag=0 spmt=1.11111e+15 spomt=0          spomt1=1.11111e+60 spmb=1.11111e+15 spomb=0 spomb1=1.11111e+60
M7 (LN LP net2 GND) nch_mac l=30n w=100n multi=cmp_mult nf=1 sd=100n ad=7.5e-15          as=7.5e-15 pd=350.0n ps=350.0n nrd=2.576626 nrs=2.576626 sa=75.0n          sb=75.0n sa1=75.0n sa2=75.0n sa3=75.0n sa4=75.0n sb1=75.0n          sb2=75.0n sb3=75.0n spa=100n spa1=100n spa2=100n spa3=100n          sap=91.9776n sapb=114.444n spba=115.715n spba1=117.043n dfm_flag=0          spmt=1.11111e+15 spomt=0 spomt1=1.11111e+60 spmb=1.11111e+15          spomb=0 spomb1=1.11111e+60
M6 (LP LN net1 GND) nch_mac l=30n w=100n multi=cmp_mult nf=1 sd=100n ad=7.5e-15          as=7.5e-15 pd=350.0n ps=350.0n nrd=2.576626 nrs=2.576626 sa=75.0n          sb=75.0n sa1=75.0n sa2=75.0n sa3=75.0n sa4=75.0n sb1=75.0n          sb2=75.0n sb3=75.0n spa=100n spa1=100n spa2=100n spa3=100n          sap=91.9776n sapb=114.444n spba=115.715n spba1=117.043n dfm_flag=0          spmt=1.11111e+15 spomt=0 spomt1=1.11111e+60 spmb=1.11111e+15          spomb=0 spomb1=1.11111e+60
ends manual_cmp

subckt manual_cdac CLKS GND VDD VIN VTOP VREFP VREFN DCTRL_7 DCTRL_6 DCTRL_5 DCTRL_4 DCTRL_3 DCTRL_2 DCTRL_1
parameters cunit=10f main_mult=1
C7 (VTOP net4) capacitor c=4*cunit
C6 (VTOP 0) capacitor c=cunit
C5 (VTOP net1) capacitor c=cunit
C4 (VTOP net2) capacitor c=2*cunit
C3 (VTOP net5) capacitor c=16*cunit
C2 (VTOP net3) capacitor c=8*cunit
C1 (VTOP net6) capacitor c=32*cunit
C0 (VTOP net7) capacitor c=64*cunit
M12 (net1 DCTRL_1 VREFP VDD) pch_mac l=100n w=3u multi=2 nf=10          sd=120.0n ad=1.8e-13 as=2.01e-13 pd=4.2u ps=4.94u nrd=0.065737          nrs=0.065737 sa=551.022n sb=551.022n sa1=212.829n sa2=458.86n          sa3=727.268n sa4=476.12n sb1=212.829n sb2=458.86n sb3=727.268n          spa=120.0n spa1=120.0n spa2=120.0n spa3=120.0n sap=191.293n          sapb=215.014n spba=162.129n spba1=166.371n dfm_flag=0          spmt=1.11111e+15 spomt=0 spomt1=1.11111e+60 spmb=1.11111e+15          spomb=0 spomb1=1.11111e+60
M9 (net2 DCTRL_2 VREFP VDD) pch_mac l=100n w=3u multi=4 nf=10 sd=120.0n          ad=1.8e-13 as=2.01e-13 pd=4.2u ps=4.94u nrd=0.065737 nrs=0.065737          sa=551.022n sb=551.022n sa1=212.829n sa2=458.86n sa3=727.268n          sa4=476.12n sb1=212.829n sb2=458.86n sb3=727.268n spa=120.0n          spa1=120.0n spa2=120.0n spa3=120.0n sap=191.293n sapb=215.014n          spba=162.129n spba1=166.371n dfm_flag=0 spmt=1.11111e+15 spomt=0          spomt1=1.11111e+60 spmb=1.11111e+15 spomb=0 spomb1=1.11111e+60
M8 (net4 DCTRL_3 VREFP VDD) pch_mac l=100n w=3u multi=8 nf=10 sd=120.0n          ad=1.8e-13 as=2.01e-13 pd=4.2u ps=4.94u nrd=0.065737 nrs=0.065737          sa=551.022n sb=551.022n sa1=212.829n sa2=458.86n sa3=727.268n          sa4=476.12n sb1=212.829n sb2=458.86n sb3=727.268n spa=120.0n          spa1=120.0n spa2=120.0n spa3=120.0n sap=191.293n sapb=215.014n          spba=162.129n spba1=166.371n dfm_flag=0 spmt=1.11111e+15 spomt=0          spomt1=1.11111e+60 spmb=1.11111e+15 spomb=0 spomb1=1.11111e+60
M6 (net3 DCTRL_4 VREFP VDD) pch_mac l=100n w=3u multi=16 nf=10          sd=120.0n ad=1.8e-13 as=2.01e-13 pd=4.2u ps=4.94u nrd=0.065737          nrs=0.065737 sa=551.022n sb=551.022n sa1=212.829n sa2=458.86n          sa3=727.268n sa4=476.12n sb1=212.829n sb2=458.86n sb3=727.268n          spa=120.0n spa1=120.0n spa2=120.0n spa3=120.0n sap=191.293n          sapb=215.014n spba=162.129n spba1=166.371n dfm_flag=0          spmt=1.11111e+15 spomt=0 spomt1=1.11111e+60 spmb=1.11111e+15          spomb=0 spomb1=1.11111e+60
M5 (net5 DCTRL_5 VREFP VDD) pch_mac l=100n w=3u multi=32 nf=10          sd=120.0n ad=1.8e-13 as=2.01e-13 pd=4.2u ps=4.94u nrd=0.065737          nrs=0.065737 sa=551.022n sb=551.022n sa1=212.829n sa2=458.86n          sa3=727.268n sa4=476.12n sb1=212.829n sb2=458.86n sb3=727.268n          spa=120.0n spa1=120.0n spa2=120.0n spa3=120.0n sap=191.293n          sapb=215.014n spba=162.129n spba1=166.371n dfm_flag=0          spmt=1.11111e+15 spomt=0 spomt1=1.11111e+60 spmb=1.11111e+15          spomb=0 spomb1=1.11111e+60
M4 (net6 DCTRL_6 VREFP VDD) pch_mac l=100n w=3u multi=64 nf=10          sd=120.0n ad=1.8e-13 as=2.01e-13 pd=4.2u ps=4.94u nrd=0.065737          nrs=0.065737 sa=551.022n sb=551.022n sa1=212.829n sa2=458.86n          sa3=727.268n sa4=476.12n sb1=212.829n sb2=458.86n sb3=727.268n          spa=120.0n spa1=120.0n spa2=120.0n spa3=120.0n sap=191.293n          sapb=215.014n spba=162.129n spba1=166.371n dfm_flag=0          spmt=1.11111e+15 spomt=0 spomt1=1.11111e+60 spmb=1.11111e+15          spomb=0 spomb1=1.11111e+60
M0 (net7 DCTRL_7 VREFP VDD) pch_mac l=100n w=3u multi=128 nf=10          sd=120.0n ad=1.8e-13 as=2.01e-13 pd=4.2u ps=4.94u nrd=0.065737          nrs=0.065737 sa=551.022n sb=551.022n sa1=212.829n sa2=458.86n          sa3=727.268n sa4=476.12n sb1=212.829n sb2=458.86n sb3=727.268n          spa=120.0n spa1=120.0n spa2=120.0n spa3=120.0n sap=191.293n          sapb=215.014n spba=162.129n spba1=166.371n dfm_flag=0          spmt=1.11111e+15 spomt=0 spomt1=1.11111e+60 spmb=1.11111e+15          spomb=0 spomb1=1.11111e+60
M14 (net1 DCTRL_1 VREFN GND) nch_mac l=30n w=1u multi=2 nf=10 sd=100n          ad=5e-14 as=5.5e-14 pd=2u ps=2.3u nrd=0.427491 nrs=0.427491          sa=349.754n sb=349.754n sa1=161.047n sa2=316.499n sa3=575.493n          sa4=331.707n sb1=161.047n sb2=316.499n sb3=575.493n spa=100n          spa1=100n spa2=100n spa3=100n sap=150.407n sapb=165.494n          spba=115.715n spba1=117.043n dfm_flag=0 spmt=1.11111e+15 spomt=0          spomt1=1.11111e+60 spmb=1.11111e+15 spomb=0 spomb1=1.11111e+60
M11 (net2 DCTRL_2 VREFN GND) nch_mac l=30n w=1u multi=4 nf=10 sd=100n          ad=5e-14 as=5.5e-14 pd=2u ps=2.3u nrd=0.427491 nrs=0.427491          sa=349.754n sb=349.754n sa1=161.047n sa2=316.499n sa3=575.493n          sa4=331.707n sb1=161.047n sb2=316.499n sb3=575.493n spa=100n          spa1=100n spa2=100n spa3=100n sap=150.407n sapb=165.494n          spba=115.715n spba1=117.043n dfm_flag=0 spmt=1.11111e+15 spomt=0          spomt1=1.11111e+60 spmb=1.11111e+15 spomb=0 spomb1=1.11111e+60
M10 (net4 DCTRL_3 VREFN GND) nch_mac l=30n w=1u multi=8 nf=10 sd=100n          ad=5e-14 as=5.5e-14 pd=2u ps=2.3u nrd=0.427491 nrs=0.427491          sa=349.754n sb=349.754n sa1=161.047n sa2=316.499n sa3=575.493n          sa4=331.707n sb1=161.047n sb2=316.499n sb3=575.493n spa=100n          spa1=100n spa2=100n spa3=100n sap=150.407n sapb=165.494n          spba=115.715n spba1=117.043n dfm_flag=0 spmt=1.11111e+15 spomt=0          spomt1=1.11111e+60 spmb=1.11111e+15 spomb=0 spomb1=1.11111e+60
M7 (net3 DCTRL_4 VREFN GND) nch_mac l=30n w=1u multi=16 nf=10 sd=100n          ad=5e-14 as=5.5e-14 pd=2u ps=2.3u nrd=0.427491 nrs=0.427491          sa=349.754n sb=349.754n sa1=161.047n sa2=316.499n sa3=575.493n          sa4=331.707n sb1=161.047n sb2=316.499n sb3=575.493n spa=100n          spa1=100n spa2=100n spa3=100n sap=150.407n sapb=165.494n          spba=115.715n spba1=117.043n dfm_flag=0 spmt=1.11111e+15 spomt=0          spomt1=1.11111e+60 spmb=1.11111e+15 spomb=0 spomb1=1.11111e+60
M3 (net5 DCTRL_5 VREFN GND) nch_mac l=30n w=1u multi=32 nf=10 sd=100n          ad=5e-14 as=5.5e-14 pd=2u ps=2.3u nrd=0.427491 nrs=0.427491          sa=349.754n sb=349.754n sa1=161.047n sa2=316.499n sa3=575.493n          sa4=331.707n sb1=161.047n sb2=316.499n sb3=575.493n spa=100n          spa1=100n spa2=100n spa3=100n sap=150.407n sapb=165.494n          spba=115.715n spba1=117.043n dfm_flag=0 spmt=1.11111e+15 spomt=0          spomt1=1.11111e+60 spmb=1.11111e+15 spomb=0 spomb1=1.11111e+60
M2 (net6 DCTRL_6 VREFN GND) nch_mac l=30n w=1u multi=64 nf=10 sd=100n          ad=5e-14 as=5.5e-14 pd=2u ps=2.3u nrd=0.427491 nrs=0.427491          sa=349.754n sb=349.754n sa1=161.047n sa2=316.499n sa3=575.493n          sa4=331.707n sb1=161.047n sb2=316.499n sb3=575.493n spa=100n          spa1=100n spa2=100n spa3=100n sap=150.407n sapb=165.494n          spba=115.715n spba1=117.043n dfm_flag=0 spmt=1.11111e+15 spomt=0          spomt1=1.11111e+60 spmb=1.11111e+15 spomb=0 spomb1=1.11111e+60
M1 (net7 DCTRL_7 VREFN GND) nch_mac l=30n w=1u multi=128 nf=10 sd=100n          ad=5e-14 as=5.5e-14 pd=2u ps=2.3u nrd=0.427491 nrs=0.427491          sa=349.754n sb=349.754n sa1=161.047n sa2=316.499n sa3=575.493n          sa4=331.707n sb1=161.047n sb2=316.499n sb3=575.493n spa=100n          spa1=100n spa2=100n spa3=100n sap=150.407n sapb=165.494n          spba=115.715n spba1=117.043n dfm_flag=0 spmt=1.11111e+15 spomt=0          spomt1=1.11111e+60 spmb=1.11111e+15 spomb=0 spomb1=1.11111e+60
I1 (CLKS GND VDD VIN VTOP) manual_boot main_mult=main_mult
ends manual_cdac

subckt manual_sar CLKS GND VDD DCMPP DCMPN CMPCK DO_7 DO_6 DO_5 DO_4 DO_3 DO_2 DO_1 DO_0 DCTRLP_7 DCTRLP_6 DCTRLP_5 DCTRLP_4 DCTRLP_3 DCTRLP_2 DCTRLP_1 DCTRLP_0 DCTRLN_7 DCTRLN_6 DCTRLN_5 DCTRLN_4 DCTRLN_3 DCTRLN_2 DCTRLN_1 DCTRLN_0
parameters tloop=2n tgate=100p
IRESET (CLKS CLKSN VDD GND) INVD4BWP12T30P140
I3 (CLKS CLK_0 net34 VDD GND) OR2D1BWP12T30P140
I2 (VALID net34 net35 VDD GND) NR2D1BWP12T30P140
I0 (DCMPP DCMPN VALID VDD GND) OR2D4BWP12T30P140
RDELAY16 (CLK_0 net3) resistor r=2000
CDELAY16 (net3 GND) capacitor c=tgate/0.69314718056/2000
RDELAY15 (CLK_1 net7) resistor r=2000
CDELAY15 (net7 GND) capacitor c=tgate/0.69314718056/2000
RDELAY14 (CLK_2 net6) resistor r=2000
CDELAY14 (net6 GND) capacitor c=tgate/0.69314718056/2000
RDELAY13 (CLK_3 net5) resistor r=2000
CDELAY13 (net5 GND) capacitor c=tgate/0.69314718056/2000
RDELAY12 (CLK_4 net4) resistor r=2000
CDELAY12 (net4 GND) capacitor c=tgate/0.69314718056/2000
RDELAY11 (CLK_5 net11) resistor r=2000
CDELAY11 (net11 GND) capacitor c=tgate/0.69314718056/2000
RDELAY10 (CLK_6 net9) resistor r=2000
CDELAY10 (net9 GND) capacitor c=tgate/0.69314718056/2000
RDELAY9 (CLK_7 net21) resistor r=2000
CDELAY9 (net21 GND) capacitor c=tgate/0.69314718056/2000
RDELAY8 (CLK_0 net15) resistor r=2000
CDELAY8 (net15 GND) capacitor c=tgate/0.69314718056/2000
RDELAY7 (CLK_1 net19) resistor r=2000
CDELAY7 (net19 GND) capacitor c=tgate/0.69314718056/2000
RDELAY6 (CLK_2 net18) resistor r=2000
CDELAY6 (net18 GND) capacitor c=tgate/0.69314718056/2000
RDELAY5 (CLK_3 net17) resistor r=2000
CDELAY5 (net17 GND) capacitor c=tgate/0.69314718056/2000
RDELAY4 (CLK_4 net16) resistor r=2000
CDELAY4 (net16 GND) capacitor c=tgate/0.69314718056/2000
RDELAY3 (CLK_5 net26) resistor r=2000
CDELAY3 (net26 GND) capacitor c=tgate/0.69314718056/2000
RDELAY2 (CLK_6 net25) resistor r=2000
CDELAY2 (net25 GND) capacitor c=tgate/0.69314718056/2000
RDELAY1 (CLK_7 net32) resistor r=2000
CDELAY1 (net32 GND) capacitor c=tgate/0.69314718056/2000
RDELAY0 (net35 CMPCKe) resistor r=2000
CDELAY0 (CMPCKe GND) capacitor c=tloop/0.69314718056/2000
I4 (CMPCKe CMPCK VDD GND) BUFFD4BWP12T30P140
I12 (CLK_1 VALID CLKSN CLK_0 VDD GND) DFCNQD1BWP12T30P140
I11 (CLK_2 VALID CLKSN CLK_1 VDD GND) DFCNQD1BWP12T30P140
I10 (CLK_3 VALID CLKSN CLK_2 VDD GND) DFCNQD1BWP12T30P140
I9 (CLK_4 VALID CLKSN CLK_3 VDD GND) DFCNQD1BWP12T30P140
I8 (CLK_5 VALID CLKSN CLK_4 VDD GND) DFCNQD1BWP12T30P140
I7 (CLK_6 VALID CLKSN CLK_5 VDD GND) DFCNQD1BWP12T30P140
I6 (CLK_7 VALID CLKSN CLK_6 VDD GND) DFCNQD1BWP12T30P140
I5 (VDD VALID CLKSN CLK_7 VDD GND) DFCNQD1BWP12T30P140
I46_7 (net31 CLKS DO_7 VDD GND) DFQD1BWP12T30P140
I46_6 (net33 CLKS DO_6 VDD GND) DFQD1BWP12T30P140
I46_5 (net24 CLKS DO_5 VDD GND) DFQD1BWP12T30P140
I46_4 (net27 CLKS DO_4 VDD GND) DFQD1BWP12T30P140
I46_3 (net28 CLKS DO_3 VDD GND) DFQD1BWP12T30P140
I46_2 (net29 CLKS DO_2 VDD GND) DFQD1BWP12T30P140
I46_1 (net30 CLKS DO_1 VDD GND) DFQD1BWP12T30P140
I46_0 (net14 CLKS DO_0 VDD GND) DFQD1BWP12T30P140
I44 (DCMPN CLK_0 net2 VDD GND) DFQD1BWP12T30P140
I42 (DCMPN CLK_1 net13 VDD GND) DFQD1BWP12T30P140
I40 (DCMPN CLK_2 net12 VDD GND) DFQD1BWP12T30P140
I38 (DCMPN CLK_3 net10 VDD GND) DFQD1BWP12T30P140
I36 (DCMPN CLK_4 net8 VDD GND) DFQD1BWP12T30P140
I34 (DCMPN CLK_5 net23 VDD GND) DFQD1BWP12T30P140
I32 (DCMPN CLK_6 net22 VDD GND) DFQD1BWP12T30P140
I30 (DCMPN CLK_7 net20 VDD GND) DFQD1BWP12T30P140
I28 (DCMPP CLK_0 net14 VDD GND) DFQD1BWP12T30P140
I26 (DCMPP CLK_1 net30 VDD GND) DFQD1BWP12T30P140
I24 (DCMPP CLK_2 net29 VDD GND) DFQD1BWP12T30P140
I22 (DCMPP CLK_3 net28 VDD GND) DFQD1BWP12T30P140
I20 (DCMPP CLK_4 net27 VDD GND) DFQD1BWP12T30P140
I18 (DCMPP CLK_5 net24 VDD GND) DFQD1BWP12T30P140
I16 (DCMPP CLK_6 net33 VDD GND) DFQD1BWP12T30P140
I14 (DCMPP CLK_7 net31 VDD GND) DFQD1BWP12T30P140
I45 (net2 net3 DCTRLN_0 VDD GND) AN2D0BWP12T30P140
I43 (net13 net7 DCTRLN_1 VDD GND) AN2D0BWP12T30P140
I41 (net12 net6 DCTRLN_2 VDD GND) AN2D0BWP12T30P140
I29 (net14 net15 DCTRLP_0 VDD GND) AN2D0BWP12T30P140
I27 (net30 net19 DCTRLP_1 VDD GND) AN2D0BWP12T30P140
I25 (net29 net18 DCTRLP_2 VDD GND) AN2D0BWP12T30P140
I31 (net20 net21 net1 VDD GND) AN2D16BWP12T30P140
I15 (net31 net32 net36 VDD GND) AN2D16BWP12T30P140
I33 (net22 net9 DCTRLN_6 VDD GND) AN2D8BWP12T30P140
I17 (net33 net25 DCTRLP_6 VDD GND) AN2D8BWP12T30P140
I35 (net23 net11 DCTRLN_5 VDD GND) AN2D4BWP12T30P140
I19 (net24 net26 DCTRLP_5 VDD GND) AN2D4BWP12T30P140
I37 (net8 net4 DCTRLN_4 VDD GND) AN2D2BWP12T30P140
I21 (net27 net16 DCTRLP_4 VDD GND) AN2D2BWP12T30P140
I39 (net10 net5 DCTRLN_3 VDD GND) AN2D1BWP12T30P140
I23 (net28 net17 DCTRLP_3 VDD GND) AN2D1BWP12T30P140
I48 (net1 DCTRLN_7 VDD GND) INVD16BWP12T30P140
I47 (net36 DCTRLP_7 VDD GND) INVD16BWP12T30P140
ends manual_sar

subckt manual_adc CLKS GND VDD VINP VINN VREFP VREFN DO_7 DO_6 DO_5 DO_4 DO_3 DO_2 DO_1 DO_0
parameters cunit=10f main_mult=1 cmp_mult=1 tloop=2n tgate=100p
XP (CLKS GND VDD VINP TOPP VREFP VREFN DN_7 DP_6 DP_5 DP_4 DP_3 DP_2 DP_1) manual_cdac cunit=cunit main_mult=main_mult
XN (CLKS GND VDD VINN TOPN VREFP VREFN DP_7 DN_6 DN_5 DN_4 DN_3 DN_2 DN_1) manual_cdac cunit=cunit main_mult=main_mult
XC (CMPCK TOPP TOPN VDD GND DCMPP DCMPN) manual_cmp cmp_mult=cmp_mult
XL (CLKS GND VDD DCMPP DCMPN CMPCK DO_7 DO_6 DO_5 DO_4 DO_3 DO_2 DO_1 DO_0 DP_7 DP_6 DP_5 DP_4 DP_3 DP_2 DP_1 DP_0 DN_7 DN_6 DN_5 DN_4 DN_3 DN_2 DN_1 DN_0) manual_sar tloop=tloop tgate=tgate
ends manual_adc
