simulator lang=spectre
global 0
include "wrappers.scs"
VVDD (VDD 0) vsource dc=0.99
VREFP (REFP 0) vsource dc=.9
VREFN (REFN 0) vsource dc=0
VCLK (CLKS 0) vsource type=pulse val0=0 val1=0.99 delay=10n rise=50p fall=50p width=39.9n period=100n
VINP (VINP 0) vsource type=pwl wave=[0n 0.0017578125 100n 0.0017578125 100.05n 0.8982421875 200n 0.8982421875 200.05n 0.3005859375 300n 0.3005859375 300.05n 0.5994140625 400n 0.5994140625 400.05n 0.4482421875 500n 0.4482421875 500.05n 0.4517578125 600n 0.4517578125 600.05n 0.0052734375 700n 0.0052734375 700.05n 0.8947265625]
VINN (VINN 0) vsource type=pwl wave=[0n 0.8982421875 100n 0.8982421875 100.05n 0.0017578125 200n 0.0017578125 200.05n 0.5994140625 300n 0.5994140625 300.05n 0.3005859375 400n 0.3005859375 400.05n 0.4517578125 500n 0.4517578125 500.05n 0.4482421875 600n 0.4482421875 600.05n 0.8947265625 700n 0.8947265625 700.05n 0.0052734375]
XADC (CLKS 0 VDD VINP VINN REFP REFN DO_7 DO_6 DO_5 DO_4 DO_3 DO_2 DO_1 DO_0 BUSY EOC FAULT REF_RST) manual_adc_cdac_real sample_rise=100p sample_start=9.980000000n
VRST (REF_RST 0) vsource dc=0
simulatorOptions options reltol=1e-6 vabstol=1e-8 iabstol=1e-14 temp=-40 tnom=27
saveOptions options save=selected currents=selected
tran_test tran stop=820n maxstep=20p errpreset=conservative
save BUSY CLKS DO_0 DO_1 DO_2 DO_3 DO_4 DO_5 DO_6 DO_7 EOC FAULT REFN REFP VDD VINN VINN:1 VINP VINP:1 VREFN:1 VREFP:1 VVDD:1 XADC.CMPCK XADC.DCMPN XADC.DCMPP XADC.DN_0 XADC.DN_1 XADC.DN_2 XADC.DN_3 XADC.DN_4 XADC.DN_5 XADC.DN_6 XADC.DN_7 XADC.DP_0 XADC.DP_1 XADC.DP_2 XADC.DP_3 XADC.DP_4 XADC.DP_5 XADC.DP_6 XADC.DP_7 XADC.TOPN XADC.TOPP XADC.XN.XD.M0:2 XADC.XN.XD.M10:2 XADC.XN.XD.M11:2 XADC.XN.XD.M12:2 XADC.XN.XD.M14:2 XADC.XN.XD.M1:2 XADC.XN.XD.M2:2 XADC.XN.XD.M3:2 XADC.XN.XD.M4:2 XADC.XN.XD.M5:2 XADC.XN.XD.M6:2 XADC.XN.XD.M7:2 XADC.XN.XD.M8:2 XADC.XN.XD.M9:2 XADC.XN.XD.net1 XADC.XN.XD.net2 XADC.XN.XD.net3 XADC.XN.XD.net4 XADC.XN.XD.net5 XADC.XN.XD.net6 XADC.XN.XD.net7 XADC.XP.XD.M0:2 XADC.XP.XD.M10:2 XADC.XP.XD.M11:2 XADC.XP.XD.M12:2 XADC.XP.XD.M14:2 XADC.XP.XD.M1:2 XADC.XP.XD.M2:2 XADC.XP.XD.M3:2 XADC.XP.XD.M4:2 XADC.XP.XD.M5:2 XADC.XP.XD.M6:2 XADC.XP.XD.M7:2 XADC.XP.XD.M8:2 XADC.XP.XD.M9:2 XADC.XP.XD.net1 XADC.XP.XD.net2 XADC.XP.XD.net3 XADC.XP.XD.net4 XADC.XP.XD.net5 XADC.XP.XD.net6 XADC.XP.XD.net7 REF_RST XADC.XP.SAMPLE_FRAC XADC.XN.SAMPLE_FRAC
save XADC.XN.XD.C0:2 XADC.XN.XD.C1:2 XADC.XN.XD.C2:2 XADC.XN.XD.C3:2 XADC.XN.XD.C4:2 XADC.XN.XD.C5:2 XADC.XN.XD.C6:1 XADC.XN.XD.C7:2 XADC.XN.XD.M0:1 XADC.XN.XD.M0:3 XADC.XN.XD.M0:4 XADC.XN.XD.M10:1 XADC.XN.XD.M10:3 XADC.XN.XD.M10:4 XADC.XN.XD.M11:1 XADC.XN.XD.M11:3 XADC.XN.XD.M11:4 XADC.XN.XD.M12:1 XADC.XN.XD.M12:3 XADC.XN.XD.M12:4 XADC.XN.XD.M14:1 XADC.XN.XD.M14:3 XADC.XN.XD.M14:4 XADC.XN.XD.M1:1 XADC.XN.XD.M1:3 XADC.XN.XD.M1:4 XADC.XN.XD.M2:1 XADC.XN.XD.M2:3 XADC.XN.XD.M2:4 XADC.XN.XD.M3:1 XADC.XN.XD.M3:3 XADC.XN.XD.M3:4 XADC.XN.XD.M4:1 XADC.XN.XD.M4:3 XADC.XN.XD.M4:4 XADC.XN.XD.M5:1 XADC.XN.XD.M5:3 XADC.XN.XD.M5:4 XADC.XN.XD.M6:1 XADC.XN.XD.M6:3 XADC.XN.XD.M6:4 XADC.XN.XD.M7:1 XADC.XN.XD.M7:3 XADC.XN.XD.M7:4 XADC.XN.XD.M8:1 XADC.XN.XD.M8:3 XADC.XN.XD.M8:4 XADC.XN.XD.M9:1 XADC.XN.XD.M9:3 XADC.XN.XD.M9:4 XADC.XP.XD.C0:2 XADC.XP.XD.C1:2 XADC.XP.XD.C2:2 XADC.XP.XD.C3:2 XADC.XP.XD.C4:2 XADC.XP.XD.C5:2 XADC.XP.XD.C6:1 XADC.XP.XD.C7:2 XADC.XP.XD.M0:1 XADC.XP.XD.M0:3 XADC.XP.XD.M0:4 XADC.XP.XD.M10:1 XADC.XP.XD.M10:3 XADC.XP.XD.M10:4 XADC.XP.XD.M11:1 XADC.XP.XD.M11:3 XADC.XP.XD.M11:4 XADC.XP.XD.M12:1 XADC.XP.XD.M12:3 XADC.XP.XD.M12:4 XADC.XP.XD.M14:1 XADC.XP.XD.M14:3 XADC.XP.XD.M14:4 XADC.XP.XD.M1:1 XADC.XP.XD.M1:3 XADC.XP.XD.M1:4 XADC.XP.XD.M2:1 XADC.XP.XD.M2:3 XADC.XP.XD.M2:4 XADC.XP.XD.M3:1 XADC.XP.XD.M3:3 XADC.XP.XD.M3:4 XADC.XP.XD.M4:1 XADC.XP.XD.M4:3 XADC.XP.XD.M4:4 XADC.XP.XD.M5:1 XADC.XP.XD.M5:3 XADC.XP.XD.M5:4 XADC.XP.XD.M6:1 XADC.XP.XD.M6:3 XADC.XP.XD.M6:4 XADC.XP.XD.M7:1 XADC.XP.XD.M7:3 XADC.XP.XD.M7:4 XADC.XP.XD.M8:1 XADC.XP.XD.M8:3 XADC.XP.XD.M8:4 XADC.XP.XD.M9:1 XADC.XP.XD.M9:3 XADC.XP.XD.M9:4
