simulator lang=spectre
global 0
include "models.scs"
VS0 (s0 0) vsource dc=0.05
VG0 (g0 s0) vsource dc=0.8
VD0 (d0 s0) vsource dc=.001
M0 (d0 g0 s0 0) nch_18_mac l=150.0n w=1u multi=6 nf=1 sd=180.0n ad=1.55e-13 as=1.55e-13 pd=2.31u ps=2.31u nrd=0 nrs=0 sa=155.00n sb=155.00n sa1=155.00n sa2=155.00n sa3=155.00n sa4=155.00n sb1=155.00n sb2=155.00n sb3=155.00n spa=180.0n spa1=180.0n spa2=180.0n spa3=180.0n sap=172.362n sapb=242.67n spba=233.666n spba1=239.844n spmt=1.11111e+15 spomt=0 spomt1=1.11111e+60 spmb=1.11111e+15 spomb=0 spomb1=1.11111e+60
VS1 (s1 0) vsource dc=0.25
VG1 (g1 s1) vsource dc=0.8
VD1 (d1 s1) vsource dc=.001
M1 (d1 g1 s1 0) nch_18_mac l=150.0n w=1u multi=6 nf=1 sd=180.0n ad=1.55e-13 as=1.55e-13 pd=2.31u ps=2.31u nrd=0 nrs=0 sa=155.00n sb=155.00n sa1=155.00n sa2=155.00n sa3=155.00n sa4=155.00n sb1=155.00n sb2=155.00n sb3=155.00n spa=180.0n spa1=180.0n spa2=180.0n spa3=180.0n sap=172.362n sapb=242.67n spba=233.666n spba1=239.844n spmt=1.11111e+15 spomt=0 spomt1=1.11111e+60 spmb=1.11111e+15 spomb=0 spomb1=1.11111e+60
VS2 (s2 0) vsource dc=0.45
VG2 (g2 s2) vsource dc=0.8
VD2 (d2 s2) vsource dc=.001
M2 (d2 g2 s2 0) nch_18_mac l=150.0n w=1u multi=6 nf=1 sd=180.0n ad=1.55e-13 as=1.55e-13 pd=2.31u ps=2.31u nrd=0 nrs=0 sa=155.00n sb=155.00n sa1=155.00n sa2=155.00n sa3=155.00n sa4=155.00n sb1=155.00n sb2=155.00n sb3=155.00n spa=180.0n spa1=180.0n spa2=180.0n spa3=180.0n sap=172.362n sapb=242.67n spba=233.666n spba1=239.844n spmt=1.11111e+15 spomt=0 spomt1=1.11111e+60 spmb=1.11111e+15 spomb=0 spomb1=1.11111e+60
VS3 (s3 0) vsource dc=0.65
VG3 (g3 s3) vsource dc=0.8
VD3 (d3 s3) vsource dc=.001
M3 (d3 g3 s3 0) nch_18_mac l=150.0n w=1u multi=6 nf=1 sd=180.0n ad=1.55e-13 as=1.55e-13 pd=2.31u ps=2.31u nrd=0 nrs=0 sa=155.00n sb=155.00n sa1=155.00n sa2=155.00n sa3=155.00n sa4=155.00n sb1=155.00n sb2=155.00n sb3=155.00n spa=180.0n spa1=180.0n spa2=180.0n spa3=180.0n sap=172.362n sapb=242.67n spba=233.666n spba1=239.844n spmt=1.11111e+15 spomt=0 spomt1=1.11111e+60 spmb=1.11111e+15 spomb=0 spomb1=1.11111e+60
VS4 (s4 0) vsource dc=0.85
VG4 (g4 s4) vsource dc=0.8
VD4 (d4 s4) vsource dc=.001
M4 (d4 g4 s4 0) nch_18_mac l=150.0n w=1u multi=6 nf=1 sd=180.0n ad=1.55e-13 as=1.55e-13 pd=2.31u ps=2.31u nrd=0 nrs=0 sa=155.00n sb=155.00n sa1=155.00n sa2=155.00n sa3=155.00n sa4=155.00n sb1=155.00n sb2=155.00n sb3=155.00n spa=180.0n spa1=180.0n spa2=180.0n spa3=180.0n sap=172.362n sapb=242.67n spba=233.666n spba1=239.844n spmt=1.11111e+15 spomt=0 spomt1=1.11111e+60 spmb=1.11111e+15 spomb=0 spomb1=1.11111e+60
VS5 (s5 0) vsource dc=0.05
VG5 (g5 s5) vsource dc=0.81
VD5 (d5 s5) vsource dc=.001
M5 (d5 g5 s5 0) nch_18_mac l=150.0n w=1u multi=6 nf=1 sd=180.0n ad=1.55e-13 as=1.55e-13 pd=2.31u ps=2.31u nrd=0 nrs=0 sa=155.00n sb=155.00n sa1=155.00n sa2=155.00n sa3=155.00n sa4=155.00n sb1=155.00n sb2=155.00n sb3=155.00n spa=180.0n spa1=180.0n spa2=180.0n spa3=180.0n sap=172.362n sapb=242.67n spba=233.666n spba1=239.844n spmt=1.11111e+15 spomt=0 spomt1=1.11111e+60 spmb=1.11111e+15 spomb=0 spomb1=1.11111e+60
VS6 (s6 0) vsource dc=0.25
VG6 (g6 s6) vsource dc=0.81
VD6 (d6 s6) vsource dc=.001
M6 (d6 g6 s6 0) nch_18_mac l=150.0n w=1u multi=6 nf=1 sd=180.0n ad=1.55e-13 as=1.55e-13 pd=2.31u ps=2.31u nrd=0 nrs=0 sa=155.00n sb=155.00n sa1=155.00n sa2=155.00n sa3=155.00n sa4=155.00n sb1=155.00n sb2=155.00n sb3=155.00n spa=180.0n spa1=180.0n spa2=180.0n spa3=180.0n sap=172.362n sapb=242.67n spba=233.666n spba1=239.844n spmt=1.11111e+15 spomt=0 spomt1=1.11111e+60 spmb=1.11111e+15 spomb=0 spomb1=1.11111e+60
VS7 (s7 0) vsource dc=0.45
VG7 (g7 s7) vsource dc=0.81
VD7 (d7 s7) vsource dc=.001
M7 (d7 g7 s7 0) nch_18_mac l=150.0n w=1u multi=6 nf=1 sd=180.0n ad=1.55e-13 as=1.55e-13 pd=2.31u ps=2.31u nrd=0 nrs=0 sa=155.00n sb=155.00n sa1=155.00n sa2=155.00n sa3=155.00n sa4=155.00n sb1=155.00n sb2=155.00n sb3=155.00n spa=180.0n spa1=180.0n spa2=180.0n spa3=180.0n sap=172.362n sapb=242.67n spba=233.666n spba1=239.844n spmt=1.11111e+15 spomt=0 spomt1=1.11111e+60 spmb=1.11111e+15 spomb=0 spomb1=1.11111e+60
VS8 (s8 0) vsource dc=0.65
VG8 (g8 s8) vsource dc=0.81
VD8 (d8 s8) vsource dc=.001
M8 (d8 g8 s8 0) nch_18_mac l=150.0n w=1u multi=6 nf=1 sd=180.0n ad=1.55e-13 as=1.55e-13 pd=2.31u ps=2.31u nrd=0 nrs=0 sa=155.00n sb=155.00n sa1=155.00n sa2=155.00n sa3=155.00n sa4=155.00n sb1=155.00n sb2=155.00n sb3=155.00n spa=180.0n spa1=180.0n spa2=180.0n spa3=180.0n sap=172.362n sapb=242.67n spba=233.666n spba1=239.844n spmt=1.11111e+15 spomt=0 spomt1=1.11111e+60 spmb=1.11111e+15 spomb=0 spomb1=1.11111e+60
VS9 (s9 0) vsource dc=0.85
VG9 (g9 s9) vsource dc=0.81
VD9 (d9 s9) vsource dc=.001
M9 (d9 g9 s9 0) nch_18_mac l=150.0n w=1u multi=6 nf=1 sd=180.0n ad=1.55e-13 as=1.55e-13 pd=2.31u ps=2.31u nrd=0 nrs=0 sa=155.00n sb=155.00n sa1=155.00n sa2=155.00n sa3=155.00n sa4=155.00n sb1=155.00n sb2=155.00n sb3=155.00n spa=180.0n spa1=180.0n spa2=180.0n spa3=180.0n sap=172.362n sapb=242.67n spba=233.666n spba1=239.844n spmt=1.11111e+15 spomt=0 spomt1=1.11111e+60 spmb=1.11111e+15 spomb=0 spomb1=1.11111e+60
VS10 (s10 0) vsource dc=0.05
VG10 (g10 s10) vsource dc=0.889
VD10 (d10 s10) vsource dc=.001
M10 (d10 g10 s10 0) nch_18_mac l=150.0n w=1u multi=6 nf=1 sd=180.0n ad=1.55e-13 as=1.55e-13 pd=2.31u ps=2.31u nrd=0 nrs=0 sa=155.00n sb=155.00n sa1=155.00n sa2=155.00n sa3=155.00n sa4=155.00n sb1=155.00n sb2=155.00n sb3=155.00n spa=180.0n spa1=180.0n spa2=180.0n spa3=180.0n sap=172.362n sapb=242.67n spba=233.666n spba1=239.844n spmt=1.11111e+15 spomt=0 spomt1=1.11111e+60 spmb=1.11111e+15 spomb=0 spomb1=1.11111e+60
VS11 (s11 0) vsource dc=0.25
VG11 (g11 s11) vsource dc=0.889
VD11 (d11 s11) vsource dc=.001
M11 (d11 g11 s11 0) nch_18_mac l=150.0n w=1u multi=6 nf=1 sd=180.0n ad=1.55e-13 as=1.55e-13 pd=2.31u ps=2.31u nrd=0 nrs=0 sa=155.00n sb=155.00n sa1=155.00n sa2=155.00n sa3=155.00n sa4=155.00n sb1=155.00n sb2=155.00n sb3=155.00n spa=180.0n spa1=180.0n spa2=180.0n spa3=180.0n sap=172.362n sapb=242.67n spba=233.666n spba1=239.844n spmt=1.11111e+15 spomt=0 spomt1=1.11111e+60 spmb=1.11111e+15 spomb=0 spomb1=1.11111e+60
VS12 (s12 0) vsource dc=0.45
VG12 (g12 s12) vsource dc=0.889
VD12 (d12 s12) vsource dc=.001
M12 (d12 g12 s12 0) nch_18_mac l=150.0n w=1u multi=6 nf=1 sd=180.0n ad=1.55e-13 as=1.55e-13 pd=2.31u ps=2.31u nrd=0 nrs=0 sa=155.00n sb=155.00n sa1=155.00n sa2=155.00n sa3=155.00n sa4=155.00n sb1=155.00n sb2=155.00n sb3=155.00n spa=180.0n spa1=180.0n spa2=180.0n spa3=180.0n sap=172.362n sapb=242.67n spba=233.666n spba1=239.844n spmt=1.11111e+15 spomt=0 spomt1=1.11111e+60 spmb=1.11111e+15 spomb=0 spomb1=1.11111e+60
VS13 (s13 0) vsource dc=0.65
VG13 (g13 s13) vsource dc=0.889
VD13 (d13 s13) vsource dc=.001
M13 (d13 g13 s13 0) nch_18_mac l=150.0n w=1u multi=6 nf=1 sd=180.0n ad=1.55e-13 as=1.55e-13 pd=2.31u ps=2.31u nrd=0 nrs=0 sa=155.00n sb=155.00n sa1=155.00n sa2=155.00n sa3=155.00n sa4=155.00n sb1=155.00n sb2=155.00n sb3=155.00n spa=180.0n spa1=180.0n spa2=180.0n spa3=180.0n sap=172.362n sapb=242.67n spba=233.666n spba1=239.844n spmt=1.11111e+15 spomt=0 spomt1=1.11111e+60 spmb=1.11111e+15 spomb=0 spomb1=1.11111e+60
VS14 (s14 0) vsource dc=0.85
VG14 (g14 s14) vsource dc=0.889
VD14 (d14 s14) vsource dc=.001
M14 (d14 g14 s14 0) nch_18_mac l=150.0n w=1u multi=6 nf=1 sd=180.0n ad=1.55e-13 as=1.55e-13 pd=2.31u ps=2.31u nrd=0 nrs=0 sa=155.00n sb=155.00n sa1=155.00n sa2=155.00n sa3=155.00n sa4=155.00n sb1=155.00n sb2=155.00n sb3=155.00n spa=180.0n spa1=180.0n spa2=180.0n spa3=180.0n sap=172.362n sapb=242.67n spba=233.666n spba1=239.844n spmt=1.11111e+15 spomt=0 spomt1=1.11111e+60 spmb=1.11111e+15 spomb=0 spomb1=1.11111e+60
VS15 (s15 0) vsource dc=0.05
VG15 (g15 s15) vsource dc=0.9
VD15 (d15 s15) vsource dc=.001
M15 (d15 g15 s15 0) nch_18_mac l=150.0n w=1u multi=6 nf=1 sd=180.0n ad=1.55e-13 as=1.55e-13 pd=2.31u ps=2.31u nrd=0 nrs=0 sa=155.00n sb=155.00n sa1=155.00n sa2=155.00n sa3=155.00n sa4=155.00n sb1=155.00n sb2=155.00n sb3=155.00n spa=180.0n spa1=180.0n spa2=180.0n spa3=180.0n sap=172.362n sapb=242.67n spba=233.666n spba1=239.844n spmt=1.11111e+15 spomt=0 spomt1=1.11111e+60 spmb=1.11111e+15 spomb=0 spomb1=1.11111e+60
VS16 (s16 0) vsource dc=0.25
VG16 (g16 s16) vsource dc=0.9
VD16 (d16 s16) vsource dc=.001
M16 (d16 g16 s16 0) nch_18_mac l=150.0n w=1u multi=6 nf=1 sd=180.0n ad=1.55e-13 as=1.55e-13 pd=2.31u ps=2.31u nrd=0 nrs=0 sa=155.00n sb=155.00n sa1=155.00n sa2=155.00n sa3=155.00n sa4=155.00n sb1=155.00n sb2=155.00n sb3=155.00n spa=180.0n spa1=180.0n spa2=180.0n spa3=180.0n sap=172.362n sapb=242.67n spba=233.666n spba1=239.844n spmt=1.11111e+15 spomt=0 spomt1=1.11111e+60 spmb=1.11111e+15 spomb=0 spomb1=1.11111e+60
VS17 (s17 0) vsource dc=0.45
VG17 (g17 s17) vsource dc=0.9
VD17 (d17 s17) vsource dc=.001
M17 (d17 g17 s17 0) nch_18_mac l=150.0n w=1u multi=6 nf=1 sd=180.0n ad=1.55e-13 as=1.55e-13 pd=2.31u ps=2.31u nrd=0 nrs=0 sa=155.00n sb=155.00n sa1=155.00n sa2=155.00n sa3=155.00n sa4=155.00n sb1=155.00n sb2=155.00n sb3=155.00n spa=180.0n spa1=180.0n spa2=180.0n spa3=180.0n sap=172.362n sapb=242.67n spba=233.666n spba1=239.844n spmt=1.11111e+15 spomt=0 spomt1=1.11111e+60 spmb=1.11111e+15 spomb=0 spomb1=1.11111e+60
VS18 (s18 0) vsource dc=0.65
VG18 (g18 s18) vsource dc=0.9
VD18 (d18 s18) vsource dc=.001
M18 (d18 g18 s18 0) nch_18_mac l=150.0n w=1u multi=6 nf=1 sd=180.0n ad=1.55e-13 as=1.55e-13 pd=2.31u ps=2.31u nrd=0 nrs=0 sa=155.00n sb=155.00n sa1=155.00n sa2=155.00n sa3=155.00n sa4=155.00n sb1=155.00n sb2=155.00n sb3=155.00n spa=180.0n spa1=180.0n spa2=180.0n spa3=180.0n sap=172.362n sapb=242.67n spba=233.666n spba1=239.844n spmt=1.11111e+15 spomt=0 spomt1=1.11111e+60 spmb=1.11111e+15 spomb=0 spomb1=1.11111e+60
VS19 (s19 0) vsource dc=0.85
VG19 (g19 s19) vsource dc=0.9
VD19 (d19 s19) vsource dc=.001
M19 (d19 g19 s19 0) nch_18_mac l=150.0n w=1u multi=6 nf=1 sd=180.0n ad=1.55e-13 as=1.55e-13 pd=2.31u ps=2.31u nrd=0 nrs=0 sa=155.00n sb=155.00n sa1=155.00n sa2=155.00n sa3=155.00n sa4=155.00n sb1=155.00n sb2=155.00n sb3=155.00n spa=180.0n spa1=180.0n spa2=180.0n spa3=180.0n sap=172.362n sapb=242.67n spba=233.666n spba1=239.844n spmt=1.11111e+15 spomt=0 spomt1=1.11111e+60 spmb=1.11111e+15 spomb=0 spomb1=1.11111e+60
simulatorOptions options reltol=1e-7 vabstol=1e-8 iabstol=1e-14 temp=-40 tnom=27
saveOptions options save=selected currents=selected
tran_test tran stop=2n maxstep=20p errpreset=conservative
save VD0:1 VD1:1 VD2:1 VD3:1 VD4:1 VD5:1 VD6:1 VD7:1 VD8:1 VD9:1 VD10:1 VD11:1 VD12:1 VD13:1 VD14:1 VD15:1 VD16:1 VD17:1 VD18:1 VD19:1
