simulator lang=spectre
subckt manual_boot CLKS GND VDD VIN VOUT
parameters main_mult=1
M11 (CLKSB CLKS GND GND) nch_18_mac l=150.0n w=1u multi=1 nf=1 sd=180.0n ad=1.55e-13 as=1.55e-13 pd=2.31u ps=2.31u nrd=0 nrs=0 sa=155.00n sb=155.00n sa1=155.00n sa2=155.00n sa3=155.00n sa4=155.00n sb1=155.00n sb2=155.00n sb3=155.00n spa=180.0n spa1=180.0n spa2=180.0n spa3=180.0n sap=172.362n sapb=242.67n spba=233.666n spba1=239.844n spmt=1.11111e+15 spomt=0 spomt1=1.11111e+60 spmb=1.11111e+15 spomb=0 spomb1=1.11111e+60
M9 (net7 CLKSB GND GND) nch_18_mac l=150.0n w=1u multi=1 nf=1 sd=180.0n ad=1.55e-13 as=1.55e-13 pd=2.31u ps=2.31u nrd=0 nrs=0 sa=155.00n sb=155.00n sa1=155.00n sa2=155.00n sa3=155.00n sa4=155.00n sb1=155.00n sb2=155.00n sb3=155.00n spa=180.0n spa1=180.0n spa2=180.0n spa3=180.0n sap=172.362n sapb=242.67n spba=233.666n spba1=239.844n spmt=1.11111e+15 spomt=0 spomt1=1.11111e+60 spmb=1.11111e+15 spomb=0 spomb1=1.11111e+60
M8 (net1 VDD net7 GND) nch_18_mac l=150.0n w=1u multi=1 nf=1 sd=180.0n ad=1.55e-13 as=1.55e-13 pd=2.31u ps=2.31u nrd=0 nrs=0 sa=155.00n sb=155.00n sa1=155.00n sa2=155.00n sa3=155.00n sa4=155.00n sb1=155.00n sb2=155.00n sb3=155.00n spa=180.0n spa1=180.0n spa2=180.0n spa3=180.0n sap=172.362n sapb=242.67n spba=233.666n spba1=239.844n spmt=1.11111e+15 spomt=0 spomt1=1.11111e+60 spmb=1.11111e+15 spomb=0 spomb1=1.11111e+60
M7 (net4 CLKS net3 GND) nch_18_mac l=150.0n w=1u multi=1 nf=1 sd=180.0n ad=1.55e-13 as=1.55e-13 pd=2.31u ps=2.31u nrd=0 nrs=0 sa=155.00n sb=155.00n sa1=155.00n sa2=155.00n sa3=155.00n sa4=155.00n sb1=155.00n sb2=155.00n sb3=155.00n spa=180.0n spa1=180.0n spa2=180.0n spa3=180.0n sap=172.362n sapb=242.67n spba=233.666n spba1=239.844n spmt=1.11111e+15 spomt=0 spomt1=1.11111e+60 spmb=1.11111e+15 spomb=0 spomb1=1.11111e+60
M5 (net4 net1 net3 GND) nch_18_mac l=150.0n w=1u multi=1 nf=1 sd=180.0n ad=1.55e-13 as=1.55e-13 pd=2.31u ps=2.31u nrd=0 nrs=0 sa=155.00n sb=155.00n sa1=155.00n sa2=155.00n sa3=155.00n sa4=155.00n sb1=155.00n sb2=155.00n sb3=155.00n spa=180.0n spa1=180.0n spa2=180.0n spa3=180.0n sap=172.362n sapb=242.67n spba=233.666n spba1=239.844n spmt=1.11111e+15 spomt=0 spomt1=1.11111e+60 spmb=1.11111e+15 spomb=0 spomb1=1.11111e+60
M4 (net3 CLKSB GND GND) nch_18_mac l=150.0n w=1u multi=1 nf=1 sd=180.0n ad=1.55e-13 as=1.55e-13 pd=2.31u ps=2.31u nrd=0 nrs=0 sa=155.00n sb=155.00n sa1=155.00n sa2=155.00n sa3=155.00n sa4=155.00n sb1=155.00n sb2=155.00n sb3=155.00n spa=180.0n spa1=180.0n spa2=180.0n spa3=180.0n sap=172.362n sapb=242.67n spba=233.666n spba1=239.844n spmt=1.11111e+15 spomt=0 spomt1=1.11111e+60 spmb=1.11111e+15 spomb=0 spomb1=1.11111e+60
M2 (net3 net1 VIN GND) nch_18_mac l=150.0n w=1u multi=1 nf=1 sd=180.0n ad=1.55e-13 as=1.55e-13 pd=2.31u ps=2.31u nrd=0 nrs=0 sa=155.00n sb=155.00n sa1=155.00n sa2=155.00n sa3=155.00n sa4=155.00n sb1=155.00n sb2=155.00n sb3=155.00n spa=180.0n spa1=180.0n spa2=180.0n spa3=180.0n sap=172.362n sapb=242.67n spba=233.666n spba1=239.844n spmt=1.11111e+15 spomt=0 spomt1=1.11111e+60 spmb=1.11111e+15 spomb=0 spomb1=1.11111e+60
VMD (VOUT m0d) vsource dc=0
M0 (m0d net1 VIN GND) nch_18_mac l=150.0n w=1u multi=main_mult nf=1 sd=180.0n ad=1.55e-13 as=1.55e-13 pd=2.31u ps=2.31u nrd=0 nrs=0 sa=155.00n sb=155.00n sa1=155.00n sa2=155.00n sa3=155.00n sa4=155.00n sb1=155.00n sb2=155.00n sb3=155.00n spa=180.0n spa1=180.0n spa2=180.0n spa3=180.0n sap=172.362n sapb=242.67n spba=233.666n spba1=239.844n spmt=1.11111e+15 spomt=0 spomt1=1.11111e+60 spmb=1.11111e+15 spomb=0 spomb1=1.11111e+60
C0 (net2 net3) capacitor c=1p
M10 (CLKSB CLKS VDD VDD) pch_18_mac l=150.0n w=1u multi=1 nf=1 sd=180.0n ad=1.55e-13 as=1.55e-13 pd=2.31u ps=2.31u nrd=0 nrs=0 sa=155.00n sb=155.00n sa1=155.00n sa2=155.00n sa3=155.00n sa4=155.00n sb1=155.00n sb2=155.00n sb3=155.00n spa=180.0n spa1=180.0n spa2=180.0n spa3=180.0n sap=172.362n sapb=242.67n spba=233.666n spba1=239.844n spmt=1.11111e+15 spomt=0 spomt1=1.11111e+60 spmb=1.11111e+15 spomb=0 spomb1=1.11111e+60
M6 (net4 CLKS VDD VDD) pch_18_mac l=150.0n w=1u multi=1 nf=1 sd=180.0n ad=1.55e-13 as=1.55e-13 pd=2.31u ps=2.31u nrd=0 nrs=0 sa=155.00n sb=155.00n sa1=155.00n sa2=155.00n sa3=155.00n sa4=155.00n sb1=155.00n sb2=155.00n sb3=155.00n spa=180.0n spa1=180.0n spa2=180.0n spa3=180.0n sap=172.362n sapb=242.67n spba=233.666n spba1=239.844n spmt=1.11111e+15 spomt=0 spomt1=1.11111e+60 spmb=1.11111e+15 spomb=0 spomb1=1.11111e+60
M3 (net1 net4 net2 net2) pch_18_mac l=150.0n w=1u multi=1 nf=1 sd=180.0n ad=1.55e-13 as=1.55e-13 pd=2.31u ps=2.31u nrd=0 nrs=0 sa=155.00n sb=155.00n sa1=155.00n sa2=155.00n sa3=155.00n sa4=155.00n sb1=155.00n sb2=155.00n sb3=155.00n spa=180.0n spa1=180.0n spa2=180.0n spa3=180.0n sap=172.362n sapb=242.67n spba=233.666n spba1=239.844n spmt=1.11111e+15 spomt=0 spomt1=1.11111e+60 spmb=1.11111e+15 spomb=0 spomb1=1.11111e+60
M1 (net2 net1 VDD net2) pch_18_mac l=150.0n w=1u multi=1 nf=1 sd=180.0n ad=1.55e-13 as=1.55e-13 pd=2.31u ps=2.31u nrd=0 nrs=0 sa=155.00n sb=155.00n sa1=155.00n sa2=155.00n sa3=155.00n sa4=155.00n sb1=155.00n sb2=155.00n sb3=155.00n spa=180.0n spa1=180.0n spa2=180.0n spa3=180.0n sap=172.362n sapb=242.67n spba=233.666n spba1=239.844n spmt=1.11111e+15 spomt=0 spomt1=1.11111e+60 spmb=1.11111e+15 spomb=0 spomb1=1.11111e+60
ends manual_boot
