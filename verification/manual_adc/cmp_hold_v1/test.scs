simulator lang=spectre
include "models.scs"
include "dut.scs"
VVDD (VDD 0) vsource dc=.9
VCLK (CK 0) vsource type=pulse val0=0 val1=.9 delay=10n rise=50p fall=50p width=3n period=20n
VTRACK (TRACK 0) vsource type=pulse val0=0 val1=.9 delay=1n rise=50p fall=50p width=7.9n period=20n
VP0 (PS0 0) vsource dc=0.45087890625
VN0 (NS0 0) vsource dc=0.44912109375
SP0 (PS0 P0 TRACK 0) relay rclosed=.01 ropen=1e15 vt1=.4 vt2=.5
SN0 (NS0 N0 TRACK 0) relay rclosed=.01 ropen=1e15 vt1=.4 vt2=.5
CP0 (P0 0) capacitor c=1.28p
CN0 (N0 0) capacitor c=1.28p
X0 (CK P0 N0 VDD 0 OP0 ON0) manual_cmp
LV0 (OP0 ON0 VALID0 VDD 0) OR2D4BWP12T30P140
LD0P0 (OP0 0 QP0_0 VDD 0) DFQD1BWP12T30P140
LD0N0 (ON0 0 QN0_0 VDD 0) DFQD1BWP12T30P140
LD0P1 (OP0 0 QP0_1 VDD 0) DFQD1BWP12T30P140
LD0N1 (ON0 0 QN0_1 VDD 0) DFQD1BWP12T30P140
LD0P2 (OP0 0 QP0_2 VDD 0) DFQD1BWP12T30P140
LD0N2 (ON0 0 QN0_2 VDD 0) DFQD1BWP12T30P140
LD0P3 (OP0 0 QP0_3 VDD 0) DFQD1BWP12T30P140
LD0N3 (ON0 0 QN0_3 VDD 0) DFQD1BWP12T30P140
LD0P4 (OP0 0 QP0_4 VDD 0) DFQD1BWP12T30P140
LD0N4 (ON0 0 QN0_4 VDD 0) DFQD1BWP12T30P140
LD0P5 (OP0 0 QP0_5 VDD 0) DFQD1BWP12T30P140
LD0N5 (ON0 0 QN0_5 VDD 0) DFQD1BWP12T30P140
LD0P6 (OP0 0 QP0_6 VDD 0) DFQD1BWP12T30P140
LD0N6 (ON0 0 QN0_6 VDD 0) DFQD1BWP12T30P140
LD0P7 (OP0 0 QP0_7 VDD 0) DFQD1BWP12T30P140
LD0N7 (ON0 0 QN0_7 VDD 0) DFQD1BWP12T30P140
VP1 (PS1 0) vsource dc=0.44912109375
VN1 (NS1 0) vsource dc=0.45087890625
SP1 (PS1 P1 TRACK 0) relay rclosed=.01 ropen=1e15 vt1=.4 vt2=.5
SN1 (NS1 N1 TRACK 0) relay rclosed=.01 ropen=1e15 vt1=.4 vt2=.5
CP1 (P1 0) capacitor c=1.28p
CN1 (N1 0) capacitor c=1.28p
X1 (CK P1 N1 VDD 0 OP1 ON1) manual_cmp
LV1 (OP1 ON1 VALID1 VDD 0) OR2D4BWP12T30P140
LD1P0 (OP1 0 QP1_0 VDD 0) DFQD1BWP12T30P140
LD1N0 (ON1 0 QN1_0 VDD 0) DFQD1BWP12T30P140
LD1P1 (OP1 0 QP1_1 VDD 0) DFQD1BWP12T30P140
LD1N1 (ON1 0 QN1_1 VDD 0) DFQD1BWP12T30P140
LD1P2 (OP1 0 QP1_2 VDD 0) DFQD1BWP12T30P140
LD1N2 (ON1 0 QN1_2 VDD 0) DFQD1BWP12T30P140
LD1P3 (OP1 0 QP1_3 VDD 0) DFQD1BWP12T30P140
LD1N3 (ON1 0 QN1_3 VDD 0) DFQD1BWP12T30P140
LD1P4 (OP1 0 QP1_4 VDD 0) DFQD1BWP12T30P140
LD1N4 (ON1 0 QN1_4 VDD 0) DFQD1BWP12T30P140
LD1P5 (OP1 0 QP1_5 VDD 0) DFQD1BWP12T30P140
LD1N5 (ON1 0 QN1_5 VDD 0) DFQD1BWP12T30P140
LD1P6 (OP1 0 QP1_6 VDD 0) DFQD1BWP12T30P140
LD1N6 (ON1 0 QN1_6 VDD 0) DFQD1BWP12T30P140
LD1P7 (OP1 0 QP1_7 VDD 0) DFQD1BWP12T30P140
LD1N7 (ON1 0 QN1_7 VDD 0) DFQD1BWP12T30P140
VP2 (PS2 0) vsource dc=0.67587890625
VN2 (NS2 0) vsource dc=0.67412109375
SP2 (PS2 P2 TRACK 0) relay rclosed=.01 ropen=1e15 vt1=.4 vt2=.5
SN2 (NS2 N2 TRACK 0) relay rclosed=.01 ropen=1e15 vt1=.4 vt2=.5
CP2 (P2 0) capacitor c=1.28p
CN2 (N2 0) capacitor c=1.28p
X2 (CK P2 N2 VDD 0 OP2 ON2) manual_cmp
LV2 (OP2 ON2 VALID2 VDD 0) OR2D4BWP12T30P140
LD2P0 (OP2 0 QP2_0 VDD 0) DFQD1BWP12T30P140
LD2N0 (ON2 0 QN2_0 VDD 0) DFQD1BWP12T30P140
LD2P1 (OP2 0 QP2_1 VDD 0) DFQD1BWP12T30P140
LD2N1 (ON2 0 QN2_1 VDD 0) DFQD1BWP12T30P140
LD2P2 (OP2 0 QP2_2 VDD 0) DFQD1BWP12T30P140
LD2N2 (ON2 0 QN2_2 VDD 0) DFQD1BWP12T30P140
LD2P3 (OP2 0 QP2_3 VDD 0) DFQD1BWP12T30P140
LD2N3 (ON2 0 QN2_3 VDD 0) DFQD1BWP12T30P140
LD2P4 (OP2 0 QP2_4 VDD 0) DFQD1BWP12T30P140
LD2N4 (ON2 0 QN2_4 VDD 0) DFQD1BWP12T30P140
LD2P5 (OP2 0 QP2_5 VDD 0) DFQD1BWP12T30P140
LD2N5 (ON2 0 QN2_5 VDD 0) DFQD1BWP12T30P140
LD2P6 (OP2 0 QP2_6 VDD 0) DFQD1BWP12T30P140
LD2N6 (ON2 0 QN2_6 VDD 0) DFQD1BWP12T30P140
LD2P7 (OP2 0 QP2_7 VDD 0) DFQD1BWP12T30P140
LD2N7 (ON2 0 QN2_7 VDD 0) DFQD1BWP12T30P140
VP3 (PS3 0) vsource dc=0.67412109375
VN3 (NS3 0) vsource dc=0.67587890625
SP3 (PS3 P3 TRACK 0) relay rclosed=.01 ropen=1e15 vt1=.4 vt2=.5
SN3 (NS3 N3 TRACK 0) relay rclosed=.01 ropen=1e15 vt1=.4 vt2=.5
CP3 (P3 0) capacitor c=1.28p
CN3 (N3 0) capacitor c=1.28p
X3 (CK P3 N3 VDD 0 OP3 ON3) manual_cmp
LV3 (OP3 ON3 VALID3 VDD 0) OR2D4BWP12T30P140
LD3P0 (OP3 0 QP3_0 VDD 0) DFQD1BWP12T30P140
LD3N0 (ON3 0 QN3_0 VDD 0) DFQD1BWP12T30P140
LD3P1 (OP3 0 QP3_1 VDD 0) DFQD1BWP12T30P140
LD3N1 (ON3 0 QN3_1 VDD 0) DFQD1BWP12T30P140
LD3P2 (OP3 0 QP3_2 VDD 0) DFQD1BWP12T30P140
LD3N2 (ON3 0 QN3_2 VDD 0) DFQD1BWP12T30P140
LD3P3 (OP3 0 QP3_3 VDD 0) DFQD1BWP12T30P140
LD3N3 (ON3 0 QN3_3 VDD 0) DFQD1BWP12T30P140
LD3P4 (OP3 0 QP3_4 VDD 0) DFQD1BWP12T30P140
LD3N4 (ON3 0 QN3_4 VDD 0) DFQD1BWP12T30P140
LD3P5 (OP3 0 QP3_5 VDD 0) DFQD1BWP12T30P140
LD3N5 (ON3 0 QN3_5 VDD 0) DFQD1BWP12T30P140
LD3P6 (OP3 0 QP3_6 VDD 0) DFQD1BWP12T30P140
LD3N6 (ON3 0 QN3_6 VDD 0) DFQD1BWP12T30P140
LD3P7 (OP3 0 QP3_7 VDD 0) DFQD1BWP12T30P140
LD3N7 (ON3 0 QN3_7 VDD 0) DFQD1BWP12T30P140
simulatorOptions options reltol=1e-5 vabstol=1e-7 iabstol=1e-13 temp=27 tnom=27 gmin=1e-12 checklimitdest=psf
saveOptions options save=selected currents=selected
tran_test tran stop=55n maxstep=20p errpreset=conservative
save CK N0 N1 N2 N3 ON0 ON1 ON2 ON3 OP0 OP1 OP2 OP3 P0 P1 P2 P3 TRACK VALID0 VALID1 VALID2 VALID3 VDD VVDD:1 X0.LN X0.LP X0.net1 X0.net2 X0.net3 X1.LN X1.LP X1.net1 X1.net2 X1.net3 X2.LN X2.LP X2.net1 X2.net2 X2.net3 X3.LN X3.LP X3.net1 X3.net2 X3.net3
