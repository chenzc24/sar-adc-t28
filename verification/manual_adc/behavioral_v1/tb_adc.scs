simulator lang=spectre
global 0
include "wrappers.scs"
VVDD (VDD 0) vsource dc=.9
VREF (REF 0) vsource dc=.9
VCLK (CLKS 0) vsource type=pulse val0=0 val1=.9 delay=10n rise=50p fall=50p width=39.9n period=100n
VINP (VINP 0) vsource type=pwl wave=[0n 0.0017578125 100n 0.0017578125 100.05n 0.8982421875 200n 0.8982421875 200.05n 0.3005859375 300n 0.3005859375 300.05n 0.5994140625 400n 0.5994140625 400.05n 0.4482421875 500n 0.4482421875 500.05n 0.4517578125 600n 0.4517578125 600.05n 0.0052734375 700n 0.0052734375 700.05n 0.8947265625]
VINN (VINN 0) vsource type=pwl wave=[0n 0.8982421875 100n 0.8982421875 100.05n 0.0017578125 200n 0.0017578125 200.05n 0.5994140625 300n 0.5994140625 300.05n 0.3005859375 400n 0.3005859375 400.05n 0.4517578125 500n 0.4517578125 500.05n 0.4482421875 600n 0.4482421875 600.05n 0.8947265625 700n 0.8947265625 700.05n 0.0052734375]
XADC (CLKS 0 VDD VINP VINN REF 0 DO_7 DO_6 DO_5 DO_4 DO_3 DO_2 DO_1 DO_0 BUSY EOC FAULT) manual_adc_beh
simulatorOptions options reltol=1e-6 vabstol=1e-8 iabstol=1e-14 temp=27 tnom=27
saveOptions options save=selected currents=selected
tran_test tran stop=820n maxstep=100p errpreset=conservative
save VDD VVDD:1 VINP VINN CLKS BUSY EOC FAULT DO_0 DO_1 DO_2 DO_3 DO_4 DO_5 DO_6 DO_7 XADC.CMPCK XADC.DCMPP XADC.DCMPN XADC.TOPP XADC.TOPN XADC.DP_0 XADC.DP_1 XADC.DP_2 XADC.DP_3 XADC.DP_4 XADC.DP_5 XADC.DP_6 XADC.DP_7 XADC.DN_0 XADC.DN_1 XADC.DN_2 XADC.DN_3 XADC.DN_4 XADC.DN_5 XADC.DN_6 XADC.DN_7
