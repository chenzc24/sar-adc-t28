simulator lang=spectre
global 0
include "wrappers.scs"
VVDD (VDD 0) vsource dc=.9
VREF (REF 0) vsource dc=.9
VCLK (CLKS 0) vsource type=pulse val0=0 val1=.9 delay=10n rise=50p fall=50p width=39.9n period=100n
VINP (VINP 0) vsource type=pwl wave=[0n 0.0017578125 100n 0.0017578125 100.05n 0.8982421875 200n 0.8982421875 200.05n 0.3005859375 300n 0.3005859375 300.05n 0.5994140625 400n 0.5994140625 400.05n 0.4482421875 500n 0.4482421875 500.05n 0.4517578125 600n 0.4517578125 600.05n 0.0052734375 700n 0.0052734375 700.05n 0.8947265625]
VINN (VINN 0) vsource type=pwl wave=[0n 0.8982421875 100n 0.8982421875 100.05n 0.0017578125 200n 0.0017578125 200.05n 0.5994140625 300n 0.5994140625 300.05n 0.3005859375 400n 0.3005859375 400.05n 0.4517578125 500n 0.4517578125 500.05n 0.4482421875 600n 0.4482421875 600.05n 0.8947265625 700n 0.8947265625 700.05n 0.0052734375]
XADC (CLKS 0 VDD VINP VINN REF 0 DO_7 DO_6 DO_5 DO_4 DO_3 DO_2 DO_1 DO_0 BUSY EOC FAULT) manual_adc_beh

// Comparator cancellation probe: first CLK pulse ends before td; second is valid.
VCP (CP 0) vsource type=pwl wave=[0 0 2n 0 2.05n .9 2.4n .9 2.45n 0 4n 0 4.05n .9 6n .9 6.05n 0]
VIP (IP 0) vsource dc=.46
VIN (IN 0) vsource dc=.44
XCANCEL (CP IP IN VDD 0 COP CON) manual8_cmp td=1n
// Invalid comparator pair and missing-result timeout are explicit SAR faults.
VBAD (BAD 0) vsource type=pwl wave=[0 0 54.5n 0 54.55n .9 60n .9 60.05n 0]
XBAD (CLKS 0 VDD BAD BAD BADCK BAD_DO7 BAD_DO6 BAD_DO5 BAD_DO4 BAD_DO3 BAD_DO2 BAD_DO1 BAD_DO0 BAD_DP7 BAD_DP6 BAD_DP5 BAD_DP4 BAD_DP3 BAD_DP2 BAD_DP1 BAD_DP0 BAD_DN7 BAD_DN6 BAD_DN5 BAD_DN4 BAD_DN3 BAD_DN2 BAD_DN1 BAD_DN0 BADBUSY BADEOC BADFAULT) manual8_sar
XTIMEOUT (CLKS 0 VDD 0 0 TIMEOUTCK TIMEOUT_DO7 TIMEOUT_DO6 TIMEOUT_DO5 TIMEOUT_DO4 TIMEOUT_DO3 TIMEOUT_DO2 TIMEOUT_DO1 TIMEOUT_DO0 TIMEOUT_DP7 TIMEOUT_DP6 TIMEOUT_DP5 TIMEOUT_DP4 TIMEOUT_DP3 TIMEOUT_DP2 TIMEOUT_DP1 TIMEOUT_DP0 TIMEOUT_DN7 TIMEOUT_DN6 TIMEOUT_DN5 TIMEOUT_DN4 TIMEOUT_DN3 TIMEOUT_DN2 TIMEOUT_DN1 TIMEOUT_DN0 TIMEOUTBUSY TIMEOUTEOC TIMEOUTFAULT) manual8_sar
VABORT (ACLKS 0) vsource type=pwl wave=[0 0 10n 0 10.05n .9 49.95n .9 50n 0 54.1n 0 54.15n .9 89.95n .9 90n 0]
XABORT (ACLKS 0 VDD IP IN REF 0 ADO_7 ADO_6 ADO_5 ADO_4 ADO_3 ADO_2 ADO_1 ADO_0 ABUSY AEOC AFAULT) manual_adc_beh
simulatorOptions options reltol=1e-6 vabstol=1e-8 iabstol=1e-14 temp=27 tnom=27
saveOptions options save=selected currents=selected
tran_test tran stop=820n maxstep=100p errpreset=conservative
save VDD VVDD:1 VINP VINN CLKS BUSY EOC FAULT COP CON CP BADFAULT BADEOC TIMEOUTFAULT TIMEOUTEOC ACLKS ABUSY AEOC AFAULT XABORT.CMPCK DO_0 DO_1 DO_2 DO_3 DO_4 DO_5 DO_6 DO_7 XADC.CMPCK XADC.DCMPP XADC.DCMPN XADC.TOPP XADC.TOPN XADC.DP_0 XADC.DP_1 XADC.DP_2 XADC.DP_3 XADC.DP_4 XADC.DP_5 XADC.DP_6 XADC.DP_7 XADC.DN_0 XADC.DN_1 XADC.DN_2 XADC.DN_3 XADC.DN_4 XADC.DN_5 XADC.DN_6 XADC.DN_7
