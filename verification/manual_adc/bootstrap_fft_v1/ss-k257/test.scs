simulator lang=spectre
global 0
include "wrappers_hybrid.scs"
VVDD (VDD 0) vsource type=pwl wave=[0 0 1n 0.81]
VVDDH (VDDH 0) vsource type=pwl wave=[0 0 1n 0.81]
VREF (REF 0) vsource type=pwl wave=[0 0 1n .9]
VCLK (CLKS 0) vsource type=pulse val0=0 val1=0.81 delay=110n rise=50p fall=50p width=39.9n period=100n
VCLKH (CLKH 0) vsource type=pulse val0=0 val1=0.81 delay=110n rise=50p fall=50p width=39.9n period=100n
VINP (VINP 0) vsource type=sine sinedc=.45 ampl=0.40106292216019 freq=2509765.625
VINN (VINN 0) vsource type=sine sinedc=.45 ampl=-0.40106292216019 freq=2509765.625
VSENP (VINP INP) vsource dc=0
VSENN (VINN INN) vsource dc=0
XADC (CLKS 0 VDD INP INN REF 0 DO_7 DO_6 DO_5 DO_4 DO_3 DO_2 DO_1 DO_0 BUSY EOC FAULT) manual_adc_boot ref_ron=.01
XIDEAL (CLKS 0 VDD VINP VINN REF 0 IDO_7 IDO_6 IDO_5 IDO_4 IDO_3 IDO_2 IDO_1 IDO_0 IBUSY IEOC IFAULT) manual_adc_beh ref_ron=.01
// Companion fixture isolates turnoff/hold from intentional DAC redistribution.
XHP (CLKH 0 VDDH VINP HP) manual_boot main_mult=6
XHN (CLKH 0 VDDH VINN HN) manual_boot main_mult=6
CHP (HP 0) capacitor c=1.28p
CHN (HN 0) capacitor c=1.28p
simulatorOptions options reltol=1e-6 vabstol=1e-8 iabstol=1e-14 temp=-40 tnom=27
saveOptions options save=selected currents=selected
tran_test tran stop=0.00010572 maxstep=50p errpreset=conservative strobeperiod=1n strobeoutput=strobeonly
save CLKS VDD VINP VINN XADC.TOPP XADC.TOPN XIDEAL.TOPP XIDEAL.TOPN FAULT IFAULT DO_0 DO_1 DO_2 DO_3 DO_4 DO_5 DO_6 DO_7 IDO_0 IDO_1 IDO_2 IDO_3 IDO_4 IDO_5 IDO_6 IDO_7

ahdl_include "bootfft_observer.va"
XOBS0 (VDD CLKS XADC.CMPCK EOC FAULT XADC.TOPP XADC.TOPN DO_7 DO_6 DO_5 DO_4 DO_3 DO_2 DO_1 DO_0) bootfft_observer tag=0
XOBS1 (VDD CLKS XIDEAL.CMPCK IEOC IFAULT XIDEAL.TOPP XIDEAL.TOPN IDO_7 IDO_6 IDO_5 IDO_4 IDO_3 IDO_2 IDO_1 IDO_0) bootfft_observer tag=1
