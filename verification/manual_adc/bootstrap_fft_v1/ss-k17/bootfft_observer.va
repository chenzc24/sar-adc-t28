`include "constants.vams"
`include "disciplines.vams"
// Infinite input impedance; no contributions, no changes to DUT models.
module bootfft_observer(VDD, CLK, CK, EOC, FAULT, TP, TN, D7, D6, D5, D4, D3, D2, D1, D0);
 input VDD, CLK, CK, EOC, FAULT, TP, TN, D7, D6, D5, D4, D3, D2, D1, D0;
 electrical VDD, CLK, CK, EOC, FAULT, TP, TN, D7, D6, D5, D4, D3, D2, D1, D0;
 parameter integer tag=0;
 integer frame,comparisons,completed,faults,code;
 real held,lastclose;
 analog begin
  @(initial_step) begin
   frame=0;comparisons=0;completed=0;faults=0;held=0;lastclose=0;
  end
  @(cross(V(CK)-0.5*V(VDD),+1)) comparisons=comparisons+1;
  @(cross(V(EOC)-0.5*V(VDD),+1)) completed=completed+1;
  @(cross(V(FAULT)-0.5*V(VDD),+1)) faults=faults+1;
  @(cross(V(CLK)-0.5*V(VDD),-1)) lastclose=$abstime;
  @(timer(150.975n,100n)) held=V(TP,TN);
  @(timer(211n,100n)) begin
   code=((V(D0)>0.5*V(VDD)) ? 1 : 0)+((V(D1)>0.5*V(VDD)) ? 2 : 0)+((V(D2)>0.5*V(VDD)) ? 4 : 0)+((V(D3)>0.5*V(VDD)) ? 8 : 0)+((V(D4)>0.5*V(VDD)) ? 16 : 0)+((V(D5)>0.5*V(VDD)) ? 32 : 0)+((V(D6)>0.5*V(VDD)) ? 64 : 0)+((V(D7)>0.5*V(VDD)) ? 128 : 0);
   $display("BOOTFFT %d %d %.15g %d %d %d %d %.15g %.15g",tag,frame,$abstime,code,comparisons,completed,faults,held,lastclose);
   frame=frame+1;comparisons=0;completed=0;faults=0;
  end
 end
endmodule
