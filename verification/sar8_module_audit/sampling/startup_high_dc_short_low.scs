// SS / 0.81V / 125C local startup diagnosis; not Spectre compiled.
simulator lang=spectre
global 0 VDD!
parameters SUP=0.81
include "/home/process/tsmc28n/PDK_mmWave/iPDK_CRN28HPC+ULL_v1.8_2p2a_20190531/tsmcN28/../models/spectre/crn28ull_1d8_elk_v1d8_2p2_shrink0d9_embedded_usage.scs" section=pre_simu
include "/home/process/tsmc28n/PDK_mmWave/iPDK_CRN28HPC+ULL_v1.8_2p2a_20190531/tsmcN28/../models/spectre/crn28ull_1d8_elk_v1d8_2p2_shrink0d9_embedded_usage.scs" section=noise_worst
include "/home/process/tsmc28n/PDK_mmWave/iPDK_CRN28HPC+ULL_v1.8_2p2a_20190531/tsmcN28/../models/spectre/crn28ull_1d8_elk_v1d8_2p2_shrink0d9_embedded_usage.scs" section=ssmacro_mos_moscap
include "/home/process/tsmc28n/PDK_mmWave/iPDK_CRN28HPC+ULL_v1.8_2p2a_20190531/tsmcN28/../models/spectre/crn28ull_1d8_elk_v1d8_2p2_shrink0d9_embedded_usage.scs" section=tt_res_bip_dio_disres
include "/home/process/tsmc28n/PDK_mmWave/iPDK_CRN28HPC+ULL_v1.8_2p2a_20190531/tsmcN28/../models/spectre/crn28ull_1d8_elk_v1d8_2p2_shrink0d9_embedded_usage.scs" section=tt_mom
include "/home/process/tsmc28n/PDK_mmWave/iPDK_CRN28HPC+ULL_v1.8_2p2a_20190531/tsmcN28/../models/spectre/crn28ull_1d8_elk_v1d8_2p2_shrink0d9_embedded_usage.scs" section=tt_ind_jvar
include "/home/process/tsmc28n/PDK_mmWave/iPDK_CRN28HPC+ULL_v1.8_2p2a_20190531/tsmcN28/../models/spectre/crn28ull_1d8_elk_v1d8_2p2_shrink0d9_embedded_usage.scs" section=tt_r_metal
include "fixture_dut.scs"
XF (SAMPLE VDD! VINN VINP VREFN VREFP CMP_RESET D0 D1 D2 D3 D4 D5 D6 D7 0) sampling_reset_fixture
VVINP (VINP_SRC 0) vsource type=pwl wave=[0n 0.855 100.2n 0.855 100.3n 0.045 200.2n 0.045 200.3n 0.45 300.2n 0.45 300.3n 0.45087890625 400.2n 0.45087890625 400.3n 0.44912109375 500.2n 0.44912109375 500.3n 0.5115234375]
VVINN (VINN_SRC 0) vsource type=pwl wave=[0n 0.045 100.2n 0.045 100.3n 0.855 200.2n 0.855 200.3n 0.45 300.2n 0.45 300.3n 0.44912109375 400.2n 0.44912109375 400.3n 0.45087890625 500.2n 0.45087890625 500.3n 0.3884765625]
VREFLOW (VREFN_SRC 0) vsource dc=0 type=dc
VREFHIGH (VREFP_SRC 0) vsource dc=0.9 type=dc
RINP (VINP_SRC VINP) resistor r=50
RINN (VINN_SRC VINN) resistor r=50
RREFP (VREFP_SRC VREFP) resistor r=50
RREFN (VREFN_SRC VREFN) resistor r=50
CREFP (VREFP 0) capacitor c=4p
CREFN (VREFN 0) capacitor c=4p
COUT0 (D0 0) capacitor c=5f
COUT1 (D1 0) capacitor c=5f
COUT2 (D2 0) capacitor c=5f
COUT3 (D3 0) capacitor c=5f
COUT4 (D4 0) capacitor c=5f
COUT5 (D5 0) capacitor c=5f
COUT6 (D6 0) capacitor c=5f
COUT7 (D7 0) capacitor c=5f
VVDD (VDD! 0) vsource dc=SUP type=dc
VCMP_RESET (CMP_RESET 0) vsource dc=0 type=dc
VSAMPLE (SAMPLE 0) vsource type=pwl wave=[0n SUP 100.8n SUP 100.9n 0 101n 0 101.1n SUP 141n SUP 141.1n 0 201n 0 201.1n SUP 241n SUP 241.1n 0]
simulatorOptions options method=gear2only reltol=1e-6 vabstol=1e-8 iabstol=1e-13 temp=125 tnom=27 scalem=1.0 scale=1.0 gmin=1e-12 rforce=1 checklimitdest=psf
saveOptions options save=allpub currents=selected subcktiprobes=no useprobes=no
save VVDD:1 VREFHIGH:1 VREFLOW:1 VVINP:1 VVINN:1 VSAMPLE:1 VCMP_RESET:1
// Observe one formal acquisition; future pulse edges retain 100ns period.
tran_startup tran stop=160n maxstep=10p errpreset=conservative lteratio=10
