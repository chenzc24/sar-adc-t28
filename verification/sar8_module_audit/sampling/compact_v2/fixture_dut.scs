// Compact native sampling attachment; not Spectre compiled.
subckt sampling_compact SAMPLE VDD! VINN VINP VREFN VREFP CMP_RESET REF0_GNNB REF0_GNPB REF0_GPNB REF0_GPPB REF1_GNNB REF1_GNPB REF1_GPNB REF1_GPPB REF2_GNNB REF2_GNPB REF2_GPNB REF2_GPPB REF3_GNNB REF3_GNPB REF3_GPNB REF3_GPPB REF4_GNNB REF4_GNPB REF4_GPNB REF4_GPPB REF5_GNNB REF5_GNPB REF5_GPNB REF5_GPPB REF6_GNNB REF6_GNPB REF6_GPNB REF6_GPPB REF7_GNNB REF7_GNPB REF7_GPNB REF7_GPPB 0
M0000 (XDUT__TOPN XDUT__XBOOTN__G VINN 0) nch_18_mac l=150.0n w=1u multi=1 nf=1 sd=180.0n ad=1.55e-13 as=1.55e-13 pd=2.31u ps=2.31u nrd=0 nrs=0 sa=155.00n sb=155.00n sa1=155.00n sa2=155.00n sa3=155.00n sa4=155.00n sb1=155.00n sb2=155.00n sb3=155.00n spa=180.0n spa1=180.0n spa2=180.0n spa3=180.0n sap=172.362n sapb=242.67n spba=233.666n spba1=239.844n spmt=1.11111e+15 spomt=0 spomt1=1.11111e+60 spmb=1.11111e+15 spomb=0 spomb1=1.11111e+60
M0001 (XDUT__TOPN XDUT__XBOOTN__G VINN 0) nch_18_mac l=150.0n w=1u multi=1 nf=1 sd=180.0n ad=1.55e-13 as=1.55e-13 pd=2.31u ps=2.31u nrd=0 nrs=0 sa=155.00n sb=155.00n sa1=155.00n sa2=155.00n sa3=155.00n sa4=155.00n sb1=155.00n sb2=155.00n sb3=155.00n spa=180.0n spa1=180.0n spa2=180.0n spa3=180.0n sap=172.362n sapb=242.67n spba=233.666n spba1=239.844n spmt=1.11111e+15 spomt=0 spomt1=1.11111e+60 spmb=1.11111e+15 spomb=0 spomb1=1.11111e+60
M0002 (XDUT__XBOOTN__CTRL XDUT__SEQ_SAMPLE XDUT__XBOOTN__BBOT 0) nch_18_mac l=150.0n w=1u multi=1 nf=1 sd=180.0n ad=1.55e-13 as=1.55e-13 pd=2.31u ps=2.31u nrd=0 nrs=0 sa=155.00n sb=155.00n sa1=155.00n sa2=155.00n sa3=155.00n sa4=155.00n sb1=155.00n sb2=155.00n sb3=155.00n spa=180.0n spa1=180.0n spa2=180.0n spa3=180.0n sap=172.362n sapb=242.67n spba=233.666n spba1=239.844n spmt=1.11111e+15 spomt=0 spomt1=1.11111e+60 spmb=1.11111e+15 spomb=0 spomb1=1.11111e+60
M0003 (XDUT__XBOOTN__BBOT XDUT__XBOOTN__G VINN 0) nch_18_mac l=150.0n w=1u multi=1 nf=1 sd=180.0n ad=1.55e-13 as=1.55e-13 pd=2.31u ps=2.31u nrd=0 nrs=0 sa=155.00n sb=155.00n sa1=155.00n sa2=155.00n sa3=155.00n sa4=155.00n sb1=155.00n sb2=155.00n sb3=155.00n spa=180.0n spa1=180.0n spa2=180.0n spa3=180.0n sap=172.362n sapb=242.67n spba=233.666n spba1=239.844n spmt=1.11111e+15 spomt=0 spomt1=1.11111e+60 spmb=1.11111e+15 spomb=0 spomb1=1.11111e+60
M0004 (XDUT__XBOOTN__G VDD! XDUT__XBOOTN__GRESET 0) nch_18_mac l=150.0n w=1u multi=1 nf=1 sd=180.0n ad=1.55e-13 as=1.55e-13 pd=2.31u ps=2.31u nrd=0 nrs=0 sa=155.00n sb=155.00n sa1=155.00n sa2=155.00n sa3=155.00n sa4=155.00n sb1=155.00n sb2=155.00n sb3=155.00n spa=180.0n spa1=180.0n spa2=180.0n spa3=180.0n sap=172.362n sapb=242.67n spba=233.666n spba1=239.844n spmt=1.11111e+15 spomt=0 spomt1=1.11111e+60 spmb=1.11111e+15 spomb=0 spomb1=1.11111e+60
M0005 (XDUT__XBOOTN__GRESET XDUT__XBOOTN__CLKSB 0 0) nch_18_mac l=150.0n w=1u multi=1 nf=1 sd=180.0n ad=1.55e-13 as=1.55e-13 pd=2.31u ps=2.31u nrd=0 nrs=0 sa=155.00n sb=155.00n sa1=155.00n sa2=155.00n sa3=155.00n sa4=155.00n sb1=155.00n sb2=155.00n sb3=155.00n spa=180.0n spa1=180.0n spa2=180.0n spa3=180.0n sap=172.362n sapb=242.67n spba=233.666n spba1=239.844n spmt=1.11111e+15 spomt=0 spomt1=1.11111e+60 spmb=1.11111e+15 spomb=0 spomb1=1.11111e+60
M0006 (XDUT__XBOOTN__CTRL XDUT__XBOOTN__G XDUT__XBOOTN__BBOT 0) nch_18_mac l=150.0n w=1u multi=1 nf=1 sd=180.0n ad=1.55e-13 as=1.55e-13 pd=2.31u ps=2.31u nrd=0 nrs=0 sa=155.00n sb=155.00n sa1=155.00n sa2=155.00n sa3=155.00n sa4=155.00n sb1=155.00n sb2=155.00n sb3=155.00n spa=180.0n spa1=180.0n spa2=180.0n spa3=180.0n sap=172.362n sapb=242.67n spba=233.666n spba1=239.844n spmt=1.11111e+15 spomt=0 spomt1=1.11111e+60 spmb=1.11111e+15 spomb=0 spomb1=1.11111e+60
M0007 (XDUT__XBOOTN__BBOT XDUT__XBOOTN__CLKSB 0 0) nch_18_mac l=150.0n w=1u multi=1 nf=1 sd=180.0n ad=1.55e-13 as=1.55e-13 pd=2.31u ps=2.31u nrd=0 nrs=0 sa=155.00n sb=155.00n sa1=155.00n sa2=155.00n sa3=155.00n sa4=155.00n sb1=155.00n sb2=155.00n sb3=155.00n spa=180.0n spa1=180.0n spa2=180.0n spa3=180.0n sap=172.362n sapb=242.67n spba=233.666n spba1=239.844n spmt=1.11111e+15 spomt=0 spomt1=1.11111e+60 spmb=1.11111e+15 spomb=0 spomb1=1.11111e+60
M0008 (XDUT__XBOOTN__CLKSB XDUT__SEQ_SAMPLE 0 0) nch_18_mac l=150.0n w=1u multi=1 nf=1 sd=180.0n ad=1.55e-13 as=1.55e-13 pd=2.31u ps=2.31u nrd=0 nrs=0 sa=155.00n sb=155.00n sa1=155.00n sa2=155.00n sa3=155.00n sa4=155.00n sb1=155.00n sb2=155.00n sb3=155.00n spa=180.0n spa1=180.0n spa2=180.0n spa3=180.0n sap=172.362n sapb=242.67n spba=233.666n spba1=239.844n spmt=1.11111e+15 spomt=0 spomt1=1.11111e+60 spmb=1.11111e+15 spomb=0 spomb1=1.11111e+60
M0009 (XDUT__XBOOTN__BTOP XDUT__XBOOTN__G VDD! XDUT__XBOOTN__BTOP) pch_18_mac l=150.0n w=1u multi=1 nf=1 sd=180.0n ad=1.55e-13 as=1.55e-13 pd=2.31u ps=2.31u nrd=0 nrs=0 sa=155.00n sb=155.00n sa1=155.00n sa2=155.00n sa3=155.00n sa4=155.00n sb1=155.00n sb2=155.00n sb3=155.00n spa=180.0n spa1=180.0n spa2=180.0n spa3=180.0n sap=172.362n sapb=242.67n spba=233.666n spba1=239.844n spmt=1.11111e+15 spomt=0 spomt1=1.11111e+60 spmb=1.11111e+15 spomb=0 spomb1=1.11111e+60
M0010 (XDUT__XBOOTN__G XDUT__XBOOTN__CTRL XDUT__XBOOTN__BTOP XDUT__XBOOTN__BTOP) pch_18_mac l=150.0n w=1u multi=1 nf=1 sd=180.0n ad=1.55e-13 as=1.55e-13 pd=2.31u ps=2.31u nrd=0 nrs=0 sa=155.00n sb=155.00n sa1=155.00n sa2=155.00n sa3=155.00n sa4=155.00n sb1=155.00n sb2=155.00n sb3=155.00n spa=180.0n spa1=180.0n spa2=180.0n spa3=180.0n sap=172.362n sapb=242.67n spba=233.666n spba1=239.844n spmt=1.11111e+15 spomt=0 spomt1=1.11111e+60 spmb=1.11111e+15 spomb=0 spomb1=1.11111e+60
M0011 (XDUT__XBOOTN__CTRL XDUT__SEQ_SAMPLE VDD! VDD!) pch_18_mac l=150.0n w=1u multi=1 nf=1 sd=180.0n ad=1.55e-13 as=1.55e-13 pd=2.31u ps=2.31u nrd=0 nrs=0 sa=155.00n sb=155.00n sa1=155.00n sa2=155.00n sa3=155.00n sa4=155.00n sb1=155.00n sb2=155.00n sb3=155.00n spa=180.0n spa1=180.0n spa2=180.0n spa3=180.0n sap=172.362n sapb=242.67n spba=233.666n spba1=239.844n spmt=1.11111e+15 spomt=0 spomt1=1.11111e+60 spmb=1.11111e+15 spomb=0 spomb1=1.11111e+60
M0012 (XDUT__XBOOTN__CLKSB XDUT__SEQ_SAMPLE VDD! VDD!) pch_18_mac l=150.0n w=1u multi=1 nf=1 sd=180.0n ad=1.55e-13 as=1.55e-13 pd=2.31u ps=2.31u nrd=0 nrs=0 sa=155.00n sb=155.00n sa1=155.00n sa2=155.00n sa3=155.00n sa4=155.00n sb1=155.00n sb2=155.00n sb3=155.00n spa=180.0n spa1=180.0n spa2=180.0n spa3=180.0n sap=172.362n sapb=242.67n spba=233.666n spba1=239.844n spmt=1.11111e+15 spomt=0 spomt1=1.11111e+60 spmb=1.11111e+15 spomb=0 spomb1=1.11111e+60
C0013 (XDUT__XBOOTN__BTOP XDUT__XBOOTN__BBOT) cfmom_2t nr=8 lr=2.5u w=50n s=50n stm=1 spm=3 multi=200 mismatchflag=1
M0014 (XDUT__TOPP XDUT__XBOOTP__G VINP 0) nch_18_mac l=150.0n w=1u multi=1 nf=1 sd=180.0n ad=1.55e-13 as=1.55e-13 pd=2.31u ps=2.31u nrd=0 nrs=0 sa=155.00n sb=155.00n sa1=155.00n sa2=155.00n sa3=155.00n sa4=155.00n sb1=155.00n sb2=155.00n sb3=155.00n spa=180.0n spa1=180.0n spa2=180.0n spa3=180.0n sap=172.362n sapb=242.67n spba=233.666n spba1=239.844n spmt=1.11111e+15 spomt=0 spomt1=1.11111e+60 spmb=1.11111e+15 spomb=0 spomb1=1.11111e+60
M0015 (XDUT__TOPP XDUT__XBOOTP__G VINP 0) nch_18_mac l=150.0n w=1u multi=1 nf=1 sd=180.0n ad=1.55e-13 as=1.55e-13 pd=2.31u ps=2.31u nrd=0 nrs=0 sa=155.00n sb=155.00n sa1=155.00n sa2=155.00n sa3=155.00n sa4=155.00n sb1=155.00n sb2=155.00n sb3=155.00n spa=180.0n spa1=180.0n spa2=180.0n spa3=180.0n sap=172.362n sapb=242.67n spba=233.666n spba1=239.844n spmt=1.11111e+15 spomt=0 spomt1=1.11111e+60 spmb=1.11111e+15 spomb=0 spomb1=1.11111e+60
M0016 (XDUT__XBOOTP__CTRL XDUT__SEQ_SAMPLE XDUT__XBOOTP__BBOT 0) nch_18_mac l=150.0n w=1u multi=1 nf=1 sd=180.0n ad=1.55e-13 as=1.55e-13 pd=2.31u ps=2.31u nrd=0 nrs=0 sa=155.00n sb=155.00n sa1=155.00n sa2=155.00n sa3=155.00n sa4=155.00n sb1=155.00n sb2=155.00n sb3=155.00n spa=180.0n spa1=180.0n spa2=180.0n spa3=180.0n sap=172.362n sapb=242.67n spba=233.666n spba1=239.844n spmt=1.11111e+15 spomt=0 spomt1=1.11111e+60 spmb=1.11111e+15 spomb=0 spomb1=1.11111e+60
M0017 (XDUT__XBOOTP__BBOT XDUT__XBOOTP__G VINP 0) nch_18_mac l=150.0n w=1u multi=1 nf=1 sd=180.0n ad=1.55e-13 as=1.55e-13 pd=2.31u ps=2.31u nrd=0 nrs=0 sa=155.00n sb=155.00n sa1=155.00n sa2=155.00n sa3=155.00n sa4=155.00n sb1=155.00n sb2=155.00n sb3=155.00n spa=180.0n spa1=180.0n spa2=180.0n spa3=180.0n sap=172.362n sapb=242.67n spba=233.666n spba1=239.844n spmt=1.11111e+15 spomt=0 spomt1=1.11111e+60 spmb=1.11111e+15 spomb=0 spomb1=1.11111e+60
M0018 (XDUT__XBOOTP__G VDD! XDUT__XBOOTP__GRESET 0) nch_18_mac l=150.0n w=1u multi=1 nf=1 sd=180.0n ad=1.55e-13 as=1.55e-13 pd=2.31u ps=2.31u nrd=0 nrs=0 sa=155.00n sb=155.00n sa1=155.00n sa2=155.00n sa3=155.00n sa4=155.00n sb1=155.00n sb2=155.00n sb3=155.00n spa=180.0n spa1=180.0n spa2=180.0n spa3=180.0n sap=172.362n sapb=242.67n spba=233.666n spba1=239.844n spmt=1.11111e+15 spomt=0 spomt1=1.11111e+60 spmb=1.11111e+15 spomb=0 spomb1=1.11111e+60
M0019 (XDUT__XBOOTP__GRESET XDUT__XBOOTP__CLKSB 0 0) nch_18_mac l=150.0n w=1u multi=1 nf=1 sd=180.0n ad=1.55e-13 as=1.55e-13 pd=2.31u ps=2.31u nrd=0 nrs=0 sa=155.00n sb=155.00n sa1=155.00n sa2=155.00n sa3=155.00n sa4=155.00n sb1=155.00n sb2=155.00n sb3=155.00n spa=180.0n spa1=180.0n spa2=180.0n spa3=180.0n sap=172.362n sapb=242.67n spba=233.666n spba1=239.844n spmt=1.11111e+15 spomt=0 spomt1=1.11111e+60 spmb=1.11111e+15 spomb=0 spomb1=1.11111e+60
M0020 (XDUT__XBOOTP__CTRL XDUT__XBOOTP__G XDUT__XBOOTP__BBOT 0) nch_18_mac l=150.0n w=1u multi=1 nf=1 sd=180.0n ad=1.55e-13 as=1.55e-13 pd=2.31u ps=2.31u nrd=0 nrs=0 sa=155.00n sb=155.00n sa1=155.00n sa2=155.00n sa3=155.00n sa4=155.00n sb1=155.00n sb2=155.00n sb3=155.00n spa=180.0n spa1=180.0n spa2=180.0n spa3=180.0n sap=172.362n sapb=242.67n spba=233.666n spba1=239.844n spmt=1.11111e+15 spomt=0 spomt1=1.11111e+60 spmb=1.11111e+15 spomb=0 spomb1=1.11111e+60
M0021 (XDUT__XBOOTP__BBOT XDUT__XBOOTP__CLKSB 0 0) nch_18_mac l=150.0n w=1u multi=1 nf=1 sd=180.0n ad=1.55e-13 as=1.55e-13 pd=2.31u ps=2.31u nrd=0 nrs=0 sa=155.00n sb=155.00n sa1=155.00n sa2=155.00n sa3=155.00n sa4=155.00n sb1=155.00n sb2=155.00n sb3=155.00n spa=180.0n spa1=180.0n spa2=180.0n spa3=180.0n sap=172.362n sapb=242.67n spba=233.666n spba1=239.844n spmt=1.11111e+15 spomt=0 spomt1=1.11111e+60 spmb=1.11111e+15 spomb=0 spomb1=1.11111e+60
M0022 (XDUT__XBOOTP__CLKSB XDUT__SEQ_SAMPLE 0 0) nch_18_mac l=150.0n w=1u multi=1 nf=1 sd=180.0n ad=1.55e-13 as=1.55e-13 pd=2.31u ps=2.31u nrd=0 nrs=0 sa=155.00n sb=155.00n sa1=155.00n sa2=155.00n sa3=155.00n sa4=155.00n sb1=155.00n sb2=155.00n sb3=155.00n spa=180.0n spa1=180.0n spa2=180.0n spa3=180.0n sap=172.362n sapb=242.67n spba=233.666n spba1=239.844n spmt=1.11111e+15 spomt=0 spomt1=1.11111e+60 spmb=1.11111e+15 spomb=0 spomb1=1.11111e+60
M0023 (XDUT__XBOOTP__BTOP XDUT__XBOOTP__G VDD! XDUT__XBOOTP__BTOP) pch_18_mac l=150.0n w=1u multi=1 nf=1 sd=180.0n ad=1.55e-13 as=1.55e-13 pd=2.31u ps=2.31u nrd=0 nrs=0 sa=155.00n sb=155.00n sa1=155.00n sa2=155.00n sa3=155.00n sa4=155.00n sb1=155.00n sb2=155.00n sb3=155.00n spa=180.0n spa1=180.0n spa2=180.0n spa3=180.0n sap=172.362n sapb=242.67n spba=233.666n spba1=239.844n spmt=1.11111e+15 spomt=0 spomt1=1.11111e+60 spmb=1.11111e+15 spomb=0 spomb1=1.11111e+60
M0024 (XDUT__XBOOTP__G XDUT__XBOOTP__CTRL XDUT__XBOOTP__BTOP XDUT__XBOOTP__BTOP) pch_18_mac l=150.0n w=1u multi=1 nf=1 sd=180.0n ad=1.55e-13 as=1.55e-13 pd=2.31u ps=2.31u nrd=0 nrs=0 sa=155.00n sb=155.00n sa1=155.00n sa2=155.00n sa3=155.00n sa4=155.00n sb1=155.00n sb2=155.00n sb3=155.00n spa=180.0n spa1=180.0n spa2=180.0n spa3=180.0n sap=172.362n sapb=242.67n spba=233.666n spba1=239.844n spmt=1.11111e+15 spomt=0 spomt1=1.11111e+60 spmb=1.11111e+15 spomb=0 spomb1=1.11111e+60
M0025 (XDUT__XBOOTP__CTRL XDUT__SEQ_SAMPLE VDD! VDD!) pch_18_mac l=150.0n w=1u multi=1 nf=1 sd=180.0n ad=1.55e-13 as=1.55e-13 pd=2.31u ps=2.31u nrd=0 nrs=0 sa=155.00n sb=155.00n sa1=155.00n sa2=155.00n sa3=155.00n sa4=155.00n sb1=155.00n sb2=155.00n sb3=155.00n spa=180.0n spa1=180.0n spa2=180.0n spa3=180.0n sap=172.362n sapb=242.67n spba=233.666n spba1=239.844n spmt=1.11111e+15 spomt=0 spomt1=1.11111e+60 spmb=1.11111e+15 spomb=0 spomb1=1.11111e+60
M0026 (XDUT__XBOOTP__CLKSB XDUT__SEQ_SAMPLE VDD! VDD!) pch_18_mac l=150.0n w=1u multi=1 nf=1 sd=180.0n ad=1.55e-13 as=1.55e-13 pd=2.31u ps=2.31u nrd=0 nrs=0 sa=155.00n sb=155.00n sa1=155.00n sa2=155.00n sa3=155.00n sa4=155.00n sb1=155.00n sb2=155.00n sb3=155.00n spa=180.0n spa1=180.0n spa2=180.0n spa3=180.0n sap=172.362n sapb=242.67n spba=233.666n spba1=239.844n spmt=1.11111e+15 spomt=0 spomt1=1.11111e+60 spmb=1.11111e+15 spomb=0 spomb1=1.11111e+60
C0027 (XDUT__XBOOTP__BTOP XDUT__XBOOTP__BBOT) cfmom_2t nr=8 lr=2.5u w=50n s=50n stm=1 spm=3 multi=200 mismatchflag=1
C0028 (XDUT__TOPN VREFN) cfmom_2t nr=8 lr=2u w=50n s=50n stm=1 spm=3 multi=1 mismatchflag=1
C0029 (XDUT__TOPN XDUT__XCDAC__BN7) cfmom_2t nr=8 lr=2u w=50n s=50n stm=1 spm=3 multi=128 mismatchflag=1
C0030 (XDUT__TOPN XDUT__XCDAC__BN6) cfmom_2t nr=8 lr=2u w=50n s=50n stm=1 spm=3 multi=64 mismatchflag=1
C0031 (XDUT__TOPN XDUT__XCDAC__BN5) cfmom_2t nr=8 lr=2u w=50n s=50n stm=1 spm=3 multi=32 mismatchflag=1
C0032 (XDUT__TOPN XDUT__XCDAC__BN4) cfmom_2t nr=8 lr=2u w=50n s=50n stm=1 spm=3 multi=16 mismatchflag=1
C0033 (XDUT__TOPN XDUT__XCDAC__BN3) cfmom_2t nr=8 lr=2u w=50n s=50n stm=1 spm=3 multi=8 mismatchflag=1
C0034 (XDUT__TOPN XDUT__XCDAC__BN2) cfmom_2t nr=8 lr=2u w=50n s=50n stm=1 spm=3 multi=4 mismatchflag=1
C0035 (XDUT__TOPN XDUT__XCDAC__BN1) cfmom_2t nr=8 lr=2u w=50n s=50n stm=1 spm=3 multi=2 mismatchflag=1
C0036 (XDUT__TOPN XDUT__XCDAC__BN0) cfmom_2t nr=8 lr=2u w=50n s=50n stm=1 spm=3 multi=1 mismatchflag=1
C0037 (XDUT__TOPP VREFP) cfmom_2t nr=8 lr=2u w=50n s=50n stm=1 spm=3 multi=1 mismatchflag=1
C0038 (XDUT__TOPP XDUT__XCDAC__BP7) cfmom_2t nr=8 lr=2u w=50n s=50n stm=1 spm=3 multi=128 mismatchflag=1
C0039 (XDUT__TOPP XDUT__XCDAC__BP6) cfmom_2t nr=8 lr=2u w=50n s=50n stm=1 spm=3 multi=64 mismatchflag=1
C0040 (XDUT__TOPP XDUT__XCDAC__BP5) cfmom_2t nr=8 lr=2u w=50n s=50n stm=1 spm=3 multi=32 mismatchflag=1
C0041 (XDUT__TOPP XDUT__XCDAC__BP4) cfmom_2t nr=8 lr=2u w=50n s=50n stm=1 spm=3 multi=16 mismatchflag=1
C0042 (XDUT__TOPP XDUT__XCDAC__BP3) cfmom_2t nr=8 lr=2u w=50n s=50n stm=1 spm=3 multi=8 mismatchflag=1
C0043 (XDUT__TOPP XDUT__XCDAC__BP2) cfmom_2t nr=8 lr=2u w=50n s=50n stm=1 spm=3 multi=4 mismatchflag=1
C0044 (XDUT__TOPP XDUT__XCDAC__BP1) cfmom_2t nr=8 lr=2u w=50n s=50n stm=1 spm=3 multi=2 mismatchflag=1
C0045 (XDUT__TOPP XDUT__XCDAC__BP0) cfmom_2t nr=8 lr=2u w=50n s=50n stm=1 spm=3 multi=1 mismatchflag=1
M0046 (XDUT__XCDAC__BN0 XDUT__GNP0 VREFP VDD!) pch_18_mac ad=4.96e-14 as=4.96e-14 l=150n nf=1 nrd=0 nrs=0 pd=950.0n ps=950.0n sa=155.00n sa1=155.00n sa2=155.00n sa3=155.00n sa4=155.00n sap=172.362n sapb=242.67n sb=155.00n sb1=155.00n sb2=155.00n sb3=155.00n sd=180n spa=180.0n spa1=180.0n spa2=180.0n spa3=180.0n spba=233.666n spba1=239.844n spmb=1.11111e15 spmt=1.11111e15 spomb=0 spomb1=1.11111e+60 spomt=0 spomt1=1.11111e+60 w=320n multi=2
M0047 (XDUT__XCDAC__BN0 XDUT__GNN0 VREFN 0) nch_18_mac ad=4.96e-14 as=4.96e-14 l=150n nf=1 nrd=0 nrs=0 pd=950.0n ps=950.0n sa=155.00n sa1=155.00n sa2=155.00n sa3=155.00n sa4=155.00n sap=172.362n sapb=242.67n sb=155.00n sb1=155.00n sb2=155.00n sb3=155.00n sd=180n spa=180.0n spa1=180.0n spa2=180.0n spa3=180.0n spba=233.666n spba1=239.844n spmb=1.11111e15 spmt=1.11111e15 spomb=0 spomb1=1.11111e+60 spomt=0 spomt1=1.11111e+60 w=320n multi=2
M0048 (XDUT__XCDAC__BP0 XDUT__GPP0 VREFP VDD!) pch_18_mac ad=4.96e-14 as=4.96e-14 l=150n nf=1 nrd=0 nrs=0 pd=950.0n ps=950.0n sa=155.00n sa1=155.00n sa2=155.00n sa3=155.00n sa4=155.00n sap=172.362n sapb=242.67n sb=155.00n sb1=155.00n sb2=155.00n sb3=155.00n sd=180n spa=180.0n spa1=180.0n spa2=180.0n spa3=180.0n spba=233.666n spba1=239.844n spmb=1.11111e15 spmt=1.11111e15 spomb=0 spomb1=1.11111e+60 spomt=0 spomt1=1.11111e+60 w=320n multi=2
M0049 (XDUT__XCDAC__BP0 XDUT__GPN0 VREFN 0) nch_18_mac ad=4.96e-14 as=4.96e-14 l=150n nf=1 nrd=0 nrs=0 pd=950.0n ps=950.0n sa=155.00n sa1=155.00n sa2=155.00n sa3=155.00n sa4=155.00n sap=172.362n sapb=242.67n sb=155.00n sb1=155.00n sb2=155.00n sb3=155.00n sd=180n spa=180.0n spa1=180.0n spa2=180.0n spa3=180.0n spba=233.666n spba1=239.844n spmb=1.11111e15 spmt=1.11111e15 spomb=0 spomb1=1.11111e+60 spomt=0 spomt1=1.11111e+60 w=320n multi=2
M0050 (XDUT__XCDAC__BN1 XDUT__GNP1 VREFP VDD!) pch_18_mac ad=4.96e-14 as=4.96e-14 l=150n nf=1 nrd=0 nrs=0 pd=950.0n ps=950.0n sa=155.00n sa1=155.00n sa2=155.00n sa3=155.00n sa4=155.00n sap=172.362n sapb=242.67n sb=155.00n sb1=155.00n sb2=155.00n sb3=155.00n sd=180n spa=180.0n spa1=180.0n spa2=180.0n spa3=180.0n spba=233.666n spba1=239.844n spmb=1.11111e15 spmt=1.11111e15 spomb=0 spomb1=1.11111e+60 spomt=0 spomt1=1.11111e+60 w=320n multi=4
M0051 (XDUT__XCDAC__BN1 XDUT__GNN1 VREFN 0) nch_18_mac ad=4.96e-14 as=4.96e-14 l=150n nf=1 nrd=0 nrs=0 pd=950.0n ps=950.0n sa=155.00n sa1=155.00n sa2=155.00n sa3=155.00n sa4=155.00n sap=172.362n sapb=242.67n sb=155.00n sb1=155.00n sb2=155.00n sb3=155.00n sd=180n spa=180.0n spa1=180.0n spa2=180.0n spa3=180.0n spba=233.666n spba1=239.844n spmb=1.11111e15 spmt=1.11111e15 spomb=0 spomb1=1.11111e+60 spomt=0 spomt1=1.11111e+60 w=320n multi=4
M0052 (XDUT__XCDAC__BP1 XDUT__GPP1 VREFP VDD!) pch_18_mac ad=4.96e-14 as=4.96e-14 l=150n nf=1 nrd=0 nrs=0 pd=950.0n ps=950.0n sa=155.00n sa1=155.00n sa2=155.00n sa3=155.00n sa4=155.00n sap=172.362n sapb=242.67n sb=155.00n sb1=155.00n sb2=155.00n sb3=155.00n sd=180n spa=180.0n spa1=180.0n spa2=180.0n spa3=180.0n spba=233.666n spba1=239.844n spmb=1.11111e15 spmt=1.11111e15 spomb=0 spomb1=1.11111e+60 spomt=0 spomt1=1.11111e+60 w=320n multi=4
M0053 (XDUT__XCDAC__BP1 XDUT__GPN1 VREFN 0) nch_18_mac ad=4.96e-14 as=4.96e-14 l=150n nf=1 nrd=0 nrs=0 pd=950.0n ps=950.0n sa=155.00n sa1=155.00n sa2=155.00n sa3=155.00n sa4=155.00n sap=172.362n sapb=242.67n sb=155.00n sb1=155.00n sb2=155.00n sb3=155.00n sd=180n spa=180.0n spa1=180.0n spa2=180.0n spa3=180.0n spba=233.666n spba1=239.844n spmb=1.11111e15 spmt=1.11111e15 spomb=0 spomb1=1.11111e+60 spomt=0 spomt1=1.11111e+60 w=320n multi=4
M0054 (XDUT__XCDAC__BN2 XDUT__GNP2 VREFP VDD!) pch_18_mac ad=4.96e-14 as=4.96e-14 l=150n nf=1 nrd=0 nrs=0 pd=950.0n ps=950.0n sa=155.00n sa1=155.00n sa2=155.00n sa3=155.00n sa4=155.00n sap=172.362n sapb=242.67n sb=155.00n sb1=155.00n sb2=155.00n sb3=155.00n sd=180n spa=180.0n spa1=180.0n spa2=180.0n spa3=180.0n spba=233.666n spba1=239.844n spmb=1.11111e15 spmt=1.11111e15 spomb=0 spomb1=1.11111e+60 spomt=0 spomt1=1.11111e+60 w=320n multi=8
M0055 (XDUT__XCDAC__BN2 XDUT__GNN2 VREFN 0) nch_18_mac ad=4.96e-14 as=4.96e-14 l=150n nf=1 nrd=0 nrs=0 pd=950.0n ps=950.0n sa=155.00n sa1=155.00n sa2=155.00n sa3=155.00n sa4=155.00n sap=172.362n sapb=242.67n sb=155.00n sb1=155.00n sb2=155.00n sb3=155.00n sd=180n spa=180.0n spa1=180.0n spa2=180.0n spa3=180.0n spba=233.666n spba1=239.844n spmb=1.11111e15 spmt=1.11111e15 spomb=0 spomb1=1.11111e+60 spomt=0 spomt1=1.11111e+60 w=320n multi=8
M0056 (XDUT__XCDAC__BP2 XDUT__GPP2 VREFP VDD!) pch_18_mac ad=4.96e-14 as=4.96e-14 l=150n nf=1 nrd=0 nrs=0 pd=950.0n ps=950.0n sa=155.00n sa1=155.00n sa2=155.00n sa3=155.00n sa4=155.00n sap=172.362n sapb=242.67n sb=155.00n sb1=155.00n sb2=155.00n sb3=155.00n sd=180n spa=180.0n spa1=180.0n spa2=180.0n spa3=180.0n spba=233.666n spba1=239.844n spmb=1.11111e15 spmt=1.11111e15 spomb=0 spomb1=1.11111e+60 spomt=0 spomt1=1.11111e+60 w=320n multi=8
M0057 (XDUT__XCDAC__BP2 XDUT__GPN2 VREFN 0) nch_18_mac ad=4.96e-14 as=4.96e-14 l=150n nf=1 nrd=0 nrs=0 pd=950.0n ps=950.0n sa=155.00n sa1=155.00n sa2=155.00n sa3=155.00n sa4=155.00n sap=172.362n sapb=242.67n sb=155.00n sb1=155.00n sb2=155.00n sb3=155.00n sd=180n spa=180.0n spa1=180.0n spa2=180.0n spa3=180.0n spba=233.666n spba1=239.844n spmb=1.11111e15 spmt=1.11111e15 spomb=0 spomb1=1.11111e+60 spomt=0 spomt1=1.11111e+60 w=320n multi=8
M0058 (XDUT__XCDAC__BN3 XDUT__GNP3 VREFP VDD!) pch_18_mac ad=4.96e-14 as=4.96e-14 l=150n nf=1 nrd=0 nrs=0 pd=950.0n ps=950.0n sa=155.00n sa1=155.00n sa2=155.00n sa3=155.00n sa4=155.00n sap=172.362n sapb=242.67n sb=155.00n sb1=155.00n sb2=155.00n sb3=155.00n sd=180n spa=180.0n spa1=180.0n spa2=180.0n spa3=180.0n spba=233.666n spba1=239.844n spmb=1.11111e15 spmt=1.11111e15 spomb=0 spomb1=1.11111e+60 spomt=0 spomt1=1.11111e+60 w=320n multi=16
M0059 (XDUT__XCDAC__BN3 XDUT__GNN3 VREFN 0) nch_18_mac ad=4.96e-14 as=4.96e-14 l=150n nf=1 nrd=0 nrs=0 pd=950.0n ps=950.0n sa=155.00n sa1=155.00n sa2=155.00n sa3=155.00n sa4=155.00n sap=172.362n sapb=242.67n sb=155.00n sb1=155.00n sb2=155.00n sb3=155.00n sd=180n spa=180.0n spa1=180.0n spa2=180.0n spa3=180.0n spba=233.666n spba1=239.844n spmb=1.11111e15 spmt=1.11111e15 spomb=0 spomb1=1.11111e+60 spomt=0 spomt1=1.11111e+60 w=320n multi=16
M0060 (XDUT__XCDAC__BP3 XDUT__GPP3 VREFP VDD!) pch_18_mac ad=4.96e-14 as=4.96e-14 l=150n nf=1 nrd=0 nrs=0 pd=950.0n ps=950.0n sa=155.00n sa1=155.00n sa2=155.00n sa3=155.00n sa4=155.00n sap=172.362n sapb=242.67n sb=155.00n sb1=155.00n sb2=155.00n sb3=155.00n sd=180n spa=180.0n spa1=180.0n spa2=180.0n spa3=180.0n spba=233.666n spba1=239.844n spmb=1.11111e15 spmt=1.11111e15 spomb=0 spomb1=1.11111e+60 spomt=0 spomt1=1.11111e+60 w=320n multi=16
M0061 (XDUT__XCDAC__BP3 XDUT__GPN3 VREFN 0) nch_18_mac ad=4.96e-14 as=4.96e-14 l=150n nf=1 nrd=0 nrs=0 pd=950.0n ps=950.0n sa=155.00n sa1=155.00n sa2=155.00n sa3=155.00n sa4=155.00n sap=172.362n sapb=242.67n sb=155.00n sb1=155.00n sb2=155.00n sb3=155.00n sd=180n spa=180.0n spa1=180.0n spa2=180.0n spa3=180.0n spba=233.666n spba1=239.844n spmb=1.11111e15 spmt=1.11111e15 spomb=0 spomb1=1.11111e+60 spomt=0 spomt1=1.11111e+60 w=320n multi=16
M0062 (XDUT__XCDAC__BN4 XDUT__GNP4 VREFP VDD!) pch_18_mac ad=4.96e-14 as=4.96e-14 l=150n nf=1 nrd=0 nrs=0 pd=950.0n ps=950.0n sa=155.00n sa1=155.00n sa2=155.00n sa3=155.00n sa4=155.00n sap=172.362n sapb=242.67n sb=155.00n sb1=155.00n sb2=155.00n sb3=155.00n sd=180n spa=180.0n spa1=180.0n spa2=180.0n spa3=180.0n spba=233.666n spba1=239.844n spmb=1.11111e15 spmt=1.11111e15 spomb=0 spomb1=1.11111e+60 spomt=0 spomt1=1.11111e+60 w=320n multi=32
M0063 (XDUT__XCDAC__BN4 XDUT__GNN4 VREFN 0) nch_18_mac ad=4.96e-14 as=4.96e-14 l=150n nf=1 nrd=0 nrs=0 pd=950.0n ps=950.0n sa=155.00n sa1=155.00n sa2=155.00n sa3=155.00n sa4=155.00n sap=172.362n sapb=242.67n sb=155.00n sb1=155.00n sb2=155.00n sb3=155.00n sd=180n spa=180.0n spa1=180.0n spa2=180.0n spa3=180.0n spba=233.666n spba1=239.844n spmb=1.11111e15 spmt=1.11111e15 spomb=0 spomb1=1.11111e+60 spomt=0 spomt1=1.11111e+60 w=320n multi=32
M0064 (XDUT__XCDAC__BP4 XDUT__GPP4 VREFP VDD!) pch_18_mac ad=4.96e-14 as=4.96e-14 l=150n nf=1 nrd=0 nrs=0 pd=950.0n ps=950.0n sa=155.00n sa1=155.00n sa2=155.00n sa3=155.00n sa4=155.00n sap=172.362n sapb=242.67n sb=155.00n sb1=155.00n sb2=155.00n sb3=155.00n sd=180n spa=180.0n spa1=180.0n spa2=180.0n spa3=180.0n spba=233.666n spba1=239.844n spmb=1.11111e15 spmt=1.11111e15 spomb=0 spomb1=1.11111e+60 spomt=0 spomt1=1.11111e+60 w=320n multi=32
M0065 (XDUT__XCDAC__BP4 XDUT__GPN4 VREFN 0) nch_18_mac ad=4.96e-14 as=4.96e-14 l=150n nf=1 nrd=0 nrs=0 pd=950.0n ps=950.0n sa=155.00n sa1=155.00n sa2=155.00n sa3=155.00n sa4=155.00n sap=172.362n sapb=242.67n sb=155.00n sb1=155.00n sb2=155.00n sb3=155.00n sd=180n spa=180.0n spa1=180.0n spa2=180.0n spa3=180.0n spba=233.666n spba1=239.844n spmb=1.11111e15 spmt=1.11111e15 spomb=0 spomb1=1.11111e+60 spomt=0 spomt1=1.11111e+60 w=320n multi=32
M0066 (XDUT__XCDAC__BN5 XDUT__GNP5 VREFP VDD!) pch_18_mac ad=4.96e-14 as=4.96e-14 l=150n nf=1 nrd=0 nrs=0 pd=950.0n ps=950.0n sa=155.00n sa1=155.00n sa2=155.00n sa3=155.00n sa4=155.00n sap=172.362n sapb=242.67n sb=155.00n sb1=155.00n sb2=155.00n sb3=155.00n sd=180n spa=180.0n spa1=180.0n spa2=180.0n spa3=180.0n spba=233.666n spba1=239.844n spmb=1.11111e15 spmt=1.11111e15 spomb=0 spomb1=1.11111e+60 spomt=0 spomt1=1.11111e+60 w=320n multi=64
M0067 (XDUT__XCDAC__BN5 XDUT__GNN5 VREFN 0) nch_18_mac ad=4.96e-14 as=4.96e-14 l=150n nf=1 nrd=0 nrs=0 pd=950.0n ps=950.0n sa=155.00n sa1=155.00n sa2=155.00n sa3=155.00n sa4=155.00n sap=172.362n sapb=242.67n sb=155.00n sb1=155.00n sb2=155.00n sb3=155.00n sd=180n spa=180.0n spa1=180.0n spa2=180.0n spa3=180.0n spba=233.666n spba1=239.844n spmb=1.11111e15 spmt=1.11111e15 spomb=0 spomb1=1.11111e+60 spomt=0 spomt1=1.11111e+60 w=320n multi=64
M0068 (XDUT__XCDAC__BP5 XDUT__GPP5 VREFP VDD!) pch_18_mac ad=4.96e-14 as=4.96e-14 l=150n nf=1 nrd=0 nrs=0 pd=950.0n ps=950.0n sa=155.00n sa1=155.00n sa2=155.00n sa3=155.00n sa4=155.00n sap=172.362n sapb=242.67n sb=155.00n sb1=155.00n sb2=155.00n sb3=155.00n sd=180n spa=180.0n spa1=180.0n spa2=180.0n spa3=180.0n spba=233.666n spba1=239.844n spmb=1.11111e15 spmt=1.11111e15 spomb=0 spomb1=1.11111e+60 spomt=0 spomt1=1.11111e+60 w=320n multi=64
M0069 (XDUT__XCDAC__BP5 XDUT__GPN5 VREFN 0) nch_18_mac ad=4.96e-14 as=4.96e-14 l=150n nf=1 nrd=0 nrs=0 pd=950.0n ps=950.0n sa=155.00n sa1=155.00n sa2=155.00n sa3=155.00n sa4=155.00n sap=172.362n sapb=242.67n sb=155.00n sb1=155.00n sb2=155.00n sb3=155.00n sd=180n spa=180.0n spa1=180.0n spa2=180.0n spa3=180.0n spba=233.666n spba1=239.844n spmb=1.11111e15 spmt=1.11111e15 spomb=0 spomb1=1.11111e+60 spomt=0 spomt1=1.11111e+60 w=320n multi=64
M0070 (XDUT__XCDAC__BN6 XDUT__GNP6 VREFP VDD!) pch_18_mac ad=4.96e-14 as=4.96e-14 l=150n nf=1 nrd=0 nrs=0 pd=950.0n ps=950.0n sa=155.00n sa1=155.00n sa2=155.00n sa3=155.00n sa4=155.00n sap=172.362n sapb=242.67n sb=155.00n sb1=155.00n sb2=155.00n sb3=155.00n sd=180n spa=180.0n spa1=180.0n spa2=180.0n spa3=180.0n spba=233.666n spba1=239.844n spmb=1.11111e15 spmt=1.11111e15 spomb=0 spomb1=1.11111e+60 spomt=0 spomt1=1.11111e+60 w=320n multi=128
M0071 (XDUT__XCDAC__BN6 XDUT__GNN6 VREFN 0) nch_18_mac ad=4.96e-14 as=4.96e-14 l=150n nf=1 nrd=0 nrs=0 pd=950.0n ps=950.0n sa=155.00n sa1=155.00n sa2=155.00n sa3=155.00n sa4=155.00n sap=172.362n sapb=242.67n sb=155.00n sb1=155.00n sb2=155.00n sb3=155.00n sd=180n spa=180.0n spa1=180.0n spa2=180.0n spa3=180.0n spba=233.666n spba1=239.844n spmb=1.11111e15 spmt=1.11111e15 spomb=0 spomb1=1.11111e+60 spomt=0 spomt1=1.11111e+60 w=320n multi=128
M0072 (XDUT__XCDAC__BP6 XDUT__GPP6 VREFP VDD!) pch_18_mac ad=4.96e-14 as=4.96e-14 l=150n nf=1 nrd=0 nrs=0 pd=950.0n ps=950.0n sa=155.00n sa1=155.00n sa2=155.00n sa3=155.00n sa4=155.00n sap=172.362n sapb=242.67n sb=155.00n sb1=155.00n sb2=155.00n sb3=155.00n sd=180n spa=180.0n spa1=180.0n spa2=180.0n spa3=180.0n spba=233.666n spba1=239.844n spmb=1.11111e15 spmt=1.11111e15 spomb=0 spomb1=1.11111e+60 spomt=0 spomt1=1.11111e+60 w=320n multi=128
M0073 (XDUT__XCDAC__BP6 XDUT__GPN6 VREFN 0) nch_18_mac ad=4.96e-14 as=4.96e-14 l=150n nf=1 nrd=0 nrs=0 pd=950.0n ps=950.0n sa=155.00n sa1=155.00n sa2=155.00n sa3=155.00n sa4=155.00n sap=172.362n sapb=242.67n sb=155.00n sb1=155.00n sb2=155.00n sb3=155.00n sd=180n spa=180.0n spa1=180.0n spa2=180.0n spa3=180.0n spba=233.666n spba1=239.844n spmb=1.11111e15 spmt=1.11111e15 spomb=0 spomb1=1.11111e+60 spomt=0 spomt1=1.11111e+60 w=320n multi=128
M0074 (XDUT__XCDAC__BN7 XDUT__GNP7 VREFP VDD!) pch_18_mac ad=4.96e-14 as=4.96e-14 l=150n nf=1 nrd=0 nrs=0 pd=950.0n ps=950.0n sa=155.00n sa1=155.00n sa2=155.00n sa3=155.00n sa4=155.00n sap=172.362n sapb=242.67n sb=155.00n sb1=155.00n sb2=155.00n sb3=155.00n sd=180n spa=180.0n spa1=180.0n spa2=180.0n spa3=180.0n spba=233.666n spba1=239.844n spmb=1.11111e15 spmt=1.11111e15 spomb=0 spomb1=1.11111e+60 spomt=0 spomt1=1.11111e+60 w=320n multi=256
M0075 (XDUT__XCDAC__BN7 XDUT__GNN7 VREFN 0) nch_18_mac ad=4.96e-14 as=4.96e-14 l=150n nf=1 nrd=0 nrs=0 pd=950.0n ps=950.0n sa=155.00n sa1=155.00n sa2=155.00n sa3=155.00n sa4=155.00n sap=172.362n sapb=242.67n sb=155.00n sb1=155.00n sb2=155.00n sb3=155.00n sd=180n spa=180.0n spa1=180.0n spa2=180.0n spa3=180.0n spba=233.666n spba1=239.844n spmb=1.11111e15 spmt=1.11111e15 spomb=0 spomb1=1.11111e+60 spomt=0 spomt1=1.11111e+60 w=320n multi=256
M0076 (XDUT__XCDAC__BP7 XDUT__GPP7 VREFP VDD!) pch_18_mac ad=4.96e-14 as=4.96e-14 l=150n nf=1 nrd=0 nrs=0 pd=950.0n ps=950.0n sa=155.00n sa1=155.00n sa2=155.00n sa3=155.00n sa4=155.00n sap=172.362n sapb=242.67n sb=155.00n sb1=155.00n sb2=155.00n sb3=155.00n sd=180n spa=180.0n spa1=180.0n spa2=180.0n spa3=180.0n spba=233.666n spba1=239.844n spmb=1.11111e15 spmt=1.11111e15 spomb=0 spomb1=1.11111e+60 spomt=0 spomt1=1.11111e+60 w=320n multi=256
M0077 (XDUT__XCDAC__BP7 XDUT__GPN7 VREFN 0) nch_18_mac ad=4.96e-14 as=4.96e-14 l=150n nf=1 nrd=0 nrs=0 pd=950.0n ps=950.0n sa=155.00n sa1=155.00n sa2=155.00n sa3=155.00n sa4=155.00n sap=172.362n sapb=242.67n sb=155.00n sb1=155.00n sb2=155.00n sb3=155.00n sd=180n spa=180.0n spa1=180.0n spa2=180.0n spa3=180.0n spba=233.666n spba1=239.844n spmb=1.11111e15 spmt=1.11111e15 spomb=0 spomb1=1.11111e+60 spomt=0 spomt1=1.11111e+60 w=320n multi=256
M0078 (XDUT__XREF__XDRV0__GNNDRV REF0_GNNB 0 0) nch_mac l=30n w=500n multi=1 nf=1 sd=100n ad=3.75e-14 as=3.75e-14 pd=1.15u ps=1.15u nrd=0.662935 nrs=0.662935 sa=75.0n sb=75.0n sa1=75.0n sa2=75.0n sa3=75.0n sa4=75.0n sb1=75.0n sb2=75.0n sb3=75.0n spa=100n spa1=100n spa2=100n spa3=100n sap=91.9776n sapb=114.444n spba=115.715n spba1=117.043n dfm_flag=0 spmt=1.11111e+15 spomt=0 spomt1=1.11111e+60 spmb=1.11111e+15 spomb=0 spomb1=1.11111e+60
M0079 (XDUT__XREF__XDRV0__GNPDRV REF0_GNPB 0 0) nch_mac l=30n w=500n multi=1 nf=1 sd=100n ad=3.75e-14 as=3.75e-14 pd=1.15u ps=1.15u nrd=0.662935 nrs=0.662935 sa=75.0n sb=75.0n sa1=75.0n sa2=75.0n sa3=75.0n sa4=75.0n sb1=75.0n sb2=75.0n sb3=75.0n spa=100n spa1=100n spa2=100n spa3=100n sap=91.9776n sapb=114.444n spba=115.715n spba1=117.043n dfm_flag=0 spmt=1.11111e+15 spomt=0 spomt1=1.11111e+60 spmb=1.11111e+15 spomb=0 spomb1=1.11111e+60
M0080 (XDUT__XREF__XDRV0__GPNDRV REF0_GPNB 0 0) nch_mac l=30n w=500n multi=1 nf=1 sd=100n ad=3.75e-14 as=3.75e-14 pd=1.15u ps=1.15u nrd=0.662935 nrs=0.662935 sa=75.0n sb=75.0n sa1=75.0n sa2=75.0n sa3=75.0n sa4=75.0n sb1=75.0n sb2=75.0n sb3=75.0n spa=100n spa1=100n spa2=100n spa3=100n sap=91.9776n sapb=114.444n spba=115.715n spba1=117.043n dfm_flag=0 spmt=1.11111e+15 spomt=0 spomt1=1.11111e+60 spmb=1.11111e+15 spomb=0 spomb1=1.11111e+60
M0081 (XDUT__XREF__XDRV0__GPPDRV REF0_GPPB 0 0) nch_mac l=30n w=500n multi=1 nf=1 sd=100n ad=3.75e-14 as=3.75e-14 pd=1.15u ps=1.15u nrd=0.662935 nrs=0.662935 sa=75.0n sb=75.0n sa1=75.0n sa2=75.0n sa3=75.0n sa4=75.0n sb1=75.0n sb2=75.0n sb3=75.0n spa=100n spa1=100n spa2=100n spa3=100n sap=91.9776n sapb=114.444n spba=115.715n spba1=117.043n dfm_flag=0 spmt=1.11111e+15 spomt=0 spomt1=1.11111e+60 spmb=1.11111e+15 spomb=0 spomb1=1.11111e+60
M0082 (XDUT__XREF__XDRV0__GNNDRV REF0_GNNB VDD! VDD!) pch_mac l=30n w=1u multi=1 nf=1 sd=100n ad=7.5e-14 as=7.5e-14 pd=2.15u ps=2.15u nrd=0.165806 nrs=0.165806 sa=75.0n sb=75.0n sa1=75.0n sa2=75.0n sa3=75.0n sa4=75.0n sb1=75.0n sb2=75.0n sb3=75.0n spa=100n spa1=100n spa2=100n spa3=100n sap=91.9776n sapb=114.444n spba=115.715n spba1=117.043n dfm_flag=0 spmt=1.11111e+15 spomt=0 spomt1=1.11111e+60 spmb=1.11111e+15 spomb=0 spomb1=1.11111e+60
M0083 (XDUT__XREF__XDRV0__GNPDRV REF0_GNPB VDD! VDD!) pch_mac l=30n w=1u multi=1 nf=1 sd=100n ad=7.5e-14 as=7.5e-14 pd=2.15u ps=2.15u nrd=0.165806 nrs=0.165806 sa=75.0n sb=75.0n sa1=75.0n sa2=75.0n sa3=75.0n sa4=75.0n sb1=75.0n sb2=75.0n sb3=75.0n spa=100n spa1=100n spa2=100n spa3=100n sap=91.9776n sapb=114.444n spba=115.715n spba1=117.043n dfm_flag=0 spmt=1.11111e+15 spomt=0 spomt1=1.11111e+60 spmb=1.11111e+15 spomb=0 spomb1=1.11111e+60
M0084 (XDUT__XREF__XDRV0__GPNDRV REF0_GPNB VDD! VDD!) pch_mac l=30n w=1u multi=1 nf=1 sd=100n ad=7.5e-14 as=7.5e-14 pd=2.15u ps=2.15u nrd=0.165806 nrs=0.165806 sa=75.0n sb=75.0n sa1=75.0n sa2=75.0n sa3=75.0n sa4=75.0n sb1=75.0n sb2=75.0n sb3=75.0n spa=100n spa1=100n spa2=100n spa3=100n sap=91.9776n sapb=114.444n spba=115.715n spba1=117.043n dfm_flag=0 spmt=1.11111e+15 spomt=0 spomt1=1.11111e+60 spmb=1.11111e+15 spomb=0 spomb1=1.11111e+60
M0085 (XDUT__XREF__XDRV0__GPPDRV REF0_GPPB VDD! VDD!) pch_mac l=30n w=1u multi=1 nf=1 sd=100n ad=7.5e-14 as=7.5e-14 pd=2.15u ps=2.15u nrd=0.165806 nrs=0.165806 sa=75.0n sb=75.0n sa1=75.0n sa2=75.0n sa3=75.0n sa4=75.0n sb1=75.0n sb2=75.0n sb3=75.0n spa=100n spa1=100n spa2=100n spa3=100n sap=91.9776n sapb=114.444n spba=115.715n spba1=117.043n dfm_flag=0 spmt=1.11111e+15 spomt=0 spomt1=1.11111e+60 spmb=1.11111e+15 spomb=0 spomb1=1.11111e+60
R0086 (XDUT__XREF__XDRV0__GNNRG XDUT__XREF__XDRV0__RGNN1_1__dmy0) rupolym l=17.13u w=1u m=1 multi=(1)
R0087 (XDUT__XREF__XDRV0__RGNN1_1__dmy0 XDUT__XREF__XDRV0__RGNN1_2__dmy0) rupolym l=17.13u w=1u m=1 multi=(1)
R0088 (XDUT__XREF__XDRV0__RGNN1_2__dmy0 XDUT__XREF__XDRV0__RGNN1_3__dmy0) rupolym l=17.13u w=1u m=1 multi=(1)
R0089 (XDUT__XREF__XDRV0__RGNN1_3__dmy0 XDUT__XREF__XDRV0__RGNN1_4__dmy0) rupolym l=17.13u w=1u m=1 multi=(1)
R0090 (XDUT__XREF__XDRV0__RGNN1_4__dmy0 XDUT__GNN0) rupolym l=17.13u w=1u m=1 multi=(1)
R0091 (XDUT__XREF__XDRV0__GNNDRV XDUT__XREF__XDRV0__RGNN0_1__dmy0) rupolym l=17.13u w=1u m=1 multi=(1)
R0092 (XDUT__XREF__XDRV0__RGNN0_1__dmy0 XDUT__XREF__XDRV0__RGNN0_2__dmy0) rupolym l=17.13u w=1u m=1 multi=(1)
R0093 (XDUT__XREF__XDRV0__RGNN0_2__dmy0 XDUT__XREF__XDRV0__RGNN0_3__dmy0) rupolym l=17.13u w=1u m=1 multi=(1)
R0094 (XDUT__XREF__XDRV0__RGNN0_3__dmy0 XDUT__XREF__XDRV0__RGNN0_4__dmy0) rupolym l=17.13u w=1u m=1 multi=(1)
R0095 (XDUT__XREF__XDRV0__RGNN0_4__dmy0 XDUT__XREF__XDRV0__GNNRG) rupolym l=17.13u w=1u m=1 multi=(1)
R0096 (XDUT__XREF__XDRV0__GNPRG XDUT__XREF__XDRV0__RGNP1_1__dmy0) rupolym l=17.13u w=1u m=1 multi=(1)
R0097 (XDUT__XREF__XDRV0__RGNP1_1__dmy0 XDUT__XREF__XDRV0__RGNP1_2__dmy0) rupolym l=17.13u w=1u m=1 multi=(1)
R0098 (XDUT__XREF__XDRV0__RGNP1_2__dmy0 XDUT__XREF__XDRV0__RGNP1_3__dmy0) rupolym l=17.13u w=1u m=1 multi=(1)
R0099 (XDUT__XREF__XDRV0__RGNP1_3__dmy0 XDUT__XREF__XDRV0__RGNP1_4__dmy0) rupolym l=17.13u w=1u m=1 multi=(1)
R0100 (XDUT__XREF__XDRV0__RGNP1_4__dmy0 XDUT__GNP0) rupolym l=17.13u w=1u m=1 multi=(1)
R0101 (XDUT__XREF__XDRV0__GNPDRV XDUT__XREF__XDRV0__RGNP0_1__dmy0) rupolym l=17.13u w=1u m=1 multi=(1)
R0102 (XDUT__XREF__XDRV0__RGNP0_1__dmy0 XDUT__XREF__XDRV0__RGNP0_2__dmy0) rupolym l=17.13u w=1u m=1 multi=(1)
R0103 (XDUT__XREF__XDRV0__RGNP0_2__dmy0 XDUT__XREF__XDRV0__RGNP0_3__dmy0) rupolym l=17.13u w=1u m=1 multi=(1)
R0104 (XDUT__XREF__XDRV0__RGNP0_3__dmy0 XDUT__XREF__XDRV0__RGNP0_4__dmy0) rupolym l=17.13u w=1u m=1 multi=(1)
R0105 (XDUT__XREF__XDRV0__RGNP0_4__dmy0 XDUT__XREF__XDRV0__GNPRG) rupolym l=17.13u w=1u m=1 multi=(1)
R0106 (XDUT__XREF__XDRV0__GPNRG XDUT__XREF__XDRV0__RGPN1_1__dmy0) rupolym l=17.13u w=1u m=1 multi=(1)
R0107 (XDUT__XREF__XDRV0__RGPN1_1__dmy0 XDUT__XREF__XDRV0__RGPN1_2__dmy0) rupolym l=17.13u w=1u m=1 multi=(1)
R0108 (XDUT__XREF__XDRV0__RGPN1_2__dmy0 XDUT__XREF__XDRV0__RGPN1_3__dmy0) rupolym l=17.13u w=1u m=1 multi=(1)
R0109 (XDUT__XREF__XDRV0__RGPN1_3__dmy0 XDUT__XREF__XDRV0__RGPN1_4__dmy0) rupolym l=17.13u w=1u m=1 multi=(1)
R0110 (XDUT__XREF__XDRV0__RGPN1_4__dmy0 XDUT__GPN0) rupolym l=17.13u w=1u m=1 multi=(1)
R0111 (XDUT__XREF__XDRV0__GPNDRV XDUT__XREF__XDRV0__RGPN0_1__dmy0) rupolym l=17.13u w=1u m=1 multi=(1)
R0112 (XDUT__XREF__XDRV0__RGPN0_1__dmy0 XDUT__XREF__XDRV0__RGPN0_2__dmy0) rupolym l=17.13u w=1u m=1 multi=(1)
R0113 (XDUT__XREF__XDRV0__RGPN0_2__dmy0 XDUT__XREF__XDRV0__RGPN0_3__dmy0) rupolym l=17.13u w=1u m=1 multi=(1)
R0114 (XDUT__XREF__XDRV0__RGPN0_3__dmy0 XDUT__XREF__XDRV0__RGPN0_4__dmy0) rupolym l=17.13u w=1u m=1 multi=(1)
R0115 (XDUT__XREF__XDRV0__RGPN0_4__dmy0 XDUT__XREF__XDRV0__GPNRG) rupolym l=17.13u w=1u m=1 multi=(1)
R0116 (XDUT__XREF__XDRV0__GPPRG XDUT__XREF__XDRV0__RGPP1_1__dmy0) rupolym l=17.13u w=1u m=1 multi=(1)
R0117 (XDUT__XREF__XDRV0__RGPP1_1__dmy0 XDUT__XREF__XDRV0__RGPP1_2__dmy0) rupolym l=17.13u w=1u m=1 multi=(1)
R0118 (XDUT__XREF__XDRV0__RGPP1_2__dmy0 XDUT__XREF__XDRV0__RGPP1_3__dmy0) rupolym l=17.13u w=1u m=1 multi=(1)
R0119 (XDUT__XREF__XDRV0__RGPP1_3__dmy0 XDUT__XREF__XDRV0__RGPP1_4__dmy0) rupolym l=17.13u w=1u m=1 multi=(1)
R0120 (XDUT__XREF__XDRV0__RGPP1_4__dmy0 XDUT__GPP0) rupolym l=17.13u w=1u m=1 multi=(1)
R0121 (XDUT__XREF__XDRV0__GPPDRV XDUT__XREF__XDRV0__RGPP0_1__dmy0) rupolym l=17.13u w=1u m=1 multi=(1)
R0122 (XDUT__XREF__XDRV0__RGPP0_1__dmy0 XDUT__XREF__XDRV0__RGPP0_2__dmy0) rupolym l=17.13u w=1u m=1 multi=(1)
R0123 (XDUT__XREF__XDRV0__RGPP0_2__dmy0 XDUT__XREF__XDRV0__RGPP0_3__dmy0) rupolym l=17.13u w=1u m=1 multi=(1)
R0124 (XDUT__XREF__XDRV0__RGPP0_3__dmy0 XDUT__XREF__XDRV0__RGPP0_4__dmy0) rupolym l=17.13u w=1u m=1 multi=(1)
R0125 (XDUT__XREF__XDRV0__RGPP0_4__dmy0 XDUT__XREF__XDRV0__GPPRG) rupolym l=17.13u w=1u m=1 multi=(1)
M0126 (XDUT__XREF__XDRV1__GNNDRV REF1_GNNB 0 0) nch_mac l=30n w=500n multi=1 nf=1 sd=100n ad=3.75e-14 as=3.75e-14 pd=1.15u ps=1.15u nrd=0.662935 nrs=0.662935 sa=75.0n sb=75.0n sa1=75.0n sa2=75.0n sa3=75.0n sa4=75.0n sb1=75.0n sb2=75.0n sb3=75.0n spa=100n spa1=100n spa2=100n spa3=100n sap=91.9776n sapb=114.444n spba=115.715n spba1=117.043n dfm_flag=0 spmt=1.11111e+15 spomt=0 spomt1=1.11111e+60 spmb=1.11111e+15 spomb=0 spomb1=1.11111e+60
M0127 (XDUT__XREF__XDRV1__GNPDRV REF1_GNPB 0 0) nch_mac l=30n w=500n multi=1 nf=1 sd=100n ad=3.75e-14 as=3.75e-14 pd=1.15u ps=1.15u nrd=0.662935 nrs=0.662935 sa=75.0n sb=75.0n sa1=75.0n sa2=75.0n sa3=75.0n sa4=75.0n sb1=75.0n sb2=75.0n sb3=75.0n spa=100n spa1=100n spa2=100n spa3=100n sap=91.9776n sapb=114.444n spba=115.715n spba1=117.043n dfm_flag=0 spmt=1.11111e+15 spomt=0 spomt1=1.11111e+60 spmb=1.11111e+15 spomb=0 spomb1=1.11111e+60
M0128 (XDUT__XREF__XDRV1__GPNDRV REF1_GPNB 0 0) nch_mac l=30n w=500n multi=1 nf=1 sd=100n ad=3.75e-14 as=3.75e-14 pd=1.15u ps=1.15u nrd=0.662935 nrs=0.662935 sa=75.0n sb=75.0n sa1=75.0n sa2=75.0n sa3=75.0n sa4=75.0n sb1=75.0n sb2=75.0n sb3=75.0n spa=100n spa1=100n spa2=100n spa3=100n sap=91.9776n sapb=114.444n spba=115.715n spba1=117.043n dfm_flag=0 spmt=1.11111e+15 spomt=0 spomt1=1.11111e+60 spmb=1.11111e+15 spomb=0 spomb1=1.11111e+60
M0129 (XDUT__XREF__XDRV1__GPPDRV REF1_GPPB 0 0) nch_mac l=30n w=500n multi=1 nf=1 sd=100n ad=3.75e-14 as=3.75e-14 pd=1.15u ps=1.15u nrd=0.662935 nrs=0.662935 sa=75.0n sb=75.0n sa1=75.0n sa2=75.0n sa3=75.0n sa4=75.0n sb1=75.0n sb2=75.0n sb3=75.0n spa=100n spa1=100n spa2=100n spa3=100n sap=91.9776n sapb=114.444n spba=115.715n spba1=117.043n dfm_flag=0 spmt=1.11111e+15 spomt=0 spomt1=1.11111e+60 spmb=1.11111e+15 spomb=0 spomb1=1.11111e+60
M0130 (XDUT__XREF__XDRV1__GNNDRV REF1_GNNB VDD! VDD!) pch_mac l=30n w=1u multi=1 nf=1 sd=100n ad=7.5e-14 as=7.5e-14 pd=2.15u ps=2.15u nrd=0.165806 nrs=0.165806 sa=75.0n sb=75.0n sa1=75.0n sa2=75.0n sa3=75.0n sa4=75.0n sb1=75.0n sb2=75.0n sb3=75.0n spa=100n spa1=100n spa2=100n spa3=100n sap=91.9776n sapb=114.444n spba=115.715n spba1=117.043n dfm_flag=0 spmt=1.11111e+15 spomt=0 spomt1=1.11111e+60 spmb=1.11111e+15 spomb=0 spomb1=1.11111e+60
M0131 (XDUT__XREF__XDRV1__GNPDRV REF1_GNPB VDD! VDD!) pch_mac l=30n w=1u multi=1 nf=1 sd=100n ad=7.5e-14 as=7.5e-14 pd=2.15u ps=2.15u nrd=0.165806 nrs=0.165806 sa=75.0n sb=75.0n sa1=75.0n sa2=75.0n sa3=75.0n sa4=75.0n sb1=75.0n sb2=75.0n sb3=75.0n spa=100n spa1=100n spa2=100n spa3=100n sap=91.9776n sapb=114.444n spba=115.715n spba1=117.043n dfm_flag=0 spmt=1.11111e+15 spomt=0 spomt1=1.11111e+60 spmb=1.11111e+15 spomb=0 spomb1=1.11111e+60
M0132 (XDUT__XREF__XDRV1__GPNDRV REF1_GPNB VDD! VDD!) pch_mac l=30n w=1u multi=1 nf=1 sd=100n ad=7.5e-14 as=7.5e-14 pd=2.15u ps=2.15u nrd=0.165806 nrs=0.165806 sa=75.0n sb=75.0n sa1=75.0n sa2=75.0n sa3=75.0n sa4=75.0n sb1=75.0n sb2=75.0n sb3=75.0n spa=100n spa1=100n spa2=100n spa3=100n sap=91.9776n sapb=114.444n spba=115.715n spba1=117.043n dfm_flag=0 spmt=1.11111e+15 spomt=0 spomt1=1.11111e+60 spmb=1.11111e+15 spomb=0 spomb1=1.11111e+60
M0133 (XDUT__XREF__XDRV1__GPPDRV REF1_GPPB VDD! VDD!) pch_mac l=30n w=1u multi=1 nf=1 sd=100n ad=7.5e-14 as=7.5e-14 pd=2.15u ps=2.15u nrd=0.165806 nrs=0.165806 sa=75.0n sb=75.0n sa1=75.0n sa2=75.0n sa3=75.0n sa4=75.0n sb1=75.0n sb2=75.0n sb3=75.0n spa=100n spa1=100n spa2=100n spa3=100n sap=91.9776n sapb=114.444n spba=115.715n spba1=117.043n dfm_flag=0 spmt=1.11111e+15 spomt=0 spomt1=1.11111e+60 spmb=1.11111e+15 spomb=0 spomb1=1.11111e+60
R0134 (XDUT__XREF__XDRV1__GNNRG XDUT__XREF__XDRV1__RGNN1_1__dmy0) rupolym l=17.13u w=1u m=2 multi=(1)
R0135 (XDUT__XREF__XDRV1__RGNN1_1__dmy0 XDUT__XREF__XDRV1__RGNN1_2__dmy0) rupolym l=17.13u w=1u m=2 multi=(1)
R0136 (XDUT__XREF__XDRV1__RGNN1_2__dmy0 XDUT__XREF__XDRV1__RGNN1_3__dmy0) rupolym l=17.13u w=1u m=2 multi=(1)
R0137 (XDUT__XREF__XDRV1__RGNN1_3__dmy0 XDUT__XREF__XDRV1__RGNN1_4__dmy0) rupolym l=17.13u w=1u m=2 multi=(1)
R0138 (XDUT__XREF__XDRV1__RGNN1_4__dmy0 XDUT__GNN1) rupolym l=17.13u w=1u m=2 multi=(1)
R0139 (XDUT__XREF__XDRV1__GNNDRV XDUT__XREF__XDRV1__RGNN0_1__dmy0) rupolym l=17.13u w=1u m=2 multi=(1)
R0140 (XDUT__XREF__XDRV1__RGNN0_1__dmy0 XDUT__XREF__XDRV1__RGNN0_2__dmy0) rupolym l=17.13u w=1u m=2 multi=(1)
R0141 (XDUT__XREF__XDRV1__RGNN0_2__dmy0 XDUT__XREF__XDRV1__RGNN0_3__dmy0) rupolym l=17.13u w=1u m=2 multi=(1)
R0142 (XDUT__XREF__XDRV1__RGNN0_3__dmy0 XDUT__XREF__XDRV1__RGNN0_4__dmy0) rupolym l=17.13u w=1u m=2 multi=(1)
R0143 (XDUT__XREF__XDRV1__RGNN0_4__dmy0 XDUT__XREF__XDRV1__GNNRG) rupolym l=17.13u w=1u m=2 multi=(1)
R0144 (XDUT__XREF__XDRV1__GNPRG XDUT__XREF__XDRV1__RGNP1_1__dmy0) rupolym l=17.13u w=1u m=2 multi=(1)
R0145 (XDUT__XREF__XDRV1__RGNP1_1__dmy0 XDUT__XREF__XDRV1__RGNP1_2__dmy0) rupolym l=17.13u w=1u m=2 multi=(1)
R0146 (XDUT__XREF__XDRV1__RGNP1_2__dmy0 XDUT__XREF__XDRV1__RGNP1_3__dmy0) rupolym l=17.13u w=1u m=2 multi=(1)
R0147 (XDUT__XREF__XDRV1__RGNP1_3__dmy0 XDUT__XREF__XDRV1__RGNP1_4__dmy0) rupolym l=17.13u w=1u m=2 multi=(1)
R0148 (XDUT__XREF__XDRV1__RGNP1_4__dmy0 XDUT__GNP1) rupolym l=17.13u w=1u m=2 multi=(1)
R0149 (XDUT__XREF__XDRV1__GNPDRV XDUT__XREF__XDRV1__RGNP0_1__dmy0) rupolym l=17.13u w=1u m=2 multi=(1)
R0150 (XDUT__XREF__XDRV1__RGNP0_1__dmy0 XDUT__XREF__XDRV1__RGNP0_2__dmy0) rupolym l=17.13u w=1u m=2 multi=(1)
R0151 (XDUT__XREF__XDRV1__RGNP0_2__dmy0 XDUT__XREF__XDRV1__RGNP0_3__dmy0) rupolym l=17.13u w=1u m=2 multi=(1)
R0152 (XDUT__XREF__XDRV1__RGNP0_3__dmy0 XDUT__XREF__XDRV1__RGNP0_4__dmy0) rupolym l=17.13u w=1u m=2 multi=(1)
R0153 (XDUT__XREF__XDRV1__RGNP0_4__dmy0 XDUT__XREF__XDRV1__GNPRG) rupolym l=17.13u w=1u m=2 multi=(1)
R0154 (XDUT__XREF__XDRV1__GPNRG XDUT__XREF__XDRV1__RGPN1_1__dmy0) rupolym l=17.13u w=1u m=2 multi=(1)
R0155 (XDUT__XREF__XDRV1__RGPN1_1__dmy0 XDUT__XREF__XDRV1__RGPN1_2__dmy0) rupolym l=17.13u w=1u m=2 multi=(1)
R0156 (XDUT__XREF__XDRV1__RGPN1_2__dmy0 XDUT__XREF__XDRV1__RGPN1_3__dmy0) rupolym l=17.13u w=1u m=2 multi=(1)
R0157 (XDUT__XREF__XDRV1__RGPN1_3__dmy0 XDUT__XREF__XDRV1__RGPN1_4__dmy0) rupolym l=17.13u w=1u m=2 multi=(1)
R0158 (XDUT__XREF__XDRV1__RGPN1_4__dmy0 XDUT__GPN1) rupolym l=17.13u w=1u m=2 multi=(1)
R0159 (XDUT__XREF__XDRV1__GPNDRV XDUT__XREF__XDRV1__RGPN0_1__dmy0) rupolym l=17.13u w=1u m=2 multi=(1)
R0160 (XDUT__XREF__XDRV1__RGPN0_1__dmy0 XDUT__XREF__XDRV1__RGPN0_2__dmy0) rupolym l=17.13u w=1u m=2 multi=(1)
R0161 (XDUT__XREF__XDRV1__RGPN0_2__dmy0 XDUT__XREF__XDRV1__RGPN0_3__dmy0) rupolym l=17.13u w=1u m=2 multi=(1)
R0162 (XDUT__XREF__XDRV1__RGPN0_3__dmy0 XDUT__XREF__XDRV1__RGPN0_4__dmy0) rupolym l=17.13u w=1u m=2 multi=(1)
R0163 (XDUT__XREF__XDRV1__RGPN0_4__dmy0 XDUT__XREF__XDRV1__GPNRG) rupolym l=17.13u w=1u m=2 multi=(1)
R0164 (XDUT__XREF__XDRV1__GPPRG XDUT__XREF__XDRV1__RGPP1_1__dmy0) rupolym l=17.13u w=1u m=2 multi=(1)
R0165 (XDUT__XREF__XDRV1__RGPP1_1__dmy0 XDUT__XREF__XDRV1__RGPP1_2__dmy0) rupolym l=17.13u w=1u m=2 multi=(1)
R0166 (XDUT__XREF__XDRV1__RGPP1_2__dmy0 XDUT__XREF__XDRV1__RGPP1_3__dmy0) rupolym l=17.13u w=1u m=2 multi=(1)
R0167 (XDUT__XREF__XDRV1__RGPP1_3__dmy0 XDUT__XREF__XDRV1__RGPP1_4__dmy0) rupolym l=17.13u w=1u m=2 multi=(1)
R0168 (XDUT__XREF__XDRV1__RGPP1_4__dmy0 XDUT__GPP1) rupolym l=17.13u w=1u m=2 multi=(1)
R0169 (XDUT__XREF__XDRV1__GPPDRV XDUT__XREF__XDRV1__RGPP0_1__dmy0) rupolym l=17.13u w=1u m=2 multi=(1)
R0170 (XDUT__XREF__XDRV1__RGPP0_1__dmy0 XDUT__XREF__XDRV1__RGPP0_2__dmy0) rupolym l=17.13u w=1u m=2 multi=(1)
R0171 (XDUT__XREF__XDRV1__RGPP0_2__dmy0 XDUT__XREF__XDRV1__RGPP0_3__dmy0) rupolym l=17.13u w=1u m=2 multi=(1)
R0172 (XDUT__XREF__XDRV1__RGPP0_3__dmy0 XDUT__XREF__XDRV1__RGPP0_4__dmy0) rupolym l=17.13u w=1u m=2 multi=(1)
R0173 (XDUT__XREF__XDRV1__RGPP0_4__dmy0 XDUT__XREF__XDRV1__GPPRG) rupolym l=17.13u w=1u m=2 multi=(1)
M0174 (XDUT__XREF__XDRV2__GNNDRV REF2_GNNB 0 0) nch_mac l=30n w=500n multi=1 nf=1 sd=100n ad=3.75e-14 as=3.75e-14 pd=1.15u ps=1.15u nrd=0.662935 nrs=0.662935 sa=75.0n sb=75.0n sa1=75.0n sa2=75.0n sa3=75.0n sa4=75.0n sb1=75.0n sb2=75.0n sb3=75.0n spa=100n spa1=100n spa2=100n spa3=100n sap=91.9776n sapb=114.444n spba=115.715n spba1=117.043n dfm_flag=0 spmt=1.11111e+15 spomt=0 spomt1=1.11111e+60 spmb=1.11111e+15 spomb=0 spomb1=1.11111e+60
M0175 (XDUT__XREF__XDRV2__GNPDRV REF2_GNPB 0 0) nch_mac l=30n w=500n multi=1 nf=1 sd=100n ad=3.75e-14 as=3.75e-14 pd=1.15u ps=1.15u nrd=0.662935 nrs=0.662935 sa=75.0n sb=75.0n sa1=75.0n sa2=75.0n sa3=75.0n sa4=75.0n sb1=75.0n sb2=75.0n sb3=75.0n spa=100n spa1=100n spa2=100n spa3=100n sap=91.9776n sapb=114.444n spba=115.715n spba1=117.043n dfm_flag=0 spmt=1.11111e+15 spomt=0 spomt1=1.11111e+60 spmb=1.11111e+15 spomb=0 spomb1=1.11111e+60
M0176 (XDUT__XREF__XDRV2__GPNDRV REF2_GPNB 0 0) nch_mac l=30n w=500n multi=1 nf=1 sd=100n ad=3.75e-14 as=3.75e-14 pd=1.15u ps=1.15u nrd=0.662935 nrs=0.662935 sa=75.0n sb=75.0n sa1=75.0n sa2=75.0n sa3=75.0n sa4=75.0n sb1=75.0n sb2=75.0n sb3=75.0n spa=100n spa1=100n spa2=100n spa3=100n sap=91.9776n sapb=114.444n spba=115.715n spba1=117.043n dfm_flag=0 spmt=1.11111e+15 spomt=0 spomt1=1.11111e+60 spmb=1.11111e+15 spomb=0 spomb1=1.11111e+60
M0177 (XDUT__XREF__XDRV2__GPPDRV REF2_GPPB 0 0) nch_mac l=30n w=500n multi=1 nf=1 sd=100n ad=3.75e-14 as=3.75e-14 pd=1.15u ps=1.15u nrd=0.662935 nrs=0.662935 sa=75.0n sb=75.0n sa1=75.0n sa2=75.0n sa3=75.0n sa4=75.0n sb1=75.0n sb2=75.0n sb3=75.0n spa=100n spa1=100n spa2=100n spa3=100n sap=91.9776n sapb=114.444n spba=115.715n spba1=117.043n dfm_flag=0 spmt=1.11111e+15 spomt=0 spomt1=1.11111e+60 spmb=1.11111e+15 spomb=0 spomb1=1.11111e+60
M0178 (XDUT__XREF__XDRV2__GNNDRV REF2_GNNB VDD! VDD!) pch_mac l=30n w=1u multi=1 nf=1 sd=100n ad=7.5e-14 as=7.5e-14 pd=2.15u ps=2.15u nrd=0.165806 nrs=0.165806 sa=75.0n sb=75.0n sa1=75.0n sa2=75.0n sa3=75.0n sa4=75.0n sb1=75.0n sb2=75.0n sb3=75.0n spa=100n spa1=100n spa2=100n spa3=100n sap=91.9776n sapb=114.444n spba=115.715n spba1=117.043n dfm_flag=0 spmt=1.11111e+15 spomt=0 spomt1=1.11111e+60 spmb=1.11111e+15 spomb=0 spomb1=1.11111e+60
M0179 (XDUT__XREF__XDRV2__GNPDRV REF2_GNPB VDD! VDD!) pch_mac l=30n w=1u multi=1 nf=1 sd=100n ad=7.5e-14 as=7.5e-14 pd=2.15u ps=2.15u nrd=0.165806 nrs=0.165806 sa=75.0n sb=75.0n sa1=75.0n sa2=75.0n sa3=75.0n sa4=75.0n sb1=75.0n sb2=75.0n sb3=75.0n spa=100n spa1=100n spa2=100n spa3=100n sap=91.9776n sapb=114.444n spba=115.715n spba1=117.043n dfm_flag=0 spmt=1.11111e+15 spomt=0 spomt1=1.11111e+60 spmb=1.11111e+15 spomb=0 spomb1=1.11111e+60
M0180 (XDUT__XREF__XDRV2__GPNDRV REF2_GPNB VDD! VDD!) pch_mac l=30n w=1u multi=1 nf=1 sd=100n ad=7.5e-14 as=7.5e-14 pd=2.15u ps=2.15u nrd=0.165806 nrs=0.165806 sa=75.0n sb=75.0n sa1=75.0n sa2=75.0n sa3=75.0n sa4=75.0n sb1=75.0n sb2=75.0n sb3=75.0n spa=100n spa1=100n spa2=100n spa3=100n sap=91.9776n sapb=114.444n spba=115.715n spba1=117.043n dfm_flag=0 spmt=1.11111e+15 spomt=0 spomt1=1.11111e+60 spmb=1.11111e+15 spomb=0 spomb1=1.11111e+60
M0181 (XDUT__XREF__XDRV2__GPPDRV REF2_GPPB VDD! VDD!) pch_mac l=30n w=1u multi=1 nf=1 sd=100n ad=7.5e-14 as=7.5e-14 pd=2.15u ps=2.15u nrd=0.165806 nrs=0.165806 sa=75.0n sb=75.0n sa1=75.0n sa2=75.0n sa3=75.0n sa4=75.0n sb1=75.0n sb2=75.0n sb3=75.0n spa=100n spa1=100n spa2=100n spa3=100n sap=91.9776n sapb=114.444n spba=115.715n spba1=117.043n dfm_flag=0 spmt=1.11111e+15 spomt=0 spomt1=1.11111e+60 spmb=1.11111e+15 spomb=0 spomb1=1.11111e+60
R0182 (XDUT__XREF__XDRV2__GNNRG XDUT__XREF__XDRV2__RGNN1_1__dmy0) rupolym l=17.13u w=1u m=4 multi=(1)
R0183 (XDUT__XREF__XDRV2__RGNN1_1__dmy0 XDUT__XREF__XDRV2__RGNN1_2__dmy0) rupolym l=17.13u w=1u m=4 multi=(1)
R0184 (XDUT__XREF__XDRV2__RGNN1_2__dmy0 XDUT__XREF__XDRV2__RGNN1_3__dmy0) rupolym l=17.13u w=1u m=4 multi=(1)
R0185 (XDUT__XREF__XDRV2__RGNN1_3__dmy0 XDUT__XREF__XDRV2__RGNN1_4__dmy0) rupolym l=17.13u w=1u m=4 multi=(1)
R0186 (XDUT__XREF__XDRV2__RGNN1_4__dmy0 XDUT__GNN2) rupolym l=17.13u w=1u m=4 multi=(1)
R0187 (XDUT__XREF__XDRV2__GNNDRV XDUT__XREF__XDRV2__RGNN0_1__dmy0) rupolym l=17.13u w=1u m=4 multi=(1)
R0188 (XDUT__XREF__XDRV2__RGNN0_1__dmy0 XDUT__XREF__XDRV2__RGNN0_2__dmy0) rupolym l=17.13u w=1u m=4 multi=(1)
R0189 (XDUT__XREF__XDRV2__RGNN0_2__dmy0 XDUT__XREF__XDRV2__RGNN0_3__dmy0) rupolym l=17.13u w=1u m=4 multi=(1)
R0190 (XDUT__XREF__XDRV2__RGNN0_3__dmy0 XDUT__XREF__XDRV2__RGNN0_4__dmy0) rupolym l=17.13u w=1u m=4 multi=(1)
R0191 (XDUT__XREF__XDRV2__RGNN0_4__dmy0 XDUT__XREF__XDRV2__GNNRG) rupolym l=17.13u w=1u m=4 multi=(1)
R0192 (XDUT__XREF__XDRV2__GNPRG XDUT__XREF__XDRV2__RGNP1_1__dmy0) rupolym l=17.13u w=1u m=4 multi=(1)
R0193 (XDUT__XREF__XDRV2__RGNP1_1__dmy0 XDUT__XREF__XDRV2__RGNP1_2__dmy0) rupolym l=17.13u w=1u m=4 multi=(1)
R0194 (XDUT__XREF__XDRV2__RGNP1_2__dmy0 XDUT__XREF__XDRV2__RGNP1_3__dmy0) rupolym l=17.13u w=1u m=4 multi=(1)
R0195 (XDUT__XREF__XDRV2__RGNP1_3__dmy0 XDUT__XREF__XDRV2__RGNP1_4__dmy0) rupolym l=17.13u w=1u m=4 multi=(1)
R0196 (XDUT__XREF__XDRV2__RGNP1_4__dmy0 XDUT__GNP2) rupolym l=17.13u w=1u m=4 multi=(1)
R0197 (XDUT__XREF__XDRV2__GNPDRV XDUT__XREF__XDRV2__RGNP0_1__dmy0) rupolym l=17.13u w=1u m=4 multi=(1)
R0198 (XDUT__XREF__XDRV2__RGNP0_1__dmy0 XDUT__XREF__XDRV2__RGNP0_2__dmy0) rupolym l=17.13u w=1u m=4 multi=(1)
R0199 (XDUT__XREF__XDRV2__RGNP0_2__dmy0 XDUT__XREF__XDRV2__RGNP0_3__dmy0) rupolym l=17.13u w=1u m=4 multi=(1)
R0200 (XDUT__XREF__XDRV2__RGNP0_3__dmy0 XDUT__XREF__XDRV2__RGNP0_4__dmy0) rupolym l=17.13u w=1u m=4 multi=(1)
R0201 (XDUT__XREF__XDRV2__RGNP0_4__dmy0 XDUT__XREF__XDRV2__GNPRG) rupolym l=17.13u w=1u m=4 multi=(1)
R0202 (XDUT__XREF__XDRV2__GPNRG XDUT__XREF__XDRV2__RGPN1_1__dmy0) rupolym l=17.13u w=1u m=4 multi=(1)
R0203 (XDUT__XREF__XDRV2__RGPN1_1__dmy0 XDUT__XREF__XDRV2__RGPN1_2__dmy0) rupolym l=17.13u w=1u m=4 multi=(1)
R0204 (XDUT__XREF__XDRV2__RGPN1_2__dmy0 XDUT__XREF__XDRV2__RGPN1_3__dmy0) rupolym l=17.13u w=1u m=4 multi=(1)
R0205 (XDUT__XREF__XDRV2__RGPN1_3__dmy0 XDUT__XREF__XDRV2__RGPN1_4__dmy0) rupolym l=17.13u w=1u m=4 multi=(1)
R0206 (XDUT__XREF__XDRV2__RGPN1_4__dmy0 XDUT__GPN2) rupolym l=17.13u w=1u m=4 multi=(1)
R0207 (XDUT__XREF__XDRV2__GPNDRV XDUT__XREF__XDRV2__RGPN0_1__dmy0) rupolym l=17.13u w=1u m=4 multi=(1)
R0208 (XDUT__XREF__XDRV2__RGPN0_1__dmy0 XDUT__XREF__XDRV2__RGPN0_2__dmy0) rupolym l=17.13u w=1u m=4 multi=(1)
R0209 (XDUT__XREF__XDRV2__RGPN0_2__dmy0 XDUT__XREF__XDRV2__RGPN0_3__dmy0) rupolym l=17.13u w=1u m=4 multi=(1)
R0210 (XDUT__XREF__XDRV2__RGPN0_3__dmy0 XDUT__XREF__XDRV2__RGPN0_4__dmy0) rupolym l=17.13u w=1u m=4 multi=(1)
R0211 (XDUT__XREF__XDRV2__RGPN0_4__dmy0 XDUT__XREF__XDRV2__GPNRG) rupolym l=17.13u w=1u m=4 multi=(1)
R0212 (XDUT__XREF__XDRV2__GPPRG XDUT__XREF__XDRV2__RGPP1_1__dmy0) rupolym l=17.13u w=1u m=4 multi=(1)
R0213 (XDUT__XREF__XDRV2__RGPP1_1__dmy0 XDUT__XREF__XDRV2__RGPP1_2__dmy0) rupolym l=17.13u w=1u m=4 multi=(1)
R0214 (XDUT__XREF__XDRV2__RGPP1_2__dmy0 XDUT__XREF__XDRV2__RGPP1_3__dmy0) rupolym l=17.13u w=1u m=4 multi=(1)
R0215 (XDUT__XREF__XDRV2__RGPP1_3__dmy0 XDUT__XREF__XDRV2__RGPP1_4__dmy0) rupolym l=17.13u w=1u m=4 multi=(1)
R0216 (XDUT__XREF__XDRV2__RGPP1_4__dmy0 XDUT__GPP2) rupolym l=17.13u w=1u m=4 multi=(1)
R0217 (XDUT__XREF__XDRV2__GPPDRV XDUT__XREF__XDRV2__RGPP0_1__dmy0) rupolym l=17.13u w=1u m=4 multi=(1)
R0218 (XDUT__XREF__XDRV2__RGPP0_1__dmy0 XDUT__XREF__XDRV2__RGPP0_2__dmy0) rupolym l=17.13u w=1u m=4 multi=(1)
R0219 (XDUT__XREF__XDRV2__RGPP0_2__dmy0 XDUT__XREF__XDRV2__RGPP0_3__dmy0) rupolym l=17.13u w=1u m=4 multi=(1)
R0220 (XDUT__XREF__XDRV2__RGPP0_3__dmy0 XDUT__XREF__XDRV2__RGPP0_4__dmy0) rupolym l=17.13u w=1u m=4 multi=(1)
R0221 (XDUT__XREF__XDRV2__RGPP0_4__dmy0 XDUT__XREF__XDRV2__GPPRG) rupolym l=17.13u w=1u m=4 multi=(1)
M0222 (XDUT__XREF__XDRV3__GNNDRV REF3_GNNB 0 0) nch_mac l=30n w=500n multi=1 nf=1 sd=100n ad=3.75e-14 as=3.75e-14 pd=1.15u ps=1.15u nrd=0.662935 nrs=0.662935 sa=75.0n sb=75.0n sa1=75.0n sa2=75.0n sa3=75.0n sa4=75.0n sb1=75.0n sb2=75.0n sb3=75.0n spa=100n spa1=100n spa2=100n spa3=100n sap=91.9776n sapb=114.444n spba=115.715n spba1=117.043n dfm_flag=0 spmt=1.11111e+15 spomt=0 spomt1=1.11111e+60 spmb=1.11111e+15 spomb=0 spomb1=1.11111e+60
M0223 (XDUT__XREF__XDRV3__GNPDRV REF3_GNPB 0 0) nch_mac l=30n w=500n multi=1 nf=1 sd=100n ad=3.75e-14 as=3.75e-14 pd=1.15u ps=1.15u nrd=0.662935 nrs=0.662935 sa=75.0n sb=75.0n sa1=75.0n sa2=75.0n sa3=75.0n sa4=75.0n sb1=75.0n sb2=75.0n sb3=75.0n spa=100n spa1=100n spa2=100n spa3=100n sap=91.9776n sapb=114.444n spba=115.715n spba1=117.043n dfm_flag=0 spmt=1.11111e+15 spomt=0 spomt1=1.11111e+60 spmb=1.11111e+15 spomb=0 spomb1=1.11111e+60
M0224 (XDUT__XREF__XDRV3__GPNDRV REF3_GPNB 0 0) nch_mac l=30n w=500n multi=1 nf=1 sd=100n ad=3.75e-14 as=3.75e-14 pd=1.15u ps=1.15u nrd=0.662935 nrs=0.662935 sa=75.0n sb=75.0n sa1=75.0n sa2=75.0n sa3=75.0n sa4=75.0n sb1=75.0n sb2=75.0n sb3=75.0n spa=100n spa1=100n spa2=100n spa3=100n sap=91.9776n sapb=114.444n spba=115.715n spba1=117.043n dfm_flag=0 spmt=1.11111e+15 spomt=0 spomt1=1.11111e+60 spmb=1.11111e+15 spomb=0 spomb1=1.11111e+60
M0225 (XDUT__XREF__XDRV3__GPPDRV REF3_GPPB 0 0) nch_mac l=30n w=500n multi=1 nf=1 sd=100n ad=3.75e-14 as=3.75e-14 pd=1.15u ps=1.15u nrd=0.662935 nrs=0.662935 sa=75.0n sb=75.0n sa1=75.0n sa2=75.0n sa3=75.0n sa4=75.0n sb1=75.0n sb2=75.0n sb3=75.0n spa=100n spa1=100n spa2=100n spa3=100n sap=91.9776n sapb=114.444n spba=115.715n spba1=117.043n dfm_flag=0 spmt=1.11111e+15 spomt=0 spomt1=1.11111e+60 spmb=1.11111e+15 spomb=0 spomb1=1.11111e+60
M0226 (XDUT__XREF__XDRV3__GNNDRV REF3_GNNB VDD! VDD!) pch_mac l=30n w=1u multi=1 nf=1 sd=100n ad=7.5e-14 as=7.5e-14 pd=2.15u ps=2.15u nrd=0.165806 nrs=0.165806 sa=75.0n sb=75.0n sa1=75.0n sa2=75.0n sa3=75.0n sa4=75.0n sb1=75.0n sb2=75.0n sb3=75.0n spa=100n spa1=100n spa2=100n spa3=100n sap=91.9776n sapb=114.444n spba=115.715n spba1=117.043n dfm_flag=0 spmt=1.11111e+15 spomt=0 spomt1=1.11111e+60 spmb=1.11111e+15 spomb=0 spomb1=1.11111e+60
M0227 (XDUT__XREF__XDRV3__GNPDRV REF3_GNPB VDD! VDD!) pch_mac l=30n w=1u multi=1 nf=1 sd=100n ad=7.5e-14 as=7.5e-14 pd=2.15u ps=2.15u nrd=0.165806 nrs=0.165806 sa=75.0n sb=75.0n sa1=75.0n sa2=75.0n sa3=75.0n sa4=75.0n sb1=75.0n sb2=75.0n sb3=75.0n spa=100n spa1=100n spa2=100n spa3=100n sap=91.9776n sapb=114.444n spba=115.715n spba1=117.043n dfm_flag=0 spmt=1.11111e+15 spomt=0 spomt1=1.11111e+60 spmb=1.11111e+15 spomb=0 spomb1=1.11111e+60
M0228 (XDUT__XREF__XDRV3__GPNDRV REF3_GPNB VDD! VDD!) pch_mac l=30n w=1u multi=1 nf=1 sd=100n ad=7.5e-14 as=7.5e-14 pd=2.15u ps=2.15u nrd=0.165806 nrs=0.165806 sa=75.0n sb=75.0n sa1=75.0n sa2=75.0n sa3=75.0n sa4=75.0n sb1=75.0n sb2=75.0n sb3=75.0n spa=100n spa1=100n spa2=100n spa3=100n sap=91.9776n sapb=114.444n spba=115.715n spba1=117.043n dfm_flag=0 spmt=1.11111e+15 spomt=0 spomt1=1.11111e+60 spmb=1.11111e+15 spomb=0 spomb1=1.11111e+60
M0229 (XDUT__XREF__XDRV3__GPPDRV REF3_GPPB VDD! VDD!) pch_mac l=30n w=1u multi=1 nf=1 sd=100n ad=7.5e-14 as=7.5e-14 pd=2.15u ps=2.15u nrd=0.165806 nrs=0.165806 sa=75.0n sb=75.0n sa1=75.0n sa2=75.0n sa3=75.0n sa4=75.0n sb1=75.0n sb2=75.0n sb3=75.0n spa=100n spa1=100n spa2=100n spa3=100n sap=91.9776n sapb=114.444n spba=115.715n spba1=117.043n dfm_flag=0 spmt=1.11111e+15 spomt=0 spomt1=1.11111e+60 spmb=1.11111e+15 spomb=0 spomb1=1.11111e+60
R0230 (XDUT__XREF__XDRV3__GNNRG XDUT__XREF__XDRV3__RGNN1_1__dmy0) rupolym l=17.13u w=1u m=8 multi=(1)
R0231 (XDUT__XREF__XDRV3__RGNN1_1__dmy0 XDUT__XREF__XDRV3__RGNN1_2__dmy0) rupolym l=17.13u w=1u m=8 multi=(1)
R0232 (XDUT__XREF__XDRV3__RGNN1_2__dmy0 XDUT__XREF__XDRV3__RGNN1_3__dmy0) rupolym l=17.13u w=1u m=8 multi=(1)
R0233 (XDUT__XREF__XDRV3__RGNN1_3__dmy0 XDUT__XREF__XDRV3__RGNN1_4__dmy0) rupolym l=17.13u w=1u m=8 multi=(1)
R0234 (XDUT__XREF__XDRV3__RGNN1_4__dmy0 XDUT__GNN3) rupolym l=17.13u w=1u m=8 multi=(1)
R0235 (XDUT__XREF__XDRV3__GNNDRV XDUT__XREF__XDRV3__RGNN0_1__dmy0) rupolym l=17.13u w=1u m=8 multi=(1)
R0236 (XDUT__XREF__XDRV3__RGNN0_1__dmy0 XDUT__XREF__XDRV3__RGNN0_2__dmy0) rupolym l=17.13u w=1u m=8 multi=(1)
R0237 (XDUT__XREF__XDRV3__RGNN0_2__dmy0 XDUT__XREF__XDRV3__RGNN0_3__dmy0) rupolym l=17.13u w=1u m=8 multi=(1)
R0238 (XDUT__XREF__XDRV3__RGNN0_3__dmy0 XDUT__XREF__XDRV3__RGNN0_4__dmy0) rupolym l=17.13u w=1u m=8 multi=(1)
R0239 (XDUT__XREF__XDRV3__RGNN0_4__dmy0 XDUT__XREF__XDRV3__GNNRG) rupolym l=17.13u w=1u m=8 multi=(1)
R0240 (XDUT__XREF__XDRV3__GNPRG XDUT__XREF__XDRV3__RGNP1_1__dmy0) rupolym l=17.13u w=1u m=8 multi=(1)
R0241 (XDUT__XREF__XDRV3__RGNP1_1__dmy0 XDUT__XREF__XDRV3__RGNP1_2__dmy0) rupolym l=17.13u w=1u m=8 multi=(1)
R0242 (XDUT__XREF__XDRV3__RGNP1_2__dmy0 XDUT__XREF__XDRV3__RGNP1_3__dmy0) rupolym l=17.13u w=1u m=8 multi=(1)
R0243 (XDUT__XREF__XDRV3__RGNP1_3__dmy0 XDUT__XREF__XDRV3__RGNP1_4__dmy0) rupolym l=17.13u w=1u m=8 multi=(1)
R0244 (XDUT__XREF__XDRV3__RGNP1_4__dmy0 XDUT__GNP3) rupolym l=17.13u w=1u m=8 multi=(1)
R0245 (XDUT__XREF__XDRV3__GNPDRV XDUT__XREF__XDRV3__RGNP0_1__dmy0) rupolym l=17.13u w=1u m=8 multi=(1)
R0246 (XDUT__XREF__XDRV3__RGNP0_1__dmy0 XDUT__XREF__XDRV3__RGNP0_2__dmy0) rupolym l=17.13u w=1u m=8 multi=(1)
R0247 (XDUT__XREF__XDRV3__RGNP0_2__dmy0 XDUT__XREF__XDRV3__RGNP0_3__dmy0) rupolym l=17.13u w=1u m=8 multi=(1)
R0248 (XDUT__XREF__XDRV3__RGNP0_3__dmy0 XDUT__XREF__XDRV3__RGNP0_4__dmy0) rupolym l=17.13u w=1u m=8 multi=(1)
R0249 (XDUT__XREF__XDRV3__RGNP0_4__dmy0 XDUT__XREF__XDRV3__GNPRG) rupolym l=17.13u w=1u m=8 multi=(1)
R0250 (XDUT__XREF__XDRV3__GPNRG XDUT__XREF__XDRV3__RGPN1_1__dmy0) rupolym l=17.13u w=1u m=8 multi=(1)
R0251 (XDUT__XREF__XDRV3__RGPN1_1__dmy0 XDUT__XREF__XDRV3__RGPN1_2__dmy0) rupolym l=17.13u w=1u m=8 multi=(1)
R0252 (XDUT__XREF__XDRV3__RGPN1_2__dmy0 XDUT__XREF__XDRV3__RGPN1_3__dmy0) rupolym l=17.13u w=1u m=8 multi=(1)
R0253 (XDUT__XREF__XDRV3__RGPN1_3__dmy0 XDUT__XREF__XDRV3__RGPN1_4__dmy0) rupolym l=17.13u w=1u m=8 multi=(1)
R0254 (XDUT__XREF__XDRV3__RGPN1_4__dmy0 XDUT__GPN3) rupolym l=17.13u w=1u m=8 multi=(1)
R0255 (XDUT__XREF__XDRV3__GPNDRV XDUT__XREF__XDRV3__RGPN0_1__dmy0) rupolym l=17.13u w=1u m=8 multi=(1)
R0256 (XDUT__XREF__XDRV3__RGPN0_1__dmy0 XDUT__XREF__XDRV3__RGPN0_2__dmy0) rupolym l=17.13u w=1u m=8 multi=(1)
R0257 (XDUT__XREF__XDRV3__RGPN0_2__dmy0 XDUT__XREF__XDRV3__RGPN0_3__dmy0) rupolym l=17.13u w=1u m=8 multi=(1)
R0258 (XDUT__XREF__XDRV3__RGPN0_3__dmy0 XDUT__XREF__XDRV3__RGPN0_4__dmy0) rupolym l=17.13u w=1u m=8 multi=(1)
R0259 (XDUT__XREF__XDRV3__RGPN0_4__dmy0 XDUT__XREF__XDRV3__GPNRG) rupolym l=17.13u w=1u m=8 multi=(1)
R0260 (XDUT__XREF__XDRV3__GPPRG XDUT__XREF__XDRV3__RGPP1_1__dmy0) rupolym l=17.13u w=1u m=8 multi=(1)
R0261 (XDUT__XREF__XDRV3__RGPP1_1__dmy0 XDUT__XREF__XDRV3__RGPP1_2__dmy0) rupolym l=17.13u w=1u m=8 multi=(1)
R0262 (XDUT__XREF__XDRV3__RGPP1_2__dmy0 XDUT__XREF__XDRV3__RGPP1_3__dmy0) rupolym l=17.13u w=1u m=8 multi=(1)
R0263 (XDUT__XREF__XDRV3__RGPP1_3__dmy0 XDUT__XREF__XDRV3__RGPP1_4__dmy0) rupolym l=17.13u w=1u m=8 multi=(1)
R0264 (XDUT__XREF__XDRV3__RGPP1_4__dmy0 XDUT__GPP3) rupolym l=17.13u w=1u m=8 multi=(1)
R0265 (XDUT__XREF__XDRV3__GPPDRV XDUT__XREF__XDRV3__RGPP0_1__dmy0) rupolym l=17.13u w=1u m=8 multi=(1)
R0266 (XDUT__XREF__XDRV3__RGPP0_1__dmy0 XDUT__XREF__XDRV3__RGPP0_2__dmy0) rupolym l=17.13u w=1u m=8 multi=(1)
R0267 (XDUT__XREF__XDRV3__RGPP0_2__dmy0 XDUT__XREF__XDRV3__RGPP0_3__dmy0) rupolym l=17.13u w=1u m=8 multi=(1)
R0268 (XDUT__XREF__XDRV3__RGPP0_3__dmy0 XDUT__XREF__XDRV3__RGPP0_4__dmy0) rupolym l=17.13u w=1u m=8 multi=(1)
R0269 (XDUT__XREF__XDRV3__RGPP0_4__dmy0 XDUT__XREF__XDRV3__GPPRG) rupolym l=17.13u w=1u m=8 multi=(1)
M0270 (XDUT__XREF__XDRV4__GNNDRV REF4_GNNB 0 0) nch_mac l=30n w=500n multi=2 nf=1 sd=100n ad=3.75e-14 as=3.75e-14 pd=1.15u ps=1.15u nrd=0.662935 nrs=0.662935 sa=75.0n sb=75.0n sa1=75.0n sa2=75.0n sa3=75.0n sa4=75.0n sb1=75.0n sb2=75.0n sb3=75.0n spa=100n spa1=100n spa2=100n spa3=100n sap=91.9776n sapb=114.444n spba=115.715n spba1=117.043n dfm_flag=0 spmt=1.11111e+15 spomt=0 spomt1=1.11111e+60 spmb=1.11111e+15 spomb=0 spomb1=1.11111e+60
M0271 (XDUT__XREF__XDRV4__GNPDRV REF4_GNPB 0 0) nch_mac l=30n w=500n multi=2 nf=1 sd=100n ad=3.75e-14 as=3.75e-14 pd=1.15u ps=1.15u nrd=0.662935 nrs=0.662935 sa=75.0n sb=75.0n sa1=75.0n sa2=75.0n sa3=75.0n sa4=75.0n sb1=75.0n sb2=75.0n sb3=75.0n spa=100n spa1=100n spa2=100n spa3=100n sap=91.9776n sapb=114.444n spba=115.715n spba1=117.043n dfm_flag=0 spmt=1.11111e+15 spomt=0 spomt1=1.11111e+60 spmb=1.11111e+15 spomb=0 spomb1=1.11111e+60
M0272 (XDUT__XREF__XDRV4__GPNDRV REF4_GPNB 0 0) nch_mac l=30n w=500n multi=2 nf=1 sd=100n ad=3.75e-14 as=3.75e-14 pd=1.15u ps=1.15u nrd=0.662935 nrs=0.662935 sa=75.0n sb=75.0n sa1=75.0n sa2=75.0n sa3=75.0n sa4=75.0n sb1=75.0n sb2=75.0n sb3=75.0n spa=100n spa1=100n spa2=100n spa3=100n sap=91.9776n sapb=114.444n spba=115.715n spba1=117.043n dfm_flag=0 spmt=1.11111e+15 spomt=0 spomt1=1.11111e+60 spmb=1.11111e+15 spomb=0 spomb1=1.11111e+60
M0273 (XDUT__XREF__XDRV4__GPPDRV REF4_GPPB 0 0) nch_mac l=30n w=500n multi=2 nf=1 sd=100n ad=3.75e-14 as=3.75e-14 pd=1.15u ps=1.15u nrd=0.662935 nrs=0.662935 sa=75.0n sb=75.0n sa1=75.0n sa2=75.0n sa3=75.0n sa4=75.0n sb1=75.0n sb2=75.0n sb3=75.0n spa=100n spa1=100n spa2=100n spa3=100n sap=91.9776n sapb=114.444n spba=115.715n spba1=117.043n dfm_flag=0 spmt=1.11111e+15 spomt=0 spomt1=1.11111e+60 spmb=1.11111e+15 spomb=0 spomb1=1.11111e+60
M0274 (XDUT__XREF__XDRV4__GNNDRV REF4_GNNB VDD! VDD!) pch_mac l=30n w=1u multi=2 nf=1 sd=100n ad=7.5e-14 as=7.5e-14 pd=2.15u ps=2.15u nrd=0.165806 nrs=0.165806 sa=75.0n sb=75.0n sa1=75.0n sa2=75.0n sa3=75.0n sa4=75.0n sb1=75.0n sb2=75.0n sb3=75.0n spa=100n spa1=100n spa2=100n spa3=100n sap=91.9776n sapb=114.444n spba=115.715n spba1=117.043n dfm_flag=0 spmt=1.11111e+15 spomt=0 spomt1=1.11111e+60 spmb=1.11111e+15 spomb=0 spomb1=1.11111e+60
M0275 (XDUT__XREF__XDRV4__GNPDRV REF4_GNPB VDD! VDD!) pch_mac l=30n w=1u multi=2 nf=1 sd=100n ad=7.5e-14 as=7.5e-14 pd=2.15u ps=2.15u nrd=0.165806 nrs=0.165806 sa=75.0n sb=75.0n sa1=75.0n sa2=75.0n sa3=75.0n sa4=75.0n sb1=75.0n sb2=75.0n sb3=75.0n spa=100n spa1=100n spa2=100n spa3=100n sap=91.9776n sapb=114.444n spba=115.715n spba1=117.043n dfm_flag=0 spmt=1.11111e+15 spomt=0 spomt1=1.11111e+60 spmb=1.11111e+15 spomb=0 spomb1=1.11111e+60
M0276 (XDUT__XREF__XDRV4__GPNDRV REF4_GPNB VDD! VDD!) pch_mac l=30n w=1u multi=2 nf=1 sd=100n ad=7.5e-14 as=7.5e-14 pd=2.15u ps=2.15u nrd=0.165806 nrs=0.165806 sa=75.0n sb=75.0n sa1=75.0n sa2=75.0n sa3=75.0n sa4=75.0n sb1=75.0n sb2=75.0n sb3=75.0n spa=100n spa1=100n spa2=100n spa3=100n sap=91.9776n sapb=114.444n spba=115.715n spba1=117.043n dfm_flag=0 spmt=1.11111e+15 spomt=0 spomt1=1.11111e+60 spmb=1.11111e+15 spomb=0 spomb1=1.11111e+60
M0277 (XDUT__XREF__XDRV4__GPPDRV REF4_GPPB VDD! VDD!) pch_mac l=30n w=1u multi=2 nf=1 sd=100n ad=7.5e-14 as=7.5e-14 pd=2.15u ps=2.15u nrd=0.165806 nrs=0.165806 sa=75.0n sb=75.0n sa1=75.0n sa2=75.0n sa3=75.0n sa4=75.0n sb1=75.0n sb2=75.0n sb3=75.0n spa=100n spa1=100n spa2=100n spa3=100n sap=91.9776n sapb=114.444n spba=115.715n spba1=117.043n dfm_flag=0 spmt=1.11111e+15 spomt=0 spomt1=1.11111e+60 spmb=1.11111e+15 spomb=0 spomb1=1.11111e+60
R0278 (XDUT__XREF__XDRV4__GNNRG XDUT__XREF__XDRV4__RGNN1_1__dmy0) rupolym l=17.13u w=1u m=16 multi=(1)
R0279 (XDUT__XREF__XDRV4__RGNN1_1__dmy0 XDUT__XREF__XDRV4__RGNN1_2__dmy0) rupolym l=17.13u w=1u m=16 multi=(1)
R0280 (XDUT__XREF__XDRV4__RGNN1_2__dmy0 XDUT__XREF__XDRV4__RGNN1_3__dmy0) rupolym l=17.13u w=1u m=16 multi=(1)
R0281 (XDUT__XREF__XDRV4__RGNN1_3__dmy0 XDUT__XREF__XDRV4__RGNN1_4__dmy0) rupolym l=17.13u w=1u m=16 multi=(1)
R0282 (XDUT__XREF__XDRV4__RGNN1_4__dmy0 XDUT__GNN4) rupolym l=17.13u w=1u m=16 multi=(1)
R0283 (XDUT__XREF__XDRV4__GNNDRV XDUT__XREF__XDRV4__RGNN0_1__dmy0) rupolym l=17.13u w=1u m=16 multi=(1)
R0284 (XDUT__XREF__XDRV4__RGNN0_1__dmy0 XDUT__XREF__XDRV4__RGNN0_2__dmy0) rupolym l=17.13u w=1u m=16 multi=(1)
R0285 (XDUT__XREF__XDRV4__RGNN0_2__dmy0 XDUT__XREF__XDRV4__RGNN0_3__dmy0) rupolym l=17.13u w=1u m=16 multi=(1)
R0286 (XDUT__XREF__XDRV4__RGNN0_3__dmy0 XDUT__XREF__XDRV4__RGNN0_4__dmy0) rupolym l=17.13u w=1u m=16 multi=(1)
R0287 (XDUT__XREF__XDRV4__RGNN0_4__dmy0 XDUT__XREF__XDRV4__GNNRG) rupolym l=17.13u w=1u m=16 multi=(1)
R0288 (XDUT__XREF__XDRV4__GNPRG XDUT__XREF__XDRV4__RGNP1_1__dmy0) rupolym l=17.13u w=1u m=16 multi=(1)
R0289 (XDUT__XREF__XDRV4__RGNP1_1__dmy0 XDUT__XREF__XDRV4__RGNP1_2__dmy0) rupolym l=17.13u w=1u m=16 multi=(1)
R0290 (XDUT__XREF__XDRV4__RGNP1_2__dmy0 XDUT__XREF__XDRV4__RGNP1_3__dmy0) rupolym l=17.13u w=1u m=16 multi=(1)
R0291 (XDUT__XREF__XDRV4__RGNP1_3__dmy0 XDUT__XREF__XDRV4__RGNP1_4__dmy0) rupolym l=17.13u w=1u m=16 multi=(1)
R0292 (XDUT__XREF__XDRV4__RGNP1_4__dmy0 XDUT__GNP4) rupolym l=17.13u w=1u m=16 multi=(1)
R0293 (XDUT__XREF__XDRV4__GNPDRV XDUT__XREF__XDRV4__RGNP0_1__dmy0) rupolym l=17.13u w=1u m=16 multi=(1)
R0294 (XDUT__XREF__XDRV4__RGNP0_1__dmy0 XDUT__XREF__XDRV4__RGNP0_2__dmy0) rupolym l=17.13u w=1u m=16 multi=(1)
R0295 (XDUT__XREF__XDRV4__RGNP0_2__dmy0 XDUT__XREF__XDRV4__RGNP0_3__dmy0) rupolym l=17.13u w=1u m=16 multi=(1)
R0296 (XDUT__XREF__XDRV4__RGNP0_3__dmy0 XDUT__XREF__XDRV4__RGNP0_4__dmy0) rupolym l=17.13u w=1u m=16 multi=(1)
R0297 (XDUT__XREF__XDRV4__RGNP0_4__dmy0 XDUT__XREF__XDRV4__GNPRG) rupolym l=17.13u w=1u m=16 multi=(1)
R0298 (XDUT__XREF__XDRV4__GPNRG XDUT__XREF__XDRV4__RGPN1_1__dmy0) rupolym l=17.13u w=1u m=16 multi=(1)
R0299 (XDUT__XREF__XDRV4__RGPN1_1__dmy0 XDUT__XREF__XDRV4__RGPN1_2__dmy0) rupolym l=17.13u w=1u m=16 multi=(1)
R0300 (XDUT__XREF__XDRV4__RGPN1_2__dmy0 XDUT__XREF__XDRV4__RGPN1_3__dmy0) rupolym l=17.13u w=1u m=16 multi=(1)
R0301 (XDUT__XREF__XDRV4__RGPN1_3__dmy0 XDUT__XREF__XDRV4__RGPN1_4__dmy0) rupolym l=17.13u w=1u m=16 multi=(1)
R0302 (XDUT__XREF__XDRV4__RGPN1_4__dmy0 XDUT__GPN4) rupolym l=17.13u w=1u m=16 multi=(1)
R0303 (XDUT__XREF__XDRV4__GPNDRV XDUT__XREF__XDRV4__RGPN0_1__dmy0) rupolym l=17.13u w=1u m=16 multi=(1)
R0304 (XDUT__XREF__XDRV4__RGPN0_1__dmy0 XDUT__XREF__XDRV4__RGPN0_2__dmy0) rupolym l=17.13u w=1u m=16 multi=(1)
R0305 (XDUT__XREF__XDRV4__RGPN0_2__dmy0 XDUT__XREF__XDRV4__RGPN0_3__dmy0) rupolym l=17.13u w=1u m=16 multi=(1)
R0306 (XDUT__XREF__XDRV4__RGPN0_3__dmy0 XDUT__XREF__XDRV4__RGPN0_4__dmy0) rupolym l=17.13u w=1u m=16 multi=(1)
R0307 (XDUT__XREF__XDRV4__RGPN0_4__dmy0 XDUT__XREF__XDRV4__GPNRG) rupolym l=17.13u w=1u m=16 multi=(1)
R0308 (XDUT__XREF__XDRV4__GPPRG XDUT__XREF__XDRV4__RGPP1_1__dmy0) rupolym l=17.13u w=1u m=16 multi=(1)
R0309 (XDUT__XREF__XDRV4__RGPP1_1__dmy0 XDUT__XREF__XDRV4__RGPP1_2__dmy0) rupolym l=17.13u w=1u m=16 multi=(1)
R0310 (XDUT__XREF__XDRV4__RGPP1_2__dmy0 XDUT__XREF__XDRV4__RGPP1_3__dmy0) rupolym l=17.13u w=1u m=16 multi=(1)
R0311 (XDUT__XREF__XDRV4__RGPP1_3__dmy0 XDUT__XREF__XDRV4__RGPP1_4__dmy0) rupolym l=17.13u w=1u m=16 multi=(1)
R0312 (XDUT__XREF__XDRV4__RGPP1_4__dmy0 XDUT__GPP4) rupolym l=17.13u w=1u m=16 multi=(1)
R0313 (XDUT__XREF__XDRV4__GPPDRV XDUT__XREF__XDRV4__RGPP0_1__dmy0) rupolym l=17.13u w=1u m=16 multi=(1)
R0314 (XDUT__XREF__XDRV4__RGPP0_1__dmy0 XDUT__XREF__XDRV4__RGPP0_2__dmy0) rupolym l=17.13u w=1u m=16 multi=(1)
R0315 (XDUT__XREF__XDRV4__RGPP0_2__dmy0 XDUT__XREF__XDRV4__RGPP0_3__dmy0) rupolym l=17.13u w=1u m=16 multi=(1)
R0316 (XDUT__XREF__XDRV4__RGPP0_3__dmy0 XDUT__XREF__XDRV4__RGPP0_4__dmy0) rupolym l=17.13u w=1u m=16 multi=(1)
R0317 (XDUT__XREF__XDRV4__RGPP0_4__dmy0 XDUT__XREF__XDRV4__GPPRG) rupolym l=17.13u w=1u m=16 multi=(1)
M0318 (XDUT__XREF__XDRV5__GNNDRV REF5_GNNB 0 0) nch_mac l=30n w=500n multi=4 nf=1 sd=100n ad=3.75e-14 as=3.75e-14 pd=1.15u ps=1.15u nrd=0.662935 nrs=0.662935 sa=75.0n sb=75.0n sa1=75.0n sa2=75.0n sa3=75.0n sa4=75.0n sb1=75.0n sb2=75.0n sb3=75.0n spa=100n spa1=100n spa2=100n spa3=100n sap=91.9776n sapb=114.444n spba=115.715n spba1=117.043n dfm_flag=0 spmt=1.11111e+15 spomt=0 spomt1=1.11111e+60 spmb=1.11111e+15 spomb=0 spomb1=1.11111e+60
M0319 (XDUT__XREF__XDRV5__GNPDRV REF5_GNPB 0 0) nch_mac l=30n w=500n multi=4 nf=1 sd=100n ad=3.75e-14 as=3.75e-14 pd=1.15u ps=1.15u nrd=0.662935 nrs=0.662935 sa=75.0n sb=75.0n sa1=75.0n sa2=75.0n sa3=75.0n sa4=75.0n sb1=75.0n sb2=75.0n sb3=75.0n spa=100n spa1=100n spa2=100n spa3=100n sap=91.9776n sapb=114.444n spba=115.715n spba1=117.043n dfm_flag=0 spmt=1.11111e+15 spomt=0 spomt1=1.11111e+60 spmb=1.11111e+15 spomb=0 spomb1=1.11111e+60
M0320 (XDUT__XREF__XDRV5__GPNDRV REF5_GPNB 0 0) nch_mac l=30n w=500n multi=4 nf=1 sd=100n ad=3.75e-14 as=3.75e-14 pd=1.15u ps=1.15u nrd=0.662935 nrs=0.662935 sa=75.0n sb=75.0n sa1=75.0n sa2=75.0n sa3=75.0n sa4=75.0n sb1=75.0n sb2=75.0n sb3=75.0n spa=100n spa1=100n spa2=100n spa3=100n sap=91.9776n sapb=114.444n spba=115.715n spba1=117.043n dfm_flag=0 spmt=1.11111e+15 spomt=0 spomt1=1.11111e+60 spmb=1.11111e+15 spomb=0 spomb1=1.11111e+60
M0321 (XDUT__XREF__XDRV5__GPPDRV REF5_GPPB 0 0) nch_mac l=30n w=500n multi=4 nf=1 sd=100n ad=3.75e-14 as=3.75e-14 pd=1.15u ps=1.15u nrd=0.662935 nrs=0.662935 sa=75.0n sb=75.0n sa1=75.0n sa2=75.0n sa3=75.0n sa4=75.0n sb1=75.0n sb2=75.0n sb3=75.0n spa=100n spa1=100n spa2=100n spa3=100n sap=91.9776n sapb=114.444n spba=115.715n spba1=117.043n dfm_flag=0 spmt=1.11111e+15 spomt=0 spomt1=1.11111e+60 spmb=1.11111e+15 spomb=0 spomb1=1.11111e+60
M0322 (XDUT__XREF__XDRV5__GNNDRV REF5_GNNB VDD! VDD!) pch_mac l=30n w=1u multi=4 nf=1 sd=100n ad=7.5e-14 as=7.5e-14 pd=2.15u ps=2.15u nrd=0.165806 nrs=0.165806 sa=75.0n sb=75.0n sa1=75.0n sa2=75.0n sa3=75.0n sa4=75.0n sb1=75.0n sb2=75.0n sb3=75.0n spa=100n spa1=100n spa2=100n spa3=100n sap=91.9776n sapb=114.444n spba=115.715n spba1=117.043n dfm_flag=0 spmt=1.11111e+15 spomt=0 spomt1=1.11111e+60 spmb=1.11111e+15 spomb=0 spomb1=1.11111e+60
M0323 (XDUT__XREF__XDRV5__GNPDRV REF5_GNPB VDD! VDD!) pch_mac l=30n w=1u multi=4 nf=1 sd=100n ad=7.5e-14 as=7.5e-14 pd=2.15u ps=2.15u nrd=0.165806 nrs=0.165806 sa=75.0n sb=75.0n sa1=75.0n sa2=75.0n sa3=75.0n sa4=75.0n sb1=75.0n sb2=75.0n sb3=75.0n spa=100n spa1=100n spa2=100n spa3=100n sap=91.9776n sapb=114.444n spba=115.715n spba1=117.043n dfm_flag=0 spmt=1.11111e+15 spomt=0 spomt1=1.11111e+60 spmb=1.11111e+15 spomb=0 spomb1=1.11111e+60
M0324 (XDUT__XREF__XDRV5__GPNDRV REF5_GPNB VDD! VDD!) pch_mac l=30n w=1u multi=4 nf=1 sd=100n ad=7.5e-14 as=7.5e-14 pd=2.15u ps=2.15u nrd=0.165806 nrs=0.165806 sa=75.0n sb=75.0n sa1=75.0n sa2=75.0n sa3=75.0n sa4=75.0n sb1=75.0n sb2=75.0n sb3=75.0n spa=100n spa1=100n spa2=100n spa3=100n sap=91.9776n sapb=114.444n spba=115.715n spba1=117.043n dfm_flag=0 spmt=1.11111e+15 spomt=0 spomt1=1.11111e+60 spmb=1.11111e+15 spomb=0 spomb1=1.11111e+60
M0325 (XDUT__XREF__XDRV5__GPPDRV REF5_GPPB VDD! VDD!) pch_mac l=30n w=1u multi=4 nf=1 sd=100n ad=7.5e-14 as=7.5e-14 pd=2.15u ps=2.15u nrd=0.165806 nrs=0.165806 sa=75.0n sb=75.0n sa1=75.0n sa2=75.0n sa3=75.0n sa4=75.0n sb1=75.0n sb2=75.0n sb3=75.0n spa=100n spa1=100n spa2=100n spa3=100n sap=91.9776n sapb=114.444n spba=115.715n spba1=117.043n dfm_flag=0 spmt=1.11111e+15 spomt=0 spomt1=1.11111e+60 spmb=1.11111e+15 spomb=0 spomb1=1.11111e+60
R0326 (XDUT__XREF__XDRV5__GNNRG XDUT__XREF__XDRV5__RGNN1_1__dmy0) rupolym l=17.13u w=1u m=32 multi=(1)
R0327 (XDUT__XREF__XDRV5__RGNN1_1__dmy0 XDUT__XREF__XDRV5__RGNN1_2__dmy0) rupolym l=17.13u w=1u m=32 multi=(1)
R0328 (XDUT__XREF__XDRV5__RGNN1_2__dmy0 XDUT__XREF__XDRV5__RGNN1_3__dmy0) rupolym l=17.13u w=1u m=32 multi=(1)
R0329 (XDUT__XREF__XDRV5__RGNN1_3__dmy0 XDUT__XREF__XDRV5__RGNN1_4__dmy0) rupolym l=17.13u w=1u m=32 multi=(1)
R0330 (XDUT__XREF__XDRV5__RGNN1_4__dmy0 XDUT__GNN5) rupolym l=17.13u w=1u m=32 multi=(1)
R0331 (XDUT__XREF__XDRV5__GNNDRV XDUT__XREF__XDRV5__RGNN0_1__dmy0) rupolym l=17.13u w=1u m=32 multi=(1)
R0332 (XDUT__XREF__XDRV5__RGNN0_1__dmy0 XDUT__XREF__XDRV5__RGNN0_2__dmy0) rupolym l=17.13u w=1u m=32 multi=(1)
R0333 (XDUT__XREF__XDRV5__RGNN0_2__dmy0 XDUT__XREF__XDRV5__RGNN0_3__dmy0) rupolym l=17.13u w=1u m=32 multi=(1)
R0334 (XDUT__XREF__XDRV5__RGNN0_3__dmy0 XDUT__XREF__XDRV5__RGNN0_4__dmy0) rupolym l=17.13u w=1u m=32 multi=(1)
R0335 (XDUT__XREF__XDRV5__RGNN0_4__dmy0 XDUT__XREF__XDRV5__GNNRG) rupolym l=17.13u w=1u m=32 multi=(1)
R0336 (XDUT__XREF__XDRV5__GNPRG XDUT__XREF__XDRV5__RGNP1_1__dmy0) rupolym l=17.13u w=1u m=32 multi=(1)
R0337 (XDUT__XREF__XDRV5__RGNP1_1__dmy0 XDUT__XREF__XDRV5__RGNP1_2__dmy0) rupolym l=17.13u w=1u m=32 multi=(1)
R0338 (XDUT__XREF__XDRV5__RGNP1_2__dmy0 XDUT__XREF__XDRV5__RGNP1_3__dmy0) rupolym l=17.13u w=1u m=32 multi=(1)
R0339 (XDUT__XREF__XDRV5__RGNP1_3__dmy0 XDUT__XREF__XDRV5__RGNP1_4__dmy0) rupolym l=17.13u w=1u m=32 multi=(1)
R0340 (XDUT__XREF__XDRV5__RGNP1_4__dmy0 XDUT__GNP5) rupolym l=17.13u w=1u m=32 multi=(1)
R0341 (XDUT__XREF__XDRV5__GNPDRV XDUT__XREF__XDRV5__RGNP0_1__dmy0) rupolym l=17.13u w=1u m=32 multi=(1)
R0342 (XDUT__XREF__XDRV5__RGNP0_1__dmy0 XDUT__XREF__XDRV5__RGNP0_2__dmy0) rupolym l=17.13u w=1u m=32 multi=(1)
R0343 (XDUT__XREF__XDRV5__RGNP0_2__dmy0 XDUT__XREF__XDRV5__RGNP0_3__dmy0) rupolym l=17.13u w=1u m=32 multi=(1)
R0344 (XDUT__XREF__XDRV5__RGNP0_3__dmy0 XDUT__XREF__XDRV5__RGNP0_4__dmy0) rupolym l=17.13u w=1u m=32 multi=(1)
R0345 (XDUT__XREF__XDRV5__RGNP0_4__dmy0 XDUT__XREF__XDRV5__GNPRG) rupolym l=17.13u w=1u m=32 multi=(1)
R0346 (XDUT__XREF__XDRV5__GPNRG XDUT__XREF__XDRV5__RGPN1_1__dmy0) rupolym l=17.13u w=1u m=32 multi=(1)
R0347 (XDUT__XREF__XDRV5__RGPN1_1__dmy0 XDUT__XREF__XDRV5__RGPN1_2__dmy0) rupolym l=17.13u w=1u m=32 multi=(1)
R0348 (XDUT__XREF__XDRV5__RGPN1_2__dmy0 XDUT__XREF__XDRV5__RGPN1_3__dmy0) rupolym l=17.13u w=1u m=32 multi=(1)
R0349 (XDUT__XREF__XDRV5__RGPN1_3__dmy0 XDUT__XREF__XDRV5__RGPN1_4__dmy0) rupolym l=17.13u w=1u m=32 multi=(1)
R0350 (XDUT__XREF__XDRV5__RGPN1_4__dmy0 XDUT__GPN5) rupolym l=17.13u w=1u m=32 multi=(1)
R0351 (XDUT__XREF__XDRV5__GPNDRV XDUT__XREF__XDRV5__RGPN0_1__dmy0) rupolym l=17.13u w=1u m=32 multi=(1)
R0352 (XDUT__XREF__XDRV5__RGPN0_1__dmy0 XDUT__XREF__XDRV5__RGPN0_2__dmy0) rupolym l=17.13u w=1u m=32 multi=(1)
R0353 (XDUT__XREF__XDRV5__RGPN0_2__dmy0 XDUT__XREF__XDRV5__RGPN0_3__dmy0) rupolym l=17.13u w=1u m=32 multi=(1)
R0354 (XDUT__XREF__XDRV5__RGPN0_3__dmy0 XDUT__XREF__XDRV5__RGPN0_4__dmy0) rupolym l=17.13u w=1u m=32 multi=(1)
R0355 (XDUT__XREF__XDRV5__RGPN0_4__dmy0 XDUT__XREF__XDRV5__GPNRG) rupolym l=17.13u w=1u m=32 multi=(1)
R0356 (XDUT__XREF__XDRV5__GPPRG XDUT__XREF__XDRV5__RGPP1_1__dmy0) rupolym l=17.13u w=1u m=32 multi=(1)
R0357 (XDUT__XREF__XDRV5__RGPP1_1__dmy0 XDUT__XREF__XDRV5__RGPP1_2__dmy0) rupolym l=17.13u w=1u m=32 multi=(1)
R0358 (XDUT__XREF__XDRV5__RGPP1_2__dmy0 XDUT__XREF__XDRV5__RGPP1_3__dmy0) rupolym l=17.13u w=1u m=32 multi=(1)
R0359 (XDUT__XREF__XDRV5__RGPP1_3__dmy0 XDUT__XREF__XDRV5__RGPP1_4__dmy0) rupolym l=17.13u w=1u m=32 multi=(1)
R0360 (XDUT__XREF__XDRV5__RGPP1_4__dmy0 XDUT__GPP5) rupolym l=17.13u w=1u m=32 multi=(1)
R0361 (XDUT__XREF__XDRV5__GPPDRV XDUT__XREF__XDRV5__RGPP0_1__dmy0) rupolym l=17.13u w=1u m=32 multi=(1)
R0362 (XDUT__XREF__XDRV5__RGPP0_1__dmy0 XDUT__XREF__XDRV5__RGPP0_2__dmy0) rupolym l=17.13u w=1u m=32 multi=(1)
R0363 (XDUT__XREF__XDRV5__RGPP0_2__dmy0 XDUT__XREF__XDRV5__RGPP0_3__dmy0) rupolym l=17.13u w=1u m=32 multi=(1)
R0364 (XDUT__XREF__XDRV5__RGPP0_3__dmy0 XDUT__XREF__XDRV5__RGPP0_4__dmy0) rupolym l=17.13u w=1u m=32 multi=(1)
R0365 (XDUT__XREF__XDRV5__RGPP0_4__dmy0 XDUT__XREF__XDRV5__GPPRG) rupolym l=17.13u w=1u m=32 multi=(1)
M0366 (XDUT__XREF__XDRV6__GNNDRV REF6_GNNB 0 0) nch_mac l=30n w=500n multi=8 nf=1 sd=100n ad=3.75e-14 as=3.75e-14 pd=1.15u ps=1.15u nrd=0.662935 nrs=0.662935 sa=75.0n sb=75.0n sa1=75.0n sa2=75.0n sa3=75.0n sa4=75.0n sb1=75.0n sb2=75.0n sb3=75.0n spa=100n spa1=100n spa2=100n spa3=100n sap=91.9776n sapb=114.444n spba=115.715n spba1=117.043n dfm_flag=0 spmt=1.11111e+15 spomt=0 spomt1=1.11111e+60 spmb=1.11111e+15 spomb=0 spomb1=1.11111e+60
M0367 (XDUT__XREF__XDRV6__GNPDRV REF6_GNPB 0 0) nch_mac l=30n w=500n multi=8 nf=1 sd=100n ad=3.75e-14 as=3.75e-14 pd=1.15u ps=1.15u nrd=0.662935 nrs=0.662935 sa=75.0n sb=75.0n sa1=75.0n sa2=75.0n sa3=75.0n sa4=75.0n sb1=75.0n sb2=75.0n sb3=75.0n spa=100n spa1=100n spa2=100n spa3=100n sap=91.9776n sapb=114.444n spba=115.715n spba1=117.043n dfm_flag=0 spmt=1.11111e+15 spomt=0 spomt1=1.11111e+60 spmb=1.11111e+15 spomb=0 spomb1=1.11111e+60
M0368 (XDUT__XREF__XDRV6__GPNDRV REF6_GPNB 0 0) nch_mac l=30n w=500n multi=8 nf=1 sd=100n ad=3.75e-14 as=3.75e-14 pd=1.15u ps=1.15u nrd=0.662935 nrs=0.662935 sa=75.0n sb=75.0n sa1=75.0n sa2=75.0n sa3=75.0n sa4=75.0n sb1=75.0n sb2=75.0n sb3=75.0n spa=100n spa1=100n spa2=100n spa3=100n sap=91.9776n sapb=114.444n spba=115.715n spba1=117.043n dfm_flag=0 spmt=1.11111e+15 spomt=0 spomt1=1.11111e+60 spmb=1.11111e+15 spomb=0 spomb1=1.11111e+60
M0369 (XDUT__XREF__XDRV6__GPPDRV REF6_GPPB 0 0) nch_mac l=30n w=500n multi=8 nf=1 sd=100n ad=3.75e-14 as=3.75e-14 pd=1.15u ps=1.15u nrd=0.662935 nrs=0.662935 sa=75.0n sb=75.0n sa1=75.0n sa2=75.0n sa3=75.0n sa4=75.0n sb1=75.0n sb2=75.0n sb3=75.0n spa=100n spa1=100n spa2=100n spa3=100n sap=91.9776n sapb=114.444n spba=115.715n spba1=117.043n dfm_flag=0 spmt=1.11111e+15 spomt=0 spomt1=1.11111e+60 spmb=1.11111e+15 spomb=0 spomb1=1.11111e+60
M0370 (XDUT__XREF__XDRV6__GNNDRV REF6_GNNB VDD! VDD!) pch_mac l=30n w=1u multi=8 nf=1 sd=100n ad=7.5e-14 as=7.5e-14 pd=2.15u ps=2.15u nrd=0.165806 nrs=0.165806 sa=75.0n sb=75.0n sa1=75.0n sa2=75.0n sa3=75.0n sa4=75.0n sb1=75.0n sb2=75.0n sb3=75.0n spa=100n spa1=100n spa2=100n spa3=100n sap=91.9776n sapb=114.444n spba=115.715n spba1=117.043n dfm_flag=0 spmt=1.11111e+15 spomt=0 spomt1=1.11111e+60 spmb=1.11111e+15 spomb=0 spomb1=1.11111e+60
M0371 (XDUT__XREF__XDRV6__GNPDRV REF6_GNPB VDD! VDD!) pch_mac l=30n w=1u multi=8 nf=1 sd=100n ad=7.5e-14 as=7.5e-14 pd=2.15u ps=2.15u nrd=0.165806 nrs=0.165806 sa=75.0n sb=75.0n sa1=75.0n sa2=75.0n sa3=75.0n sa4=75.0n sb1=75.0n sb2=75.0n sb3=75.0n spa=100n spa1=100n spa2=100n spa3=100n sap=91.9776n sapb=114.444n spba=115.715n spba1=117.043n dfm_flag=0 spmt=1.11111e+15 spomt=0 spomt1=1.11111e+60 spmb=1.11111e+15 spomb=0 spomb1=1.11111e+60
M0372 (XDUT__XREF__XDRV6__GPNDRV REF6_GPNB VDD! VDD!) pch_mac l=30n w=1u multi=8 nf=1 sd=100n ad=7.5e-14 as=7.5e-14 pd=2.15u ps=2.15u nrd=0.165806 nrs=0.165806 sa=75.0n sb=75.0n sa1=75.0n sa2=75.0n sa3=75.0n sa4=75.0n sb1=75.0n sb2=75.0n sb3=75.0n spa=100n spa1=100n spa2=100n spa3=100n sap=91.9776n sapb=114.444n spba=115.715n spba1=117.043n dfm_flag=0 spmt=1.11111e+15 spomt=0 spomt1=1.11111e+60 spmb=1.11111e+15 spomb=0 spomb1=1.11111e+60
M0373 (XDUT__XREF__XDRV6__GPPDRV REF6_GPPB VDD! VDD!) pch_mac l=30n w=1u multi=8 nf=1 sd=100n ad=7.5e-14 as=7.5e-14 pd=2.15u ps=2.15u nrd=0.165806 nrs=0.165806 sa=75.0n sb=75.0n sa1=75.0n sa2=75.0n sa3=75.0n sa4=75.0n sb1=75.0n sb2=75.0n sb3=75.0n spa=100n spa1=100n spa2=100n spa3=100n sap=91.9776n sapb=114.444n spba=115.715n spba1=117.043n dfm_flag=0 spmt=1.11111e+15 spomt=0 spomt1=1.11111e+60 spmb=1.11111e+15 spomb=0 spomb1=1.11111e+60
R0374 (XDUT__XREF__XDRV6__GNNRG XDUT__XREF__XDRV6__RGNN1_1__dmy0) rupolym l=17.13u w=1u m=64 multi=(1)
R0375 (XDUT__XREF__XDRV6__RGNN1_1__dmy0 XDUT__XREF__XDRV6__RGNN1_2__dmy0) rupolym l=17.13u w=1u m=64 multi=(1)
R0376 (XDUT__XREF__XDRV6__RGNN1_2__dmy0 XDUT__XREF__XDRV6__RGNN1_3__dmy0) rupolym l=17.13u w=1u m=64 multi=(1)
R0377 (XDUT__XREF__XDRV6__RGNN1_3__dmy0 XDUT__XREF__XDRV6__RGNN1_4__dmy0) rupolym l=17.13u w=1u m=64 multi=(1)
R0378 (XDUT__XREF__XDRV6__RGNN1_4__dmy0 XDUT__GNN6) rupolym l=17.13u w=1u m=64 multi=(1)
R0379 (XDUT__XREF__XDRV6__GNNDRV XDUT__XREF__XDRV6__RGNN0_1__dmy0) rupolym l=17.13u w=1u m=64 multi=(1)
R0380 (XDUT__XREF__XDRV6__RGNN0_1__dmy0 XDUT__XREF__XDRV6__RGNN0_2__dmy0) rupolym l=17.13u w=1u m=64 multi=(1)
R0381 (XDUT__XREF__XDRV6__RGNN0_2__dmy0 XDUT__XREF__XDRV6__RGNN0_3__dmy0) rupolym l=17.13u w=1u m=64 multi=(1)
R0382 (XDUT__XREF__XDRV6__RGNN0_3__dmy0 XDUT__XREF__XDRV6__RGNN0_4__dmy0) rupolym l=17.13u w=1u m=64 multi=(1)
R0383 (XDUT__XREF__XDRV6__RGNN0_4__dmy0 XDUT__XREF__XDRV6__GNNRG) rupolym l=17.13u w=1u m=64 multi=(1)
R0384 (XDUT__XREF__XDRV6__GNPRG XDUT__XREF__XDRV6__RGNP1_1__dmy0) rupolym l=17.13u w=1u m=64 multi=(1)
R0385 (XDUT__XREF__XDRV6__RGNP1_1__dmy0 XDUT__XREF__XDRV6__RGNP1_2__dmy0) rupolym l=17.13u w=1u m=64 multi=(1)
R0386 (XDUT__XREF__XDRV6__RGNP1_2__dmy0 XDUT__XREF__XDRV6__RGNP1_3__dmy0) rupolym l=17.13u w=1u m=64 multi=(1)
R0387 (XDUT__XREF__XDRV6__RGNP1_3__dmy0 XDUT__XREF__XDRV6__RGNP1_4__dmy0) rupolym l=17.13u w=1u m=64 multi=(1)
R0388 (XDUT__XREF__XDRV6__RGNP1_4__dmy0 XDUT__GNP6) rupolym l=17.13u w=1u m=64 multi=(1)
R0389 (XDUT__XREF__XDRV6__GNPDRV XDUT__XREF__XDRV6__RGNP0_1__dmy0) rupolym l=17.13u w=1u m=64 multi=(1)
R0390 (XDUT__XREF__XDRV6__RGNP0_1__dmy0 XDUT__XREF__XDRV6__RGNP0_2__dmy0) rupolym l=17.13u w=1u m=64 multi=(1)
R0391 (XDUT__XREF__XDRV6__RGNP0_2__dmy0 XDUT__XREF__XDRV6__RGNP0_3__dmy0) rupolym l=17.13u w=1u m=64 multi=(1)
R0392 (XDUT__XREF__XDRV6__RGNP0_3__dmy0 XDUT__XREF__XDRV6__RGNP0_4__dmy0) rupolym l=17.13u w=1u m=64 multi=(1)
R0393 (XDUT__XREF__XDRV6__RGNP0_4__dmy0 XDUT__XREF__XDRV6__GNPRG) rupolym l=17.13u w=1u m=64 multi=(1)
R0394 (XDUT__XREF__XDRV6__GPNRG XDUT__XREF__XDRV6__RGPN1_1__dmy0) rupolym l=17.13u w=1u m=64 multi=(1)
R0395 (XDUT__XREF__XDRV6__RGPN1_1__dmy0 XDUT__XREF__XDRV6__RGPN1_2__dmy0) rupolym l=17.13u w=1u m=64 multi=(1)
R0396 (XDUT__XREF__XDRV6__RGPN1_2__dmy0 XDUT__XREF__XDRV6__RGPN1_3__dmy0) rupolym l=17.13u w=1u m=64 multi=(1)
R0397 (XDUT__XREF__XDRV6__RGPN1_3__dmy0 XDUT__XREF__XDRV6__RGPN1_4__dmy0) rupolym l=17.13u w=1u m=64 multi=(1)
R0398 (XDUT__XREF__XDRV6__RGPN1_4__dmy0 XDUT__GPN6) rupolym l=17.13u w=1u m=64 multi=(1)
R0399 (XDUT__XREF__XDRV6__GPNDRV XDUT__XREF__XDRV6__RGPN0_1__dmy0) rupolym l=17.13u w=1u m=64 multi=(1)
R0400 (XDUT__XREF__XDRV6__RGPN0_1__dmy0 XDUT__XREF__XDRV6__RGPN0_2__dmy0) rupolym l=17.13u w=1u m=64 multi=(1)
R0401 (XDUT__XREF__XDRV6__RGPN0_2__dmy0 XDUT__XREF__XDRV6__RGPN0_3__dmy0) rupolym l=17.13u w=1u m=64 multi=(1)
R0402 (XDUT__XREF__XDRV6__RGPN0_3__dmy0 XDUT__XREF__XDRV6__RGPN0_4__dmy0) rupolym l=17.13u w=1u m=64 multi=(1)
R0403 (XDUT__XREF__XDRV6__RGPN0_4__dmy0 XDUT__XREF__XDRV6__GPNRG) rupolym l=17.13u w=1u m=64 multi=(1)
R0404 (XDUT__XREF__XDRV6__GPPRG XDUT__XREF__XDRV6__RGPP1_1__dmy0) rupolym l=17.13u w=1u m=64 multi=(1)
R0405 (XDUT__XREF__XDRV6__RGPP1_1__dmy0 XDUT__XREF__XDRV6__RGPP1_2__dmy0) rupolym l=17.13u w=1u m=64 multi=(1)
R0406 (XDUT__XREF__XDRV6__RGPP1_2__dmy0 XDUT__XREF__XDRV6__RGPP1_3__dmy0) rupolym l=17.13u w=1u m=64 multi=(1)
R0407 (XDUT__XREF__XDRV6__RGPP1_3__dmy0 XDUT__XREF__XDRV6__RGPP1_4__dmy0) rupolym l=17.13u w=1u m=64 multi=(1)
R0408 (XDUT__XREF__XDRV6__RGPP1_4__dmy0 XDUT__GPP6) rupolym l=17.13u w=1u m=64 multi=(1)
R0409 (XDUT__XREF__XDRV6__GPPDRV XDUT__XREF__XDRV6__RGPP0_1__dmy0) rupolym l=17.13u w=1u m=64 multi=(1)
R0410 (XDUT__XREF__XDRV6__RGPP0_1__dmy0 XDUT__XREF__XDRV6__RGPP0_2__dmy0) rupolym l=17.13u w=1u m=64 multi=(1)
R0411 (XDUT__XREF__XDRV6__RGPP0_2__dmy0 XDUT__XREF__XDRV6__RGPP0_3__dmy0) rupolym l=17.13u w=1u m=64 multi=(1)
R0412 (XDUT__XREF__XDRV6__RGPP0_3__dmy0 XDUT__XREF__XDRV6__RGPP0_4__dmy0) rupolym l=17.13u w=1u m=64 multi=(1)
R0413 (XDUT__XREF__XDRV6__RGPP0_4__dmy0 XDUT__XREF__XDRV6__GPPRG) rupolym l=17.13u w=1u m=64 multi=(1)
M0414 (XDUT__XREF__XDRV7__GNNDRV REF7_GNNB 0 0) nch_mac l=30n w=500n multi=16 nf=1 sd=100n ad=3.75e-14 as=3.75e-14 pd=1.15u ps=1.15u nrd=0.662935 nrs=0.662935 sa=75.0n sb=75.0n sa1=75.0n sa2=75.0n sa3=75.0n sa4=75.0n sb1=75.0n sb2=75.0n sb3=75.0n spa=100n spa1=100n spa2=100n spa3=100n sap=91.9776n sapb=114.444n spba=115.715n spba1=117.043n dfm_flag=0 spmt=1.11111e+15 spomt=0 spomt1=1.11111e+60 spmb=1.11111e+15 spomb=0 spomb1=1.11111e+60
M0415 (XDUT__XREF__XDRV7__GNPDRV REF7_GNPB 0 0) nch_mac l=30n w=500n multi=16 nf=1 sd=100n ad=3.75e-14 as=3.75e-14 pd=1.15u ps=1.15u nrd=0.662935 nrs=0.662935 sa=75.0n sb=75.0n sa1=75.0n sa2=75.0n sa3=75.0n sa4=75.0n sb1=75.0n sb2=75.0n sb3=75.0n spa=100n spa1=100n spa2=100n spa3=100n sap=91.9776n sapb=114.444n spba=115.715n spba1=117.043n dfm_flag=0 spmt=1.11111e+15 spomt=0 spomt1=1.11111e+60 spmb=1.11111e+15 spomb=0 spomb1=1.11111e+60
M0416 (XDUT__XREF__XDRV7__GPNDRV REF7_GPNB 0 0) nch_mac l=30n w=500n multi=16 nf=1 sd=100n ad=3.75e-14 as=3.75e-14 pd=1.15u ps=1.15u nrd=0.662935 nrs=0.662935 sa=75.0n sb=75.0n sa1=75.0n sa2=75.0n sa3=75.0n sa4=75.0n sb1=75.0n sb2=75.0n sb3=75.0n spa=100n spa1=100n spa2=100n spa3=100n sap=91.9776n sapb=114.444n spba=115.715n spba1=117.043n dfm_flag=0 spmt=1.11111e+15 spomt=0 spomt1=1.11111e+60 spmb=1.11111e+15 spomb=0 spomb1=1.11111e+60
M0417 (XDUT__XREF__XDRV7__GPPDRV REF7_GPPB 0 0) nch_mac l=30n w=500n multi=16 nf=1 sd=100n ad=3.75e-14 as=3.75e-14 pd=1.15u ps=1.15u nrd=0.662935 nrs=0.662935 sa=75.0n sb=75.0n sa1=75.0n sa2=75.0n sa3=75.0n sa4=75.0n sb1=75.0n sb2=75.0n sb3=75.0n spa=100n spa1=100n spa2=100n spa3=100n sap=91.9776n sapb=114.444n spba=115.715n spba1=117.043n dfm_flag=0 spmt=1.11111e+15 spomt=0 spomt1=1.11111e+60 spmb=1.11111e+15 spomb=0 spomb1=1.11111e+60
M0418 (XDUT__XREF__XDRV7__GNNDRV REF7_GNNB VDD! VDD!) pch_mac l=30n w=1u multi=16 nf=1 sd=100n ad=7.5e-14 as=7.5e-14 pd=2.15u ps=2.15u nrd=0.165806 nrs=0.165806 sa=75.0n sb=75.0n sa1=75.0n sa2=75.0n sa3=75.0n sa4=75.0n sb1=75.0n sb2=75.0n sb3=75.0n spa=100n spa1=100n spa2=100n spa3=100n sap=91.9776n sapb=114.444n spba=115.715n spba1=117.043n dfm_flag=0 spmt=1.11111e+15 spomt=0 spomt1=1.11111e+60 spmb=1.11111e+15 spomb=0 spomb1=1.11111e+60
M0419 (XDUT__XREF__XDRV7__GNPDRV REF7_GNPB VDD! VDD!) pch_mac l=30n w=1u multi=16 nf=1 sd=100n ad=7.5e-14 as=7.5e-14 pd=2.15u ps=2.15u nrd=0.165806 nrs=0.165806 sa=75.0n sb=75.0n sa1=75.0n sa2=75.0n sa3=75.0n sa4=75.0n sb1=75.0n sb2=75.0n sb3=75.0n spa=100n spa1=100n spa2=100n spa3=100n sap=91.9776n sapb=114.444n spba=115.715n spba1=117.043n dfm_flag=0 spmt=1.11111e+15 spomt=0 spomt1=1.11111e+60 spmb=1.11111e+15 spomb=0 spomb1=1.11111e+60
M0420 (XDUT__XREF__XDRV7__GPNDRV REF7_GPNB VDD! VDD!) pch_mac l=30n w=1u multi=16 nf=1 sd=100n ad=7.5e-14 as=7.5e-14 pd=2.15u ps=2.15u nrd=0.165806 nrs=0.165806 sa=75.0n sb=75.0n sa1=75.0n sa2=75.0n sa3=75.0n sa4=75.0n sb1=75.0n sb2=75.0n sb3=75.0n spa=100n spa1=100n spa2=100n spa3=100n sap=91.9776n sapb=114.444n spba=115.715n spba1=117.043n dfm_flag=0 spmt=1.11111e+15 spomt=0 spomt1=1.11111e+60 spmb=1.11111e+15 spomb=0 spomb1=1.11111e+60
M0421 (XDUT__XREF__XDRV7__GPPDRV REF7_GPPB VDD! VDD!) pch_mac l=30n w=1u multi=16 nf=1 sd=100n ad=7.5e-14 as=7.5e-14 pd=2.15u ps=2.15u nrd=0.165806 nrs=0.165806 sa=75.0n sb=75.0n sa1=75.0n sa2=75.0n sa3=75.0n sa4=75.0n sb1=75.0n sb2=75.0n sb3=75.0n spa=100n spa1=100n spa2=100n spa3=100n sap=91.9776n sapb=114.444n spba=115.715n spba1=117.043n dfm_flag=0 spmt=1.11111e+15 spomt=0 spomt1=1.11111e+60 spmb=1.11111e+15 spomb=0 spomb1=1.11111e+60
R0422 (XDUT__XREF__XDRV7__GNNRG XDUT__XREF__XDRV7__RGNN1_1__dmy0) rupolym l=17.13u w=1u m=128 multi=(1)
R0423 (XDUT__XREF__XDRV7__RGNN1_1__dmy0 XDUT__XREF__XDRV7__RGNN1_2__dmy0) rupolym l=17.13u w=1u m=128 multi=(1)
R0424 (XDUT__XREF__XDRV7__RGNN1_2__dmy0 XDUT__XREF__XDRV7__RGNN1_3__dmy0) rupolym l=17.13u w=1u m=128 multi=(1)
R0425 (XDUT__XREF__XDRV7__RGNN1_3__dmy0 XDUT__XREF__XDRV7__RGNN1_4__dmy0) rupolym l=17.13u w=1u m=128 multi=(1)
R0426 (XDUT__XREF__XDRV7__RGNN1_4__dmy0 XDUT__GNN7) rupolym l=17.13u w=1u m=128 multi=(1)
R0427 (XDUT__XREF__XDRV7__GNNDRV XDUT__XREF__XDRV7__RGNN0_1__dmy0) rupolym l=17.13u w=1u m=128 multi=(1)
R0428 (XDUT__XREF__XDRV7__RGNN0_1__dmy0 XDUT__XREF__XDRV7__RGNN0_2__dmy0) rupolym l=17.13u w=1u m=128 multi=(1)
R0429 (XDUT__XREF__XDRV7__RGNN0_2__dmy0 XDUT__XREF__XDRV7__RGNN0_3__dmy0) rupolym l=17.13u w=1u m=128 multi=(1)
R0430 (XDUT__XREF__XDRV7__RGNN0_3__dmy0 XDUT__XREF__XDRV7__RGNN0_4__dmy0) rupolym l=17.13u w=1u m=128 multi=(1)
R0431 (XDUT__XREF__XDRV7__RGNN0_4__dmy0 XDUT__XREF__XDRV7__GNNRG) rupolym l=17.13u w=1u m=128 multi=(1)
R0432 (XDUT__XREF__XDRV7__GNPRG XDUT__XREF__XDRV7__RGNP1_1__dmy0) rupolym l=17.13u w=1u m=128 multi=(1)
R0433 (XDUT__XREF__XDRV7__RGNP1_1__dmy0 XDUT__XREF__XDRV7__RGNP1_2__dmy0) rupolym l=17.13u w=1u m=128 multi=(1)
R0434 (XDUT__XREF__XDRV7__RGNP1_2__dmy0 XDUT__XREF__XDRV7__RGNP1_3__dmy0) rupolym l=17.13u w=1u m=128 multi=(1)
R0435 (XDUT__XREF__XDRV7__RGNP1_3__dmy0 XDUT__XREF__XDRV7__RGNP1_4__dmy0) rupolym l=17.13u w=1u m=128 multi=(1)
R0436 (XDUT__XREF__XDRV7__RGNP1_4__dmy0 XDUT__GNP7) rupolym l=17.13u w=1u m=128 multi=(1)
R0437 (XDUT__XREF__XDRV7__GNPDRV XDUT__XREF__XDRV7__RGNP0_1__dmy0) rupolym l=17.13u w=1u m=128 multi=(1)
R0438 (XDUT__XREF__XDRV7__RGNP0_1__dmy0 XDUT__XREF__XDRV7__RGNP0_2__dmy0) rupolym l=17.13u w=1u m=128 multi=(1)
R0439 (XDUT__XREF__XDRV7__RGNP0_2__dmy0 XDUT__XREF__XDRV7__RGNP0_3__dmy0) rupolym l=17.13u w=1u m=128 multi=(1)
R0440 (XDUT__XREF__XDRV7__RGNP0_3__dmy0 XDUT__XREF__XDRV7__RGNP0_4__dmy0) rupolym l=17.13u w=1u m=128 multi=(1)
R0441 (XDUT__XREF__XDRV7__RGNP0_4__dmy0 XDUT__XREF__XDRV7__GNPRG) rupolym l=17.13u w=1u m=128 multi=(1)
R0442 (XDUT__XREF__XDRV7__GPNRG XDUT__XREF__XDRV7__RGPN1_1__dmy0) rupolym l=17.13u w=1u m=128 multi=(1)
R0443 (XDUT__XREF__XDRV7__RGPN1_1__dmy0 XDUT__XREF__XDRV7__RGPN1_2__dmy0) rupolym l=17.13u w=1u m=128 multi=(1)
R0444 (XDUT__XREF__XDRV7__RGPN1_2__dmy0 XDUT__XREF__XDRV7__RGPN1_3__dmy0) rupolym l=17.13u w=1u m=128 multi=(1)
R0445 (XDUT__XREF__XDRV7__RGPN1_3__dmy0 XDUT__XREF__XDRV7__RGPN1_4__dmy0) rupolym l=17.13u w=1u m=128 multi=(1)
R0446 (XDUT__XREF__XDRV7__RGPN1_4__dmy0 XDUT__GPN7) rupolym l=17.13u w=1u m=128 multi=(1)
R0447 (XDUT__XREF__XDRV7__GPNDRV XDUT__XREF__XDRV7__RGPN0_1__dmy0) rupolym l=17.13u w=1u m=128 multi=(1)
R0448 (XDUT__XREF__XDRV7__RGPN0_1__dmy0 XDUT__XREF__XDRV7__RGPN0_2__dmy0) rupolym l=17.13u w=1u m=128 multi=(1)
R0449 (XDUT__XREF__XDRV7__RGPN0_2__dmy0 XDUT__XREF__XDRV7__RGPN0_3__dmy0) rupolym l=17.13u w=1u m=128 multi=(1)
R0450 (XDUT__XREF__XDRV7__RGPN0_3__dmy0 XDUT__XREF__XDRV7__RGPN0_4__dmy0) rupolym l=17.13u w=1u m=128 multi=(1)
R0451 (XDUT__XREF__XDRV7__RGPN0_4__dmy0 XDUT__XREF__XDRV7__GPNRG) rupolym l=17.13u w=1u m=128 multi=(1)
R0452 (XDUT__XREF__XDRV7__GPPRG XDUT__XREF__XDRV7__RGPP1_1__dmy0) rupolym l=17.13u w=1u m=128 multi=(1)
R0453 (XDUT__XREF__XDRV7__RGPP1_1__dmy0 XDUT__XREF__XDRV7__RGPP1_2__dmy0) rupolym l=17.13u w=1u m=128 multi=(1)
R0454 (XDUT__XREF__XDRV7__RGPP1_2__dmy0 XDUT__XREF__XDRV7__RGPP1_3__dmy0) rupolym l=17.13u w=1u m=128 multi=(1)
R0455 (XDUT__XREF__XDRV7__RGPP1_3__dmy0 XDUT__XREF__XDRV7__RGPP1_4__dmy0) rupolym l=17.13u w=1u m=128 multi=(1)
R0456 (XDUT__XREF__XDRV7__RGPP1_4__dmy0 XDUT__GPP7) rupolym l=17.13u w=1u m=128 multi=(1)
R0457 (XDUT__XREF__XDRV7__GPPDRV XDUT__XREF__XDRV7__RGPP0_1__dmy0) rupolym l=17.13u w=1u m=128 multi=(1)
R0458 (XDUT__XREF__XDRV7__RGPP0_1__dmy0 XDUT__XREF__XDRV7__RGPP0_2__dmy0) rupolym l=17.13u w=1u m=128 multi=(1)
R0459 (XDUT__XREF__XDRV7__RGPP0_2__dmy0 XDUT__XREF__XDRV7__RGPP0_3__dmy0) rupolym l=17.13u w=1u m=128 multi=(1)
R0460 (XDUT__XREF__XDRV7__RGPP0_3__dmy0 XDUT__XREF__XDRV7__RGPP0_4__dmy0) rupolym l=17.13u w=1u m=128 multi=(1)
R0461 (XDUT__XREF__XDRV7__RGPP0_4__dmy0 XDUT__XREF__XDRV7__GPPRG) rupolym l=17.13u w=1u m=128 multi=(1)
M0462 (XDUT__COMP_N XDUT__COMP_P XDUT__XCOMP__Y 0) nch_na18_mac ad=7.75e-14 as=7.75e-14 l=800n nf=1 nrd=0 nrs=0 pd=1.31u ps=1.31u sa=155.00n sa1=155.00n sa2=155.00n sa3=155.00n sa4=155.00n sap=172.362n sapb=242.67n sb=155.00n sb1=155.00n sb2=155.00n sb3=155.00n sd=180n spa=180.0n spa1=180.0n spa2=180.0n spa3=180.0n spba=269.815n spba1=305.941n spmb=1.11111e15 spmt=1.11111e15 spomb=0 spomb1=1.11111e+60 spomt=0 spomt1=1.11111e+60 w=500n multi=4
M0463 (XDUT__COMP_P XDUT__COMP_N XDUT__XCOMP__X 0) nch_na18_mac ad=7.75e-14 as=7.75e-14 l=800n nf=1 nrd=0 nrs=0 pd=1.31u ps=1.31u sa=155.00n sa1=155.00n sa2=155.00n sa3=155.00n sa4=155.00n sap=172.362n sapb=242.67n sb=155.00n sb1=155.00n sb2=155.00n sb3=155.00n sd=180n spa=180.0n spa1=180.0n spa2=180.0n spa3=180.0n spba=269.815n spba1=305.941n spmb=1.11111e15 spmt=1.11111e15 spomb=0 spomb1=1.11111e+60 spomt=0 spomt1=1.11111e+60 w=500n multi=4
M0464 (XDUT__XCOMP__X XDUT__TOPN XDUT__XCOMP__TAIL 0) nch_na18_mac ad=7.75e-14 as=7.75e-14 l=800n nf=1 nrd=0 nrs=0 pd=1.31u ps=1.31u sa=155.00n sa1=155.00n sa2=155.00n sa3=155.00n sa4=155.00n sap=172.362n sapb=242.67n sb=155.00n sb1=155.00n sb2=155.00n sb3=155.00n sd=180n spa=180.0n spa1=180.0n spa2=180.0n spa3=180.0n spba=269.815n spba1=305.941n spmb=1.11111e15 spmt=1.11111e15 spomb=0 spomb1=1.11111e+60 spomt=0 spomt1=1.11111e+60 w=500n multi=8
M0465 (XDUT__XCOMP__Y XDUT__TOPP XDUT__XCOMP__TAIL 0) nch_na18_mac ad=7.75e-14 as=7.75e-14 l=800n nf=1 nrd=0 nrs=0 pd=1.31u ps=1.31u sa=155.00n sa1=155.00n sa2=155.00n sa3=155.00n sa4=155.00n sap=172.362n sapb=242.67n sb=155.00n sb1=155.00n sb2=155.00n sb3=155.00n sd=180n spa=180.0n spa1=180.0n spa2=180.0n spa3=180.0n spba=269.815n spba1=305.941n spmb=1.11111e15 spmt=1.11111e15 spomb=0 spomb1=1.11111e+60 spomt=0 spomt1=1.11111e+60 w=500n multi=8
M0466 (XDUT__XCOMP__TAIL CMP_RESET 0 0) nch_18_mac ad=4.96e-14 as=4.96e-14 l=150n nf=1 nrd=0 nrs=0 pd=950.0n ps=950.0n sa=155.00n sa1=155.00n sa2=155.00n sa3=155.00n sa4=155.00n sap=172.362n sapb=242.67n sb=155.00n sb1=155.00n sb2=155.00n sb3=155.00n sd=180n spa=180.0n spa1=180.0n spa2=180.0n spa3=180.0n spba=233.666n spba1=239.844n spmb=1.11111e15 spmt=1.11111e15 spomb=0 spomb1=1.11111e+60 spomt=0 spomt1=1.11111e+60 w=320n multi=4
M0467 (XDUT__COMP_N CMP_RESET VDD! VDD!) pch_18_mac ad=4.96e-14 as=4.96e-14 l=150n nf=1 nrd=0 nrs=0 pd=950.0n ps=950.0n sa=155.00n sa1=155.00n sa2=155.00n sa3=155.00n sa4=155.00n sap=172.362n sapb=242.67n sb=155.00n sb1=155.00n sb2=155.00n sb3=155.00n sd=180n spa=180.0n spa1=180.0n spa2=180.0n spa3=180.0n spba=233.666n spba1=239.844n spmb=1.11111e15 spmt=1.11111e15 spomb=0 spomb1=1.11111e+60 spomt=0 spomt1=1.11111e+60 w=320n multi=2
M0468 (XDUT__COMP_P CMP_RESET VDD! VDD!) pch_18_mac ad=4.96e-14 as=4.96e-14 l=150n nf=1 nrd=0 nrs=0 pd=950.0n ps=950.0n sa=155.00n sa1=155.00n sa2=155.00n sa3=155.00n sa4=155.00n sap=172.362n sapb=242.67n sb=155.00n sb1=155.00n sb2=155.00n sb3=155.00n sd=180n spa=180.0n spa1=180.0n spa2=180.0n spa3=180.0n spba=233.666n spba1=239.844n spmb=1.11111e15 spmt=1.11111e15 spomb=0 spomb1=1.11111e+60 spomt=0 spomt1=1.11111e+60 w=320n multi=2
M0469 (XDUT__XCOMP__Y CMP_RESET VDD! VDD!) pch_18_mac ad=4.96e-14 as=4.96e-14 l=150n nf=1 nrd=0 nrs=0 pd=950.0n ps=950.0n sa=155.00n sa1=155.00n sa2=155.00n sa3=155.00n sa4=155.00n sap=172.362n sapb=242.67n sb=155.00n sb1=155.00n sb2=155.00n sb3=155.00n sd=180n spa=180.0n spa1=180.0n spa2=180.0n spa3=180.0n spba=233.666n spba1=239.844n spmb=1.11111e15 spmt=1.11111e15 spomb=0 spomb1=1.11111e+60 spomt=0 spomt1=1.11111e+60 w=320n multi=2
M0470 (XDUT__XCOMP__X CMP_RESET VDD! VDD!) pch_18_mac ad=4.96e-14 as=4.96e-14 l=150n nf=1 nrd=0 nrs=0 pd=950.0n ps=950.0n sa=155.00n sa1=155.00n sa2=155.00n sa3=155.00n sa4=155.00n sap=172.362n sapb=242.67n sb=155.00n sb1=155.00n sb2=155.00n sb3=155.00n sd=180n spa=180.0n spa1=180.0n spa2=180.0n spa3=180.0n spba=233.666n spba1=239.844n spmb=1.11111e15 spmt=1.11111e15 spomb=0 spomb1=1.11111e+60 spomt=0 spomt1=1.11111e+60 w=320n multi=2
M0471 (XDUT__COMP_N XDUT__COMP_P VDD! VDD!) pch_18_mac ad=4.96e-14 as=4.96e-14 l=150n nf=1 nrd=0 nrs=0 pd=950.0n ps=950.0n sa=155.00n sa1=155.00n sa2=155.00n sa3=155.00n sa4=155.00n sap=172.362n sapb=242.67n sb=155.00n sb1=155.00n sb2=155.00n sb3=155.00n sd=180n spa=180.0n spa1=180.0n spa2=180.0n spa3=180.0n spba=233.666n spba1=239.844n spmb=1.11111e15 spmt=1.11111e15 spomb=0 spomb1=1.11111e+60 spomt=0 spomt1=1.11111e+60 w=320n multi=2
M0472 (XDUT__COMP_P XDUT__COMP_N VDD! VDD!) pch_18_mac ad=4.96e-14 as=4.96e-14 l=150n nf=1 nrd=0 nrs=0 pd=950.0n ps=950.0n sa=155.00n sa1=155.00n sa2=155.00n sa3=155.00n sa4=155.00n sap=172.362n sapb=242.67n sb=155.00n sb1=155.00n sb2=155.00n sb3=155.00n sd=180n spa=180.0n spa1=180.0n spa2=180.0n spa3=180.0n spba=233.666n spba1=239.844n spmb=1.11111e15 spmt=1.11111e15 spomb=0 spomb1=1.11111e+60 spomt=0 spomt1=1.11111e+60 w=320n multi=2
M0473 (XDUT__XCTRL__XTIM__NR XDUT__XCTRL__XTIM__X003__N VDD! VDD!) pch_mac l=30n w=1u multi=1 nf=1 sd=100n ad=7.5e-14 as=7.5e-14 pd=2.15u ps=2.15u nrd=0.165806 nrs=0.165806 sa=75.0n sb=75.0n sa1=75.0n sa2=75.0n sa3=75.0n sa4=75.0n sb1=75.0n sb2=75.0n sb3=75.0n spa=100n spa1=100n spa2=100n spa3=100n sap=91.9776n sapb=114.444n spba=115.715n spba1=117.043n dfm_flag=0 spmt=1.11111e+15 spomt=0 spomt1=1.11111e+60 spmb=1.11111e+15 spomb=0 spomb1=1.11111e+60
M0474 (XDUT__XCTRL__XTIM__NR XDUT__XCTRL__XTIM__X003__N 0 0) nch_mac l=30n w=500n multi=1 nf=1 sd=100n ad=3.75e-14 as=3.75e-14 pd=1.15u ps=1.15u nrd=0.662935 nrs=0.662935 sa=75.0n sb=75.0n sa1=75.0n sa2=75.0n sa3=75.0n sa4=75.0n sb1=75.0n sb2=75.0n sb3=75.0n spa=100n spa1=100n spa2=100n spa3=100n sap=91.9776n sapb=114.444n spba=115.715n spba1=117.043n dfm_flag=0 spmt=1.11111e+15 spomt=0 spomt1=1.11111e+60 spmb=1.11111e+15 spomb=0 spomb1=1.11111e+60
M0475 (XDUT__XCTRL__XTIM__X003__N XDUT__COMP_N VDD! VDD!) pch_18_mac ad=4.96e-14 as=4.96e-14 l=150n nf=1 nrd=0 nrs=0 pd=950.0n ps=950.0n sa=155.00n sa1=155.00n sa2=155.00n sa3=155.00n sa4=155.00n sap=172.362n sapb=242.67n sb=155.00n sb1=155.00n sb2=155.00n sb3=155.00n sd=180n spa=180.0n spa1=180.0n spa2=180.0n spa3=180.0n spba=233.666n spba1=239.844n spmb=1.11111e15 spmt=1.11111e15 spomb=0 spomb1=1.11111e+60 spomt=0 spomt1=1.11111e+60 w=320n multi=4
M0476 (XDUT__XCTRL__XTIM__X003__N XDUT__COMP_N 0 0) nch_18_mac ad=4.96e-14 as=4.96e-14 l=150n nf=1 nrd=0 nrs=0 pd=950.0n ps=950.0n sa=155.00n sa1=155.00n sa2=155.00n sa3=155.00n sa4=155.00n sap=172.362n sapb=242.67n sb=155.00n sb1=155.00n sb2=155.00n sb3=155.00n sd=180n spa=180.0n spa1=180.0n spa2=180.0n spa3=180.0n spba=233.666n spba1=239.844n spmb=1.11111e15 spmt=1.11111e15 spomb=0 spomb1=1.11111e+60 spomt=0 spomt1=1.11111e+60 w=320n multi=2
M0477 (XDUT__XCTRL__XTIM__PR XDUT__XCTRL__XTIM__X002__N VDD! VDD!) pch_mac l=30n w=1u multi=1 nf=1 sd=100n ad=7.5e-14 as=7.5e-14 pd=2.15u ps=2.15u nrd=0.165806 nrs=0.165806 sa=75.0n sb=75.0n sa1=75.0n sa2=75.0n sa3=75.0n sa4=75.0n sb1=75.0n sb2=75.0n sb3=75.0n spa=100n spa1=100n spa2=100n spa3=100n sap=91.9776n sapb=114.444n spba=115.715n spba1=117.043n dfm_flag=0 spmt=1.11111e+15 spomt=0 spomt1=1.11111e+60 spmb=1.11111e+15 spomb=0 spomb1=1.11111e+60
M0478 (XDUT__XCTRL__XTIM__PR XDUT__XCTRL__XTIM__X002__N 0 0) nch_mac l=30n w=500n multi=1 nf=1 sd=100n ad=3.75e-14 as=3.75e-14 pd=1.15u ps=1.15u nrd=0.662935 nrs=0.662935 sa=75.0n sb=75.0n sa1=75.0n sa2=75.0n sa3=75.0n sa4=75.0n sb1=75.0n sb2=75.0n sb3=75.0n spa=100n spa1=100n spa2=100n spa3=100n sap=91.9776n sapb=114.444n spba=115.715n spba1=117.043n dfm_flag=0 spmt=1.11111e+15 spomt=0 spomt1=1.11111e+60 spmb=1.11111e+15 spomb=0 spomb1=1.11111e+60
M0479 (XDUT__XCTRL__XTIM__X002__N XDUT__COMP_P VDD! VDD!) pch_18_mac ad=4.96e-14 as=4.96e-14 l=150n nf=1 nrd=0 nrs=0 pd=950.0n ps=950.0n sa=155.00n sa1=155.00n sa2=155.00n sa3=155.00n sa4=155.00n sap=172.362n sapb=242.67n sb=155.00n sb1=155.00n sb2=155.00n sb3=155.00n sd=180n spa=180.0n spa1=180.0n spa2=180.0n spa3=180.0n spba=233.666n spba1=239.844n spmb=1.11111e15 spmt=1.11111e15 spomb=0 spomb1=1.11111e+60 spomt=0 spomt1=1.11111e+60 w=320n multi=4
M0480 (XDUT__XCTRL__XTIM__X002__N XDUT__COMP_P 0 0) nch_18_mac ad=4.96e-14 as=4.96e-14 l=150n nf=1 nrd=0 nrs=0 pd=950.0n ps=950.0n sa=155.00n sa1=155.00n sa2=155.00n sa3=155.00n sa4=155.00n sap=172.362n sapb=242.67n sb=155.00n sb1=155.00n sb2=155.00n sb3=155.00n sd=180n spa=180.0n spa1=180.0n spa2=180.0n spa3=180.0n spba=233.666n spba1=239.844n spmb=1.11111e15 spmt=1.11111e15 spomb=0 spomb1=1.11111e+60 spomt=0 spomt1=1.11111e+60 w=320n multi=2
M0481 (XDUT__XCTRL__XTIM__NRB XDUT__XCTRL__XTIM__NR VDD! VDD!) pch_mac l=30n w=1u multi=1 nf=1 sd=100n ad=7.5e-14 as=7.5e-14 pd=2.15u ps=2.15u nrd=0.165806 nrs=0.165806 sa=75.0n sb=75.0n sa1=75.0n sa2=75.0n sa3=75.0n sa4=75.0n sb1=75.0n sb2=75.0n sb3=75.0n spa=100n spa1=100n spa2=100n spa3=100n sap=91.9776n sapb=114.444n spba=115.715n spba1=117.043n dfm_flag=0 spmt=1.11111e+15 spomt=0 spomt1=1.11111e+60 spmb=1.11111e+15 spomb=0 spomb1=1.11111e+60
M0482 (XDUT__XCTRL__XTIM__NRB XDUT__XCTRL__XTIM__NR 0 0) nch_mac l=30n w=500n multi=1 nf=1 sd=100n ad=3.75e-14 as=3.75e-14 pd=1.15u ps=1.15u nrd=0.662935 nrs=0.662935 sa=75.0n sb=75.0n sa1=75.0n sa2=75.0n sa3=75.0n sa4=75.0n sb1=75.0n sb2=75.0n sb3=75.0n spa=100n spa1=100n spa2=100n spa3=100n sap=91.9776n sapb=114.444n spba=115.715n spba1=117.043n dfm_flag=0 spmt=1.11111e+15 spomt=0 spomt1=1.11111e+60 spmb=1.11111e+15 spomb=0 spomb1=1.11111e+60
M0483 (XDUT__XCTRL__XTIM__X005__N XDUT__XCTRL__XTIM__NRB VDD! VDD!) pch_mac l=30n w=1u multi=1 nf=1 sd=100n ad=7.5e-14 as=7.5e-14 pd=2.15u ps=2.15u nrd=0.165806 nrs=0.165806 sa=75.0n sb=75.0n sa1=75.0n sa2=75.0n sa3=75.0n sa4=75.0n sb1=75.0n sb2=75.0n sb3=75.0n spa=100n spa1=100n spa2=100n spa3=100n sap=91.9776n sapb=114.444n spba=115.715n spba1=117.043n dfm_flag=0 spmt=1.11111e+15 spomt=0 spomt1=1.11111e+60 spmb=1.11111e+15 spomb=0 spomb1=1.11111e+60
M0484 (XDUT__XCTRL__XTIM__X005__N XDUT__XCTRL__XTIM__PR VDD! VDD!) pch_mac l=30n w=1u multi=1 nf=1 sd=100n ad=7.5e-14 as=7.5e-14 pd=2.15u ps=2.15u nrd=0.165806 nrs=0.165806 sa=75.0n sb=75.0n sa1=75.0n sa2=75.0n sa3=75.0n sa4=75.0n sb1=75.0n sb2=75.0n sb3=75.0n spa=100n spa1=100n spa2=100n spa3=100n sap=91.9776n sapb=114.444n spba=115.715n spba1=117.043n dfm_flag=0 spmt=1.11111e+15 spomt=0 spomt1=1.11111e+60 spmb=1.11111e+15 spomb=0 spomb1=1.11111e+60
M0485 (XDUT__XCTRL__XTIM__X005__X000__MID XDUT__XCTRL__XTIM__NRB 0 0) nch_mac l=30n w=1u multi=1 nf=1 sd=100n ad=7.5e-14 as=7.5e-14 pd=2.15u ps=2.15u nrd=0.289519 nrs=0.289519 sa=75.0n sb=75.0n sa1=75.0n sa2=75.0n sa3=75.0n sa4=75.0n sb1=75.0n sb2=75.0n sb3=75.0n spa=100n spa1=100n spa2=100n spa3=100n sap=91.9776n sapb=114.444n spba=115.715n spba1=117.043n dfm_flag=0 spmt=1.11111e+15 spomt=0 spomt1=1.11111e+60 spmb=1.11111e+15 spomb=0 spomb1=1.11111e+60
M0486 (XDUT__XCTRL__XTIM__X005__N XDUT__XCTRL__XTIM__PR XDUT__XCTRL__XTIM__X005__X000__MID 0) nch_mac l=30n w=1u multi=1 nf=1 sd=100n ad=7.5e-14 as=7.5e-14 pd=2.15u ps=2.15u nrd=0.289519 nrs=0.289519 sa=75.0n sb=75.0n sa1=75.0n sa2=75.0n sa3=75.0n sa4=75.0n sb1=75.0n sb2=75.0n sb3=75.0n spa=100n spa1=100n spa2=100n spa3=100n sap=91.9776n sapb=114.444n spba=115.715n spba1=117.043n dfm_flag=0 spmt=1.11111e+15 spomt=0 spomt1=1.11111e+60 spmb=1.11111e+15 spomb=0 spomb1=1.11111e+60
C0487 (XDUT__XCTRL__XTIM__X005__X000__MID 0) cfmom_2t nr=8 lr=2.5u w=50n s=50n stm=1 spm=3 multi=2 mismatchflag=1
M0488 (XDUT__XCTRL__DATA XDUT__XCTRL__XTIM__X005__N VDD! VDD!) pch_mac l=30n w=1u multi=1 nf=1 sd=100n ad=7.5e-14 as=7.5e-14 pd=2.15u ps=2.15u nrd=0.165806 nrs=0.165806 sa=75.0n sb=75.0n sa1=75.0n sa2=75.0n sa3=75.0n sa4=75.0n sb1=75.0n sb2=75.0n sb3=75.0n spa=100n spa1=100n spa2=100n spa3=100n sap=91.9776n sapb=114.444n spba=115.715n spba1=117.043n dfm_flag=0 spmt=1.11111e+15 spomt=0 spomt1=1.11111e+60 spmb=1.11111e+15 spomb=0 spomb1=1.11111e+60
M0489 (XDUT__XCTRL__DATA XDUT__XCTRL__XTIM__X005__N 0 0) nch_mac l=30n w=500n multi=1 nf=1 sd=100n ad=3.75e-14 as=3.75e-14 pd=1.15u ps=1.15u nrd=0.662935 nrs=0.662935 sa=75.0n sb=75.0n sa1=75.0n sa2=75.0n sa3=75.0n sa4=75.0n sb1=75.0n sb2=75.0n sb3=75.0n spa=100n spa1=100n spa2=100n spa3=100n sap=91.9776n sapb=114.444n spba=115.715n spba1=117.043n dfm_flag=0 spmt=1.11111e+15 spomt=0 spomt1=1.11111e+60 spmb=1.11111e+15 spomb=0 spomb1=1.11111e+60
M0490 (XDUT__XCTRL__XTIM__RAW XDUT__XCTRL__XTIM__X006__NB VDD! VDD!) pch_mac l=30n w=1u multi=1 nf=1 sd=100n ad=7.5e-14 as=7.5e-14 pd=2.15u ps=2.15u nrd=0.165806 nrs=0.165806 sa=75.0n sb=75.0n sa1=75.0n sa2=75.0n sa3=75.0n sa4=75.0n sb1=75.0n sb2=75.0n sb3=75.0n spa=100n spa1=100n spa2=100n spa3=100n sap=91.9776n sapb=114.444n spba=115.715n spba1=117.043n dfm_flag=0 spmt=1.11111e+15 spomt=0 spomt1=1.11111e+60 spmb=1.11111e+15 spomb=0 spomb1=1.11111e+60
M0491 (XDUT__XCTRL__XTIM__RAW XDUT__XCTRL__XTIM__X006__NA VDD! VDD!) pch_mac l=30n w=1u multi=1 nf=1 sd=100n ad=7.5e-14 as=7.5e-14 pd=2.15u ps=2.15u nrd=0.165806 nrs=0.165806 sa=75.0n sb=75.0n sa1=75.0n sa2=75.0n sa3=75.0n sa4=75.0n sb1=75.0n sb2=75.0n sb3=75.0n spa=100n spa1=100n spa2=100n spa3=100n sap=91.9776n sapb=114.444n spba=115.715n spba1=117.043n dfm_flag=0 spmt=1.11111e+15 spomt=0 spomt1=1.11111e+60 spmb=1.11111e+15 spomb=0 spomb1=1.11111e+60
M0492 (XDUT__XCTRL__XTIM__X006__X003__MID XDUT__XCTRL__XTIM__X006__NB 0 0) nch_mac l=30n w=1u multi=1 nf=1 sd=100n ad=7.5e-14 as=7.5e-14 pd=2.15u ps=2.15u nrd=0.289519 nrs=0.289519 sa=75.0n sb=75.0n sa1=75.0n sa2=75.0n sa3=75.0n sa4=75.0n sb1=75.0n sb2=75.0n sb3=75.0n spa=100n spa1=100n spa2=100n spa3=100n sap=91.9776n sapb=114.444n spba=115.715n spba1=117.043n dfm_flag=0 spmt=1.11111e+15 spomt=0 spomt1=1.11111e+60 spmb=1.11111e+15 spomb=0 spomb1=1.11111e+60
M0493 (XDUT__XCTRL__XTIM__RAW XDUT__XCTRL__XTIM__X006__NA XDUT__XCTRL__XTIM__X006__X003__MID 0) nch_mac l=30n w=1u multi=1 nf=1 sd=100n ad=7.5e-14 as=7.5e-14 pd=2.15u ps=2.15u nrd=0.289519 nrs=0.289519 sa=75.0n sb=75.0n sa1=75.0n sa2=75.0n sa3=75.0n sa4=75.0n sb1=75.0n sb2=75.0n sb3=75.0n spa=100n spa1=100n spa2=100n spa3=100n sap=91.9776n sapb=114.444n spba=115.715n spba1=117.043n dfm_flag=0 spmt=1.11111e+15 spomt=0 spomt1=1.11111e+60 spmb=1.11111e+15 spomb=0 spomb1=1.11111e+60
C0494 (XDUT__XCTRL__XTIM__X006__X003__MID 0) cfmom_2t nr=8 lr=2.5u w=50n s=50n stm=1 spm=3 multi=2 mismatchflag=1
M0495 (XDUT__XCTRL__XTIM__X006__NB XDUT__XCTRL__XTIM__X006__N VDD! VDD!) pch_mac l=30n w=1u multi=1 nf=1 sd=100n ad=7.5e-14 as=7.5e-14 pd=2.15u ps=2.15u nrd=0.165806 nrs=0.165806 sa=75.0n sb=75.0n sa1=75.0n sa2=75.0n sa3=75.0n sa4=75.0n sb1=75.0n sb2=75.0n sb3=75.0n spa=100n spa1=100n spa2=100n spa3=100n sap=91.9776n sapb=114.444n spba=115.715n spba1=117.043n dfm_flag=0 spmt=1.11111e+15 spomt=0 spomt1=1.11111e+60 spmb=1.11111e+15 spomb=0 spomb1=1.11111e+60
M0496 (XDUT__XCTRL__XTIM__X006__NB XDUT__XCTRL__XTIM__NR VDD! VDD!) pch_mac l=30n w=1u multi=1 nf=1 sd=100n ad=7.5e-14 as=7.5e-14 pd=2.15u ps=2.15u nrd=0.165806 nrs=0.165806 sa=75.0n sb=75.0n sa1=75.0n sa2=75.0n sa3=75.0n sa4=75.0n sb1=75.0n sb2=75.0n sb3=75.0n spa=100n spa1=100n spa2=100n spa3=100n sap=91.9776n sapb=114.444n spba=115.715n spba1=117.043n dfm_flag=0 spmt=1.11111e+15 spomt=0 spomt1=1.11111e+60 spmb=1.11111e+15 spomb=0 spomb1=1.11111e+60
M0497 (XDUT__XCTRL__XTIM__X006__X002__MID XDUT__XCTRL__XTIM__X006__N 0 0) nch_mac l=30n w=1u multi=1 nf=1 sd=100n ad=7.5e-14 as=7.5e-14 pd=2.15u ps=2.15u nrd=0.289519 nrs=0.289519 sa=75.0n sb=75.0n sa1=75.0n sa2=75.0n sa3=75.0n sa4=75.0n sb1=75.0n sb2=75.0n sb3=75.0n spa=100n spa1=100n spa2=100n spa3=100n sap=91.9776n sapb=114.444n spba=115.715n spba1=117.043n dfm_flag=0 spmt=1.11111e+15 spomt=0 spomt1=1.11111e+60 spmb=1.11111e+15 spomb=0 spomb1=1.11111e+60
M0498 (XDUT__XCTRL__XTIM__X006__NB XDUT__XCTRL__XTIM__NR XDUT__XCTRL__XTIM__X006__X002__MID 0) nch_mac l=30n w=1u multi=1 nf=1 sd=100n ad=7.5e-14 as=7.5e-14 pd=2.15u ps=2.15u nrd=0.289519 nrs=0.289519 sa=75.0n sb=75.0n sa1=75.0n sa2=75.0n sa3=75.0n sa4=75.0n sb1=75.0n sb2=75.0n sb3=75.0n spa=100n spa1=100n spa2=100n spa3=100n sap=91.9776n sapb=114.444n spba=115.715n spba1=117.043n dfm_flag=0 spmt=1.11111e+15 spomt=0 spomt1=1.11111e+60 spmb=1.11111e+15 spomb=0 spomb1=1.11111e+60
C0499 (XDUT__XCTRL__XTIM__X006__X002__MID 0) cfmom_2t nr=8 lr=2.5u w=50n s=50n stm=1 spm=3 multi=2 mismatchflag=1
M0500 (XDUT__XCTRL__XTIM__X006__NA XDUT__XCTRL__XTIM__X006__N VDD! VDD!) pch_mac l=30n w=1u multi=1 nf=1 sd=100n ad=7.5e-14 as=7.5e-14 pd=2.15u ps=2.15u nrd=0.165806 nrs=0.165806 sa=75.0n sb=75.0n sa1=75.0n sa2=75.0n sa3=75.0n sa4=75.0n sb1=75.0n sb2=75.0n sb3=75.0n spa=100n spa1=100n spa2=100n spa3=100n sap=91.9776n sapb=114.444n spba=115.715n spba1=117.043n dfm_flag=0 spmt=1.11111e+15 spomt=0 spomt1=1.11111e+60 spmb=1.11111e+15 spomb=0 spomb1=1.11111e+60
M0501 (XDUT__XCTRL__XTIM__X006__NA XDUT__XCTRL__XTIM__PR VDD! VDD!) pch_mac l=30n w=1u multi=1 nf=1 sd=100n ad=7.5e-14 as=7.5e-14 pd=2.15u ps=2.15u nrd=0.165806 nrs=0.165806 sa=75.0n sb=75.0n sa1=75.0n sa2=75.0n sa3=75.0n sa4=75.0n sb1=75.0n sb2=75.0n sb3=75.0n spa=100n spa1=100n spa2=100n spa3=100n sap=91.9776n sapb=114.444n spba=115.715n spba1=117.043n dfm_flag=0 spmt=1.11111e+15 spomt=0 spomt1=1.11111e+60 spmb=1.11111e+15 spomb=0 spomb1=1.11111e+60
M0502 (XDUT__XCTRL__XTIM__X006__X001__MID XDUT__XCTRL__XTIM__X006__N 0 0) nch_mac l=30n w=1u multi=1 nf=1 sd=100n ad=7.5e-14 as=7.5e-14 pd=2.15u ps=2.15u nrd=0.289519 nrs=0.289519 sa=75.0n sb=75.0n sa1=75.0n sa2=75.0n sa3=75.0n sa4=75.0n sb1=75.0n sb2=75.0n sb3=75.0n spa=100n spa1=100n spa2=100n spa3=100n sap=91.9776n sapb=114.444n spba=115.715n spba1=117.043n dfm_flag=0 spmt=1.11111e+15 spomt=0 spomt1=1.11111e+60 spmb=1.11111e+15 spomb=0 spomb1=1.11111e+60
M0503 (XDUT__XCTRL__XTIM__X006__NA XDUT__XCTRL__XTIM__PR XDUT__XCTRL__XTIM__X006__X001__MID 0) nch_mac l=30n w=1u multi=1 nf=1 sd=100n ad=7.5e-14 as=7.5e-14 pd=2.15u ps=2.15u nrd=0.289519 nrs=0.289519 sa=75.0n sb=75.0n sa1=75.0n sa2=75.0n sa3=75.0n sa4=75.0n sb1=75.0n sb2=75.0n sb3=75.0n spa=100n spa1=100n spa2=100n spa3=100n sap=91.9776n sapb=114.444n spba=115.715n spba1=117.043n dfm_flag=0 spmt=1.11111e+15 spomt=0 spomt1=1.11111e+60 spmb=1.11111e+15 spomb=0 spomb1=1.11111e+60
C0504 (XDUT__XCTRL__XTIM__X006__X001__MID 0) cfmom_2t nr=8 lr=2.5u w=50n s=50n stm=1 spm=3 multi=2 mismatchflag=1
M0505 (XDUT__XCTRL__XTIM__X006__N XDUT__XCTRL__XTIM__NR VDD! VDD!) pch_mac l=30n w=1u multi=1 nf=1 sd=100n ad=7.5e-14 as=7.5e-14 pd=2.15u ps=2.15u nrd=0.165806 nrs=0.165806 sa=75.0n sb=75.0n sa1=75.0n sa2=75.0n sa3=75.0n sa4=75.0n sb1=75.0n sb2=75.0n sb3=75.0n spa=100n spa1=100n spa2=100n spa3=100n sap=91.9776n sapb=114.444n spba=115.715n spba1=117.043n dfm_flag=0 spmt=1.11111e+15 spomt=0 spomt1=1.11111e+60 spmb=1.11111e+15 spomb=0 spomb1=1.11111e+60
M0506 (XDUT__XCTRL__XTIM__X006__N XDUT__XCTRL__XTIM__PR VDD! VDD!) pch_mac l=30n w=1u multi=1 nf=1 sd=100n ad=7.5e-14 as=7.5e-14 pd=2.15u ps=2.15u nrd=0.165806 nrs=0.165806 sa=75.0n sb=75.0n sa1=75.0n sa2=75.0n sa3=75.0n sa4=75.0n sb1=75.0n sb2=75.0n sb3=75.0n spa=100n spa1=100n spa2=100n spa3=100n sap=91.9776n sapb=114.444n spba=115.715n spba1=117.043n dfm_flag=0 spmt=1.11111e+15 spomt=0 spomt1=1.11111e+60 spmb=1.11111e+15 spomb=0 spomb1=1.11111e+60
M0507 (XDUT__XCTRL__XTIM__X006__X000__MID XDUT__XCTRL__XTIM__NR 0 0) nch_mac l=30n w=1u multi=1 nf=1 sd=100n ad=7.5e-14 as=7.5e-14 pd=2.15u ps=2.15u nrd=0.289519 nrs=0.289519 sa=75.0n sb=75.0n sa1=75.0n sa2=75.0n sa3=75.0n sa4=75.0n sb1=75.0n sb2=75.0n sb3=75.0n spa=100n spa1=100n spa2=100n spa3=100n sap=91.9776n sapb=114.444n spba=115.715n spba1=117.043n dfm_flag=0 spmt=1.11111e+15 spomt=0 spomt1=1.11111e+60 spmb=1.11111e+15 spomb=0 spomb1=1.11111e+60
M0508 (XDUT__XCTRL__XTIM__X006__N XDUT__XCTRL__XTIM__PR XDUT__XCTRL__XTIM__X006__X000__MID 0) nch_mac l=30n w=1u multi=1 nf=1 sd=100n ad=7.5e-14 as=7.5e-14 pd=2.15u ps=2.15u nrd=0.289519 nrs=0.289519 sa=75.0n sb=75.0n sa1=75.0n sa2=75.0n sa3=75.0n sa4=75.0n sb1=75.0n sb2=75.0n sb3=75.0n spa=100n spa1=100n spa2=100n spa3=100n sap=91.9776n sapb=114.444n spba=115.715n spba1=117.043n dfm_flag=0 spmt=1.11111e+15 spomt=0 spomt1=1.11111e+60 spmb=1.11111e+15 spomb=0 spomb1=1.11111e+60
C0509 (XDUT__XCTRL__XTIM__X006__X000__MID 0) cfmom_2t nr=8 lr=2.5u w=50n s=50n stm=1 spm=3 multi=2 mismatchflag=1
C0510 (XDUT__COMP_N 0) cfmom_2t nr=8 lr=2.5u w=50n s=50n stm=1 spm=3 multi=2 mismatchflag=1
C0511 (XDUT__COMP_P 0) cfmom_2t nr=8 lr=2.5u w=50n s=50n stm=1 spm=3 multi=2 mismatchflag=1
C0512 (CMP_RESET 0) cfmom_2t nr=8 lr=2.5u w=50n s=50n stm=1 spm=3 multi=2 mismatchflag=1
R0513 (XDUT__XSEQ__XD__B XDUT__XSEQ__XD__RC1) rupolym l=17.13u w=1u m=1 multi=(1)
R0514 (XDUT__SAMPLE_MATCH XDUT__XSEQ__XD__RC0) rupolym l=17.13u w=1u m=1 multi=(1)
C0515 (XDUT__XSEQ__XD__RC1 0) cfmom_2t nr=8 lr=2.5u w=50n s=50n stm=1 spm=3 multi=20 mismatchflag=1
C0516 (XDUT__XSEQ__XD__RC0 0) cfmom_2t nr=8 lr=2.5u w=50n s=50n stm=1 spm=3 multi=20 mismatchflag=1
M0517 (XDUT__XSEQ__XD__AB XDUT__SAMPLE_MATCH VDD! VDD!) pch_mac l=30n w=1u multi=1 nf=1 sd=100n ad=7.5e-14 as=7.5e-14 pd=2.15u ps=2.15u nrd=0.165806 nrs=0.165806 sa=75.0n sb=75.0n sa1=75.0n sa2=75.0n sa3=75.0n sa4=75.0n sb1=75.0n sb2=75.0n sb3=75.0n spa=100n spa1=100n spa2=100n spa3=100n sap=91.9776n sapb=114.444n spba=115.715n spba1=117.043n dfm_flag=0 spmt=1.11111e+15 spomt=0 spomt1=1.11111e+60 spmb=1.11111e+15 spomb=0 spomb1=1.11111e+60
M0518 (XDUT__XSEQ__XD__AB XDUT__SAMPLE_MATCH 0 0) nch_mac l=30n w=500n multi=1 nf=1 sd=100n ad=3.75e-14 as=3.75e-14 pd=1.15u ps=1.15u nrd=0.662935 nrs=0.662935 sa=75.0n sb=75.0n sa1=75.0n sa2=75.0n sa3=75.0n sa4=75.0n sb1=75.0n sb2=75.0n sb3=75.0n spa=100n spa1=100n spa2=100n spa3=100n sap=91.9776n sapb=114.444n spba=115.715n spba1=117.043n dfm_flag=0 spmt=1.11111e+15 spomt=0 spomt1=1.11111e+60 spmb=1.11111e+15 spomb=0 spomb1=1.11111e+60
M0519 (XDUT__XSEQ__AD XDUT__XSEQ__XD__RC1 VDD! VDD!) pch_mac l=30n w=1u multi=1 nf=1 sd=100n ad=7.5e-14 as=7.5e-14 pd=2.15u ps=2.15u nrd=0.165806 nrs=0.165806 sa=75.0n sb=75.0n sa1=75.0n sa2=75.0n sa3=75.0n sa4=75.0n sb1=75.0n sb2=75.0n sb3=75.0n spa=100n spa1=100n spa2=100n spa3=100n sap=91.9776n sapb=114.444n spba=115.715n spba1=117.043n dfm_flag=0 spmt=1.11111e+15 spomt=0 spomt1=1.11111e+60 spmb=1.11111e+15 spomb=0 spomb1=1.11111e+60
M0520 (XDUT__XSEQ__AD XDUT__XSEQ__XD__RC1 0 0) nch_mac l=30n w=500n multi=1 nf=1 sd=100n ad=3.75e-14 as=3.75e-14 pd=1.15u ps=1.15u nrd=0.662935 nrs=0.662935 sa=75.0n sb=75.0n sa1=75.0n sa2=75.0n sa3=75.0n sa4=75.0n sb1=75.0n sb2=75.0n sb3=75.0n spa=100n spa1=100n spa2=100n spa3=100n sap=91.9776n sapb=114.444n spba=115.715n spba1=117.043n dfm_flag=0 spmt=1.11111e+15 spomt=0 spomt1=1.11111e+60 spmb=1.11111e+15 spomb=0 spomb1=1.11111e+60
M0521 (XDUT__XSEQ__XD__B XDUT__XSEQ__XD__RC0 VDD! VDD!) pch_mac l=30n w=1u multi=1 nf=1 sd=100n ad=7.5e-14 as=7.5e-14 pd=2.15u ps=2.15u nrd=0.165806 nrs=0.165806 sa=75.0n sb=75.0n sa1=75.0n sa2=75.0n sa3=75.0n sa4=75.0n sb1=75.0n sb2=75.0n sb3=75.0n spa=100n spa1=100n spa2=100n spa3=100n sap=91.9776n sapb=114.444n spba=115.715n spba1=117.043n dfm_flag=0 spmt=1.11111e+15 spomt=0 spomt1=1.11111e+60 spmb=1.11111e+15 spomb=0 spomb1=1.11111e+60
M0522 (XDUT__XSEQ__XD__B XDUT__XSEQ__XD__RC0 0 0) nch_mac l=30n w=500n multi=1 nf=1 sd=100n ad=3.75e-14 as=3.75e-14 pd=1.15u ps=1.15u nrd=0.662935 nrs=0.662935 sa=75.0n sb=75.0n sa1=75.0n sa2=75.0n sa3=75.0n sa4=75.0n sb1=75.0n sb2=75.0n sb3=75.0n spa=100n spa1=100n spa2=100n spa3=100n sap=91.9776n sapb=114.444n spba=115.715n spba1=117.043n dfm_flag=0 spmt=1.11111e+15 spomt=0 spomt1=1.11111e+60 spmb=1.11111e+15 spomb=0 spomb1=1.11111e+60
M0523 (XDUT__XSEQ__XD__RC0 XDUT__XSEQ__XD__AB 0 0) nch_mac l=30n w=2u multi=1 nf=1 sd=100n ad=1.5e-13 as=1.5e-13 pd=4.15u ps=4.15u nrd=0.144730 nrs=0.144730 sa=75.0n sb=75.0n sa1=75.0n sa2=75.0n sa3=75.0n sa4=75.0n sb1=75.0n sb2=75.0n sb3=75.0n spa=100n spa1=100n spa2=100n spa3=100n sap=91.9776n sapb=114.444n spba=115.715n spba1=117.043n dfm_flag=0 spmt=1.11111e+15 spomt=0 spomt1=1.11111e+60 spmb=1.11111e+15 spomb=0 spomb1=1.11111e+60
M0524 (XDUT__XSEQ__XD__RC1 XDUT__SAMPLE_MATCH VDD! VDD!) pch_mac l=30n w=3u multi=1 nf=1 sd=100n ad=2.25e-13 as=2.25e-13 pd=6.15u ps=6.15u nrd=0.055246 nrs=0.055246 sa=75.0n sb=75.0n sa1=75.0n sa2=75.0n sa3=75.0n sa4=75.0n sb1=75.0n sb2=75.0n sb3=75.0n spa=100n spa1=100n spa2=100n spa3=100n sap=91.9776n sapb=114.444n spba=115.715n spba1=117.043n dfm_flag=0 spmt=1.11111e+15 spomt=0 spomt1=1.11111e+60 spmb=1.11111e+15 spomb=0 spomb1=1.11111e+60
M0525 (XDUT__XSEQ__XA__N XDUT__XSEQ__AD VDD! VDD!) pch_mac l=30n w=1u multi=1 nf=1 sd=100n ad=7.5e-14 as=7.5e-14 pd=2.15u ps=2.15u nrd=0.165806 nrs=0.165806 sa=75.0n sb=75.0n sa1=75.0n sa2=75.0n sa3=75.0n sa4=75.0n sb1=75.0n sb2=75.0n sb3=75.0n spa=100n spa1=100n spa2=100n spa3=100n sap=91.9776n sapb=114.444n spba=115.715n spba1=117.043n dfm_flag=0 spmt=1.11111e+15 spomt=0 spomt1=1.11111e+60 spmb=1.11111e+15 spomb=0 spomb1=1.11111e+60
M0526 (XDUT__XSEQ__XA__N XDUT__SAMPLE_MATCH VDD! VDD!) pch_mac l=30n w=1u multi=1 nf=1 sd=100n ad=7.5e-14 as=7.5e-14 pd=2.15u ps=2.15u nrd=0.165806 nrs=0.165806 sa=75.0n sb=75.0n sa1=75.0n sa2=75.0n sa3=75.0n sa4=75.0n sb1=75.0n sb2=75.0n sb3=75.0n spa=100n spa1=100n spa2=100n spa3=100n sap=91.9776n sapb=114.444n spba=115.715n spba1=117.043n dfm_flag=0 spmt=1.11111e+15 spomt=0 spomt1=1.11111e+60 spmb=1.11111e+15 spomb=0 spomb1=1.11111e+60
M0527 (XDUT__XSEQ__XA__X000__MID XDUT__XSEQ__AD 0 0) nch_mac l=30n w=1u multi=1 nf=1 sd=100n ad=7.5e-14 as=7.5e-14 pd=2.15u ps=2.15u nrd=0.289519 nrs=0.289519 sa=75.0n sb=75.0n sa1=75.0n sa2=75.0n sa3=75.0n sa4=75.0n sb1=75.0n sb2=75.0n sb3=75.0n spa=100n spa1=100n spa2=100n spa3=100n sap=91.9776n sapb=114.444n spba=115.715n spba1=117.043n dfm_flag=0 spmt=1.11111e+15 spomt=0 spomt1=1.11111e+60 spmb=1.11111e+15 spomb=0 spomb1=1.11111e+60
M0528 (XDUT__XSEQ__XA__N XDUT__SAMPLE_MATCH XDUT__XSEQ__XA__X000__MID 0) nch_mac l=30n w=1u multi=1 nf=1 sd=100n ad=7.5e-14 as=7.5e-14 pd=2.15u ps=2.15u nrd=0.289519 nrs=0.289519 sa=75.0n sb=75.0n sa1=75.0n sa2=75.0n sa3=75.0n sa4=75.0n sb1=75.0n sb2=75.0n sb3=75.0n spa=100n spa1=100n spa2=100n spa3=100n sap=91.9776n sapb=114.444n spba=115.715n spba1=117.043n dfm_flag=0 spmt=1.11111e+15 spomt=0 spomt1=1.11111e+60 spmb=1.11111e+15 spomb=0 spomb1=1.11111e+60
C0529 (XDUT__XSEQ__XA__X000__MID 0) cfmom_2t nr=8 lr=2.5u w=50n s=50n stm=1 spm=3 multi=2 mismatchflag=1
M0530 (XDUT__XSEQ__QUAL XDUT__XSEQ__XA__N VDD! VDD!) pch_mac l=30n w=1u multi=1 nf=1 sd=100n ad=7.5e-14 as=7.5e-14 pd=2.15u ps=2.15u nrd=0.165806 nrs=0.165806 sa=75.0n sb=75.0n sa1=75.0n sa2=75.0n sa3=75.0n sa4=75.0n sb1=75.0n sb2=75.0n sb3=75.0n spa=100n spa1=100n spa2=100n spa3=100n sap=91.9776n sapb=114.444n spba=115.715n spba1=117.043n dfm_flag=0 spmt=1.11111e+15 spomt=0 spomt1=1.11111e+60 spmb=1.11111e+15 spomb=0 spomb1=1.11111e+60
M0531 (XDUT__XSEQ__QUAL XDUT__XSEQ__XA__N 0 0) nch_mac l=30n w=500n multi=1 nf=1 sd=100n ad=3.75e-14 as=3.75e-14 pd=1.15u ps=1.15u nrd=0.662935 nrs=0.662935 sa=75.0n sb=75.0n sa1=75.0n sa2=75.0n sa3=75.0n sa4=75.0n sb1=75.0n sb2=75.0n sb3=75.0n spa=100n spa1=100n spa2=100n spa3=100n sap=91.9776n sapb=114.444n spba=115.715n spba1=117.043n dfm_flag=0 spmt=1.11111e+15 spomt=0 spomt1=1.11111e+60 spmb=1.11111e+15 spomb=0 spomb1=1.11111e+60
M0532 (XDUT__XSEQ__XB__AB XDUT__XSEQ__QUAL VDD! VDD!) pch_mac l=30n w=1u multi=1 nf=1 sd=100n ad=7.5e-14 as=7.5e-14 pd=2.15u ps=2.15u nrd=0.165806 nrs=0.165806 sa=75.0n sb=75.0n sa1=75.0n sa2=75.0n sa3=75.0n sa4=75.0n sb1=75.0n sb2=75.0n sb3=75.0n spa=100n spa1=100n spa2=100n spa3=100n sap=91.9776n sapb=114.444n spba=115.715n spba1=117.043n dfm_flag=0 spmt=1.11111e+15 spomt=0 spomt1=1.11111e+60 spmb=1.11111e+15 spomb=0 spomb1=1.11111e+60
M0533 (XDUT__XSEQ__XB__AB XDUT__XSEQ__QUAL 0 0) nch_mac l=30n w=500n multi=1 nf=1 sd=100n ad=3.75e-14 as=3.75e-14 pd=1.15u ps=1.15u nrd=0.662935 nrs=0.662935 sa=75.0n sb=75.0n sa1=75.0n sa2=75.0n sa3=75.0n sa4=75.0n sb1=75.0n sb2=75.0n sb3=75.0n spa=100n spa1=100n spa2=100n spa3=100n sap=91.9776n sapb=114.444n spba=115.715n spba1=117.043n dfm_flag=0 spmt=1.11111e+15 spomt=0 spomt1=1.11111e+60 spmb=1.11111e+15 spomb=0 spomb1=1.11111e+60
M0534 (XDUT__SEQ_SAMPLE XDUT__XSEQ__XB__AB 0 0) nch_mac l=30n w=2u multi=1 nf=1 sd=100n ad=1.5e-13 as=1.5e-13 pd=4.15u ps=4.15u nrd=0.144730 nrs=0.144730 sa=75.0n sb=75.0n sa1=75.0n sa2=75.0n sa3=75.0n sa4=75.0n sb1=75.0n sb2=75.0n sb3=75.0n spa=100n spa1=100n spa2=100n spa3=100n sap=91.9776n sapb=114.444n spba=115.715n spba1=117.043n dfm_flag=0 spmt=1.11111e+15 spomt=0 spomt1=1.11111e+60 spmb=1.11111e+15 spomb=0 spomb1=1.11111e+60
M0535 (XDUT__SEQ_SAMPLE XDUT__XSEQ__XB__AB VDD! VDD!) pch_mac l=30n w=3u multi=1 nf=1 sd=100n ad=2.25e-13 as=2.25e-13 pd=6.15u ps=6.15u nrd=0.055246 nrs=0.055246 sa=75.0n sb=75.0n sa1=75.0n sa2=75.0n sa3=75.0n sa4=75.0n sb1=75.0n sb2=75.0n sb3=75.0n spa=100n spa1=100n spa2=100n spa3=100n sap=91.9776n sapb=114.444n spba=115.715n spba1=117.043n dfm_flag=0 spmt=1.11111e+15 spomt=0 spomt1=1.11111e+60 spmb=1.11111e+15 spomb=0 spomb1=1.11111e+60
M0536 (XDUT__XIDLE__XA__N XDUT__SAMPLE_INT VDD! VDD!) pch_mac l=30n w=1u multi=1 nf=1 sd=100n ad=7.5e-14 as=7.5e-14 pd=2.15u ps=2.15u nrd=0.165806 nrs=0.165806 sa=75.0n sb=75.0n sa1=75.0n sa2=75.0n sa3=75.0n sa4=75.0n sb1=75.0n sb2=75.0n sb3=75.0n spa=100n spa1=100n spa2=100n spa3=100n sap=91.9776n sapb=114.444n spba=115.715n spba1=117.043n dfm_flag=0 spmt=1.11111e+15 spomt=0 spomt1=1.11111e+60 spmb=1.11111e+15 spomb=0 spomb1=1.11111e+60
M0537 (XDUT__XIDLE__XA__N XDUT__SAMPLE_INT VDD! VDD!) pch_mac l=30n w=1u multi=1 nf=1 sd=100n ad=7.5e-14 as=7.5e-14 pd=2.15u ps=2.15u nrd=0.165806 nrs=0.165806 sa=75.0n sb=75.0n sa1=75.0n sa2=75.0n sa3=75.0n sa4=75.0n sb1=75.0n sb2=75.0n sb3=75.0n spa=100n spa1=100n spa2=100n spa3=100n sap=91.9776n sapb=114.444n spba=115.715n spba1=117.043n dfm_flag=0 spmt=1.11111e+15 spomt=0 spomt1=1.11111e+60 spmb=1.11111e+15 spomb=0 spomb1=1.11111e+60
M0538 (XDUT__XIDLE__XA__X000__MID XDUT__SAMPLE_INT 0 0) nch_mac l=30n w=1u multi=1 nf=1 sd=100n ad=7.5e-14 as=7.5e-14 pd=2.15u ps=2.15u nrd=0.289519 nrs=0.289519 sa=75.0n sb=75.0n sa1=75.0n sa2=75.0n sa3=75.0n sa4=75.0n sb1=75.0n sb2=75.0n sb3=75.0n spa=100n spa1=100n spa2=100n spa3=100n sap=91.9776n sapb=114.444n spba=115.715n spba1=117.043n dfm_flag=0 spmt=1.11111e+15 spomt=0 spomt1=1.11111e+60 spmb=1.11111e+15 spomb=0 spomb1=1.11111e+60
M0539 (XDUT__XIDLE__XA__N XDUT__SAMPLE_INT XDUT__XIDLE__XA__X000__MID 0) nch_mac l=30n w=1u multi=1 nf=1 sd=100n ad=7.5e-14 as=7.5e-14 pd=2.15u ps=2.15u nrd=0.289519 nrs=0.289519 sa=75.0n sb=75.0n sa1=75.0n sa2=75.0n sa3=75.0n sa4=75.0n sb1=75.0n sb2=75.0n sb3=75.0n spa=100n spa1=100n spa2=100n spa3=100n sap=91.9776n sapb=114.444n spba=115.715n spba1=117.043n dfm_flag=0 spmt=1.11111e+15 spomt=0 spomt1=1.11111e+60 spmb=1.11111e+15 spomb=0 spomb1=1.11111e+60
C0540 (XDUT__XIDLE__XA__X000__MID 0) cfmom_2t nr=8 lr=2.5u w=50n s=50n stm=1 spm=3 multi=2 mismatchflag=1
M0541 (XDUT__XIDLE__SAMPLE_AND XDUT__XIDLE__XA__N VDD! VDD!) pch_mac l=30n w=1u multi=1 nf=1 sd=100n ad=7.5e-14 as=7.5e-14 pd=2.15u ps=2.15u nrd=0.165806 nrs=0.165806 sa=75.0n sb=75.0n sa1=75.0n sa2=75.0n sa3=75.0n sa4=75.0n sb1=75.0n sb2=75.0n sb3=75.0n spa=100n spa1=100n spa2=100n spa3=100n sap=91.9776n sapb=114.444n spba=115.715n spba1=117.043n dfm_flag=0 spmt=1.11111e+15 spomt=0 spomt1=1.11111e+60 spmb=1.11111e+15 spomb=0 spomb1=1.11111e+60
M0542 (XDUT__XIDLE__SAMPLE_AND XDUT__XIDLE__XA__N 0 0) nch_mac l=30n w=500n multi=1 nf=1 sd=100n ad=3.75e-14 as=3.75e-14 pd=1.15u ps=1.15u nrd=0.662935 nrs=0.662935 sa=75.0n sb=75.0n sa1=75.0n sa2=75.0n sa3=75.0n sa4=75.0n sb1=75.0n sb2=75.0n sb3=75.0n spa=100n spa1=100n spa2=100n spa3=100n sap=91.9776n sapb=114.444n spba=115.715n spba1=117.043n dfm_flag=0 spmt=1.11111e+15 spomt=0 spomt1=1.11111e+60 spmb=1.11111e+15 spomb=0 spomb1=1.11111e+60
M0543 (XDUT__SAMPLE_MATCH XDUT__XIDLE__XB__N VDD! VDD!) pch_mac l=30n w=1u multi=1 nf=1 sd=100n ad=7.5e-14 as=7.5e-14 pd=2.15u ps=2.15u nrd=0.165806 nrs=0.165806 sa=75.0n sb=75.0n sa1=75.0n sa2=75.0n sa3=75.0n sa4=75.0n sb1=75.0n sb2=75.0n sb3=75.0n spa=100n spa1=100n spa2=100n spa3=100n sap=91.9776n sapb=114.444n spba=115.715n spba1=117.043n dfm_flag=0 spmt=1.11111e+15 spomt=0 spomt1=1.11111e+60 spmb=1.11111e+15 spomb=0 spomb1=1.11111e+60
M0544 (XDUT__SAMPLE_MATCH XDUT__XIDLE__XB__N 0 0) nch_mac l=30n w=500n multi=1 nf=1 sd=100n ad=3.75e-14 as=3.75e-14 pd=1.15u ps=1.15u nrd=0.662935 nrs=0.662935 sa=75.0n sb=75.0n sa1=75.0n sa2=75.0n sa3=75.0n sa4=75.0n sb1=75.0n sb2=75.0n sb3=75.0n spa=100n spa1=100n spa2=100n spa3=100n sap=91.9776n sapb=114.444n spba=115.715n spba1=117.043n dfm_flag=0 spmt=1.11111e+15 spomt=0 spomt1=1.11111e+60 spmb=1.11111e+15 spomb=0 spomb1=1.11111e+60
M0545 (XDUT__XIDLE__XB__N XDUT__XIDLE__SAMPLE_AND VDD! VDD!) pch_mac l=30n w=1u multi=1 nf=1 sd=100n ad=7.5e-14 as=7.5e-14 pd=2.15u ps=2.15u nrd=0.165806 nrs=0.165806 sa=75.0n sb=75.0n sa1=75.0n sa2=75.0n sa3=75.0n sa4=75.0n sb1=75.0n sb2=75.0n sb3=75.0n spa=100n spa1=100n spa2=100n spa3=100n sap=91.9776n sapb=114.444n spba=115.715n spba1=117.043n dfm_flag=0 spmt=1.11111e+15 spomt=0 spomt1=1.11111e+60 spmb=1.11111e+15 spomb=0 spomb1=1.11111e+60
M0546 (XDUT__XIDLE__XB__N XDUT__XIDLE__SAMPLE_AND 0 0) nch_mac l=30n w=500n multi=1 nf=1 sd=100n ad=3.75e-14 as=3.75e-14 pd=1.15u ps=1.15u nrd=0.662935 nrs=0.662935 sa=75.0n sb=75.0n sa1=75.0n sa2=75.0n sa3=75.0n sa4=75.0n sb1=75.0n sb2=75.0n sb3=75.0n spa=100n spa1=100n spa2=100n spa3=100n sap=91.9776n sapb=114.444n spba=115.715n spba1=117.043n dfm_flag=0 spmt=1.11111e+15 spomt=0 spomt1=1.11111e+60 spmb=1.11111e+15 spomb=0 spomb1=1.11111e+60
M0547 (XDUT__XSAMPLE__AB SAMPLE VDD! VDD!) pch_mac l=30n w=1u multi=1 nf=1 sd=100n ad=7.5e-14 as=7.5e-14 pd=2.15u ps=2.15u nrd=0.165806 nrs=0.165806 sa=75.0n sb=75.0n sa1=75.0n sa2=75.0n sa3=75.0n sa4=75.0n sb1=75.0n sb2=75.0n sb3=75.0n spa=100n spa1=100n spa2=100n spa3=100n sap=91.9776n sapb=114.444n spba=115.715n spba1=117.043n dfm_flag=0 spmt=1.11111e+15 spomt=0 spomt1=1.11111e+60 spmb=1.11111e+15 spomb=0 spomb1=1.11111e+60
M0548 (XDUT__XSAMPLE__AB SAMPLE 0 0) nch_mac l=30n w=500n multi=1 nf=1 sd=100n ad=3.75e-14 as=3.75e-14 pd=1.15u ps=1.15u nrd=0.662935 nrs=0.662935 sa=75.0n sb=75.0n sa1=75.0n sa2=75.0n sa3=75.0n sa4=75.0n sb1=75.0n sb2=75.0n sb3=75.0n spa=100n spa1=100n spa2=100n spa3=100n sap=91.9776n sapb=114.444n spba=115.715n spba1=117.043n dfm_flag=0 spmt=1.11111e+15 spomt=0 spomt1=1.11111e+60 spmb=1.11111e+15 spomb=0 spomb1=1.11111e+60
M0549 (XDUT__SAMPLE_INT XDUT__XSAMPLE__AB 0 0) nch_mac l=30n w=2u multi=1 nf=1 sd=100n ad=1.5e-13 as=1.5e-13 pd=4.15u ps=4.15u nrd=0.144730 nrs=0.144730 sa=75.0n sb=75.0n sa1=75.0n sa2=75.0n sa3=75.0n sa4=75.0n sb1=75.0n sb2=75.0n sb3=75.0n spa=100n spa1=100n spa2=100n spa3=100n sap=91.9776n sapb=114.444n spba=115.715n spba1=117.043n dfm_flag=0 spmt=1.11111e+15 spomt=0 spomt1=1.11111e+60 spmb=1.11111e+15 spomb=0 spomb1=1.11111e+60
M0550 (XDUT__SAMPLE_INT XDUT__XSAMPLE__AB VDD! VDD!) pch_mac l=30n w=3u multi=1 nf=1 sd=100n ad=2.25e-13 as=2.25e-13 pd=6.15u ps=6.15u nrd=0.055246 nrs=0.055246 sa=75.0n sb=75.0n sa1=75.0n sa2=75.0n sa3=75.0n sa4=75.0n sb1=75.0n sb2=75.0n sb3=75.0n spa=100n spa1=100n spa2=100n spa3=100n sap=91.9776n sapb=114.444n spba=115.715n spba1=117.043n dfm_flag=0 spmt=1.11111e+15 spomt=0 spomt1=1.11111e+60 spmb=1.11111e+15 spomb=0 spomb1=1.11111e+60
M0551 (XDUT__XCTRL__XBIT0__XSTORE__RN XDUT__SAMPLE_INT VDD! VDD!) pch_mac l=30n w=1u multi=1 nf=1 sd=100n ad=7.5e-14 as=7.5e-14 pd=2.15u ps=2.15u nrd=0.165806 nrs=0.165806 sa=75.0n sb=75.0n sa1=75.0n sa2=75.0n sa3=75.0n sa4=75.0n sb1=75.0n sb2=75.0n sb3=75.0n spa=100n spa1=100n spa2=100n spa3=100n sap=91.9776n sapb=114.444n spba=115.715n spba1=117.043n dfm_flag=0 spmt=1.11111e+15 spomt=0 spomt1=1.11111e+60 spmb=1.11111e+15 spomb=0 spomb1=1.11111e+60
M0552 (XDUT__XCTRL__XBIT0__XSTORE__RN XDUT__SAMPLE_INT 0 0) nch_mac l=30n w=500n multi=1 nf=1 sd=100n ad=3.75e-14 as=3.75e-14 pd=1.15u ps=1.15u nrd=0.662935 nrs=0.662935 sa=75.0n sb=75.0n sa1=75.0n sa2=75.0n sa3=75.0n sa4=75.0n sb1=75.0n sb2=75.0n sb3=75.0n spa=100n spa1=100n spa2=100n spa3=100n sap=91.9776n sapb=114.444n spba=115.715n spba1=117.043n dfm_flag=0 spmt=1.11111e+15 spomt=0 spomt1=1.11111e+60 spmb=1.11111e+15 spomb=0 spomb1=1.11111e+60
M0553 (XDUT__XCTRL__XBIT1__XSTORE__RN XDUT__SAMPLE_INT VDD! VDD!) pch_mac l=30n w=1u multi=1 nf=1 sd=100n ad=7.5e-14 as=7.5e-14 pd=2.15u ps=2.15u nrd=0.165806 nrs=0.165806 sa=75.0n sb=75.0n sa1=75.0n sa2=75.0n sa3=75.0n sa4=75.0n sb1=75.0n sb2=75.0n sb3=75.0n spa=100n spa1=100n spa2=100n spa3=100n sap=91.9776n sapb=114.444n spba=115.715n spba1=117.043n dfm_flag=0 spmt=1.11111e+15 spomt=0 spomt1=1.11111e+60 spmb=1.11111e+15 spomb=0 spomb1=1.11111e+60
M0554 (XDUT__XCTRL__XBIT1__XSTORE__RN XDUT__SAMPLE_INT 0 0) nch_mac l=30n w=500n multi=1 nf=1 sd=100n ad=3.75e-14 as=3.75e-14 pd=1.15u ps=1.15u nrd=0.662935 nrs=0.662935 sa=75.0n sb=75.0n sa1=75.0n sa2=75.0n sa3=75.0n sa4=75.0n sb1=75.0n sb2=75.0n sb3=75.0n spa=100n spa1=100n spa2=100n spa3=100n sap=91.9776n sapb=114.444n spba=115.715n spba1=117.043n dfm_flag=0 spmt=1.11111e+15 spomt=0 spomt1=1.11111e+60 spmb=1.11111e+15 spomb=0 spomb1=1.11111e+60
M0555 (XDUT__XCTRL__XBIT2__XSTORE__RN XDUT__SAMPLE_INT VDD! VDD!) pch_mac l=30n w=1u multi=1 nf=1 sd=100n ad=7.5e-14 as=7.5e-14 pd=2.15u ps=2.15u nrd=0.165806 nrs=0.165806 sa=75.0n sb=75.0n sa1=75.0n sa2=75.0n sa3=75.0n sa4=75.0n sb1=75.0n sb2=75.0n sb3=75.0n spa=100n spa1=100n spa2=100n spa3=100n sap=91.9776n sapb=114.444n spba=115.715n spba1=117.043n dfm_flag=0 spmt=1.11111e+15 spomt=0 spomt1=1.11111e+60 spmb=1.11111e+15 spomb=0 spomb1=1.11111e+60
M0556 (XDUT__XCTRL__XBIT2__XSTORE__RN XDUT__SAMPLE_INT 0 0) nch_mac l=30n w=500n multi=1 nf=1 sd=100n ad=3.75e-14 as=3.75e-14 pd=1.15u ps=1.15u nrd=0.662935 nrs=0.662935 sa=75.0n sb=75.0n sa1=75.0n sa2=75.0n sa3=75.0n sa4=75.0n sb1=75.0n sb2=75.0n sb3=75.0n spa=100n spa1=100n spa2=100n spa3=100n sap=91.9776n sapb=114.444n spba=115.715n spba1=117.043n dfm_flag=0 spmt=1.11111e+15 spomt=0 spomt1=1.11111e+60 spmb=1.11111e+15 spomb=0 spomb1=1.11111e+60
M0557 (XDUT__XCTRL__XBIT3__XSTORE__RN XDUT__SAMPLE_INT VDD! VDD!) pch_mac l=30n w=1u multi=1 nf=1 sd=100n ad=7.5e-14 as=7.5e-14 pd=2.15u ps=2.15u nrd=0.165806 nrs=0.165806 sa=75.0n sb=75.0n sa1=75.0n sa2=75.0n sa3=75.0n sa4=75.0n sb1=75.0n sb2=75.0n sb3=75.0n spa=100n spa1=100n spa2=100n spa3=100n sap=91.9776n sapb=114.444n spba=115.715n spba1=117.043n dfm_flag=0 spmt=1.11111e+15 spomt=0 spomt1=1.11111e+60 spmb=1.11111e+15 spomb=0 spomb1=1.11111e+60
M0558 (XDUT__XCTRL__XBIT3__XSTORE__RN XDUT__SAMPLE_INT 0 0) nch_mac l=30n w=500n multi=1 nf=1 sd=100n ad=3.75e-14 as=3.75e-14 pd=1.15u ps=1.15u nrd=0.662935 nrs=0.662935 sa=75.0n sb=75.0n sa1=75.0n sa2=75.0n sa3=75.0n sa4=75.0n sb1=75.0n sb2=75.0n sb3=75.0n spa=100n spa1=100n spa2=100n spa3=100n sap=91.9776n sapb=114.444n spba=115.715n spba1=117.043n dfm_flag=0 spmt=1.11111e+15 spomt=0 spomt1=1.11111e+60 spmb=1.11111e+15 spomb=0 spomb1=1.11111e+60
M0559 (XDUT__XCTRL__XBIT4__XSTORE__RN XDUT__SAMPLE_INT VDD! VDD!) pch_mac l=30n w=1u multi=1 nf=1 sd=100n ad=7.5e-14 as=7.5e-14 pd=2.15u ps=2.15u nrd=0.165806 nrs=0.165806 sa=75.0n sb=75.0n sa1=75.0n sa2=75.0n sa3=75.0n sa4=75.0n sb1=75.0n sb2=75.0n sb3=75.0n spa=100n spa1=100n spa2=100n spa3=100n sap=91.9776n sapb=114.444n spba=115.715n spba1=117.043n dfm_flag=0 spmt=1.11111e+15 spomt=0 spomt1=1.11111e+60 spmb=1.11111e+15 spomb=0 spomb1=1.11111e+60
M0560 (XDUT__XCTRL__XBIT4__XSTORE__RN XDUT__SAMPLE_INT 0 0) nch_mac l=30n w=500n multi=1 nf=1 sd=100n ad=3.75e-14 as=3.75e-14 pd=1.15u ps=1.15u nrd=0.662935 nrs=0.662935 sa=75.0n sb=75.0n sa1=75.0n sa2=75.0n sa3=75.0n sa4=75.0n sb1=75.0n sb2=75.0n sb3=75.0n spa=100n spa1=100n spa2=100n spa3=100n sap=91.9776n sapb=114.444n spba=115.715n spba1=117.043n dfm_flag=0 spmt=1.11111e+15 spomt=0 spomt1=1.11111e+60 spmb=1.11111e+15 spomb=0 spomb1=1.11111e+60
M0561 (XDUT__XCTRL__XBIT5__XSTORE__RN XDUT__SAMPLE_INT VDD! VDD!) pch_mac l=30n w=1u multi=1 nf=1 sd=100n ad=7.5e-14 as=7.5e-14 pd=2.15u ps=2.15u nrd=0.165806 nrs=0.165806 sa=75.0n sb=75.0n sa1=75.0n sa2=75.0n sa3=75.0n sa4=75.0n sb1=75.0n sb2=75.0n sb3=75.0n spa=100n spa1=100n spa2=100n spa3=100n sap=91.9776n sapb=114.444n spba=115.715n spba1=117.043n dfm_flag=0 spmt=1.11111e+15 spomt=0 spomt1=1.11111e+60 spmb=1.11111e+15 spomb=0 spomb1=1.11111e+60
M0562 (XDUT__XCTRL__XBIT5__XSTORE__RN XDUT__SAMPLE_INT 0 0) nch_mac l=30n w=500n multi=1 nf=1 sd=100n ad=3.75e-14 as=3.75e-14 pd=1.15u ps=1.15u nrd=0.662935 nrs=0.662935 sa=75.0n sb=75.0n sa1=75.0n sa2=75.0n sa3=75.0n sa4=75.0n sb1=75.0n sb2=75.0n sb3=75.0n spa=100n spa1=100n spa2=100n spa3=100n sap=91.9776n sapb=114.444n spba=115.715n spba1=117.043n dfm_flag=0 spmt=1.11111e+15 spomt=0 spomt1=1.11111e+60 spmb=1.11111e+15 spomb=0 spomb1=1.11111e+60
M0563 (XDUT__XCTRL__XBIT6__XSTORE__RN XDUT__SAMPLE_INT VDD! VDD!) pch_mac l=30n w=1u multi=1 nf=1 sd=100n ad=7.5e-14 as=7.5e-14 pd=2.15u ps=2.15u nrd=0.165806 nrs=0.165806 sa=75.0n sb=75.0n sa1=75.0n sa2=75.0n sa3=75.0n sa4=75.0n sb1=75.0n sb2=75.0n sb3=75.0n spa=100n spa1=100n spa2=100n spa3=100n sap=91.9776n sapb=114.444n spba=115.715n spba1=117.043n dfm_flag=0 spmt=1.11111e+15 spomt=0 spomt1=1.11111e+60 spmb=1.11111e+15 spomb=0 spomb1=1.11111e+60
M0564 (XDUT__XCTRL__XBIT6__XSTORE__RN XDUT__SAMPLE_INT 0 0) nch_mac l=30n w=500n multi=1 nf=1 sd=100n ad=3.75e-14 as=3.75e-14 pd=1.15u ps=1.15u nrd=0.662935 nrs=0.662935 sa=75.0n sb=75.0n sa1=75.0n sa2=75.0n sa3=75.0n sa4=75.0n sb1=75.0n sb2=75.0n sb3=75.0n spa=100n spa1=100n spa2=100n spa3=100n sap=91.9776n sapb=114.444n spba=115.715n spba1=117.043n dfm_flag=0 spmt=1.11111e+15 spomt=0 spomt1=1.11111e+60 spmb=1.11111e+15 spomb=0 spomb1=1.11111e+60
M0565 (XDUT__XCTRL__XBIT7__XSTORE__RN XDUT__SAMPLE_INT VDD! VDD!) pch_mac l=30n w=1u multi=1 nf=1 sd=100n ad=7.5e-14 as=7.5e-14 pd=2.15u ps=2.15u nrd=0.165806 nrs=0.165806 sa=75.0n sb=75.0n sa1=75.0n sa2=75.0n sa3=75.0n sa4=75.0n sb1=75.0n sb2=75.0n sb3=75.0n spa=100n spa1=100n spa2=100n spa3=100n sap=91.9776n sapb=114.444n spba=115.715n spba1=117.043n dfm_flag=0 spmt=1.11111e+15 spomt=0 spomt1=1.11111e+60 spmb=1.11111e+15 spomb=0 spomb1=1.11111e+60
M0566 (XDUT__XCTRL__XBIT7__XSTORE__RN XDUT__SAMPLE_INT 0 0) nch_mac l=30n w=500n multi=1 nf=1 sd=100n ad=3.75e-14 as=3.75e-14 pd=1.15u ps=1.15u nrd=0.662935 nrs=0.662935 sa=75.0n sb=75.0n sa1=75.0n sa2=75.0n sa3=75.0n sa4=75.0n sb1=75.0n sb2=75.0n sb3=75.0n spa=100n spa1=100n spa2=100n spa3=100n sap=91.9776n sapb=114.444n spba=115.715n spba1=117.043n dfm_flag=0 spmt=1.11111e+15 spomt=0 spomt1=1.11111e+60 spmb=1.11111e+15 spomb=0 spomb1=1.11111e+60
M0567 (XDUT__XCTRL__XSEQ__XF0__RN XDUT__SAMPLE_INT VDD! VDD!) pch_mac l=30n w=1u multi=1 nf=1 sd=100n ad=7.5e-14 as=7.5e-14 pd=2.15u ps=2.15u nrd=0.165806 nrs=0.165806 sa=75.0n sb=75.0n sa1=75.0n sa2=75.0n sa3=75.0n sa4=75.0n sb1=75.0n sb2=75.0n sb3=75.0n spa=100n spa1=100n spa2=100n spa3=100n sap=91.9776n sapb=114.444n spba=115.715n spba1=117.043n dfm_flag=0 spmt=1.11111e+15 spomt=0 spomt1=1.11111e+60 spmb=1.11111e+15 spomb=0 spomb1=1.11111e+60
M0568 (XDUT__XCTRL__XSEQ__XF0__RN XDUT__SAMPLE_INT 0 0) nch_mac l=30n w=500n multi=1 nf=1 sd=100n ad=3.75e-14 as=3.75e-14 pd=1.15u ps=1.15u nrd=0.662935 nrs=0.662935 sa=75.0n sb=75.0n sa1=75.0n sa2=75.0n sa3=75.0n sa4=75.0n sb1=75.0n sb2=75.0n sb3=75.0n spa=100n spa1=100n spa2=100n spa3=100n sap=91.9776n sapb=114.444n spba=115.715n spba1=117.043n dfm_flag=0 spmt=1.11111e+15 spomt=0 spomt1=1.11111e+60 spmb=1.11111e+15 spomb=0 spomb1=1.11111e+60
M0569 (XDUT__XCTRL__XSEQ__XF1__RN XDUT__SAMPLE_INT VDD! VDD!) pch_mac l=30n w=1u multi=1 nf=1 sd=100n ad=7.5e-14 as=7.5e-14 pd=2.15u ps=2.15u nrd=0.165806 nrs=0.165806 sa=75.0n sb=75.0n sa1=75.0n sa2=75.0n sa3=75.0n sa4=75.0n sb1=75.0n sb2=75.0n sb3=75.0n spa=100n spa1=100n spa2=100n spa3=100n sap=91.9776n sapb=114.444n spba=115.715n spba1=117.043n dfm_flag=0 spmt=1.11111e+15 spomt=0 spomt1=1.11111e+60 spmb=1.11111e+15 spomb=0 spomb1=1.11111e+60
M0570 (XDUT__XCTRL__XSEQ__XF1__RN XDUT__SAMPLE_INT 0 0) nch_mac l=30n w=500n multi=1 nf=1 sd=100n ad=3.75e-14 as=3.75e-14 pd=1.15u ps=1.15u nrd=0.662935 nrs=0.662935 sa=75.0n sb=75.0n sa1=75.0n sa2=75.0n sa3=75.0n sa4=75.0n sb1=75.0n sb2=75.0n sb3=75.0n spa=100n spa1=100n spa2=100n spa3=100n sap=91.9776n sapb=114.444n spba=115.715n spba1=117.043n dfm_flag=0 spmt=1.11111e+15 spomt=0 spomt1=1.11111e+60 spmb=1.11111e+15 spomb=0 spomb1=1.11111e+60
M0571 (XDUT__XCTRL__XSEQ__XF2__RN XDUT__SAMPLE_INT VDD! VDD!) pch_mac l=30n w=1u multi=1 nf=1 sd=100n ad=7.5e-14 as=7.5e-14 pd=2.15u ps=2.15u nrd=0.165806 nrs=0.165806 sa=75.0n sb=75.0n sa1=75.0n sa2=75.0n sa3=75.0n sa4=75.0n sb1=75.0n sb2=75.0n sb3=75.0n spa=100n spa1=100n spa2=100n spa3=100n sap=91.9776n sapb=114.444n spba=115.715n spba1=117.043n dfm_flag=0 spmt=1.11111e+15 spomt=0 spomt1=1.11111e+60 spmb=1.11111e+15 spomb=0 spomb1=1.11111e+60
M0572 (XDUT__XCTRL__XSEQ__XF2__RN XDUT__SAMPLE_INT 0 0) nch_mac l=30n w=500n multi=1 nf=1 sd=100n ad=3.75e-14 as=3.75e-14 pd=1.15u ps=1.15u nrd=0.662935 nrs=0.662935 sa=75.0n sb=75.0n sa1=75.0n sa2=75.0n sa3=75.0n sa4=75.0n sb1=75.0n sb2=75.0n sb3=75.0n spa=100n spa1=100n spa2=100n spa3=100n sap=91.9776n sapb=114.444n spba=115.715n spba1=117.043n dfm_flag=0 spmt=1.11111e+15 spomt=0 spomt1=1.11111e+60 spmb=1.11111e+15 spomb=0 spomb1=1.11111e+60
M0573 (XDUT__XCTRL__XSEQ__XF3__RN XDUT__SAMPLE_INT VDD! VDD!) pch_mac l=30n w=1u multi=1 nf=1 sd=100n ad=7.5e-14 as=7.5e-14 pd=2.15u ps=2.15u nrd=0.165806 nrs=0.165806 sa=75.0n sb=75.0n sa1=75.0n sa2=75.0n sa3=75.0n sa4=75.0n sb1=75.0n sb2=75.0n sb3=75.0n spa=100n spa1=100n spa2=100n spa3=100n sap=91.9776n sapb=114.444n spba=115.715n spba1=117.043n dfm_flag=0 spmt=1.11111e+15 spomt=0 spomt1=1.11111e+60 spmb=1.11111e+15 spomb=0 spomb1=1.11111e+60
M0574 (XDUT__XCTRL__XSEQ__XF3__RN XDUT__SAMPLE_INT 0 0) nch_mac l=30n w=500n multi=1 nf=1 sd=100n ad=3.75e-14 as=3.75e-14 pd=1.15u ps=1.15u nrd=0.662935 nrs=0.662935 sa=75.0n sb=75.0n sa1=75.0n sa2=75.0n sa3=75.0n sa4=75.0n sb1=75.0n sb2=75.0n sb3=75.0n spa=100n spa1=100n spa2=100n spa3=100n sap=91.9776n sapb=114.444n spba=115.715n spba1=117.043n dfm_flag=0 spmt=1.11111e+15 spomt=0 spomt1=1.11111e+60 spmb=1.11111e+15 spomb=0 spomb1=1.11111e+60
M0575 (XDUT__XCTRL__XSEQ__XF4__RN XDUT__SAMPLE_INT VDD! VDD!) pch_mac l=30n w=1u multi=1 nf=1 sd=100n ad=7.5e-14 as=7.5e-14 pd=2.15u ps=2.15u nrd=0.165806 nrs=0.165806 sa=75.0n sb=75.0n sa1=75.0n sa2=75.0n sa3=75.0n sa4=75.0n sb1=75.0n sb2=75.0n sb3=75.0n spa=100n spa1=100n spa2=100n spa3=100n sap=91.9776n sapb=114.444n spba=115.715n spba1=117.043n dfm_flag=0 spmt=1.11111e+15 spomt=0 spomt1=1.11111e+60 spmb=1.11111e+15 spomb=0 spomb1=1.11111e+60
M0576 (XDUT__XCTRL__XSEQ__XF4__RN XDUT__SAMPLE_INT 0 0) nch_mac l=30n w=500n multi=1 nf=1 sd=100n ad=3.75e-14 as=3.75e-14 pd=1.15u ps=1.15u nrd=0.662935 nrs=0.662935 sa=75.0n sb=75.0n sa1=75.0n sa2=75.0n sa3=75.0n sa4=75.0n sb1=75.0n sb2=75.0n sb3=75.0n spa=100n spa1=100n spa2=100n spa3=100n sap=91.9776n sapb=114.444n spba=115.715n spba1=117.043n dfm_flag=0 spmt=1.11111e+15 spomt=0 spomt1=1.11111e+60 spmb=1.11111e+15 spomb=0 spomb1=1.11111e+60
M0577 (XDUT__XCTRL__XSEQ__XF5__RN XDUT__SAMPLE_INT VDD! VDD!) pch_mac l=30n w=1u multi=1 nf=1 sd=100n ad=7.5e-14 as=7.5e-14 pd=2.15u ps=2.15u nrd=0.165806 nrs=0.165806 sa=75.0n sb=75.0n sa1=75.0n sa2=75.0n sa3=75.0n sa4=75.0n sb1=75.0n sb2=75.0n sb3=75.0n spa=100n spa1=100n spa2=100n spa3=100n sap=91.9776n sapb=114.444n spba=115.715n spba1=117.043n dfm_flag=0 spmt=1.11111e+15 spomt=0 spomt1=1.11111e+60 spmb=1.11111e+15 spomb=0 spomb1=1.11111e+60
M0578 (XDUT__XCTRL__XSEQ__XF5__RN XDUT__SAMPLE_INT 0 0) nch_mac l=30n w=500n multi=1 nf=1 sd=100n ad=3.75e-14 as=3.75e-14 pd=1.15u ps=1.15u nrd=0.662935 nrs=0.662935 sa=75.0n sb=75.0n sa1=75.0n sa2=75.0n sa3=75.0n sa4=75.0n sb1=75.0n sb2=75.0n sb3=75.0n spa=100n spa1=100n spa2=100n spa3=100n sap=91.9776n sapb=114.444n spba=115.715n spba1=117.043n dfm_flag=0 spmt=1.11111e+15 spomt=0 spomt1=1.11111e+60 spmb=1.11111e+15 spomb=0 spomb1=1.11111e+60
M0579 (XDUT__XCTRL__XSEQ__XF6__RN XDUT__SAMPLE_INT VDD! VDD!) pch_mac l=30n w=1u multi=1 nf=1 sd=100n ad=7.5e-14 as=7.5e-14 pd=2.15u ps=2.15u nrd=0.165806 nrs=0.165806 sa=75.0n sb=75.0n sa1=75.0n sa2=75.0n sa3=75.0n sa4=75.0n sb1=75.0n sb2=75.0n sb3=75.0n spa=100n spa1=100n spa2=100n spa3=100n sap=91.9776n sapb=114.444n spba=115.715n spba1=117.043n dfm_flag=0 spmt=1.11111e+15 spomt=0 spomt1=1.11111e+60 spmb=1.11111e+15 spomb=0 spomb1=1.11111e+60
M0580 (XDUT__XCTRL__XSEQ__XF6__RN XDUT__SAMPLE_INT 0 0) nch_mac l=30n w=500n multi=1 nf=1 sd=100n ad=3.75e-14 as=3.75e-14 pd=1.15u ps=1.15u nrd=0.662935 nrs=0.662935 sa=75.0n sb=75.0n sa1=75.0n sa2=75.0n sa3=75.0n sa4=75.0n sb1=75.0n sb2=75.0n sb3=75.0n spa=100n spa1=100n spa2=100n spa3=100n sap=91.9776n sapb=114.444n spba=115.715n spba1=117.043n dfm_flag=0 spmt=1.11111e+15 spomt=0 spomt1=1.11111e+60 spmb=1.11111e+15 spomb=0 spomb1=1.11111e+60
M0581 (XDUT__XCTRL__XSEQ__XF7__RN XDUT__SAMPLE_INT VDD! VDD!) pch_mac l=30n w=1u multi=1 nf=1 sd=100n ad=7.5e-14 as=7.5e-14 pd=2.15u ps=2.15u nrd=0.165806 nrs=0.165806 sa=75.0n sb=75.0n sa1=75.0n sa2=75.0n sa3=75.0n sa4=75.0n sb1=75.0n sb2=75.0n sb3=75.0n spa=100n spa1=100n spa2=100n spa3=100n sap=91.9776n sapb=114.444n spba=115.715n spba1=117.043n dfm_flag=0 spmt=1.11111e+15 spomt=0 spomt1=1.11111e+60 spmb=1.11111e+15 spomb=0 spomb1=1.11111e+60
M0582 (XDUT__XCTRL__XSEQ__XF7__RN XDUT__SAMPLE_INT 0 0) nch_mac l=30n w=500n multi=1 nf=1 sd=100n ad=3.75e-14 as=3.75e-14 pd=1.15u ps=1.15u nrd=0.662935 nrs=0.662935 sa=75.0n sb=75.0n sa1=75.0n sa2=75.0n sa3=75.0n sa4=75.0n sb1=75.0n sb2=75.0n sb3=75.0n spa=100n spa1=100n spa2=100n spa3=100n sap=91.9776n sapb=114.444n spba=115.715n spba1=117.043n dfm_flag=0 spmt=1.11111e+15 spomt=0 spomt1=1.11111e+60 spmb=1.11111e+15 spomb=0 spomb1=1.11111e+60
M0583 (XDUT__XCTRL__XTIM__SN XDUT__SAMPLE_INT VDD! VDD!) pch_mac l=30n w=1u multi=1 nf=1 sd=100n ad=7.5e-14 as=7.5e-14 pd=2.15u ps=2.15u nrd=0.165806 nrs=0.165806 sa=75.0n sb=75.0n sa1=75.0n sa2=75.0n sa3=75.0n sa4=75.0n sb1=75.0n sb2=75.0n sb3=75.0n spa=100n spa1=100n spa2=100n spa3=100n sap=91.9776n sapb=114.444n spba=115.715n spba1=117.043n dfm_flag=0 spmt=1.11111e+15 spomt=0 spomt1=1.11111e+60 spmb=1.11111e+15 spomb=0 spomb1=1.11111e+60
M0584 (XDUT__XCTRL__XTIM__SN XDUT__SAMPLE_INT 0 0) nch_mac l=30n w=500n multi=1 nf=1 sd=100n ad=3.75e-14 as=3.75e-14 pd=1.15u ps=1.15u nrd=0.662935 nrs=0.662935 sa=75.0n sb=75.0n sa1=75.0n sa2=75.0n sa3=75.0n sa4=75.0n sb1=75.0n sb2=75.0n sb3=75.0n spa=100n spa1=100n spa2=100n spa3=100n sap=91.9776n sapb=114.444n spba=115.715n spba1=117.043n dfm_flag=0 spmt=1.11111e+15 spomt=0 spomt1=1.11111e+60 spmb=1.11111e+15 spomb=0 spomb1=1.11111e+60
M0585 (XDUT__XCTRL__XTIM__X023__AB XDUT__SAMPLE_INT VDD! VDD!) pch_mac l=30n w=1u multi=1 nf=1 sd=100n ad=7.5e-14 as=7.5e-14 pd=2.15u ps=2.15u nrd=0.165806 nrs=0.165806 sa=75.0n sb=75.0n sa1=75.0n sa2=75.0n sa3=75.0n sa4=75.0n sb1=75.0n sb2=75.0n sb3=75.0n spa=100n spa1=100n spa2=100n spa3=100n sap=91.9776n sapb=114.444n spba=115.715n spba1=117.043n dfm_flag=0 spmt=1.11111e+15 spomt=0 spomt1=1.11111e+60 spmb=1.11111e+15 spomb=0 spomb1=1.11111e+60
M0586 (XDUT__XCTRL__XTIM__X023__AB XDUT__SAMPLE_INT 0 0) nch_mac l=30n w=500n multi=1 nf=1 sd=100n ad=3.75e-14 as=3.75e-14 pd=1.15u ps=1.15u nrd=0.662935 nrs=0.662935 sa=75.0n sb=75.0n sa1=75.0n sa2=75.0n sa3=75.0n sa4=75.0n sb1=75.0n sb2=75.0n sb3=75.0n spa=100n spa1=100n spa2=100n spa3=100n sap=91.9776n sapb=114.444n spba=115.715n spba1=117.043n dfm_flag=0 spmt=1.11111e+15 spomt=0 spomt1=1.11111e+60 spmb=1.11111e+15 spomb=0 spomb1=1.11111e+60
M0587 (XDUT__XIDLE__XP__AB XDUT__SAMPLE_INT VDD! VDD!) pch_mac l=30n w=1u multi=1 nf=1 sd=100n ad=7.5e-14 as=7.5e-14 pd=2.15u ps=2.15u nrd=0.165806 nrs=0.165806 sa=75.0n sb=75.0n sa1=75.0n sa2=75.0n sa3=75.0n sa4=75.0n sb1=75.0n sb2=75.0n sb3=75.0n spa=100n spa1=100n spa2=100n spa3=100n sap=91.9776n sapb=114.444n spba=115.715n spba1=117.043n dfm_flag=0 spmt=1.11111e+15 spomt=0 spomt1=1.11111e+60 spmb=1.11111e+15 spomb=0 spomb1=1.11111e+60
M0588 (XDUT__XIDLE__XP__AB XDUT__SAMPLE_INT 0 0) nch_mac l=30n w=500n multi=1 nf=1 sd=100n ad=3.75e-14 as=3.75e-14 pd=1.15u ps=1.15u nrd=0.662935 nrs=0.662935 sa=75.0n sb=75.0n sa1=75.0n sa2=75.0n sa3=75.0n sa4=75.0n sb1=75.0n sb2=75.0n sb3=75.0n spa=100n spa1=100n spa2=100n spa3=100n sap=91.9776n sapb=114.444n spba=115.715n spba1=117.043n dfm_flag=0 spmt=1.11111e+15 spomt=0 spomt1=1.11111e+60 spmb=1.11111e+15 spomb=0 spomb1=1.11111e+60
M0589 (XDUT__XREF__X003__AB XDUT__SAMPLE_INT VDD! VDD!) pch_mac l=30n w=1u multi=1 nf=1 sd=100n ad=7.5e-14 as=7.5e-14 pd=2.15u ps=2.15u nrd=0.165806 nrs=0.165806 sa=75.0n sb=75.0n sa1=75.0n sa2=75.0n sa3=75.0n sa4=75.0n sb1=75.0n sb2=75.0n sb3=75.0n spa=100n spa1=100n spa2=100n spa3=100n sap=91.9776n sapb=114.444n spba=115.715n spba1=117.043n dfm_flag=0 spmt=1.11111e+15 spomt=0 spomt1=1.11111e+60 spmb=1.11111e+15 spomb=0 spomb1=1.11111e+60
M0590 (XDUT__XREF__X003__AB XDUT__SAMPLE_INT 0 0) nch_mac l=30n w=500n multi=1 nf=1 sd=100n ad=3.75e-14 as=3.75e-14 pd=1.15u ps=1.15u nrd=0.662935 nrs=0.662935 sa=75.0n sb=75.0n sa1=75.0n sa2=75.0n sa3=75.0n sa4=75.0n sb1=75.0n sb2=75.0n sb3=75.0n spa=100n spa1=100n spa2=100n spa3=100n sap=91.9776n sapb=114.444n spba=115.715n spba1=117.043n dfm_flag=0 spmt=1.11111e+15 spomt=0 spomt1=1.11111e+60 spmb=1.11111e+15 spomb=0 spomb1=1.11111e+60
ends sampling_compact
