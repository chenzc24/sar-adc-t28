// Independent logic cell characterization; not a SAR conversion.
simulator lang=spectre
global 0 VDD!
parameters SUP=0.99
include "/home/process/tsmc28n/PDK_mmWave/iPDK_CRN28HPC+ULL_v1.8_2p2a_20190531/tsmcN28/../models/spectre/crn28ull_1d8_elk_v1d8_2p2_shrink0d9_embedded_usage.scs" section=pre_simu
include "/home/process/tsmc28n/PDK_mmWave/iPDK_CRN28HPC+ULL_v1.8_2p2a_20190531/tsmcN28/../models/spectre/crn28ull_1d8_elk_v1d8_2p2_shrink0d9_embedded_usage.scs" section=noise_worst
include "/home/process/tsmc28n/PDK_mmWave/iPDK_CRN28HPC+ULL_v1.8_2p2a_20190531/tsmcN28/../models/spectre/crn28ull_1d8_elk_v1d8_2p2_shrink0d9_embedded_usage.scs" section=ffmacro_mos_moscap
include "/home/process/tsmc28n/PDK_mmWave/iPDK_CRN28HPC+ULL_v1.8_2p2a_20190531/tsmcN28/../models/spectre/crn28ull_1d8_elk_v1d8_2p2_shrink0d9_embedded_usage.scs" section=tt_res_bip_dio_disres
include "/home/process/tsmc28n/PDK_mmWave/iPDK_CRN28HPC+ULL_v1.8_2p2a_20190531/tsmcN28/../models/spectre/crn28ull_1d8_elk_v1d8_2p2_shrink0d9_embedded_usage.scs" section=tt_mom
include "/home/process/tsmc28n/PDK_mmWave/iPDK_CRN28HPC+ULL_v1.8_2p2a_20190531/tsmcN28/../models/spectre/crn28ull_1d8_elk_v1d8_2p2_shrink0d9_embedded_usage.scs" section=tt_ind_jvar
include "/home/process/tsmc28n/PDK_mmWave/iPDK_CRN28HPC+ULL_v1.8_2p2a_20190531/tsmcN28/../models/spectre/crn28ull_1d8_elk_v1d8_2p2_shrink0d9_embedded_usage.scs" section=tt_r_metal
simulator lang=spice
.include "/home/process/tsmc28n/STD_CELL/tcbn28hpcplusbwp12t30p140_190a/tcbn28hpcplusbwp12t30p140_170a_spi/TSMCHOME/digital/Back_End/spice/tcbn28hpcplusbwp12t30p140_170a/tcbn28hpcplusbwp12t30p140_170a.spi"
simulator lang=spectre
include "dut.scs"
XDUT (CODE SAMPLE CMP_CLK VINN VINP VREFN VREFP VDD! 0) sar8_realpre_unit
VVDD (VDD! 0) vsource dc=0.99
VSAMPLE (SAMPLE 0) vsource type=pulse val0=SUP val1=0 delay=41n rise=100p fall=100p width=59.9n period=100n
VCODE (CODE 0) vsource type=pwl wave=[0 0 4.2995000000000002e-08 0 4.3005e-08 0.98999999999999999 4.7995000000000001e-08 0.98999999999999999 4.8004999999999999e-08 0 5.2000000000000002e-08 0]
VCMP (CMP_CLK 0) vsource dc=0
VVINN (VINN_SRC 0) vsource type=pwl wave=[0n 0.045 100.2n 0.045 100.3n 0.855 200.2n 0.855 200.3n 0.45 300.2n 0.45 300.3n 0.44912109375 400.2n 0.44912109375 400.3n 0.45087890625 500.2n 0.45087890625 500.3n 0.3884765625]
VVINP (VINP_SRC 0) vsource type=pwl wave=[0n 0.855 100.2n 0.855 100.3n 0.045 200.2n 0.045 200.3n 0.45 300.2n 0.45 300.3n 0.45087890625 400.2n 0.45087890625 400.3n 0.44912109375 500.2n 0.44912109375 500.3n 0.5115234375]
VREFLOW (VREFN_SRC 0) vsource dc=0 type=dc
VREFHIGH (VREFP_SRC 0) vsource dc=0.9 type=dc
RREFN (VREFN_SRC VREFN) resistor r=50
RREFP (VREFP_SRC VREFP) resistor r=50
RINN (VINN_SRC VINN) resistor r=50
RINP (VINP_SRC VINP) resistor r=50
CREFN (VREFN 0) capacitor c=4p
CREFP (VREFP 0) capacitor c=4p
simulatorOptions options temp=-40 tnom=27 method=gear2only reltol=1e-6 vabstol=1e-8 iabstol=1e-13 gmin=1e-12
saveOptions options save=selected currents=selected subcktiprobes=no useprobes=no
tran_cell tran stop=52n maxstep=10p errpreset=conservative
save CMP_CLK
save CODE
save CREFN:1
save CREFP:1
save RINN:1
save RINN:2
save RINP:1
save RINP:2
save RREFN:1
save RREFN:2
save RREFP:1
save RREFP:2
save SAMPLE
save VCMP:1
save VCODE:1
save VDD!
save VINN
save VINN_SRC
save VINP
save VINP_SRC
save VREFHIGH:1
save VREFLOW:1
save VREFN
save VREFN_SRC
save VREFP
save VREFP_SRC
save VSAMPLE:1
save VVDD:1
save VVINN:1
save VVINP:1
save XDUT.CL_CMP_CLK:1
save XDUT.CL_CMP_CLK:2
save XDUT.CL_COMP_N:1
save XDUT.CL_COMP_N:2
save XDUT.CL_COMP_P:1
save XDUT.CL_COMP_P:2
save XDUT.COMP_N
save XDUT.COMP_P
save XDUT.GNN0
save XDUT.GNNA
save XDUT.GNNAN:1
save XDUT.GNNAN:2
save XDUT.GNNAN:3
save XDUT.GNNAN:4
save XDUT.GNNAP:1
save XDUT.GNNAP:2
save XDUT.GNNAP:3
save XDUT.GNNAP:4
save XDUT.GNNB
save XDUT.GNNBN:1
save XDUT.GNNBN:2
save XDUT.GNNBN:3
save XDUT.GNNBN:4
save XDUT.GNNBP:1
save XDUT.GNNBP:2
save XDUT.GNNBP:3
save XDUT.GNNBP:4
save XDUT.GNNCN:1
save XDUT.GNNCN:2
save XDUT.GNNCN:3
save XDUT.GNNCN:4
save XDUT.GNNCP:1
save XDUT.GNNCP:2
save XDUT.GNNCP:3
save XDUT.GNNCP:4
save XDUT.GNNDRV
save XDUT.GNNRG
save XDUT.GNP0
save XDUT.GNPA
save XDUT.GNPB
save XDUT.GNPDRV
save XDUT.GNPRG
save XDUT.GPN0
save XDUT.GPNA
save XDUT.GPNB
save XDUT.GPNDRV
save XDUT.GPNPRE
save XDUT.GPNRG
save XDUT.GPP0
save XDUT.GPPDRV
save XDUT.GPPIN:1
save XDUT.GPPIN:2
save XDUT.GPPIN:3
save XDUT.GPPIN:4
save XDUT.GPPIP:1
save XDUT.GPPIP:2
save XDUT.GPPIP:3
save XDUT.GPPIP:4
save XDUT.GPPRG
save XDUT.H0
save XDUT.L0
save XDUT.PRE
save XDUT.RGNN0:1
save XDUT.RGNN0:2
save XDUT.RGNN0_1__dmy0
save XDUT.RGNN0_2__dmy0
save XDUT.RGNN0_2__dmy0:1
save XDUT.RGNN0_2__dmy0:2
save XDUT.RGNN0_3__dmy0
save XDUT.RGNN0_3__dmy0:1
save XDUT.RGNN0_3__dmy0:2
save XDUT.RGNN0_4__dmy0
save XDUT.RGNN0_4__dmy0:1
save XDUT.RGNN0_4__dmy0:2
save XDUT.RGNN0_5__dmy0:1
save XDUT.RGNN0_5__dmy0:2
save XDUT.RGNN1:1
save XDUT.RGNN1:2
save XDUT.RGNN1_1__dmy0
save XDUT.RGNN1_2__dmy0
save XDUT.RGNN1_2__dmy0:1
save XDUT.RGNN1_2__dmy0:2
save XDUT.RGNN1_3__dmy0
save XDUT.RGNN1_3__dmy0:1
save XDUT.RGNN1_3__dmy0:2
save XDUT.RGNN1_4__dmy0
save XDUT.RGNN1_4__dmy0:1
save XDUT.RGNN1_4__dmy0:2
save XDUT.RGNN1_5__dmy0:1
save XDUT.RGNN1_5__dmy0:2
save XDUT.RGNP0:1
save XDUT.RGNP0:2
save XDUT.RGNP0_1__dmy0
save XDUT.RGNP0_2__dmy0
save XDUT.RGNP0_2__dmy0:1
save XDUT.RGNP0_2__dmy0:2
save XDUT.RGNP0_3__dmy0
save XDUT.RGNP0_3__dmy0:1
save XDUT.RGNP0_3__dmy0:2
save XDUT.RGNP0_4__dmy0
save XDUT.RGNP0_4__dmy0:1
save XDUT.RGNP0_4__dmy0:2
save XDUT.RGNP0_5__dmy0:1
save XDUT.RGNP0_5__dmy0:2
save XDUT.RGNP1:1
save XDUT.RGNP1:2
save XDUT.RGNP1_1__dmy0
save XDUT.RGNP1_2__dmy0
save XDUT.RGNP1_2__dmy0:1
save XDUT.RGNP1_2__dmy0:2
save XDUT.RGNP1_3__dmy0
save XDUT.RGNP1_3__dmy0:1
save XDUT.RGNP1_3__dmy0:2
save XDUT.RGNP1_4__dmy0
save XDUT.RGNP1_4__dmy0:1
save XDUT.RGNP1_4__dmy0:2
save XDUT.RGNP1_5__dmy0:1
save XDUT.RGNP1_5__dmy0:2
save XDUT.RGPN0:1
save XDUT.RGPN0:2
save XDUT.RGPN0_1__dmy0
save XDUT.RGPN0_2__dmy0
save XDUT.RGPN0_2__dmy0:1
save XDUT.RGPN0_2__dmy0:2
save XDUT.RGPN0_3__dmy0
save XDUT.RGPN0_3__dmy0:1
save XDUT.RGPN0_3__dmy0:2
save XDUT.RGPN0_4__dmy0
save XDUT.RGPN0_4__dmy0:1
save XDUT.RGPN0_4__dmy0:2
save XDUT.RGPN0_5__dmy0:1
save XDUT.RGPN0_5__dmy0:2
save XDUT.RGPN1:1
save XDUT.RGPN1:2
save XDUT.RGPN1_1__dmy0
save XDUT.RGPN1_2__dmy0
save XDUT.RGPN1_2__dmy0:1
save XDUT.RGPN1_2__dmy0:2
save XDUT.RGPN1_3__dmy0
save XDUT.RGPN1_3__dmy0:1
save XDUT.RGPN1_3__dmy0:2
save XDUT.RGPN1_4__dmy0
save XDUT.RGPN1_4__dmy0:1
save XDUT.RGPN1_4__dmy0:2
save XDUT.RGPN1_5__dmy0:1
save XDUT.RGPN1_5__dmy0:2
save XDUT.RGPP0:1
save XDUT.RGPP0:2
save XDUT.RGPP0_1__dmy0
save XDUT.RGPP0_2__dmy0
save XDUT.RGPP0_2__dmy0:1
save XDUT.RGPP0_2__dmy0:2
save XDUT.RGPP0_3__dmy0
save XDUT.RGPP0_3__dmy0:1
save XDUT.RGPP0_3__dmy0:2
save XDUT.RGPP0_4__dmy0
save XDUT.RGPP0_4__dmy0:1
save XDUT.RGPP0_4__dmy0:2
save XDUT.RGPP0_5__dmy0:1
save XDUT.RGPP0_5__dmy0:2
save XDUT.RGPP1:1
save XDUT.RGPP1:2
save XDUT.RGPP1_1__dmy0
save XDUT.RGPP1_2__dmy0
save XDUT.RGPP1_2__dmy0:1
save XDUT.RGPP1_2__dmy0:2
save XDUT.RGPP1_3__dmy0
save XDUT.RGPP1_3__dmy0:1
save XDUT.RGPP1_3__dmy0:2
save XDUT.RGPP1_4__dmy0
save XDUT.RGPP1_4__dmy0:1
save XDUT.RGPP1_4__dmy0:2
save XDUT.RGPP1_5__dmy0:1
save XDUT.RGPP1_5__dmy0:2
save XDUT.TOPN
save XDUT.TOPP
save XDUT.X008.XLIB.MM0:1
save XDUT.X008.XLIB.MM0:2
save XDUT.X008.XLIB.MM0:3
save XDUT.X008.XLIB.MM0:4
save XDUT.X008.XLIB.MM1:1
save XDUT.X008.XLIB.MM1:2
save XDUT.X008.XLIB.MM1:3
save XDUT.X008.XLIB.MM1:4
save XDUT.X025.XLIB.MM0:1
save XDUT.X025.XLIB.MM0:2
save XDUT.X025.XLIB.MM0:3
save XDUT.X025.XLIB.MM0:4
save XDUT.X025.XLIB.MM1:1
save XDUT.X025.XLIB.MM1:2
save XDUT.X025.XLIB.MM1:3
save XDUT.X025.XLIB.MM1:4
save XDUT.XBBM0.CB
save XDUT.XBBM0.HD
save XDUT.XBBM0.LD
save XDUT.XBBM0.X000.XLIB.MM0:1
save XDUT.XBBM0.X000.XLIB.MM0:2
save XDUT.XBBM0.X000.XLIB.MM0:3
save XDUT.XBBM0.X000.XLIB.MM0:4
save XDUT.XBBM0.X000.XLIB.MM1:1
save XDUT.XBBM0.X000.XLIB.MM1:2
save XDUT.XBBM0.X000.XLIB.MM1:3
save XDUT.XBBM0.X000.XLIB.MM1:4
save XDUT.XBBM0.X002.N
save XDUT.XBBM0.X002.X000.XLIB.MM1:1
save XDUT.XBBM0.X002.X000.XLIB.MM1:2
save XDUT.XBBM0.X002.X000.XLIB.MM1:3
save XDUT.XBBM0.X002.X000.XLIB.MM1:4
save XDUT.XBBM0.X002.X000.XLIB.MM2:1
save XDUT.XBBM0.X002.X000.XLIB.MM2:2
save XDUT.XBBM0.X002.X000.XLIB.MM2:3
save XDUT.XBBM0.X002.X000.XLIB.MM2:4
save XDUT.XBBM0.X002.X000.XLIB.MM4:1
save XDUT.XBBM0.X002.X000.XLIB.MM4:2
save XDUT.XBBM0.X002.X000.XLIB.MM4:3
save XDUT.XBBM0.X002.X000.XLIB.MM4:4
save XDUT.XBBM0.X002.X000.XLIB.MM9:1
save XDUT.XBBM0.X002.X000.XLIB.MM9:2
save XDUT.XBBM0.X002.X000.XLIB.MM9:3
save XDUT.XBBM0.X002.X000.XLIB.MM9:4
save XDUT.XBBM0.X002.X000.XLIB.net10
save XDUT.XBBM0.X002.X001.XLIB.MM0:1
save XDUT.XBBM0.X002.X001.XLIB.MM0:2
save XDUT.XBBM0.X002.X001.XLIB.MM0:3
save XDUT.XBBM0.X002.X001.XLIB.MM0:4
save XDUT.XBBM0.X002.X001.XLIB.MM1:1
save XDUT.XBBM0.X002.X001.XLIB.MM1:2
save XDUT.XBBM0.X002.X001.XLIB.MM1:3
save XDUT.XBBM0.X002.X001.XLIB.MM1:4
save XDUT.XBBM0.X004.N
save XDUT.XBBM0.X004.X000.XLIB.MM1:1
save XDUT.XBBM0.X004.X000.XLIB.MM1:2
save XDUT.XBBM0.X004.X000.XLIB.MM1:3
save XDUT.XBBM0.X004.X000.XLIB.MM1:4
save XDUT.XBBM0.X004.X000.XLIB.MM2:1
save XDUT.XBBM0.X004.X000.XLIB.MM2:2
save XDUT.XBBM0.X004.X000.XLIB.MM2:3
save XDUT.XBBM0.X004.X000.XLIB.MM2:4
save XDUT.XBBM0.X004.X000.XLIB.MM4:1
save XDUT.XBBM0.X004.X000.XLIB.MM4:2
save XDUT.XBBM0.X004.X000.XLIB.MM4:3
save XDUT.XBBM0.X004.X000.XLIB.MM4:4
save XDUT.XBBM0.X004.X000.XLIB.MM9:1
save XDUT.XBBM0.X004.X000.XLIB.MM9:2
save XDUT.XBBM0.X004.X000.XLIB.MM9:3
save XDUT.XBBM0.X004.X000.XLIB.MM9:4
save XDUT.XBBM0.X004.X000.XLIB.net10
save XDUT.XBBM0.X004.X001.XLIB.MM0:1
save XDUT.XBBM0.X004.X001.XLIB.MM0:2
save XDUT.XBBM0.X004.X001.XLIB.MM0:3
save XDUT.XBBM0.X004.X001.XLIB.MM0:4
save XDUT.XBBM0.X004.X001.XLIB.MM1:1
save XDUT.XBBM0.X004.X001.XLIB.MM1:2
save XDUT.XBBM0.X004.X001.XLIB.MM1:3
save XDUT.XBBM0.X004.X001.XLIB.MM1:4
save XDUT.XBBM0.XD_HD.AB
save XDUT.XBBM0.XD_HD.B
save XDUT.XBBM0.XD_HD.C0:1
save XDUT.XBBM0.XD_HD.C0:2
save XDUT.XBBM0.XD_HD.C1:1
save XDUT.XBBM0.XD_HD.C1:2
save XDUT.XBBM0.XD_HD.CLEAR_G
save XDUT.XBBM0.XD_HD.C_GUARD:1
save XDUT.XBBM0.XD_HD.C_GUARD:2
save XDUT.XBBM0.XD_HD.GUARD_DN
save XDUT.XBBM0.XD_HD.GUARD_UP
save XDUT.XBBM0.XD_HD.HD_RAW
save XDUT.XBBM0.XD_HD.MN_CLEAR:1
save XDUT.XBBM0.XD_HD.MN_CLEAR:2
save XDUT.XBBM0.XD_HD.MN_CLEAR:3
save XDUT.XBBM0.XD_HD.MN_CLEAR:4
save XDUT.XBBM0.XD_HD.MP_CLEAR:1
save XDUT.XBBM0.XD_HD.MP_CLEAR:2
save XDUT.XBBM0.XD_HD.MP_CLEAR:3
save XDUT.XBBM0.XD_HD.MP_CLEAR:4
save XDUT.XBBM0.XD_HD.R0:1
save XDUT.XBBM0.XD_HD.R0:2
save XDUT.XBBM0.XD_HD.R1:1
save XDUT.XBBM0.XD_HD.R1:2
save XDUT.XBBM0.XD_HD.RC0
save XDUT.XBBM0.XD_HD.RC1
save XDUT.XBBM0.XD_HD.R_CLEAR_GATE:1
save XDUT.XBBM0.XD_HD.R_CLEAR_GATE:2
save XDUT.XBBM0.XD_HD.R_GDN0:1
save XDUT.XBBM0.XD_HD.R_GDN0:2
save XDUT.XBBM0.XD_HD.R_GDN1:1
save XDUT.XBBM0.XD_HD.R_GDN1:2
save XDUT.XBBM0.XD_HD.R_GUARD:1
save XDUT.XBBM0.XD_HD.R_GUARD:2
save XDUT.XBBM0.XD_HD.R_GUP0:1
save XDUT.XBBM0.XD_HD.R_GUP0:2
save XDUT.XBBM0.XD_HD.R_GUP1:1
save XDUT.XBBM0.XD_HD.R_GUP1:2
save XDUT.XBBM0.XD_HD.X002.XLIB.MM0:1
save XDUT.XBBM0.XD_HD.X002.XLIB.MM0:2
save XDUT.XBBM0.XD_HD.X002.XLIB.MM0:3
save XDUT.XBBM0.XD_HD.X002.XLIB.MM0:4
save XDUT.XBBM0.XD_HD.X002.XLIB.MM1:1
save XDUT.XBBM0.XD_HD.X002.XLIB.MM1:2
save XDUT.XBBM0.XD_HD.X002.XLIB.MM1:3
save XDUT.XBBM0.XD_HD.X002.XLIB.MM1:4
save XDUT.XBBM0.XD_HD.X005.MN_IO:1
save XDUT.XBBM0.XD_HD.X005.MN_IO:2
save XDUT.XBBM0.XD_HD.X005.MN_IO:3
save XDUT.XBBM0.XD_HD.X005.MN_IO:4
save XDUT.XBBM0.XD_HD.X005.MP_IO:1
save XDUT.XBBM0.XD_HD.X005.MP_IO:2
save XDUT.XBBM0.XD_HD.X005.MP_IO:3
save XDUT.XBBM0.XD_HD.X005.MP_IO:4
save XDUT.XBBM0.XD_HD.X006.XLIB.MM0:1
save XDUT.XBBM0.XD_HD.X006.XLIB.MM0:2
save XDUT.XBBM0.XD_HD.X006.XLIB.MM0:3
save XDUT.XBBM0.XD_HD.X006.XLIB.MM0:4
save XDUT.XBBM0.XD_HD.X006.XLIB.MM1:1
save XDUT.XBBM0.XD_HD.X006.XLIB.MM1:2
save XDUT.XBBM0.XD_HD.X006.XLIB.MM1:3
save XDUT.XBBM0.XD_HD.X006.XLIB.MM1:4
save XDUT.XBBM0.XD_LD.AB
save XDUT.XBBM0.XD_LD.B
save XDUT.XBBM0.XD_LD.C0:1
save XDUT.XBBM0.XD_LD.C0:2
save XDUT.XBBM0.XD_LD.C1:1
save XDUT.XBBM0.XD_LD.C1:2
save XDUT.XBBM0.XD_LD.MN_CLEAR:1
save XDUT.XBBM0.XD_LD.MN_CLEAR:2
save XDUT.XBBM0.XD_LD.MN_CLEAR:3
save XDUT.XBBM0.XD_LD.MN_CLEAR:4
save XDUT.XBBM0.XD_LD.MP_CLEAR:1
save XDUT.XBBM0.XD_LD.MP_CLEAR:2
save XDUT.XBBM0.XD_LD.MP_CLEAR:3
save XDUT.XBBM0.XD_LD.MP_CLEAR:4
save XDUT.XBBM0.XD_LD.R0:1
save XDUT.XBBM0.XD_LD.R0:2
save XDUT.XBBM0.XD_LD.R1:1
save XDUT.XBBM0.XD_LD.R1:2
save XDUT.XBBM0.XD_LD.RC0
save XDUT.XBBM0.XD_LD.RC1
save XDUT.XBBM0.XD_LD.X002.XLIB.MM0:1
save XDUT.XBBM0.XD_LD.X002.XLIB.MM0:2
save XDUT.XBBM0.XD_LD.X002.XLIB.MM0:3
save XDUT.XBBM0.XD_LD.X002.XLIB.MM0:4
save XDUT.XBBM0.XD_LD.X002.XLIB.MM1:1
save XDUT.XBBM0.XD_LD.X002.XLIB.MM1:2
save XDUT.XBBM0.XD_LD.X002.XLIB.MM1:3
save XDUT.XBBM0.XD_LD.X002.XLIB.MM1:4
save XDUT.XBBM0.XD_LD.X005.XLIB.MM0:1
save XDUT.XBBM0.XD_LD.X005.XLIB.MM0:2
save XDUT.XBBM0.XD_LD.X005.XLIB.MM0:3
save XDUT.XBBM0.XD_LD.X005.XLIB.MM0:4
save XDUT.XBBM0.XD_LD.X005.XLIB.MM1:1
save XDUT.XBBM0.XD_LD.X005.XLIB.MM1:2
save XDUT.XBBM0.XD_LD.X005.XLIB.MM1:3
save XDUT.XBBM0.XD_LD.X005.XLIB.MM1:4
save XDUT.XBBM0.XD_LD.X006.XLIB.MM0:1
save XDUT.XBBM0.XD_LD.X006.XLIB.MM0:2
save XDUT.XBBM0.XD_LD.X006.XLIB.MM0:3
save XDUT.XBBM0.XD_LD.X006.XLIB.MM0:4
save XDUT.XBBM0.XD_LD.X006.XLIB.MM1:1
save XDUT.XBBM0.XD_LD.X006.XLIB.MM1:2
save XDUT.XBBM0.XD_LD.X006.XLIB.MM1:3
save XDUT.XBBM0.XD_LD.X006.XLIB.MM1:4
save XDUT.XBOOTN.BBOT
save XDUT.XBOOTN.BTOP
save XDUT.XBOOTN.CLKSB
save XDUT.XBOOTN.CTRL
save XDUT.XBOOTN.Cboot:1
save XDUT.XBOOTN.Cboot:2
save XDUT.XBOOTN.G
save XDUT.XBOOTN.GRESET
save XDUT.XBOOTN.M2:1
save XDUT.XBOOTN.M2:2
save XDUT.XBOOTN.M2:3
save XDUT.XBOOTN.M2:4
save XDUT.XBOOTN.M4:1
save XDUT.XBOOTN.M4:2
save XDUT.XBOOTN.M4:3
save XDUT.XBOOTN.M4:4
save XDUT.XBOOTN.M4A:1
save XDUT.XBOOTN.M4A:2
save XDUT.XBOOTN.M4A:3
save XDUT.XBOOTN.M4A:4
save XDUT.XBOOTN.M4B:1
save XDUT.XBOOTN.M4B:2
save XDUT.XBOOTN.M4B:3
save XDUT.XBOOTN.M4B:4
save XDUT.XBOOTN.M4C:1
save XDUT.XBOOTN.M4C:2
save XDUT.XBOOTN.M4C:3
save XDUT.XBOOTN.M4C:4
save XDUT.XBOOTN.M8:1
save XDUT.XBOOTN.M8:2
save XDUT.XBOOTN.M8:3
save XDUT.XBOOTN.M8:4
save XDUT.XBOOTN.MNCLK:1
save XDUT.XBOOTN.MNCLK:2
save XDUT.XBOOTN.MNCLK:3
save XDUT.XBOOTN.MNCLK:4
save XDUT.XBOOTN.MPCLK:1
save XDUT.XBOOTN.MPCLK:2
save XDUT.XBOOTN.MPCLK:3
save XDUT.XBOOTN.MPCLK:4
save XDUT.XBOOTN.MRSTG:1
save XDUT.XBOOTN.MRSTG:2
save XDUT.XBOOTN.MRSTG:3
save XDUT.XBOOTN.MRSTG:4
save XDUT.XBOOTN.Maux:1
save XDUT.XBOOTN.Maux:2
save XDUT.XBOOTN.Maux:3
save XDUT.XBOOTN.Maux:4
save XDUT.XBOOTN.Mmain:1
save XDUT.XBOOTN.Mmain:2
save XDUT.XBOOTN.Mmain:3
save XDUT.XBOOTN.Mmain:4
save XDUT.XBOOTN.Mmain_U1:1
save XDUT.XBOOTN.Mmain_U1:2
save XDUT.XBOOTN.Mmain_U1:3
save XDUT.XBOOTN.Mmain_U1:4
save XDUT.XBOOTN.Msin:1
save XDUT.XBOOTN.Msin:2
save XDUT.XBOOTN.Msin:3
save XDUT.XBOOTN.Msin:4
save XDUT.XBOOTP.BBOT
save XDUT.XBOOTP.BTOP
save XDUT.XBOOTP.CLKSB
save XDUT.XBOOTP.CTRL
save XDUT.XBOOTP.Cboot:1
save XDUT.XBOOTP.Cboot:2
save XDUT.XBOOTP.G
save XDUT.XBOOTP.GRESET
save XDUT.XBOOTP.M2:1
save XDUT.XBOOTP.M2:2
save XDUT.XBOOTP.M2:3
save XDUT.XBOOTP.M2:4
save XDUT.XBOOTP.M4:1
save XDUT.XBOOTP.M4:2
save XDUT.XBOOTP.M4:3
save XDUT.XBOOTP.M4:4
save XDUT.XBOOTP.M4A:1
save XDUT.XBOOTP.M4A:2
save XDUT.XBOOTP.M4A:3
save XDUT.XBOOTP.M4A:4
save XDUT.XBOOTP.M4B:1
save XDUT.XBOOTP.M4B:2
save XDUT.XBOOTP.M4B:3
save XDUT.XBOOTP.M4B:4
save XDUT.XBOOTP.M4C:1
save XDUT.XBOOTP.M4C:2
save XDUT.XBOOTP.M4C:3
save XDUT.XBOOTP.M4C:4
save XDUT.XBOOTP.M8:1
save XDUT.XBOOTP.M8:2
save XDUT.XBOOTP.M8:3
save XDUT.XBOOTP.M8:4
save XDUT.XBOOTP.MNCLK:1
save XDUT.XBOOTP.MNCLK:2
save XDUT.XBOOTP.MNCLK:3
save XDUT.XBOOTP.MNCLK:4
save XDUT.XBOOTP.MPCLK:1
save XDUT.XBOOTP.MPCLK:2
save XDUT.XBOOTP.MPCLK:3
save XDUT.XBOOTP.MPCLK:4
save XDUT.XBOOTP.MRSTG:1
save XDUT.XBOOTP.MRSTG:2
save XDUT.XBOOTP.MRSTG:3
save XDUT.XBOOTP.MRSTG:4
save XDUT.XBOOTP.Maux:1
save XDUT.XBOOTP.Maux:2
save XDUT.XBOOTP.Maux:3
save XDUT.XBOOTP.Maux:4
save XDUT.XBOOTP.Mmain:1
save XDUT.XBOOTP.Mmain:2
save XDUT.XBOOTP.Mmain:3
save XDUT.XBOOTP.Mmain:4
save XDUT.XBOOTP.Mmain_U1:1
save XDUT.XBOOTP.Mmain_U1:2
save XDUT.XBOOTP.Mmain_U1:3
save XDUT.XBOOTP.Mmain_U1:4
save XDUT.XBOOTP.Msin:1
save XDUT.XBOOTP.Msin:2
save XDUT.XBOOTP.Msin:3
save XDUT.XBOOTP.Msin:4
save XDUT.XCDAC.BN0
save XDUT.XCDAC.BN1
save XDUT.XCDAC.BN2
save XDUT.XCDAC.BN3
save XDUT.XCDAC.BN4
save XDUT.XCDAC.BN5
save XDUT.XCDAC.BN6
save XDUT.XCDAC.BN7
save XDUT.XCDAC.BP0
save XDUT.XCDAC.BP1
save XDUT.XCDAC.BP2
save XDUT.XCDAC.BP3
save XDUT.XCDAC.BP4
save XDUT.XCDAC.BP5
save XDUT.XCDAC.BP6
save XDUT.XCDAC.BP7
save XDUT.XCDAC.CMOMN0:1
save XDUT.XCDAC.CMOMN0:2
save XDUT.XCDAC.CMOMN1:1
save XDUT.XCDAC.CMOMN1:2
save XDUT.XCDAC.CMOMN2:1
save XDUT.XCDAC.CMOMN2:2
save XDUT.XCDAC.CMOMN3:1
save XDUT.XCDAC.CMOMN3:2
save XDUT.XCDAC.CMOMN4:1
save XDUT.XCDAC.CMOMN4:2
save XDUT.XCDAC.CMOMN5:1
save XDUT.XCDAC.CMOMN5:2
save XDUT.XCDAC.CMOMN6:1
save XDUT.XCDAC.CMOMN6:2
save XDUT.XCDAC.CMOMN7:1
save XDUT.XCDAC.CMOMN7:2
save XDUT.XCDAC.CMOMN8:1
save XDUT.XCDAC.CMOMN8:2
save XDUT.XCDAC.CMOMP0:1
save XDUT.XCDAC.CMOMP0:2
save XDUT.XCDAC.CMOMP1:1
save XDUT.XCDAC.CMOMP1:2
save XDUT.XCDAC.CMOMP2:1
save XDUT.XCDAC.CMOMP2:2
save XDUT.XCDAC.CMOMP3:1
save XDUT.XCDAC.CMOMP3:2
save XDUT.XCDAC.CMOMP4:1
save XDUT.XCDAC.CMOMP4:2
save XDUT.XCDAC.CMOMP5:1
save XDUT.XCDAC.CMOMP5:2
save XDUT.XCDAC.CMOMP6:1
save XDUT.XCDAC.CMOMP6:2
save XDUT.XCDAC.CMOMP7:1
save XDUT.XCDAC.CMOMP7:2
save XDUT.XCDAC.CMOMP8:1
save XDUT.XCDAC.CMOMP8:2
save XDUT.XCDAC.XSN0.MN_LOW:1
save XDUT.XCDAC.XSN0.MN_LOW:2
save XDUT.XCDAC.XSN0.MN_LOW:3
save XDUT.XCDAC.XSN0.MN_LOW:4
save XDUT.XCDAC.XSN0.MP_HIGH:1
save XDUT.XCDAC.XSN0.MP_HIGH:2
save XDUT.XCDAC.XSN0.MP_HIGH:3
save XDUT.XCDAC.XSN0.MP_HIGH:4
save XDUT.XCDAC.XSN1.MN_LOW:1
save XDUT.XCDAC.XSN1.MN_LOW:2
save XDUT.XCDAC.XSN1.MN_LOW:3
save XDUT.XCDAC.XSN1.MN_LOW:4
save XDUT.XCDAC.XSN1.MP_HIGH:1
save XDUT.XCDAC.XSN1.MP_HIGH:2
save XDUT.XCDAC.XSN1.MP_HIGH:3
save XDUT.XCDAC.XSN1.MP_HIGH:4
save XDUT.XCDAC.XSN2.MN_LOW:1
save XDUT.XCDAC.XSN2.MN_LOW:2
save XDUT.XCDAC.XSN2.MN_LOW:3
save XDUT.XCDAC.XSN2.MN_LOW:4
save XDUT.XCDAC.XSN2.MP_HIGH:1
save XDUT.XCDAC.XSN2.MP_HIGH:2
save XDUT.XCDAC.XSN2.MP_HIGH:3
save XDUT.XCDAC.XSN2.MP_HIGH:4
save XDUT.XCDAC.XSN3.MN_LOW:1
save XDUT.XCDAC.XSN3.MN_LOW:2
save XDUT.XCDAC.XSN3.MN_LOW:3
save XDUT.XCDAC.XSN3.MN_LOW:4
save XDUT.XCDAC.XSN3.MP_HIGH:1
save XDUT.XCDAC.XSN3.MP_HIGH:2
save XDUT.XCDAC.XSN3.MP_HIGH:3
save XDUT.XCDAC.XSN3.MP_HIGH:4
save XDUT.XCDAC.XSN4.MN_LOW:1
save XDUT.XCDAC.XSN4.MN_LOW:2
save XDUT.XCDAC.XSN4.MN_LOW:3
save XDUT.XCDAC.XSN4.MN_LOW:4
save XDUT.XCDAC.XSN4.MP_HIGH:1
save XDUT.XCDAC.XSN4.MP_HIGH:2
save XDUT.XCDAC.XSN4.MP_HIGH:3
save XDUT.XCDAC.XSN4.MP_HIGH:4
save XDUT.XCDAC.XSN5.MN_LOW:1
save XDUT.XCDAC.XSN5.MN_LOW:2
save XDUT.XCDAC.XSN5.MN_LOW:3
save XDUT.XCDAC.XSN5.MN_LOW:4
save XDUT.XCDAC.XSN5.MP_HIGH:1
save XDUT.XCDAC.XSN5.MP_HIGH:2
save XDUT.XCDAC.XSN5.MP_HIGH:3
save XDUT.XCDAC.XSN5.MP_HIGH:4
save XDUT.XCDAC.XSN6.MN_LOW:1
save XDUT.XCDAC.XSN6.MN_LOW:2
save XDUT.XCDAC.XSN6.MN_LOW:3
save XDUT.XCDAC.XSN6.MN_LOW:4
save XDUT.XCDAC.XSN6.MP_HIGH:1
save XDUT.XCDAC.XSN6.MP_HIGH:2
save XDUT.XCDAC.XSN6.MP_HIGH:3
save XDUT.XCDAC.XSN6.MP_HIGH:4
save XDUT.XCDAC.XSN7.MN_LOW:1
save XDUT.XCDAC.XSN7.MN_LOW:2
save XDUT.XCDAC.XSN7.MN_LOW:3
save XDUT.XCDAC.XSN7.MN_LOW:4
save XDUT.XCDAC.XSN7.MP_HIGH:1
save XDUT.XCDAC.XSN7.MP_HIGH:2
save XDUT.XCDAC.XSN7.MP_HIGH:3
save XDUT.XCDAC.XSN7.MP_HIGH:4
save XDUT.XCDAC.XSP0.MN_LOW:1
save XDUT.XCDAC.XSP0.MN_LOW:2
save XDUT.XCDAC.XSP0.MN_LOW:3
save XDUT.XCDAC.XSP0.MN_LOW:4
save XDUT.XCDAC.XSP0.MP_HIGH:1
save XDUT.XCDAC.XSP0.MP_HIGH:2
save XDUT.XCDAC.XSP0.MP_HIGH:3
save XDUT.XCDAC.XSP0.MP_HIGH:4
save XDUT.XCDAC.XSP1.MN_LOW:1
save XDUT.XCDAC.XSP1.MN_LOW:2
save XDUT.XCDAC.XSP1.MN_LOW:3
save XDUT.XCDAC.XSP1.MN_LOW:4
save XDUT.XCDAC.XSP1.MP_HIGH:1
save XDUT.XCDAC.XSP1.MP_HIGH:2
save XDUT.XCDAC.XSP1.MP_HIGH:3
save XDUT.XCDAC.XSP1.MP_HIGH:4
save XDUT.XCDAC.XSP2.MN_LOW:1
save XDUT.XCDAC.XSP2.MN_LOW:2
save XDUT.XCDAC.XSP2.MN_LOW:3
save XDUT.XCDAC.XSP2.MN_LOW:4
save XDUT.XCDAC.XSP2.MP_HIGH:1
save XDUT.XCDAC.XSP2.MP_HIGH:2
save XDUT.XCDAC.XSP2.MP_HIGH:3
save XDUT.XCDAC.XSP2.MP_HIGH:4
save XDUT.XCDAC.XSP3.MN_LOW:1
save XDUT.XCDAC.XSP3.MN_LOW:2
save XDUT.XCDAC.XSP3.MN_LOW:3
save XDUT.XCDAC.XSP3.MN_LOW:4
save XDUT.XCDAC.XSP3.MP_HIGH:1
save XDUT.XCDAC.XSP3.MP_HIGH:2
save XDUT.XCDAC.XSP3.MP_HIGH:3
save XDUT.XCDAC.XSP3.MP_HIGH:4
save XDUT.XCDAC.XSP4.MN_LOW:1
save XDUT.XCDAC.XSP4.MN_LOW:2
save XDUT.XCDAC.XSP4.MN_LOW:3
save XDUT.XCDAC.XSP4.MN_LOW:4
save XDUT.XCDAC.XSP4.MP_HIGH:1
save XDUT.XCDAC.XSP4.MP_HIGH:2
save XDUT.XCDAC.XSP4.MP_HIGH:3
save XDUT.XCDAC.XSP4.MP_HIGH:4
save XDUT.XCDAC.XSP5.MN_LOW:1
save XDUT.XCDAC.XSP5.MN_LOW:2
save XDUT.XCDAC.XSP5.MN_LOW:3
save XDUT.XCDAC.XSP5.MN_LOW:4
save XDUT.XCDAC.XSP5.MP_HIGH:1
save XDUT.XCDAC.XSP5.MP_HIGH:2
save XDUT.XCDAC.XSP5.MP_HIGH:3
save XDUT.XCDAC.XSP5.MP_HIGH:4
save XDUT.XCDAC.XSP6.MN_LOW:1
save XDUT.XCDAC.XSP6.MN_LOW:2
save XDUT.XCDAC.XSP6.MN_LOW:3
save XDUT.XCDAC.XSP6.MN_LOW:4
save XDUT.XCDAC.XSP6.MP_HIGH:1
save XDUT.XCDAC.XSP6.MP_HIGH:2
save XDUT.XCDAC.XSP6.MP_HIGH:3
save XDUT.XCDAC.XSP6.MP_HIGH:4
save XDUT.XCDAC.XSP7.MN_LOW:1
save XDUT.XCDAC.XSP7.MN_LOW:2
save XDUT.XCDAC.XSP7.MN_LOW:3
save XDUT.XCDAC.XSP7.MN_LOW:4
save XDUT.XCDAC.XSP7.MP_HIGH:1
save XDUT.XCDAC.XSP7.MP_HIGH:2
save XDUT.XCDAC.XSP7.MP_HIGH:3
save XDUT.XCDAC.XSP7.MP_HIGH:4
save XDUT.XCOMP.MNINN:1
save XDUT.XCOMP.MNINN:2
save XDUT.XCOMP.MNINN:3
save XDUT.XCOMP.MNINN:4
save XDUT.XCOMP.MNINP:1
save XDUT.XCOMP.MNINP:2
save XDUT.XCOMP.MNINP:3
save XDUT.XCOMP.MNINP:4
save XDUT.XCOMP.MNLATN:1
save XDUT.XCOMP.MNLATN:2
save XDUT.XCOMP.MNLATN:3
save XDUT.XCOMP.MNLATN:4
save XDUT.XCOMP.MNLATP:1
save XDUT.XCOMP.MNLATP:2
save XDUT.XCOMP.MNLATP:3
save XDUT.XCOMP.MNLATP:4
save XDUT.XCOMP.MNTAIL:1
save XDUT.XCOMP.MNTAIL:2
save XDUT.XCOMP.MNTAIL:3
save XDUT.XCOMP.MNTAIL:4
save XDUT.XCOMP.MPLATN:1
save XDUT.XCOMP.MPLATN:2
save XDUT.XCOMP.MPLATN:3
save XDUT.XCOMP.MPLATN:4
save XDUT.XCOMP.MPLATP:1
save XDUT.XCOMP.MPLATP:2
save XDUT.XCOMP.MPLATP:3
save XDUT.XCOMP.MPLATP:4
save XDUT.XCOMP.MPRSTN:1
save XDUT.XCOMP.MPRSTN:2
save XDUT.XCOMP.MPRSTN:3
save XDUT.XCOMP.MPRSTN:4
save XDUT.XCOMP.MPRSTP:1
save XDUT.XCOMP.MPRSTP:2
save XDUT.XCOMP.MPRSTP:3
save XDUT.XCOMP.MPRSTP:4
save XDUT.XCOMP.MPRSTX:1
save XDUT.XCOMP.MPRSTX:2
save XDUT.XCOMP.MPRSTX:3
save XDUT.XCOMP.MPRSTX:4
save XDUT.XCOMP.MPRSTY:1
save XDUT.XCOMP.MPRSTY:2
save XDUT.XCOMP.MPRSTY:3
save XDUT.XCOMP.MPRSTY:4
save XDUT.XCOMP.TAIL
save XDUT.XCOMP.X
save XDUT.XCOMP.Y
save XDUT.XSTD_GNPAN.MM0:1
save XDUT.XSTD_GNPAN.MM0:2
save XDUT.XSTD_GNPAN.MM0:3
save XDUT.XSTD_GNPAN.MM0:4
save XDUT.XSTD_GNPAN.MM1:1
save XDUT.XSTD_GNPAN.MM1:2
save XDUT.XSTD_GNPAN.MM1:3
save XDUT.XSTD_GNPAN.MM1:4
save XDUT.XSTD_GNPBN.MM0:1
save XDUT.XSTD_GNPBN.MM0:2
save XDUT.XSTD_GNPBN.MM0:3
save XDUT.XSTD_GNPBN.MM0:4
save XDUT.XSTD_GNPBN.MM1:1
save XDUT.XSTD_GNPBN.MM1:2
save XDUT.XSTD_GNPBN.MM1:3
save XDUT.XSTD_GNPBN.MM1:4
save XDUT.XSTD_GNPCN.MM0:1
save XDUT.XSTD_GNPCN.MM0:2
save XDUT.XSTD_GNPCN.MM0:3
save XDUT.XSTD_GNPCN.MM0:4
save XDUT.XSTD_GNPCN.MM1:1
save XDUT.XSTD_GNPCN.MM1:2
save XDUT.XSTD_GNPCN.MM1:3
save XDUT.XSTD_GNPCN.MM1:4
save XDUT.XSTD_GPNAN.MM0:1
save XDUT.XSTD_GPNAN.MM0:2
save XDUT.XSTD_GPNAN.MM0:3
save XDUT.XSTD_GPNAN.MM0:4
save XDUT.XSTD_GPNAN.MM1:1
save XDUT.XSTD_GPNAN.MM1:2
save XDUT.XSTD_GPNAN.MM1:3
save XDUT.XSTD_GPNAN.MM1:4
save XDUT.XSTD_GPNBN.MM0:1
save XDUT.XSTD_GPNBN.MM0:2
save XDUT.XSTD_GPNBN.MM0:3
save XDUT.XSTD_GPNBN.MM0:4
save XDUT.XSTD_GPNBN.MM1:1
save XDUT.XSTD_GPNBN.MM1:2
save XDUT.XSTD_GPNBN.MM1:3
save XDUT.XSTD_GPNBN.MM1:4
save XDUT.XSTD_GPNCN.MM0:1
save XDUT.XSTD_GPNCN.MM0:2
save XDUT.XSTD_GPNCN.MM0:3
save XDUT.XSTD_GPNCN.MM0:4
save XDUT.XSTD_GPNCN.MM1:1
save XDUT.XSTD_GPNCN.MM1:2
save XDUT.XSTD_GPNCN.MM1:3
save XDUT.XSTD_GPNCN.MM1:4
