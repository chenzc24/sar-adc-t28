subckt sar8_realpre_unit CODE SAMPLE CMP_CLK VINN VINP VREFN VREFP VDD VSS
    GNNCN (GNNDRV GNNB VSS VSS) nch_18_mac ad=4.96e-14 as=4.96e-14 l=150n nf=1 nrd=0 nrs=0 pd=950.0n ps=950.0n sa=155.00n sa1=155.00n sa2=155.00n sa3=155.00n sa4=155.00n sap=172.362n sapb=242.67n sb=155.00n sb1=155.00n sb2=155.00n sb3=155.00n sd=180n spa=180.0n spa1=180.0n spa2=180.0n spa3=180.0n spba=233.666n spba1=239.844n spmb=1.11111e15 spmt=1.11111e15 spomb=0 spomb1=1.11111e+60 spomt=0 spomt1=1.11111e+60 w=320n multi=2
    GNNBN (GNNB GNNA VSS VSS) nch_18_mac ad=4.96e-14 as=4.96e-14 l=150n nf=1 nrd=0 nrs=0 pd=950.0n ps=950.0n sa=155.00n sa1=155.00n sa2=155.00n sa3=155.00n sa4=155.00n sap=172.362n sapb=242.67n sb=155.00n sb1=155.00n sb2=155.00n sb3=155.00n sd=180n spa=180.0n spa1=180.0n spa2=180.0n spa3=180.0n spba=233.666n spba1=239.844n spmb=1.11111e15 spmt=1.11111e15 spomb=0 spomb1=1.11111e+60 spomt=0 spomt1=1.11111e+60 w=320n multi=2
    GNNAN (GNNA PRE VSS VSS) nch_18_mac ad=4.96e-14 as=4.96e-14 l=150n nf=1 nrd=0 nrs=0 pd=950.0n ps=950.0n sa=155.00n sa1=155.00n sa2=155.00n sa3=155.00n sa4=155.00n sap=172.362n sapb=242.67n sb=155.00n sb1=155.00n sb2=155.00n sb3=155.00n sd=180n spa=180.0n spa1=180.0n spa2=180.0n spa3=180.0n spba=233.666n spba1=239.844n spmb=1.11111e15 spmt=1.11111e15 spomb=0 spomb1=1.11111e+60 spomt=0 spomt1=1.11111e+60 w=320n multi=2
    GNNCP (GNNDRV GNNB VDD VDD) pch_18_mac ad=4.96e-14 as=4.96e-14 l=150n nf=1 nrd=0 nrs=0 pd=950.0n ps=950.0n sa=155.00n sa1=155.00n sa2=155.00n sa3=155.00n sa4=155.00n sap=172.362n sapb=242.67n sb=155.00n sb1=155.00n sb2=155.00n sb3=155.00n sd=180n spa=180.0n spa1=180.0n spa2=180.0n spa3=180.0n spba=233.666n spba1=239.844n spmb=1.11111e15 spmt=1.11111e15 spomb=0 spomb1=1.11111e+60 spomt=0 spomt1=1.11111e+60 w=320n multi=4
    GNNBP (GNNB GNNA VDD VDD) pch_18_mac ad=4.96e-14 as=4.96e-14 l=150n nf=1 nrd=0 nrs=0 pd=950.0n ps=950.0n sa=155.00n sa1=155.00n sa2=155.00n sa3=155.00n sa4=155.00n sap=172.362n sapb=242.67n sb=155.00n sb1=155.00n sb2=155.00n sb3=155.00n sd=180n spa=180.0n spa1=180.0n spa2=180.0n spa3=180.0n spba=233.666n spba1=239.844n spmb=1.11111e15 spmt=1.11111e15 spomb=0 spomb1=1.11111e+60 spomt=0 spomt1=1.11111e+60 w=320n multi=4
    GNNAP (GNNA PRE VDD VDD) pch_18_mac ad=4.96e-14 as=4.96e-14 l=150n nf=1 nrd=0 nrs=0 pd=950.0n ps=950.0n sa=155.00n sa1=155.00n sa2=155.00n sa3=155.00n sa4=155.00n sap=172.362n sapb=242.67n sb=155.00n sb1=155.00n sb2=155.00n sb3=155.00n sd=180n spa=180.0n spa1=180.0n spa2=180.0n spa3=180.0n spba=233.666n spba1=239.844n spmb=1.11111e15 spmt=1.11111e15 spomb=0 spomb1=1.11111e+60 spomt=0 spomt1=1.11111e+60 w=320n multi=4
    RGNN1 (GNNRG RGNN1_1__dmy0) rupolym l=17.13u w=1u m=1 multi=(1)
    RGNN1_2__dmy0 (RGNN1_1__dmy0 RGNN1_2__dmy0) rupolym l=17.13u w=1u m=1          multi=(1)
    RGNN1_3__dmy0 (RGNN1_2__dmy0 RGNN1_3__dmy0) rupolym l=17.13u w=1u m=1          multi=(1)
    RGNN1_4__dmy0 (RGNN1_3__dmy0 RGNN1_4__dmy0) rupolym l=17.13u w=1u m=1          multi=(1)
    RGNN1_5__dmy0 (RGNN1_4__dmy0 GNN0) rupolym l=17.13u w=1u m=1 multi=(1)
    RGNN0 (GNNDRV RGNN0_1__dmy0) rupolym l=17.13u w=1u m=1 multi=(1)
    RGNN0_2__dmy0 (RGNN0_1__dmy0 RGNN0_2__dmy0) rupolym l=17.13u w=1u m=1          multi=(1)
    RGNN0_3__dmy0 (RGNN0_2__dmy0 RGNN0_3__dmy0) rupolym l=17.13u w=1u m=1          multi=(1)
    RGNN0_4__dmy0 (RGNN0_3__dmy0 RGNN0_4__dmy0) rupolym l=17.13u w=1u m=1          multi=(1)
    RGNN0_5__dmy0 (RGNN0_4__dmy0 GNNRG) rupolym l=17.13u w=1u m=1 multi=(1)
    RGNP1 (GNPRG RGNP1_1__dmy0) rupolym l=17.13u w=1u m=1 multi=(1)
    RGNP1_2__dmy0 (RGNP1_1__dmy0 RGNP1_2__dmy0) rupolym l=17.13u w=1u m=1          multi=(1)
    RGNP1_3__dmy0 (RGNP1_2__dmy0 RGNP1_3__dmy0) rupolym l=17.13u w=1u m=1          multi=(1)
    RGNP1_4__dmy0 (RGNP1_3__dmy0 RGNP1_4__dmy0) rupolym l=17.13u w=1u m=1          multi=(1)
    RGNP1_5__dmy0 (RGNP1_4__dmy0 GNP0) rupolym l=17.13u w=1u m=1 multi=(1)
    RGNP0 (GNPDRV RGNP0_1__dmy0) rupolym l=17.13u w=1u m=1 multi=(1)
    RGNP0_2__dmy0 (RGNP0_1__dmy0 RGNP0_2__dmy0) rupolym l=17.13u w=1u m=1          multi=(1)
    RGNP0_3__dmy0 (RGNP0_2__dmy0 RGNP0_3__dmy0) rupolym l=17.13u w=1u m=1          multi=(1)
    RGNP0_4__dmy0 (RGNP0_3__dmy0 RGNP0_4__dmy0) rupolym l=17.13u w=1u m=1          multi=(1)
    RGNP0_5__dmy0 (RGNP0_4__dmy0 GNPRG) rupolym l=17.13u w=1u m=1 multi=(1)
    RGPN1 (GPNRG RGPN1_1__dmy0) rupolym l=17.13u w=1u m=1 multi=(1)
    RGPN1_2__dmy0 (RGPN1_1__dmy0 RGPN1_2__dmy0) rupolym l=17.13u w=1u m=1          multi=(1)
    RGPN1_3__dmy0 (RGPN1_2__dmy0 RGPN1_3__dmy0) rupolym l=17.13u w=1u m=1          multi=(1)
    RGPN1_4__dmy0 (RGPN1_3__dmy0 RGPN1_4__dmy0) rupolym l=17.13u w=1u m=1          multi=(1)
    RGPN1_5__dmy0 (RGPN1_4__dmy0 GPN0) rupolym l=17.13u w=1u m=1 multi=(1)
    RGPN0 (GPNDRV RGPN0_1__dmy0) rupolym l=17.13u w=1u m=1 multi=(1)
    RGPN0_2__dmy0 (RGPN0_1__dmy0 RGPN0_2__dmy0) rupolym l=17.13u w=1u m=1          multi=(1)
    RGPN0_3__dmy0 (RGPN0_2__dmy0 RGPN0_3__dmy0) rupolym l=17.13u w=1u m=1          multi=(1)
    RGPN0_4__dmy0 (RGPN0_3__dmy0 RGPN0_4__dmy0) rupolym l=17.13u w=1u m=1          multi=(1)
    RGPN0_5__dmy0 (RGPN0_4__dmy0 GPNRG) rupolym l=17.13u w=1u m=1 multi=(1)
    RGPP1 (GPPRG RGPP1_1__dmy0) rupolym l=17.13u w=1u m=1 multi=(1)
    RGPP1_2__dmy0 (RGPP1_1__dmy0 RGPP1_2__dmy0) rupolym l=17.13u w=1u m=1          multi=(1)
    RGPP1_3__dmy0 (RGPP1_2__dmy0 RGPP1_3__dmy0) rupolym l=17.13u w=1u m=1          multi=(1)
    RGPP1_4__dmy0 (RGPP1_3__dmy0 RGPP1_4__dmy0) rupolym l=17.13u w=1u m=1          multi=(1)
    RGPP1_5__dmy0 (RGPP1_4__dmy0 GPP0) rupolym l=17.13u w=1u m=1 multi=(1)
    RGPP0 (GPPDRV RGPP0_1__dmy0) rupolym l=17.13u w=1u m=1 multi=(1)
    RGPP0_2__dmy0 (RGPP0_1__dmy0 RGPP0_2__dmy0) rupolym l=17.13u w=1u m=1          multi=(1)
    RGPP0_3__dmy0 (RGPP0_2__dmy0 RGPP0_3__dmy0) rupolym l=17.13u w=1u m=1          multi=(1)
    RGPP0_4__dmy0 (RGPP0_3__dmy0 RGPP0_4__dmy0) rupolym l=17.13u w=1u m=1          multi=(1)
    RGPP0_5__dmy0 (RGPP0_4__dmy0 GPPRG) rupolym l=17.13u w=1u m=1 multi=(1)
    XBOOTN (SAMPLE TOPN VINN) sar_bootstrap_flat_8b_p
    XBOOTP (SAMPLE TOPP VINP) sar_bootstrap_flat_8b_p
    XCDAC (GNN0 VDD VDD VDD VDD VDD VDD VDD GNP0 VDD VDD VDD VDD VDD VDD VDD GPN0 VSS VSS VSS VSS VSS VSS VSS GPP0 VSS VSS VSS VSS VSS VSS VSS TOPN TOPP VDD VREFN VREFP VSS) sar8j_r1_cdac
    XCOMP (CMP_CLK COMP_N COMP_P VDD TOPN TOPP VSS) sar_strongarm_t28
    CL_COMP_N (COMP_N 0) cfmom_2t nr=8 lr=2.5u w=50n s=50n stm=1 spm=3  multi=2 mismatchflag=1
    CL_COMP_P (COMP_P 0) cfmom_2t nr=8 lr=2.5u w=50n s=50n stm=1 spm=3  multi=2 mismatchflag=1
    CL_CMP_CLK (CMP_CLK 0) cfmom_2t nr=8 lr=2.5u w=50n s=50n stm=1 spm=3  multi=2 mismatchflag=1
    X025 (L0 VDD VSS PRE) sar8p_inv
    GPPIN (GPPDRV L0 VSS VSS) nch_18_mac ad=4.96e-14 as=4.96e-14 l=150n nf=1 nrd=0 nrs=0 pd=950.0n ps=950.0n sa=155.00n sa1=155.00n sa2=155.00n sa3=155.00n sa4=155.00n sap=172.362n sapb=242.67n sb=155.00n sb1=155.00n sb2=155.00n sb3=155.00n sd=180n spa=180.0n spa1=180.0n spa2=180.0n spa3=180.0n spba=233.666n spba1=239.844n spmb=1.11111e15 spmt=1.11111e15 spomb=0 spomb1=1.11111e+60 spomt=0 spomt1=1.11111e+60 w=320n multi=2
    GPPIP (GPPDRV L0 VDD VDD) pch_18_mac ad=4.96e-14 as=4.96e-14 l=150n nf=1 nrd=0 nrs=0 pd=950.0n ps=950.0n sa=155.00n sa1=155.00n sa2=155.00n sa3=155.00n sa4=155.00n sap=172.362n sapb=242.67n sb=155.00n sb1=155.00n sb2=155.00n sb3=155.00n sd=180n spa=180.0n spa1=180.0n spa2=180.0n spa3=180.0n spba=233.666n spba1=239.844n spmb=1.11111e15 spmt=1.11111e15 spomb=0 spomb1=1.11111e+60 spomt=0 spomt1=1.11111e+60 w=320n multi=4
    GNPCN (GNPDRV GNPB VSS VSS) nch_mac l=30n w=500n multi=1 nf=1 sd=100n          ad=3.75e-14 as=3.75e-14 pd=1.15u ps=1.15u nrd=0.662935          nrs=0.662935 sa=75.0n sb=75.0n sa1=75.0n sa2=75.0n sa3=75.0n          sa4=75.0n sb1=75.0n sb2=75.0n sb3=75.0n spa=100n spa1=100n          spa2=100n spa3=100n sap=91.9776n sapb=114.444n spba=115.715n          spba1=117.043n dfm_flag=0 spmt=1.11111e+15 spomt=0          spomt1=1.11111e+60 spmb=1.11111e+15 spomb=0 spomb1=1.11111e+60
    GNPBN (GNPB GNPA VSS VSS) nch_mac l=30n w=500n multi=1 nf=1 sd=100n          ad=3.75e-14 as=3.75e-14 pd=1.15u ps=1.15u nrd=0.662935          nrs=0.662935 sa=75.0n sb=75.0n sa1=75.0n sa2=75.0n sa3=75.0n          sa4=75.0n sb1=75.0n sb2=75.0n sb3=75.0n spa=100n spa1=100n          spa2=100n spa3=100n sap=91.9776n sapb=114.444n spba=115.715n          spba1=117.043n dfm_flag=0 spmt=1.11111e+15 spomt=0          spomt1=1.11111e+60 spmb=1.11111e+15 spomb=0 spomb1=1.11111e+60
    GNPAN (GNPA H0 VSS VSS) nch_mac l=30n w=500n multi=1 nf=1 sd=100n          ad=3.75e-14 as=3.75e-14 pd=1.15u ps=1.15u nrd=0.662935          nrs=0.662935 sa=75.0n sb=75.0n sa1=75.0n sa2=75.0n sa3=75.0n          sa4=75.0n sb1=75.0n sb2=75.0n sb3=75.0n spa=100n spa1=100n          spa2=100n spa3=100n sap=91.9776n sapb=114.444n spba=115.715n          spba1=117.043n dfm_flag=0 spmt=1.11111e+15 spomt=0          spomt1=1.11111e+60 spmb=1.11111e+15 spomb=0 spomb1=1.11111e+60
    GPNCN (GPNDRV GPNB VSS VSS) nch_mac l=30n w=500n multi=1 nf=1 sd=100n          ad=3.75e-14 as=3.75e-14 pd=1.15u ps=1.15u nrd=0.662935          nrs=0.662935 sa=75.0n sb=75.0n sa1=75.0n sa2=75.0n sa3=75.0n          sa4=75.0n sb1=75.0n sb2=75.0n sb3=75.0n spa=100n spa1=100n          spa2=100n spa3=100n sap=91.9776n sapb=114.444n spba=115.715n          spba1=117.043n dfm_flag=0 spmt=1.11111e+15 spomt=0          spomt1=1.11111e+60 spmb=1.11111e+15 spomb=0 spomb1=1.11111e+60
    GPNBN (GPNB GPNA VSS VSS) nch_mac l=30n w=500n multi=1 nf=1 sd=100n          ad=3.75e-14 as=3.75e-14 pd=1.15u ps=1.15u nrd=0.662935          nrs=0.662935 sa=75.0n sb=75.0n sa1=75.0n sa2=75.0n sa3=75.0n          sa4=75.0n sb1=75.0n sb2=75.0n sb3=75.0n spa=100n spa1=100n          spa2=100n spa3=100n sap=91.9776n sapb=114.444n spba=115.715n          spba1=117.043n dfm_flag=0 spmt=1.11111e+15 spomt=0          spomt1=1.11111e+60 spmb=1.11111e+15 spomb=0 spomb1=1.11111e+60
    GPNAN (GPNA GPNPRE VSS VSS) nch_mac l=30n w=500n multi=1 nf=1 sd=100n          ad=3.75e-14 as=3.75e-14 pd=1.15u ps=1.15u nrd=0.662935          nrs=0.662935 sa=75.0n sb=75.0n sa1=75.0n sa2=75.0n sa3=75.0n          sa4=75.0n sb1=75.0n sb2=75.0n sb3=75.0n spa=100n spa1=100n          spa2=100n spa3=100n sap=91.9776n sapb=114.444n spba=115.715n          spba1=117.043n dfm_flag=0 spmt=1.11111e+15 spomt=0          spomt1=1.11111e+60 spmb=1.11111e+15 spomb=0 spomb1=1.11111e+60
    GNPCP (GNPDRV GNPB VDD VDD) pch_mac l=30n w=1u multi=1 nf=1 sd=100n          ad=7.5e-14 as=7.5e-14 pd=2.15u ps=2.15u nrd=0.165806 nrs=0.165806          sa=75.0n sb=75.0n sa1=75.0n sa2=75.0n sa3=75.0n sa4=75.0n          sb1=75.0n sb2=75.0n sb3=75.0n spa=100n spa1=100n spa2=100n          spa3=100n sap=91.9776n sapb=114.444n spba=115.715n spba1=117.043n          dfm_flag=0 spmt=1.11111e+15 spomt=0 spomt1=1.11111e+60          spmb=1.11111e+15 spomb=0 spomb1=1.11111e+60
    GNPBP (GNPB GNPA VDD VDD) pch_mac l=30n w=1u multi=1 nf=1 sd=100n          ad=7.5e-14 as=7.5e-14 pd=2.15u ps=2.15u nrd=0.165806 nrs=0.165806          sa=75.0n sb=75.0n sa1=75.0n sa2=75.0n sa3=75.0n sa4=75.0n          sb1=75.0n sb2=75.0n sb3=75.0n spa=100n spa1=100n spa2=100n          spa3=100n sap=91.9776n sapb=114.444n spba=115.715n spba1=117.043n          dfm_flag=0 spmt=1.11111e+15 spomt=0 spomt1=1.11111e+60          spmb=1.11111e+15 spomb=0 spomb1=1.11111e+60
    GNPAP (GNPA H0 VDD VDD) pch_mac l=30n w=1u multi=1 nf=1 sd=100n          ad=7.5e-14 as=7.5e-14 pd=2.15u ps=2.15u nrd=0.165806 nrs=0.165806          sa=75.0n sb=75.0n sa1=75.0n sa2=75.0n sa3=75.0n sa4=75.0n          sb1=75.0n sb2=75.0n sb3=75.0n spa=100n spa1=100n spa2=100n          spa3=100n sap=91.9776n sapb=114.444n spba=115.715n spba1=117.043n          dfm_flag=0 spmt=1.11111e+15 spomt=0 spomt1=1.11111e+60          spmb=1.11111e+15 spomb=0 spomb1=1.11111e+60
    GPNCP (GPNDRV GPNB VDD VDD) pch_mac l=30n w=1u multi=1 nf=1 sd=100n          ad=7.5e-14 as=7.5e-14 pd=2.15u ps=2.15u nrd=0.165806 nrs=0.165806          sa=75.0n sb=75.0n sa1=75.0n sa2=75.0n sa3=75.0n sa4=75.0n          sb1=75.0n sb2=75.0n sb3=75.0n spa=100n spa1=100n spa2=100n          spa3=100n sap=91.9776n sapb=114.444n spba=115.715n spba1=117.043n          dfm_flag=0 spmt=1.11111e+15 spomt=0 spomt1=1.11111e+60          spmb=1.11111e+15 spomb=0 spomb1=1.11111e+60
    GPNBP (GPNB GPNA VDD VDD) pch_mac l=30n w=1u multi=1 nf=1 sd=100n          ad=7.5e-14 as=7.5e-14 pd=2.15u ps=2.15u nrd=0.165806 nrs=0.165806          sa=75.0n sb=75.0n sa1=75.0n sa2=75.0n sa3=75.0n sa4=75.0n          sb1=75.0n sb2=75.0n sb3=75.0n spa=100n spa1=100n spa2=100n          spa3=100n sap=91.9776n sapb=114.444n spba=115.715n spba1=117.043n          dfm_flag=0 spmt=1.11111e+15 spomt=0 spomt1=1.11111e+60          spmb=1.11111e+15 spomb=0 spomb1=1.11111e+60
    GPNAP (GPNA GPNPRE VDD VDD) pch_mac l=30n w=1u multi=1 nf=1 sd=100n          ad=7.5e-14 as=7.5e-14 pd=2.15u ps=2.15u nrd=0.165806 nrs=0.165806          sa=75.0n sb=75.0n sa1=75.0n sa2=75.0n sa3=75.0n sa4=75.0n          sb1=75.0n sb2=75.0n sb3=75.0n spa=100n spa1=100n spa2=100n          spa3=100n sap=91.9776n sapb=114.444n spba=115.715n spba1=117.043n          dfm_flag=0 spmt=1.11111e+15 spomt=0 spomt1=1.11111e+60          spmb=1.11111e+15 spomb=0 spomb1=1.11111e+60
    X008 (H0 VDD VSS GPNPRE) sar8p_inv
    XBBM0 (CODE H0 L0 VDD VSS) sar8p_nonoverlap
ends sar8_realpre_unit

subckt sar8j_r1_cdac GNN0 GNN1 GNN2 GNN3 GNN4 GNN5 GNN6 GNN7 GNP0 GNP1 \
        GNP2 GNP3 GNP4 GNP5 GNP6 GNP7 GPN0 GPN1 GPN2 GPN3 GPN4 GPN5 GPN6 \
        GPN7 GPP0 GPP1 GPP2 GPP3 GPP4 GPP5 GPP6 GPP7 TOPN TOPP VDD VREFN \
        VREFP VSS
    CMOMN8 (TOPN VREFN) cfmom_2t nr=8 lr=2u w=50n s=50n stm=1 spm=3 \
        multi=1 mismatchflag=1
    CMOMN7 (TOPN BN7) cfmom_2t nr=8 lr=2u w=50n s=50n stm=1 spm=3 \
        multi=128 mismatchflag=1
    CMOMN6 (TOPN BN6) cfmom_2t nr=8 lr=2u w=50n s=50n stm=1 spm=3 multi=64 \
        mismatchflag=1
    CMOMN5 (TOPN BN5) cfmom_2t nr=8 lr=2u w=50n s=50n stm=1 spm=3 multi=32 \
        mismatchflag=1
    CMOMN4 (TOPN BN4) cfmom_2t nr=8 lr=2u w=50n s=50n stm=1 spm=3 multi=16 \
        mismatchflag=1
    CMOMN3 (TOPN BN3) cfmom_2t nr=8 lr=2u w=50n s=50n stm=1 spm=3 multi=8 \
        mismatchflag=1
    CMOMN2 (TOPN BN2) cfmom_2t nr=8 lr=2u w=50n s=50n stm=1 spm=3 multi=4 \
        mismatchflag=1
    CMOMN1 (TOPN BN1) cfmom_2t nr=8 lr=2u w=50n s=50n stm=1 spm=3 multi=2 \
        mismatchflag=1
    CMOMN0 (TOPN BN0) cfmom_2t nr=8 lr=2u w=50n s=50n stm=1 spm=3 multi=1 \
        mismatchflag=1
    CMOMP8 (TOPP VREFP) cfmom_2t nr=8 lr=2u w=50n s=50n stm=1 spm=3 \
        multi=1 mismatchflag=1
    CMOMP7 (TOPP BP7) cfmom_2t nr=8 lr=2u w=50n s=50n stm=1 spm=3 \
        multi=128 mismatchflag=1
    CMOMP6 (TOPP BP6) cfmom_2t nr=8 lr=2u w=50n s=50n stm=1 spm=3 multi=64 \
        mismatchflag=1
    CMOMP5 (TOPP BP5) cfmom_2t nr=8 lr=2u w=50n s=50n stm=1 spm=3 multi=32 \
        mismatchflag=1
    CMOMP4 (TOPP BP4) cfmom_2t nr=8 lr=2u w=50n s=50n stm=1 spm=3 multi=16 \
        mismatchflag=1
    CMOMP3 (TOPP BP3) cfmom_2t nr=8 lr=2u w=50n s=50n stm=1 spm=3 multi=8 \
        mismatchflag=1
    CMOMP2 (TOPP BP2) cfmom_2t nr=8 lr=2u w=50n s=50n stm=1 spm=3 multi=4 \
        mismatchflag=1
    CMOMP1 (TOPP BP1) cfmom_2t nr=8 lr=2u w=50n s=50n stm=1 spm=3 multi=2 \
        mismatchflag=1
    CMOMP0 (TOPP BP0) cfmom_2t nr=8 lr=2u w=50n s=50n stm=1 spm=3 multi=1 \
        mismatchflag=1
    XSN0 (BN0 GNN0 GNP0 VDD VREFN VREFP VSS) sar8j_r1_sw_b0
    XSP0 (BP0 GPN0 GPP0 VDD VREFN VREFP VSS) sar8j_r1_sw_b0
    XSN1 (BN1 GNN1 GNP1 VDD VREFN VREFP VSS) sar8j_r1_sw_b1
    XSP1 (BP1 GPN1 GPP1 VDD VREFN VREFP VSS) sar8j_r1_sw_b1
    XSN2 (BN2 GNN2 GNP2 VDD VREFN VREFP VSS) sar8j_r1_sw_b2
    XSP2 (BP2 GPN2 GPP2 VDD VREFN VREFP VSS) sar8j_r1_sw_b2
    XSN3 (BN3 GNN3 GNP3 VDD VREFN VREFP VSS) sar8j_r1_sw_b3
    XSP3 (BP3 GPN3 GPP3 VDD VREFN VREFP VSS) sar8j_r1_sw_b3
    XSN4 (BN4 GNN4 GNP4 VDD VREFN VREFP VSS) sar8j_r1_sw_b4
    XSP4 (BP4 GPN4 GPP4 VDD VREFN VREFP VSS) sar8j_r1_sw_b4
    XSN5 (BN5 GNN5 GNP5 VDD VREFN VREFP VSS) sar8j_r1_sw_b5
    XSP5 (BP5 GPN5 GPP5 VDD VREFN VREFP VSS) sar8j_r1_sw_b5
    XSN6 (BN6 GNN6 GNP6 VDD VREFN VREFP VSS) sar8j_r1_sw_b6
    XSP6 (BP6 GPN6 GPP6 VDD VREFN VREFP VSS) sar8j_r1_sw_b6
    XSN7 (BN7 GNN7 GNP7 VDD VREFN VREFP VSS) sar8j_r1_sw_b7
    XSP7 (BP7 GPN7 GPP7 VDD VREFN VREFP VSS) sar8j_r1_sw_b7
ends sar8j_r1_cdac

subckt sar8j_r1_sw_b0 BOT GN GP VDD VREFN VREFP VSS
    MP_HIGH (BOT GP VREFP VDD) pch_18_mac ad=4.96e-14 as=4.96e-14 l=150n nf=1 nrd=0 nrs=0 pd=950.0n ps=950.0n sa=155.00n sa1=155.00n sa2=155.00n sa3=155.00n sa4=155.00n sap=172.362n sapb=242.67n sb=155.00n sb1=155.00n sb2=155.00n sb3=155.00n sd=180n spa=180.0n spa1=180.0n spa2=180.0n spa3=180.0n spba=233.666n spba1=239.844n spmb=1.11111e15 spmt=1.11111e15 spomb=0 spomb1=1.11111e+60 spomt=0 spomt1=1.11111e+60 w=320n multi=2
    MN_LOW (BOT GN VREFN VSS) nch_18_mac ad=4.96e-14 as=4.96e-14 l=150n nf=1 nrd=0 nrs=0 pd=950.0n ps=950.0n sa=155.00n sa1=155.00n sa2=155.00n sa3=155.00n sa4=155.00n sap=172.362n sapb=242.67n sb=155.00n sb1=155.00n sb2=155.00n sb3=155.00n sd=180n spa=180.0n spa1=180.0n spa2=180.0n spa3=180.0n spba=233.666n spba1=239.844n spmb=1.11111e15 spmt=1.11111e15 spomb=0 spomb1=1.11111e+60 spomt=0 spomt1=1.11111e+60 w=320n multi=2
ends sar8j_r1_sw_b0

subckt sar8j_r1_sw_b1 BOT GN GP VDD VREFN VREFP VSS
    MP_HIGH (BOT GP VREFP VDD) pch_18_mac ad=4.96e-14 as=4.96e-14 l=150n nf=1 nrd=0 nrs=0 pd=950.0n ps=950.0n sa=155.00n sa1=155.00n sa2=155.00n sa3=155.00n sa4=155.00n sap=172.362n sapb=242.67n sb=155.00n sb1=155.00n sb2=155.00n sb3=155.00n sd=180n spa=180.0n spa1=180.0n spa2=180.0n spa3=180.0n spba=233.666n spba1=239.844n spmb=1.11111e15 spmt=1.11111e15 spomb=0 spomb1=1.11111e+60 spomt=0 spomt1=1.11111e+60 w=320n multi=4
    MN_LOW (BOT GN VREFN VSS) nch_18_mac ad=4.96e-14 as=4.96e-14 l=150n nf=1 nrd=0 nrs=0 pd=950.0n ps=950.0n sa=155.00n sa1=155.00n sa2=155.00n sa3=155.00n sa4=155.00n sap=172.362n sapb=242.67n sb=155.00n sb1=155.00n sb2=155.00n sb3=155.00n sd=180n spa=180.0n spa1=180.0n spa2=180.0n spa3=180.0n spba=233.666n spba1=239.844n spmb=1.11111e15 spmt=1.11111e15 spomb=0 spomb1=1.11111e+60 spomt=0 spomt1=1.11111e+60 w=320n multi=4
ends sar8j_r1_sw_b1

subckt sar8j_r1_sw_b2 BOT GN GP VDD VREFN VREFP VSS
    MP_HIGH (BOT GP VREFP VDD) pch_18_mac ad=4.96e-14 as=4.96e-14 l=150n nf=1 nrd=0 nrs=0 pd=950.0n ps=950.0n sa=155.00n sa1=155.00n sa2=155.00n sa3=155.00n sa4=155.00n sap=172.362n sapb=242.67n sb=155.00n sb1=155.00n sb2=155.00n sb3=155.00n sd=180n spa=180.0n spa1=180.0n spa2=180.0n spa3=180.0n spba=233.666n spba1=239.844n spmb=1.11111e15 spmt=1.11111e15 spomb=0 spomb1=1.11111e+60 spomt=0 spomt1=1.11111e+60 w=320n multi=8
    MN_LOW (BOT GN VREFN VSS) nch_18_mac ad=4.96e-14 as=4.96e-14 l=150n nf=1 nrd=0 nrs=0 pd=950.0n ps=950.0n sa=155.00n sa1=155.00n sa2=155.00n sa3=155.00n sa4=155.00n sap=172.362n sapb=242.67n sb=155.00n sb1=155.00n sb2=155.00n sb3=155.00n sd=180n spa=180.0n spa1=180.0n spa2=180.0n spa3=180.0n spba=233.666n spba1=239.844n spmb=1.11111e15 spmt=1.11111e15 spomb=0 spomb1=1.11111e+60 spomt=0 spomt1=1.11111e+60 w=320n multi=8
ends sar8j_r1_sw_b2

subckt sar8j_r1_sw_b3 BOT GN GP VDD VREFN VREFP VSS
    MP_HIGH (BOT GP VREFP VDD) pch_18_mac ad=4.96e-14 as=4.96e-14 l=150n nf=1 nrd=0 nrs=0 pd=950.0n ps=950.0n sa=155.00n sa1=155.00n sa2=155.00n sa3=155.00n sa4=155.00n sap=172.362n sapb=242.67n sb=155.00n sb1=155.00n sb2=155.00n sb3=155.00n sd=180n spa=180.0n spa1=180.0n spa2=180.0n spa3=180.0n spba=233.666n spba1=239.844n spmb=1.11111e15 spmt=1.11111e15 spomb=0 spomb1=1.11111e+60 spomt=0 spomt1=1.11111e+60 w=320n multi=16
    MN_LOW (BOT GN VREFN VSS) nch_18_mac ad=4.96e-14 as=4.96e-14 l=150n nf=1 nrd=0 nrs=0 pd=950.0n ps=950.0n sa=155.00n sa1=155.00n sa2=155.00n sa3=155.00n sa4=155.00n sap=172.362n sapb=242.67n sb=155.00n sb1=155.00n sb2=155.00n sb3=155.00n sd=180n spa=180.0n spa1=180.0n spa2=180.0n spa3=180.0n spba=233.666n spba1=239.844n spmb=1.11111e15 spmt=1.11111e15 spomb=0 spomb1=1.11111e+60 spomt=0 spomt1=1.11111e+60 w=320n multi=16
ends sar8j_r1_sw_b3

subckt sar8j_r1_sw_b4 BOT GN GP VDD VREFN VREFP VSS
    MP_HIGH (BOT GP VREFP VDD) pch_18_mac ad=4.96e-14 as=4.96e-14 l=150n nf=1 nrd=0 nrs=0 pd=950.0n ps=950.0n sa=155.00n sa1=155.00n sa2=155.00n sa3=155.00n sa4=155.00n sap=172.362n sapb=242.67n sb=155.00n sb1=155.00n sb2=155.00n sb3=155.00n sd=180n spa=180.0n spa1=180.0n spa2=180.0n spa3=180.0n spba=233.666n spba1=239.844n spmb=1.11111e15 spmt=1.11111e15 spomb=0 spomb1=1.11111e+60 spomt=0 spomt1=1.11111e+60 w=320n multi=32
    MN_LOW (BOT GN VREFN VSS) nch_18_mac ad=4.96e-14 as=4.96e-14 l=150n nf=1 nrd=0 nrs=0 pd=950.0n ps=950.0n sa=155.00n sa1=155.00n sa2=155.00n sa3=155.00n sa4=155.00n sap=172.362n sapb=242.67n sb=155.00n sb1=155.00n sb2=155.00n sb3=155.00n sd=180n spa=180.0n spa1=180.0n spa2=180.0n spa3=180.0n spba=233.666n spba1=239.844n spmb=1.11111e15 spmt=1.11111e15 spomb=0 spomb1=1.11111e+60 spomt=0 spomt1=1.11111e+60 w=320n multi=32
ends sar8j_r1_sw_b4

subckt sar8j_r1_sw_b5 BOT GN GP VDD VREFN VREFP VSS
    MP_HIGH (BOT GP VREFP VDD) pch_18_mac ad=4.96e-14 as=4.96e-14 l=150n nf=1 nrd=0 nrs=0 pd=950.0n ps=950.0n sa=155.00n sa1=155.00n sa2=155.00n sa3=155.00n sa4=155.00n sap=172.362n sapb=242.67n sb=155.00n sb1=155.00n sb2=155.00n sb3=155.00n sd=180n spa=180.0n spa1=180.0n spa2=180.0n spa3=180.0n spba=233.666n spba1=239.844n spmb=1.11111e15 spmt=1.11111e15 spomb=0 spomb1=1.11111e+60 spomt=0 spomt1=1.11111e+60 w=320n multi=64
    MN_LOW (BOT GN VREFN VSS) nch_18_mac ad=4.96e-14 as=4.96e-14 l=150n nf=1 nrd=0 nrs=0 pd=950.0n ps=950.0n sa=155.00n sa1=155.00n sa2=155.00n sa3=155.00n sa4=155.00n sap=172.362n sapb=242.67n sb=155.00n sb1=155.00n sb2=155.00n sb3=155.00n sd=180n spa=180.0n spa1=180.0n spa2=180.0n spa3=180.0n spba=233.666n spba1=239.844n spmb=1.11111e15 spmt=1.11111e15 spomb=0 spomb1=1.11111e+60 spomt=0 spomt1=1.11111e+60 w=320n multi=64
ends sar8j_r1_sw_b5

subckt sar8j_r1_sw_b6 BOT GN GP VDD VREFN VREFP VSS
    MP_HIGH (BOT GP VREFP VDD) pch_18_mac ad=4.96e-14 as=4.96e-14 l=150n nf=1 nrd=0 nrs=0 pd=950.0n ps=950.0n sa=155.00n sa1=155.00n sa2=155.00n sa3=155.00n sa4=155.00n sap=172.362n sapb=242.67n sb=155.00n sb1=155.00n sb2=155.00n sb3=155.00n sd=180n spa=180.0n spa1=180.0n spa2=180.0n spa3=180.0n spba=233.666n spba1=239.844n spmb=1.11111e15 spmt=1.11111e15 spomb=0 spomb1=1.11111e+60 spomt=0 spomt1=1.11111e+60 w=320n multi=128
    MN_LOW (BOT GN VREFN VSS) nch_18_mac ad=4.96e-14 as=4.96e-14 l=150n nf=1 nrd=0 nrs=0 pd=950.0n ps=950.0n sa=155.00n sa1=155.00n sa2=155.00n sa3=155.00n sa4=155.00n sap=172.362n sapb=242.67n sb=155.00n sb1=155.00n sb2=155.00n sb3=155.00n sd=180n spa=180.0n spa1=180.0n spa2=180.0n spa3=180.0n spba=233.666n spba1=239.844n spmb=1.11111e15 spmt=1.11111e15 spomb=0 spomb1=1.11111e+60 spomt=0 spomt1=1.11111e+60 w=320n multi=128
ends sar8j_r1_sw_b6

subckt sar8j_r1_sw_b7 BOT GN GP VDD VREFN VREFP VSS
    MP_HIGH (BOT GP VREFP VDD) pch_18_mac ad=4.96e-14 as=4.96e-14 l=150n nf=1 nrd=0 nrs=0 pd=950.0n ps=950.0n sa=155.00n sa1=155.00n sa2=155.00n sa3=155.00n sa4=155.00n sap=172.362n sapb=242.67n sb=155.00n sb1=155.00n sb2=155.00n sb3=155.00n sd=180n spa=180.0n spa1=180.0n spa2=180.0n spa3=180.0n spba=233.666n spba1=239.844n spmb=1.11111e15 spmt=1.11111e15 spomb=0 spomb1=1.11111e+60 spomt=0 spomt1=1.11111e+60 w=320n multi=256
    MN_LOW (BOT GN VREFN VSS) nch_18_mac ad=4.96e-14 as=4.96e-14 l=150n nf=1 nrd=0 nrs=0 pd=950.0n ps=950.0n sa=155.00n sa1=155.00n sa2=155.00n sa3=155.00n sa4=155.00n sap=172.362n sapb=242.67n sb=155.00n sb1=155.00n sb2=155.00n sb3=155.00n sd=180n spa=180.0n spa1=180.0n spa2=180.0n spa3=180.0n spba=233.666n spba1=239.844n spmb=1.11111e15 spmt=1.11111e15 spomb=0 spomb1=1.11111e+60 spomt=0 spomt1=1.11111e+60 w=320n multi=256
ends sar8j_r1_sw_b7

subckt sar8p_and2 A B VDD VSS Y
    X000 (A B VDD VSS N) sar8p_nand2
    X001 (N VDD VSS Y) sar8p_inv
ends sar8p_and2

subckt sar8p_delay_bbm A VDD VSS Y
R1 (B RC1 ) rupolym l=17.13u w=1u m=1 multi=(1)

R0 (A RC0 ) rupolym l=17.13u w=1u m=1 multi=(1)

    C1 (RC1 VSS) cfmom_2t nr=8 lr=2.5u w=50n s=50n stm=1 spm=3 multi=1 \
        mismatchflag=1
    C0 (RC0 VSS) cfmom_2t nr=8 lr=2.5u w=50n s=50n stm=1 spm=3 multi=1 \
        mismatchflag=1
    X006 (A VDD VSS AB) sar8p_inv
    X005 (RC1 VDD VSS Y) sar8p_inv
    X002 (RC0 VDD VSS B) sar8p_inv
    MN_CLEAR (RC0 AB VSS VSS) nch_mac l=30n w=2u multi=1 nf=1 sd=100n \
        ad=1.5e-13 as=1.5e-13 pd=4.15u ps=4.15u nrd=0.144730 nrs=0.144730 \
        sa=75.0n sb=75.0n sa1=75.0n sa2=75.0n sa3=75.0n sa4=75.0n \
        sb1=75.0n sb2=75.0n sb3=75.0n spa=100n spa1=100n spa2=100n \
        spa3=100n sap=91.9776n sapb=114.444n spba=115.715n spba1=117.043n \
        dfm_flag=0 spmt=1.11111e+15 spomt=0 spomt1=1.11111e+60 \
        spmb=1.11111e+15 spomb=0 spomb1=1.11111e+60
    MP_CLEAR (RC1 A VDD VDD) pch_mac l=30n w=3u multi=1 nf=1 sd=100n \
        ad=2.25e-13 as=2.25e-13 pd=6.15u ps=6.15u nrd=0.055246 \
        nrs=0.055246 sa=75.0n sb=75.0n sa1=75.0n sa2=75.0n sa3=75.0n \
        sa4=75.0n sb1=75.0n sb2=75.0n sb3=75.0n spa=100n spa1=100n \
        spa2=100n spa3=100n sap=91.9776n sapb=114.444n spba=115.715n \
        spba1=117.043n dfm_flag=0 spmt=1.11111e+15 spomt=0 \
        spomt1=1.11111e+60 spmb=1.11111e+15 spomb=0 spomb1=1.11111e+60
ends sar8p_delay_bbm

subckt sar8p_delay_bbm_HD_C0x4 A VDD VSS Y
    R1 (B RC1) rupolym l=17.13u w=1u m=1 multi=(1)
    R0 (A RC0) rupolym l=17.13u w=1u m=1 multi=(1)
    C1 (RC1 VSS) cfmom_2t nr=8 lr=2.5u w=50n s=50n stm=1 spm=3 multi=1          mismatchflag=1
    C0 (RC0 VSS) cfmom_2t nr=8 lr=2.5u w=50n s=50n stm=1 spm=3 multi=4          mismatchflag=1
    X006 (A VDD VSS AB) sar8p_inv
    X005 (RC1 VDD VSS Y) sar8p_inv
    X002 (RC0 VDD VSS B) sar8p_inv
    MN_CLEAR (RC0 AB VSS VSS) nch_mac l=30n w=2u multi=1 nf=1 sd=100n          ad=1.5e-13 as=1.5e-13 pd=4.15u ps=4.15u nrd=0.144730 nrs=0.144730          sa=75.0n sb=75.0n sa1=75.0n sa2=75.0n sa3=75.0n sa4=75.0n          sb1=75.0n sb2=75.0n sb3=75.0n spa=100n spa1=100n spa2=100n          spa3=100n sap=91.9776n sapb=114.444n spba=115.715n spba1=117.043n          dfm_flag=0 spmt=1.11111e+15 spomt=0 spomt1=1.11111e+60          spmb=1.11111e+15 spomb=0 spomb1=1.11111e+60
    MP_CLEAR (RC1 A VDD VDD) pch_mac l=30n w=3u multi=1 nf=1 sd=100n          ad=2.25e-13 as=2.25e-13 pd=6.15u ps=6.15u nrd=0.055246          nrs=0.055246 sa=75.0n sb=75.0n sa1=75.0n sa2=75.0n sa3=75.0n          sa4=75.0n sb1=75.0n sb2=75.0n sb3=75.0n spa=100n spa1=100n          spa2=100n spa3=100n sap=91.9776n sapb=114.444n spba=115.715n          spba1=117.043n dfm_flag=0 spmt=1.11111e+15 spomt=0          spomt1=1.11111e+60 spmb=1.11111e+15 spomb=0 spomb1=1.11111e+60
ends sar8p_delay_bbm_HD_C0x4

subckt sar8p_inv A VDD VSS Y
    MP (Y A VDD VDD) pch_mac l=30n w=1u multi=1 nf=1 sd=100n ad=7.5e-14 \
        as=7.5e-14 pd=2.15u ps=2.15u nrd=0.165806 nrs=0.165806 sa=75.0n \
        sb=75.0n sa1=75.0n sa2=75.0n sa3=75.0n sa4=75.0n sb1=75.0n \
        sb2=75.0n sb3=75.0n spa=100n spa1=100n spa2=100n spa3=100n \
        sap=91.9776n sapb=114.444n spba=115.715n spba1=117.043n dfm_flag=0 \
        spmt=1.11111e+15 spomt=0 spomt1=1.11111e+60 spmb=1.11111e+15 \
        spomb=0 spomb1=1.11111e+60
    MN (Y A VSS VSS) nch_mac l=30n w=500n multi=1 nf=1 sd=100n ad=3.75e-14 \
        as=3.75e-14 pd=1.15u ps=1.15u nrd=0.662935 nrs=0.662935 sa=75.0n \
        sb=75.0n sa1=75.0n sa2=75.0n sa3=75.0n sa4=75.0n sb1=75.0n \
        sb2=75.0n sb3=75.0n spa=100n spa1=100n spa2=100n spa3=100n \
        sap=91.9776n sapb=114.444n spba=115.715n spba1=117.043n dfm_flag=0 \
        spmt=1.11111e+15 spomt=0 spomt1=1.11111e+60 spmb=1.11111e+15 \
        spomb=0 spomb1=1.11111e+60
ends sar8p_inv

subckt sar8p_nand2 A B VDD VSS Y
    MP1 (Y B VDD VDD) pch_mac l=30n w=1u multi=1 nf=1 sd=100n ad=7.5e-14 \
        as=7.5e-14 pd=2.15u ps=2.15u nrd=0.165806 nrs=0.165806 sa=75.0n \
        sb=75.0n sa1=75.0n sa2=75.0n sa3=75.0n sa4=75.0n sb1=75.0n \
        sb2=75.0n sb3=75.0n spa=100n spa1=100n spa2=100n spa3=100n \
        sap=91.9776n sapb=114.444n spba=115.715n spba1=117.043n dfm_flag=0 \
        spmt=1.11111e+15 spomt=0 spomt1=1.11111e+60 spmb=1.11111e+15 \
        spomb=0 spomb1=1.11111e+60
    MP0 (Y A VDD VDD) pch_mac l=30n w=1u multi=1 nf=1 sd=100n ad=7.5e-14 \
        as=7.5e-14 pd=2.15u ps=2.15u nrd=0.165806 nrs=0.165806 sa=75.0n \
        sb=75.0n sa1=75.0n sa2=75.0n sa3=75.0n sa4=75.0n sb1=75.0n \
        sb2=75.0n sb3=75.0n spa=100n spa1=100n spa2=100n spa3=100n \
        sap=91.9776n sapb=114.444n spba=115.715n spba1=117.043n dfm_flag=0 \
        spmt=1.11111e+15 spomt=0 spomt1=1.11111e+60 spmb=1.11111e+15 \
        spomb=0 spomb1=1.11111e+60
    MN1 (MID B VSS VSS) nch_mac l=30n w=1u multi=1 nf=1 sd=100n ad=7.5e-14 \
        as=7.5e-14 pd=2.15u ps=2.15u nrd=0.289519 nrs=0.289519 sa=75.0n \
        sb=75.0n sa1=75.0n sa2=75.0n sa3=75.0n sa4=75.0n sb1=75.0n \
        sb2=75.0n sb3=75.0n spa=100n spa1=100n spa2=100n spa3=100n \
        sap=91.9776n sapb=114.444n spba=115.715n spba1=117.043n dfm_flag=0 \
        spmt=1.11111e+15 spomt=0 spomt1=1.11111e+60 spmb=1.11111e+15 \
        spomb=0 spomb1=1.11111e+60
    MN0 (Y A MID VSS) nch_mac l=30n w=1u multi=1 nf=1 sd=100n ad=7.5e-14 \
        as=7.5e-14 pd=2.15u ps=2.15u nrd=0.289519 nrs=0.289519 sa=75.0n \
        sb=75.0n sa1=75.0n sa2=75.0n sa3=75.0n sa4=75.0n sb1=75.0n \
        sb2=75.0n sb3=75.0n spa=100n spa1=100n spa2=100n spa3=100n \
        sap=91.9776n sapb=114.444n spba=115.715n spba1=117.043n dfm_flag=0 \
        spmt=1.11111e+15 spomt=0 spomt1=1.11111e+60 spmb=1.11111e+15 \
        spomb=0 spomb1=1.11111e+60
    CMID (MID VSS) cfmom_2t nr=8 lr=2.5u w=50n s=50n stm=1 spm=3 multi=2 \
        mismatchflag=1
ends sar8p_nand2

subckt sar8p_nonoverlap CODE H L VDD VSS
    X000 (CODE VDD VSS CB) sar8p_inv
    XD_LD (CB VDD VSS LD) sar8p_delay_bbm
    XD_HD (CODE VDD VSS HD) sar8p_delay_bbm_HD_C0x4
    X004 (CB LD VDD VSS L) sar8p_and2
    X002 (CODE HD VDD VSS H) sar8p_and2
ends sar8p_nonoverlap

subckt sar_bootstrap_flat_8b_p CLKS VOUT Vin
    Mmain (VOUT G Vin 0) nch_18_mac l=150.0n w=1u multi=1 nf=1 sd=180.0n \
        ad=1.55e-13 as=1.55e-13 pd=2.31u ps=2.31u nrd=0 nrs=0 sa=155.00n \
        sb=155.00n sa1=155.00n sa2=155.00n sa3=155.00n sa4=155.00n \
        sb1=155.00n sb2=155.00n sb3=155.00n spa=180.0n spa1=180.0n \
        spa2=180.0n spa3=180.0n sap=172.362n sapb=242.67n spba=233.666n \
        spba1=239.844n spmt=1.11111e+15 spomt=0 spomt1=1.11111e+60 \
        spmb=1.11111e+15 spomb=0 spomb1=1.11111e+60
    Mmain_U1 (VOUT G Vin 0) nch_18_mac l=150.0n w=1u multi=1 nf=1 sd=180.0n \
        ad=1.55e-13 as=1.55e-13 pd=2.31u ps=2.31u nrd=0 nrs=0 sa=155.00n \
        sb=155.00n sa1=155.00n sa2=155.00n sa3=155.00n sa4=155.00n \
        sb1=155.00n sb2=155.00n sb3=155.00n spa=180.0n spa1=180.0n \
        spa2=180.0n spa3=180.0n sap=172.362n sapb=242.67n spba=233.666n \
        spba1=239.844n spmt=1.11111e+15 spomt=0 spomt1=1.11111e+60 \
        spmb=1.11111e+15 spomb=0 spomb1=1.11111e+60
    M4C (CTRL CLKS BBOT 0) nch_18_mac l=150.0n w=1u multi=1 nf=1 sd=180.0n \
        ad=1.55e-13 as=1.55e-13 pd=2.31u ps=2.31u nrd=0 nrs=0 sa=155.00n \
        sb=155.00n sa1=155.00n sa2=155.00n sa3=155.00n sa4=155.00n \
        sb1=155.00n sb2=155.00n sb3=155.00n spa=180.0n spa1=180.0n \
        spa2=180.0n spa3=180.0n sap=172.362n sapb=242.67n spba=233.666n \
        spba1=239.844n spmt=1.11111e+15 spomt=0 spomt1=1.11111e+60 \
        spmb=1.11111e+15 spomb=0 spomb1=1.11111e+60
    Msin (BBOT G Vin 0) nch_18_mac l=150.0n w=1u multi=1 nf=1 sd=180.0n \
        ad=1.55e-13 as=1.55e-13 pd=2.31u ps=2.31u nrd=0 nrs=0 sa=155.00n \
        sb=155.00n sa1=155.00n sa2=155.00n sa3=155.00n sa4=155.00n \
        sb1=155.00n sb2=155.00n sb3=155.00n spa=180.0n spa1=180.0n \
        spa2=180.0n spa3=180.0n sap=172.362n sapb=242.67n spba=233.666n \
        spba1=239.844n spmt=1.11111e+15 spomt=0 spomt1=1.11111e+60 \
        spmb=1.11111e+15 spomb=0 spomb1=1.11111e+60
    Maux (G VDD! GRESET 0) nch_18_mac l=150.0n w=1u multi=1 nf=1 sd=180.0n \
        ad=1.55e-13 as=1.55e-13 pd=2.31u ps=2.31u nrd=0 nrs=0 sa=155.00n \
        sb=155.00n sa1=155.00n sa2=155.00n sa3=155.00n sa4=155.00n \
        sb1=155.00n sb2=155.00n sb3=155.00n spa=180.0n spa1=180.0n \
        spa2=180.0n spa3=180.0n sap=172.362n sapb=242.67n spba=233.666n \
        spba1=239.844n spmt=1.11111e+15 spomt=0 spomt1=1.11111e+60 \
        spmb=1.11111e+15 spomb=0 spomb1=1.11111e+60
    MRSTG (GRESET CLKSB 0 0) nch_18_mac l=150.0n w=1u multi=1 nf=1 \
        sd=180.0n ad=1.55e-13 as=1.55e-13 pd=2.31u ps=2.31u nrd=0 nrs=0 \
        sa=155.00n sb=155.00n sa1=155.00n sa2=155.00n sa3=155.00n \
        sa4=155.00n sb1=155.00n sb2=155.00n sb3=155.00n spa=180.0n \
        spa1=180.0n spa2=180.0n spa3=180.0n sap=172.362n sapb=242.67n \
        spba=233.666n spba1=239.844n spmt=1.11111e+15 spomt=0 \
        spomt1=1.11111e+60 spmb=1.11111e+15 spomb=0 spomb1=1.11111e+60
    M4A (CTRL G BBOT 0) nch_18_mac l=150.0n w=1u multi=1 nf=1 sd=180.0n \
        ad=1.55e-13 as=1.55e-13 pd=2.31u ps=2.31u nrd=0 nrs=0 sa=155.00n \
        sb=155.00n sa1=155.00n sa2=155.00n sa3=155.00n sa4=155.00n \
        sb1=155.00n sb2=155.00n sb3=155.00n spa=180.0n spa1=180.0n \
        spa2=180.0n spa3=180.0n sap=172.362n sapb=242.67n spba=233.666n \
        spba1=239.844n spmt=1.11111e+15 spomt=0 spomt1=1.11111e+60 \
        spmb=1.11111e+15 spomb=0 spomb1=1.11111e+60
    M8 (BBOT CLKSB 0 0) nch_18_mac l=150.0n w=1u multi=1 nf=1 sd=180.0n \
        ad=1.55e-13 as=1.55e-13 pd=2.31u ps=2.31u nrd=0 nrs=0 sa=155.00n \
        sb=155.00n sa1=155.00n sa2=155.00n sa3=155.00n sa4=155.00n \
        sb1=155.00n sb2=155.00n sb3=155.00n spa=180.0n spa1=180.0n \
        spa2=180.0n spa3=180.0n sap=172.362n sapb=242.67n spba=233.666n \
        spba1=239.844n spmt=1.11111e+15 spomt=0 spomt1=1.11111e+60 \
        spmb=1.11111e+15 spomb=0 spomb1=1.11111e+60
    MNCLK (CLKSB CLKS 0 0) nch_18_mac l=150.0n w=1u multi=1 nf=1 sd=180.0n \
        ad=1.55e-13 as=1.55e-13 pd=2.31u ps=2.31u nrd=0 nrs=0 sa=155.00n \
        sb=155.00n sa1=155.00n sa2=155.00n sa3=155.00n sa4=155.00n \
        sb1=155.00n sb2=155.00n sb3=155.00n spa=180.0n spa1=180.0n \
        spa2=180.0n spa3=180.0n sap=172.362n sapb=242.67n spba=233.666n \
        spba1=239.844n spmt=1.11111e+15 spomt=0 spomt1=1.11111e+60 \
        spmb=1.11111e+15 spomb=0 spomb1=1.11111e+60
    M2 (BTOP G VDD! BTOP) pch_18_mac l=150.0n w=1u multi=1 nf=1 sd=180.0n \
        ad=1.55e-13 as=1.55e-13 pd=2.31u ps=2.31u nrd=0 nrs=0 sa=155.00n \
        sb=155.00n sa1=155.00n sa2=155.00n sa3=155.00n sa4=155.00n \
        sb1=155.00n sb2=155.00n sb3=155.00n spa=180.0n spa1=180.0n \
        spa2=180.0n spa3=180.0n sap=172.362n sapb=242.67n spba=233.666n \
        spba1=239.844n spmt=1.11111e+15 spomt=0 spomt1=1.11111e+60 \
        spmb=1.11111e+15 spomb=0 spomb1=1.11111e+60
    M4 (G CTRL BTOP BTOP) pch_18_mac l=150.0n w=1u multi=1 nf=1 sd=180.0n \
        ad=1.55e-13 as=1.55e-13 pd=2.31u ps=2.31u nrd=0 nrs=0 sa=155.00n \
        sb=155.00n sa1=155.00n sa2=155.00n sa3=155.00n sa4=155.00n \
        sb1=155.00n sb2=155.00n sb3=155.00n spa=180.0n spa1=180.0n \
        spa2=180.0n spa3=180.0n sap=172.362n sapb=242.67n spba=233.666n \
        spba1=239.844n spmt=1.11111e+15 spomt=0 spomt1=1.11111e+60 \
        spmb=1.11111e+15 spomb=0 spomb1=1.11111e+60
    M4B (CTRL CLKS VDD! VDD!) pch_18_mac l=150.0n w=1u multi=1 nf=1 \
        sd=180.0n ad=1.55e-13 as=1.55e-13 pd=2.31u ps=2.31u nrd=0 nrs=0 \
        sa=155.00n sb=155.00n sa1=155.00n sa2=155.00n sa3=155.00n \
        sa4=155.00n sb1=155.00n sb2=155.00n sb3=155.00n spa=180.0n \
        spa1=180.0n spa2=180.0n spa3=180.0n sap=172.362n sapb=242.67n \
        spba=233.666n spba1=239.844n spmt=1.11111e+15 spomt=0 \
        spomt1=1.11111e+60 spmb=1.11111e+15 spomb=0 spomb1=1.11111e+60
    MPCLK (CLKSB CLKS VDD! VDD!) pch_18_mac l=150.0n w=1u multi=1 nf=1 \
        sd=180.0n ad=1.55e-13 as=1.55e-13 pd=2.31u ps=2.31u nrd=0 nrs=0 \
        sa=155.00n sb=155.00n sa1=155.00n sa2=155.00n sa3=155.00n \
        sa4=155.00n sb1=155.00n sb2=155.00n sb3=155.00n spa=180.0n \
        spa1=180.0n spa2=180.0n spa3=180.0n sap=172.362n sapb=242.67n \
        spba=233.666n spba1=239.844n spmt=1.11111e+15 spomt=0 \
        spomt1=1.11111e+60 spmb=1.11111e+15 spomb=0 spomb1=1.11111e+60
    Cboot (BTOP BBOT) cfmom_2t nr=8 lr=2.5u w=50n s=50n stm=1 spm=3 \
        multi=200 mismatchflag=1
ends sar_bootstrap_flat_8b_p

subckt sar_strongarm_t28 CLK OUTN OUTP VDD VINN VINP VSS
    MNLATN (OUTN OUTP Y VSS) nch_mac l=30n w=500n multi=1 nf=1 sd=100n \
        ad=3.75e-14 as=3.75e-14 pd=1.15u ps=1.15u nrd=0.662935 \
        nrs=0.662935 sa=75.0n sb=75.0n sa1=75.0n sa2=75.0n sa3=75.0n \
        sa4=75.0n sb1=75.0n sb2=75.0n sb3=75.0n spa=100n spa1=100n \
        spa2=100n spa3=100n sap=91.9776n sapb=114.444n spba=115.715n \
        spba1=117.043n dfm_flag=0 spmt=1.11111e+15 spomt=0 \
        spomt1=1.11111e+60 spmb=1.11111e+15 spomb=0 spomb1=1.11111e+60
    MNLATP (OUTP OUTN X VSS) nch_mac l=30n w=500n multi=1 nf=1 sd=100n \
        ad=3.75e-14 as=3.75e-14 pd=1.15u ps=1.15u nrd=0.662935 \
        nrs=0.662935 sa=75.0n sb=75.0n sa1=75.0n sa2=75.0n sa3=75.0n \
        sa4=75.0n sb1=75.0n sb2=75.0n sb3=75.0n spa=100n spa1=100n \
        spa2=100n spa3=100n sap=91.9776n sapb=114.444n spba=115.715n \
        spba1=117.043n dfm_flag=0 spmt=1.11111e+15 spomt=0 \
        spomt1=1.11111e+60 spmb=1.11111e+15 spomb=0 spomb1=1.11111e+60
    MNINN (X VINN TAIL VSS) nch_mac l=30n w=1u multi=1 nf=1 sd=100n \
        ad=7.5e-14 as=7.5e-14 pd=2.15u ps=2.15u nrd=0.289519 nrs=0.289519 \
        sa=75.0n sb=75.0n sa1=75.0n sa2=75.0n sa3=75.0n sa4=75.0n \
        sb1=75.0n sb2=75.0n sb3=75.0n spa=100n spa1=100n spa2=100n \
        spa3=100n sap=91.9776n sapb=114.444n spba=115.715n spba1=117.043n \
        dfm_flag=0 spmt=1.11111e+15 spomt=0 spomt1=1.11111e+60 \
        spmb=1.11111e+15 spomb=0 spomb1=1.11111e+60
    MNINP (Y VINP TAIL VSS) nch_mac l=30n w=1u multi=1 nf=1 sd=100n \
        ad=7.5e-14 as=7.5e-14 pd=2.15u ps=2.15u nrd=0.289519 nrs=0.289519 \
        sa=75.0n sb=75.0n sa1=75.0n sa2=75.0n sa3=75.0n sa4=75.0n \
        sb1=75.0n sb2=75.0n sb3=75.0n spa=100n spa1=100n spa2=100n \
        spa3=100n sap=91.9776n sapb=114.444n spba=115.715n spba1=117.043n \
        dfm_flag=0 spmt=1.11111e+15 spomt=0 spomt1=1.11111e+60 \
        spmb=1.11111e+15 spomb=0 spomb1=1.11111e+60
    MNTAIL (TAIL CLK VSS VSS) nch_mac l=30n w=1u multi=1 nf=1 sd=100n \
        ad=7.5e-14 as=7.5e-14 pd=2.15u ps=2.15u nrd=0.289519 nrs=0.289519 \
        sa=75.0n sb=75.0n sa1=75.0n sa2=75.0n sa3=75.0n sa4=75.0n \
        sb1=75.0n sb2=75.0n sb3=75.0n spa=100n spa1=100n spa2=100n \
        spa3=100n sap=91.9776n sapb=114.444n spba=115.715n spba1=117.043n \
        dfm_flag=0 spmt=1.11111e+15 spomt=0 spomt1=1.11111e+60 \
        spmb=1.11111e+15 spomb=0 spomb1=1.11111e+60
    MPRSTN (OUTN CLK VDD VDD) pch_mac l=30n w=500n multi=1 nf=1 sd=100n \
        ad=3.75e-14 as=3.75e-14 pd=1.15u ps=1.15u nrd=0.383209 \
        nrs=0.383209 sa=75.0n sb=75.0n sa1=75.0n sa2=75.0n sa3=75.0n \
        sa4=75.0n sb1=75.0n sb2=75.0n sb3=75.0n spa=100n spa1=100n \
        spa2=100n spa3=100n sap=91.9776n sapb=114.444n spba=115.715n \
        spba1=117.043n dfm_flag=0 spmt=1.11111e+15 spomt=0 \
        spomt1=1.11111e+60 spmb=1.11111e+15 spomb=0 spomb1=1.11111e+60
    MPRSTP (OUTP CLK VDD VDD) pch_mac l=30n w=500n multi=1 nf=1 sd=100n \
        ad=3.75e-14 as=3.75e-14 pd=1.15u ps=1.15u nrd=0.383209 \
        nrs=0.383209 sa=75.0n sb=75.0n sa1=75.0n sa2=75.0n sa3=75.0n \
        sa4=75.0n sb1=75.0n sb2=75.0n sb3=75.0n spa=100n spa1=100n \
        spa2=100n spa3=100n sap=91.9776n sapb=114.444n spba=115.715n \
        spba1=117.043n dfm_flag=0 spmt=1.11111e+15 spomt=0 \
        spomt1=1.11111e+60 spmb=1.11111e+15 spomb=0 spomb1=1.11111e+60
    MPRSTY (Y CLK VDD VDD) pch_mac l=30n w=500n multi=1 nf=1 sd=100n \
        ad=3.75e-14 as=3.75e-14 pd=1.15u ps=1.15u nrd=0.383209 \
        nrs=0.383209 sa=75.0n sb=75.0n sa1=75.0n sa2=75.0n sa3=75.0n \
        sa4=75.0n sb1=75.0n sb2=75.0n sb3=75.0n spa=100n spa1=100n \
        spa2=100n spa3=100n sap=91.9776n sapb=114.444n spba=115.715n \
        spba1=117.043n dfm_flag=0 spmt=1.11111e+15 spomt=0 \
        spomt1=1.11111e+60 spmb=1.11111e+15 spomb=0 spomb1=1.11111e+60
    MPRSTX (X CLK VDD VDD) pch_mac l=30n w=500n multi=1 nf=1 sd=100n \
        ad=3.75e-14 as=3.75e-14 pd=1.15u ps=1.15u nrd=0.383209 \
        nrs=0.383209 sa=75.0n sb=75.0n sa1=75.0n sa2=75.0n sa3=75.0n \
        sa4=75.0n sb1=75.0n sb2=75.0n sb3=75.0n spa=100n spa1=100n \
        spa2=100n spa3=100n sap=91.9776n sapb=114.444n spba=115.715n \
        spba1=117.043n dfm_flag=0 spmt=1.11111e+15 spomt=0 \
        spomt1=1.11111e+60 spmb=1.11111e+15 spomb=0 spomb1=1.11111e+60
    MPLATN (OUTN OUTP VDD VDD) pch_mac l=30n w=500n multi=1 nf=1 sd=100n \
        ad=3.75e-14 as=3.75e-14 pd=1.15u ps=1.15u nrd=0.383209 \
        nrs=0.383209 sa=75.0n sb=75.0n sa1=75.0n sa2=75.0n sa3=75.0n \
        sa4=75.0n sb1=75.0n sb2=75.0n sb3=75.0n spa=100n spa1=100n \
        spa2=100n spa3=100n sap=91.9776n sapb=114.444n spba=115.715n \
        spba1=117.043n dfm_flag=0 spmt=1.11111e+15 spomt=0 \
        spomt1=1.11111e+60 spmb=1.11111e+15 spomb=0 spomb1=1.11111e+60
    MPLATP (OUTP OUTN VDD VDD) pch_mac l=30n w=500n multi=1 nf=1 sd=100n \
        ad=3.75e-14 as=3.75e-14 pd=1.15u ps=1.15u nrd=0.383209 \
        nrs=0.383209 sa=75.0n sb=75.0n sa1=75.0n sa2=75.0n sa3=75.0n \
        sa4=75.0n sb1=75.0n sb2=75.0n sb3=75.0n spa=100n spa1=100n \
        spa2=100n spa3=100n sap=91.9776n sapb=114.444n spba=115.715n \
        spba1=117.043n dfm_flag=0 spmt=1.11111e+15 spomt=0 \
        spomt1=1.11111e+60 spmb=1.11111e+15 spomb=0 spomb1=1.11111e+60
ends sar_strongarm_t28
