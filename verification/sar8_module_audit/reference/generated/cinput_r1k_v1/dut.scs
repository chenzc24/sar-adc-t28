// Local uncompiled reference reproduction fixture; no size optimization.
subckt audit_ref_capture CODE0 CODE1 CODE2 CODE3 CODE4 CODE5 CODE6 CODE7 D0 D1 D2 D3 D4 D5 D6 D7 GNN0 GNN1 GNN2 GNN3 GNN4 GNN5 GNN6 GNN7 GNP0 GNP1 GNP2 GNP3 GNP4 GNP5 GNP6 GNP7 GPN0 GPN1 GPN2 GPN3 GPN4 GPN5 GPN6 GPN7 GPP0 GPP1 GPP2 GPP3 GPP4 GPP5 GPP6 GPP7 PHI_U CAP_REQ RST0 RST1 RST2 RST3 RST4 RST5 RST6 RST7 VDD VSS
    X008 (CAP_REQ VDD VSS CAP_CLK) sar8p_clkbuf
    XMUX7 (CODE7 D7 PHI_U VDD VSS TARGET7) sar8p_mux2
    XMUX6 (CODE6 D6 PHI_U VDD VSS TARGET6) sar8p_mux2
    XMUX5 (CODE5 D5 PHI_U VDD VSS TARGET5) sar8p_mux2
    XMUX4 (CODE4 D4 PHI_U VDD VSS TARGET4) sar8p_mux2
    XMUX3 (CODE3 D3 PHI_U VDD VSS TARGET3) sar8p_mux2
    XMUX2 (CODE2 D2 PHI_U VDD VSS TARGET2) sar8p_mux2
    XMUX1 (CODE1 D1 PHI_U VDD VSS TARGET1) sar8p_mux2
    XMUX0 (CODE0 D0 PHI_U VDD VSS TARGET0) sar8p_mux2
    X018 (MSB_QN VDD VSS Q7) sar8p_inv
    X017 (TARGET7 VDD VSS MSB_DN) sar8p_inv
    XSTORE7 (CAP_CLK MSB_DN MSB_QN RST7 VDD VSS) sar8p_dffr
    XSTORE6 (CAP_CLK TARGET6 Q6 RST6 VDD VSS) sar8p_dffr
    XSTORE5 (CAP_CLK TARGET5 Q5 RST5 VDD VSS) sar8p_dffr
    XSTORE4 (CAP_CLK TARGET4 Q4 RST4 VDD VSS) sar8p_dffr
    XSTORE3 (CAP_CLK TARGET3 Q3 RST3 VDD VSS) sar8p_dffr
    XSTORE2 (CAP_CLK TARGET2 Q2 RST2 VDD VSS) sar8p_dffr
    XSTORE1 (CAP_CLK TARGET1 Q1 RST1 VDD VSS) sar8p_dffr
    XSTORE0 (CAP_CLK TARGET0 Q0 RST0 VDD VSS) sar8p_dffr
    XBBM7 (Q7 H7 L7 VDD VSS) sar8p_nonoverlap
    XBBM6 (Q6 H6 L6 VDD VSS) sar8p_nonoverlap
    XBBM5 (Q5 H5 L5 VDD VSS) sar8p_nonoverlap
    XBBM4 (Q4 H4 L4 VDD VSS) sar8p_nonoverlap
    XBBM3 (Q3 H3 L3 VDD VSS) sar8p_nonoverlap
    XBBM2 (Q2 H2 L2 VDD VSS) sar8p_nonoverlap
    XBBM1 (Q1 H1 L1 VDD VSS) sar8p_nonoverlap
    XBBM0 (Q0 H0 L0 VDD VSS) sar8p_nonoverlap
    XDRV0 (GNN0 GNP0 GPN0 GPP0 H0 L0 VDD VSS) sar8p_refdrv_b0
    XDRV1 (GNN1 GNP1 GPN1 GPP1 H1 L1 VDD VSS) sar8p_refdrv_b1
    XDRV2 (GNN2 GNP2 GPN2 GPP2 H2 L2 VDD VSS) sar8p_refdrv_b2
    XDRV3 (GNN3 GNP3 GPN3 GPP3 H3 L3 VDD VSS) sar8p_refdrv_b3
    XDRV4 (GNN4 GNP4 GPN4 GPP4 H4 L4 VDD VSS) sar8p_refdrv_b4
    XDRV5 (GNN5 GNP5 GPN5 GPP5 H5 L5 VDD VSS) sar8p_refdrv_b5
    XDRV6 (GNN6 GNP6 GPN6 GPP6 H6 L6 VDD VSS) sar8p_refdrv_b6
    XDRV7 (GNN7 GNP7 GPN7 GPP7 H7 L7 VDD VSS) sar8p_refdrv_b7
ends audit_ref_capture

subckt audit_ref_load_ctrl CMP_CLK CODE0 CODE1 CODE2 CODE3 CODE4 CODE5 CODE6 CODE7 COMP_N COMP_P D0 D1 D2 D3 D4 D5 D6 D7 PHI_U SAMPLE VDD VSS ACTIVE PHI_U_CMD
    XTIM (CMP_CLK COMP_N COMP_P DATA PHI_U PHI_W SAMPLE VDD VSS) audit_ref_load_timing
    XSEQ (PHI_U_CMD SAMPLE T0 T1 T2 T3 T4 T5 T6 T7 VDD VSS) sar8p_bitseq8
    XBIT7 (CODE7 D7 DATA PHI_W SAMPLE T7 VDD VSS) sar8p_bit
    XBIT6 (CODE6 D6 DATA PHI_W SAMPLE T6 VDD VSS) sar8p_bit
    XBIT5 (CODE5 D5 DATA PHI_W SAMPLE T5 VDD VSS) sar8p_bit
    XBIT4 (CODE4 D4 DATA PHI_W SAMPLE T4 VDD VSS) sar8p_bit
    XBIT3 (CODE3 D3 DATA PHI_W SAMPLE T3 VDD VSS) sar8p_bit
    XBIT2 (CODE2 D2 DATA PHI_W SAMPLE T2 VDD VSS) sar8p_bit
    XBIT1 (CODE1 D1 DATA PHI_W SAMPLE T1 VDD VSS) sar8p_bit
    XBIT0 (CODE0 D0 DATA PHI_W SAMPLE T0 VDD VSS) sar8p_bit
    X018 (A01 A23 VDD VSS ACTIVE) sar8p_or2
    X017 (A2 A3 VDD VSS A23) sar8p_or2
    X016 (A0 A1 VDD VSS A01) sar8p_or2
    X015 (T6 T7 VDD VSS A3) sar8p_or2
    X014 (T4 T5 VDD VSS A2) sar8p_or2
    X013 (T2 T3 VDD VSS A1) sar8p_or2
    X012 (T0 T1 VDD VSS A0) sar8p_or2
ends audit_ref_load_ctrl

subckt audit_ref_load_timing CMP_CLK COMP_N COMP_P DATA PHI_U PHI_W SAMPLE VDD VSS
    X016 (PHI_W VDD VSS WN) sar8p_inv
    X015 (CMP_CLK VDD VSS CN) sar8p_inv
    X004 (NR VDD VSS NRB) sar8p_inv
    X000 (SAMPLE VDD VSS SN) sar8p_inv
    X014 (UD SN VDD VSS PHI_U) sar8p_and2
    X013 (PHI_W WRITE_D VDD VSS UD) sar8p_and2
    X010 (WD SN VDD VSS WRITE_REQ) sar8p_and2
    X009 (DEC CMP_CLK VDD VSS WD) sar8p_and2
    X008 (RAW RAW_D VDD VSS DEC) sar8p_and2
    X005 (PR NRB VDD VSS DATA) sar8p_and2
    X003 (COMP_N VDD VSS NR) sar8p_buf
    X002 (COMP_P VDD VSS PR) sar8p_buf
    X006 (PR NR VDD VSS RAW) sar8p_xor2
    XD_RAW_D (RAW VDD VSS RAW_D) sar8p_delay_valid
    X011 (WRITE_REQ VDD VSS PHI_W) sar8p_clkbuf
    XD_WRITE_D (PHI_W VDD VSS WRITE_D) sar8p_delay_write
ends audit_ref_load_timing

subckt sar8_reference_isolation_v1 PHI_U CAP_REQ SAMPLE_INT SEQ_SAMPLE CMP_CLK RST0 RST1 RST2 RST3 RST4 RST5 RST6 RST7 D0 D1 D2 D3 D4 D5 D6 D7 CODE0 CODE1 CODE2 CODE3 CODE4 CODE5 CODE6 CODE7 VDD! VINN VINP VREFN VREFP VSS
    XBOOTN (SEQ_SAMPLE TOPN VINN) sar_bootstrap_flat_8b_p
    XBOOTP (SEQ_SAMPLE TOPP VINP) sar_bootstrap_flat_8b_p
    XCDAC (GNN0 GNN1 GNN2 GNN3 GNN4 GNN5 GNN6 GNN7 GNP0 GNP1 GNP2 GNP3 GNP4 GNP5 GNP6 GNP7 GPN0 GPN1 GPN2 GPN3 GPN4 GPN5 GPN6 GPN7 GPP0 GPP1 GPP2 GPP3 GPP4 GPP5 GPP6 GPP7 TOPN TOPP VDD! VREFN VREFP 0) sar8j_r1_cdac
    XCOMP (CMP_CLK COMP_N COMP_P VDD! TOPN TOPP 0) sar_strongarm_t28
    CL_COMP_N (COMP_N 0) cfmom_2t nr=8 lr=2.5u w=50n s=50n stm=1 spm=3  multi=2 mismatchflag=1
    CL_COMP_P (COMP_P 0) cfmom_2t nr=8 lr=2.5u w=50n s=50n stm=1 spm=3  multi=2 mismatchflag=1
    CL_CMP_CLK (CMP_CLK 0) cfmom_2t nr=8 lr=2.5u w=50n s=50n stm=1 spm=3  multi=2 mismatchflag=1
    XREF (CODE0 CODE1 CODE2 CODE3 CODE4 CODE5 CODE6 CODE7 D0 D1 D2 D3 D4 D5 D6 D7 GNN0 GNN1 GNN2 GNN3 GNN4 GNN5 GNN6 GNN7 GNP0 GNP1 GNP2 GNP3 GNP4 GNP5 GNP6 GNP7 GPN0 GPN1 GPN2 GPN3 GPN4 GPN5 GPN6 GPN7 GPP0 GPP1 GPP2 GPP3 GPP4 GPP5 GPP6 GPP7 PHI_U CAP_REQ RST0 RST1 RST2 RST3 RST4 RST5 RST6 RST7 VDD! 0) audit_ref_capture
    XLOADCTRL (CMP_CLK LOAD_CODE0 LOAD_CODE1 LOAD_CODE2 LOAD_CODE3 LOAD_CODE4 LOAD_CODE5 LOAD_CODE6 LOAD_CODE7 COMP_N COMP_P LOAD_D0 LOAD_D1 LOAD_D2 LOAD_D3 LOAD_D4 LOAD_D5 LOAD_D6 LOAD_D7 LOAD_PHI_U SAMPLE_INT VDD! 0 LOAD_ACTIVE PHI_U) audit_ref_load_ctrl
    COUT_LOAD0 (LOAD_D0 0) capacitor c=5f
    COUT_LOAD1 (LOAD_D1 0) capacitor c=5f
    COUT_LOAD2 (LOAD_D2 0) capacitor c=5f
    COUT_LOAD3 (LOAD_D3 0) capacitor c=5f
    COUT_LOAD4 (LOAD_D4 0) capacitor c=5f
    COUT_LOAD5 (LOAD_D5 0) capacitor c=5f
    COUT_LOAD6 (LOAD_D6 0) capacitor c=5f
    COUT_LOAD7 (LOAD_D7 0) capacitor c=5f
ends sar8_reference_isolation_v1

subckt sar8j_r1_cdac GNN0 GNN1 GNN2 GNN3 GNN4 GNN5 GNN6 GNN7 GNP0 GNP1 \
        GNP2 GNP3 GNP4 GNP5 GNP6 GNP7 GPN0 GPN1 GPN2 GPN3 GPN4 GPN5 GPN6 \
        GPN7 GPP0 GPP1 GPP2 GPP3 GPP4 GPP5 GPP6 GPP7 TOPN TOPP VDD VREFN \
        VREFP VSS
    CMOMN8 (TOPN VREFN) cfmom_2t nr=8 lr=2u w=50n s=50n stm=1 spm=3 \
        multi=1 mismatchflag=1
    CMOMN7 (TOPN BN7) cfmom_2t nr=8 lr=2u w=50n s=50n stm=1 spm=3 \
        multi=128 mismatchflag=1
    CMOMN6 (TOPN BN6) cfmom_2t nr=8 lr=2u w=50n s=50n stm=1 spm=3 multi=64 \
        mismatchflag=1
    CMOMN5 (TOPN BN5) cfmom_2t nr=8 lr=2u w=50n s=50n stm=1 spm=3 multi=32 \
        mismatchflag=1
    CMOMN4 (TOPN BN4) cfmom_2t nr=8 lr=2u w=50n s=50n stm=1 spm=3 multi=16 \
        mismatchflag=1
    CMOMN3 (TOPN BN3) cfmom_2t nr=8 lr=2u w=50n s=50n stm=1 spm=3 multi=8 \
        mismatchflag=1
    CMOMN2 (TOPN BN2) cfmom_2t nr=8 lr=2u w=50n s=50n stm=1 spm=3 multi=4 \
        mismatchflag=1
    CMOMN1 (TOPN BN1) cfmom_2t nr=8 lr=2u w=50n s=50n stm=1 spm=3 multi=2 \
        mismatchflag=1
    CMOMN0 (TOPN BN0) cfmom_2t nr=8 lr=2u w=50n s=50n stm=1 spm=3 multi=1 \
        mismatchflag=1
    CMOMP8 (TOPP VREFP) cfmom_2t nr=8 lr=2u w=50n s=50n stm=1 spm=3 \
        multi=1 mismatchflag=1
    CMOMP7 (TOPP BP7) cfmom_2t nr=8 lr=2u w=50n s=50n stm=1 spm=3 \
        multi=128 mismatchflag=1
    CMOMP6 (TOPP BP6) cfmom_2t nr=8 lr=2u w=50n s=50n stm=1 spm=3 multi=64 \
        mismatchflag=1
    CMOMP5 (TOPP BP5) cfmom_2t nr=8 lr=2u w=50n s=50n stm=1 spm=3 multi=32 \
        mismatchflag=1
    CMOMP4 (TOPP BP4) cfmom_2t nr=8 lr=2u w=50n s=50n stm=1 spm=3 multi=16 \
        mismatchflag=1
    CMOMP3 (TOPP BP3) cfmom_2t nr=8 lr=2u w=50n s=50n stm=1 spm=3 multi=8 \
        mismatchflag=1
    CMOMP2 (TOPP BP2) cfmom_2t nr=8 lr=2u w=50n s=50n stm=1 spm=3 multi=4 \
        mismatchflag=1
    CMOMP1 (TOPP BP1) cfmom_2t nr=8 lr=2u w=50n s=50n stm=1 spm=3 multi=2 \
        mismatchflag=1
    CMOMP0 (TOPP BP0) cfmom_2t nr=8 lr=2u w=50n s=50n stm=1 spm=3 multi=1 \
        mismatchflag=1
    XSN0 (BN0 GNN0 GNP0 VDD VREFN VREFP VSS) sar8j_r1_sw_b0
    XSP0 (BP0 GPN0 GPP0 VDD VREFN VREFP VSS) sar8j_r1_sw_b0
    XSN1 (BN1 GNN1 GNP1 VDD VREFN VREFP VSS) sar8j_r1_sw_b1
    XSP1 (BP1 GPN1 GPP1 VDD VREFN VREFP VSS) sar8j_r1_sw_b1
    XSN2 (BN2 GNN2 GNP2 VDD VREFN VREFP VSS) sar8j_r1_sw_b2
    XSP2 (BP2 GPN2 GPP2 VDD VREFN VREFP VSS) sar8j_r1_sw_b2
    XSN3 (BN3 GNN3 GNP3 VDD VREFN VREFP VSS) sar8j_r1_sw_b3
    XSP3 (BP3 GPN3 GPP3 VDD VREFN VREFP VSS) sar8j_r1_sw_b3
    XSN4 (BN4 GNN4 GNP4 VDD VREFN VREFP VSS) sar8j_r1_sw_b4
    XSP4 (BP4 GPN4 GPP4 VDD VREFN VREFP VSS) sar8j_r1_sw_b4
    XSN5 (BN5 GNN5 GNP5 VDD VREFN VREFP VSS) sar8j_r1_sw_b5
    XSP5 (BP5 GPN5 GPP5 VDD VREFN VREFP VSS) sar8j_r1_sw_b5
    XSN6 (BN6 GNN6 GNP6 VDD VREFN VREFP VSS) sar8j_r1_sw_b6
    XSP6 (BP6 GPN6 GPP6 VDD VREFN VREFP VSS) sar8j_r1_sw_b6
    XSN7 (BN7 GNN7 GNP7 VDD VREFN VREFP VSS) sar8j_r1_sw_b7
    XSP7 (BP7 GPN7 GPP7 VDD VREFN VREFP VSS) sar8j_r1_sw_b7
ends sar8j_r1_cdac

subckt sar8j_r1_sw_b0 BOT GN GP VDD VREFN VREFP VSS
    MP_HIGH (BOT GP VREFP VDD) pch_18_mac ad=4.96e-14 as=4.96e-14 l=150n nf=1 nrd=0 nrs=0 pd=950.0n ps=950.0n sa=155.00n sa1=155.00n sa2=155.00n sa3=155.00n sa4=155.00n sap=172.362n sapb=242.67n sb=155.00n sb1=155.00n sb2=155.00n sb3=155.00n sd=180n spa=180.0n spa1=180.0n spa2=180.0n spa3=180.0n spba=233.666n spba1=239.844n spmb=1.11111e15 spmt=1.11111e15 spomb=0 spomb1=1.11111e+60 spomt=0 spomt1=1.11111e+60 w=320n multi=2
    MN_LOW (BOT GN VREFN VSS) nch_18_mac ad=4.96e-14 as=4.96e-14 l=150n nf=1 nrd=0 nrs=0 pd=950.0n ps=950.0n sa=155.00n sa1=155.00n sa2=155.00n sa3=155.00n sa4=155.00n sap=172.362n sapb=242.67n sb=155.00n sb1=155.00n sb2=155.00n sb3=155.00n sd=180n spa=180.0n spa1=180.0n spa2=180.0n spa3=180.0n spba=233.666n spba1=239.844n spmb=1.11111e15 spmt=1.11111e15 spomb=0 spomb1=1.11111e+60 spomt=0 spomt1=1.11111e+60 w=320n multi=2
ends sar8j_r1_sw_b0

subckt sar8j_r1_sw_b1 BOT GN GP VDD VREFN VREFP VSS
    MP_HIGH (BOT GP VREFP VDD) pch_18_mac ad=4.96e-14 as=4.96e-14 l=150n nf=1 nrd=0 nrs=0 pd=950.0n ps=950.0n sa=155.00n sa1=155.00n sa2=155.00n sa3=155.00n sa4=155.00n sap=172.362n sapb=242.67n sb=155.00n sb1=155.00n sb2=155.00n sb3=155.00n sd=180n spa=180.0n spa1=180.0n spa2=180.0n spa3=180.0n spba=233.666n spba1=239.844n spmb=1.11111e15 spmt=1.11111e15 spomb=0 spomb1=1.11111e+60 spomt=0 spomt1=1.11111e+60 w=320n multi=4
    MN_LOW (BOT GN VREFN VSS) nch_18_mac ad=4.96e-14 as=4.96e-14 l=150n nf=1 nrd=0 nrs=0 pd=950.0n ps=950.0n sa=155.00n sa1=155.00n sa2=155.00n sa3=155.00n sa4=155.00n sap=172.362n sapb=242.67n sb=155.00n sb1=155.00n sb2=155.00n sb3=155.00n sd=180n spa=180.0n spa1=180.0n spa2=180.0n spa3=180.0n spba=233.666n spba1=239.844n spmb=1.11111e15 spmt=1.11111e15 spomb=0 spomb1=1.11111e+60 spomt=0 spomt1=1.11111e+60 w=320n multi=4
ends sar8j_r1_sw_b1

subckt sar8j_r1_sw_b2 BOT GN GP VDD VREFN VREFP VSS
    MP_HIGH (BOT GP VREFP VDD) pch_18_mac ad=4.96e-14 as=4.96e-14 l=150n nf=1 nrd=0 nrs=0 pd=950.0n ps=950.0n sa=155.00n sa1=155.00n sa2=155.00n sa3=155.00n sa4=155.00n sap=172.362n sapb=242.67n sb=155.00n sb1=155.00n sb2=155.00n sb3=155.00n sd=180n spa=180.0n spa1=180.0n spa2=180.0n spa3=180.0n spba=233.666n spba1=239.844n spmb=1.11111e15 spmt=1.11111e15 spomb=0 spomb1=1.11111e+60 spomt=0 spomt1=1.11111e+60 w=320n multi=8
    MN_LOW (BOT GN VREFN VSS) nch_18_mac ad=4.96e-14 as=4.96e-14 l=150n nf=1 nrd=0 nrs=0 pd=950.0n ps=950.0n sa=155.00n sa1=155.00n sa2=155.00n sa3=155.00n sa4=155.00n sap=172.362n sapb=242.67n sb=155.00n sb1=155.00n sb2=155.00n sb3=155.00n sd=180n spa=180.0n spa1=180.0n spa2=180.0n spa3=180.0n spba=233.666n spba1=239.844n spmb=1.11111e15 spmt=1.11111e15 spomb=0 spomb1=1.11111e+60 spomt=0 spomt1=1.11111e+60 w=320n multi=8
ends sar8j_r1_sw_b2

subckt sar8j_r1_sw_b3 BOT GN GP VDD VREFN VREFP VSS
    MP_HIGH (BOT GP VREFP VDD) pch_18_mac ad=4.96e-14 as=4.96e-14 l=150n nf=1 nrd=0 nrs=0 pd=950.0n ps=950.0n sa=155.00n sa1=155.00n sa2=155.00n sa3=155.00n sa4=155.00n sap=172.362n sapb=242.67n sb=155.00n sb1=155.00n sb2=155.00n sb3=155.00n sd=180n spa=180.0n spa1=180.0n spa2=180.0n spa3=180.0n spba=233.666n spba1=239.844n spmb=1.11111e15 spmt=1.11111e15 spomb=0 spomb1=1.11111e+60 spomt=0 spomt1=1.11111e+60 w=320n multi=16
    MN_LOW (BOT GN VREFN VSS) nch_18_mac ad=4.96e-14 as=4.96e-14 l=150n nf=1 nrd=0 nrs=0 pd=950.0n ps=950.0n sa=155.00n sa1=155.00n sa2=155.00n sa3=155.00n sa4=155.00n sap=172.362n sapb=242.67n sb=155.00n sb1=155.00n sb2=155.00n sb3=155.00n sd=180n spa=180.0n spa1=180.0n spa2=180.0n spa3=180.0n spba=233.666n spba1=239.844n spmb=1.11111e15 spmt=1.11111e15 spomb=0 spomb1=1.11111e+60 spomt=0 spomt1=1.11111e+60 w=320n multi=16
ends sar8j_r1_sw_b3

subckt sar8j_r1_sw_b4 BOT GN GP VDD VREFN VREFP VSS
    MP_HIGH (BOT GP VREFP VDD) pch_18_mac ad=4.96e-14 as=4.96e-14 l=150n nf=1 nrd=0 nrs=0 pd=950.0n ps=950.0n sa=155.00n sa1=155.00n sa2=155.00n sa3=155.00n sa4=155.00n sap=172.362n sapb=242.67n sb=155.00n sb1=155.00n sb2=155.00n sb3=155.00n sd=180n spa=180.0n spa1=180.0n spa2=180.0n spa3=180.0n spba=233.666n spba1=239.844n spmb=1.11111e15 spmt=1.11111e15 spomb=0 spomb1=1.11111e+60 spomt=0 spomt1=1.11111e+60 w=320n multi=32
    MN_LOW (BOT GN VREFN VSS) nch_18_mac ad=4.96e-14 as=4.96e-14 l=150n nf=1 nrd=0 nrs=0 pd=950.0n ps=950.0n sa=155.00n sa1=155.00n sa2=155.00n sa3=155.00n sa4=155.00n sap=172.362n sapb=242.67n sb=155.00n sb1=155.00n sb2=155.00n sb3=155.00n sd=180n spa=180.0n spa1=180.0n spa2=180.0n spa3=180.0n spba=233.666n spba1=239.844n spmb=1.11111e15 spmt=1.11111e15 spomb=0 spomb1=1.11111e+60 spomt=0 spomt1=1.11111e+60 w=320n multi=32
ends sar8j_r1_sw_b4

subckt sar8j_r1_sw_b5 BOT GN GP VDD VREFN VREFP VSS
    MP_HIGH (BOT GP VREFP VDD) pch_18_mac ad=4.96e-14 as=4.96e-14 l=150n nf=1 nrd=0 nrs=0 pd=950.0n ps=950.0n sa=155.00n sa1=155.00n sa2=155.00n sa3=155.00n sa4=155.00n sap=172.362n sapb=242.67n sb=155.00n sb1=155.00n sb2=155.00n sb3=155.00n sd=180n spa=180.0n spa1=180.0n spa2=180.0n spa3=180.0n spba=233.666n spba1=239.844n spmb=1.11111e15 spmt=1.11111e15 spomb=0 spomb1=1.11111e+60 spomt=0 spomt1=1.11111e+60 w=320n multi=64
    MN_LOW (BOT GN VREFN VSS) nch_18_mac ad=4.96e-14 as=4.96e-14 l=150n nf=1 nrd=0 nrs=0 pd=950.0n ps=950.0n sa=155.00n sa1=155.00n sa2=155.00n sa3=155.00n sa4=155.00n sap=172.362n sapb=242.67n sb=155.00n sb1=155.00n sb2=155.00n sb3=155.00n sd=180n spa=180.0n spa1=180.0n spa2=180.0n spa3=180.0n spba=233.666n spba1=239.844n spmb=1.11111e15 spmt=1.11111e15 spomb=0 spomb1=1.11111e+60 spomt=0 spomt1=1.11111e+60 w=320n multi=64
ends sar8j_r1_sw_b5

subckt sar8j_r1_sw_b6 BOT GN GP VDD VREFN VREFP VSS
    MP_HIGH (BOT GP VREFP VDD) pch_18_mac ad=4.96e-14 as=4.96e-14 l=150n nf=1 nrd=0 nrs=0 pd=950.0n ps=950.0n sa=155.00n sa1=155.00n sa2=155.00n sa3=155.00n sa4=155.00n sap=172.362n sapb=242.67n sb=155.00n sb1=155.00n sb2=155.00n sb3=155.00n sd=180n spa=180.0n spa1=180.0n spa2=180.0n spa3=180.0n spba=233.666n spba1=239.844n spmb=1.11111e15 spmt=1.11111e15 spomb=0 spomb1=1.11111e+60 spomt=0 spomt1=1.11111e+60 w=320n multi=128
    MN_LOW (BOT GN VREFN VSS) nch_18_mac ad=4.96e-14 as=4.96e-14 l=150n nf=1 nrd=0 nrs=0 pd=950.0n ps=950.0n sa=155.00n sa1=155.00n sa2=155.00n sa3=155.00n sa4=155.00n sap=172.362n sapb=242.67n sb=155.00n sb1=155.00n sb2=155.00n sb3=155.00n sd=180n spa=180.0n spa1=180.0n spa2=180.0n spa3=180.0n spba=233.666n spba1=239.844n spmb=1.11111e15 spmt=1.11111e15 spomb=0 spomb1=1.11111e+60 spomt=0 spomt1=1.11111e+60 w=320n multi=128
ends sar8j_r1_sw_b6

subckt sar8j_r1_sw_b7 BOT GN GP VDD VREFN VREFP VSS
    MP_HIGH (BOT GP VREFP VDD) pch_18_mac ad=4.96e-14 as=4.96e-14 l=150n nf=1 nrd=0 nrs=0 pd=950.0n ps=950.0n sa=155.00n sa1=155.00n sa2=155.00n sa3=155.00n sa4=155.00n sap=172.362n sapb=242.67n sb=155.00n sb1=155.00n sb2=155.00n sb3=155.00n sd=180n spa=180.0n spa1=180.0n spa2=180.0n spa3=180.0n spba=233.666n spba1=239.844n spmb=1.11111e15 spmt=1.11111e15 spomb=0 spomb1=1.11111e+60 spomt=0 spomt1=1.11111e+60 w=320n multi=256
    MN_LOW (BOT GN VREFN VSS) nch_18_mac ad=4.96e-14 as=4.96e-14 l=150n nf=1 nrd=0 nrs=0 pd=950.0n ps=950.0n sa=155.00n sa1=155.00n sa2=155.00n sa3=155.00n sa4=155.00n sap=172.362n sapb=242.67n sb=155.00n sb1=155.00n sb2=155.00n sb3=155.00n sd=180n spa=180.0n spa1=180.0n spa2=180.0n spa3=180.0n spba=233.666n spba1=239.844n spmb=1.11111e15 spmt=1.11111e15 spomb=0 spomb1=1.11111e+60 spomt=0 spomt1=1.11111e+60 w=320n multi=256
ends sar8j_r1_sw_b7

subckt sar8p_and2 A B VDD VSS Y
    X000 (A B VDD VSS N) sar8p_nand2
    X001 (N VDD VSS Y) sar8p_inv
ends sar8p_and2

subckt sar8p_bit CODE D DATA PHI_W SAMPLE TOKEN VDD VSS
    XMUX (D DATA TOKEN VDD VSS NEXT_D) sar8p_mux2
    XSTORE (PHI_W NEXT_D D SAMPLE VDD VSS) sar8p_dffr
    X002 (D TOKEN VDD VSS CODE) sar8p_or2
ends sar8p_bit

subckt sar8p_bitseq8 PHI_U SAMPLE T0 T1 T2 T3 T4 T5 T6 T7 VDD VSS
    XF0 (PHI_U T1 T0 SAMPLE VDD VSS) sar8p_dffr
    XF1 (PHI_U T2 T1 SAMPLE VDD VSS) sar8p_dffr
    XF2 (PHI_U T3 T2 SAMPLE VDD VSS) sar8p_dffr
    XF3 (PHI_U T4 T3 SAMPLE VDD VSS) sar8p_dffr
    XF4 (PHI_U T5 T4 SAMPLE VDD VSS) sar8p_dffr
    XF5 (PHI_U T6 T5 SAMPLE VDD VSS) sar8p_dffr
    XF6 (PHI_U T7 T6 SAMPLE VDD VSS) sar8p_dffr
    XF7 (PHI_U VDD NT7 SAMPLE VDD VSS) sar8p_dffr
    X001 (NT7 VDD VSS T7) sar8p_inv
ends sar8p_bitseq8

subckt sar8p_buf A VDD VSS Y
    X001 (N VDD VSS Y) sar8p_inv
    X000 (A VDD VSS N) sar8p_inv
ends sar8p_buf

subckt sar8p_clkbuf A VDD VSS Y
    X000 (A VDD VSS AB) sar8p_inv
    MN (Y AB VSS VSS) nch_mac l=30n w=2u multi=1 nf=1 sd=100n ad=1.5e-13 \
        as=1.5e-13 pd=4.15u ps=4.15u nrd=0.144730 nrs=0.144730 sa=75.0n \
        sb=75.0n sa1=75.0n sa2=75.0n sa3=75.0n sa4=75.0n sb1=75.0n \
        sb2=75.0n sb3=75.0n spa=100n spa1=100n spa2=100n spa3=100n \
        sap=91.9776n sapb=114.444n spba=115.715n spba1=117.043n dfm_flag=0 \
        spmt=1.11111e+15 spomt=0 spomt1=1.11111e+60 spmb=1.11111e+15 \
        spomb=0 spomb1=1.11111e+60
    MP (Y AB VDD VDD) pch_mac l=30n w=3u multi=1 nf=1 sd=100n ad=2.25e-13 \
        as=2.25e-13 pd=6.15u ps=6.15u nrd=0.055246 nrs=0.055246 sa=75.0n \
        sb=75.0n sa1=75.0n sa2=75.0n sa3=75.0n sa4=75.0n sb1=75.0n \
        sb2=75.0n sb3=75.0n spa=100n spa1=100n spa2=100n spa3=100n \
        sap=91.9776n sapb=114.444n spba=115.715n spba1=117.043n dfm_flag=0 \
        spmt=1.11111e+15 spomt=0 spomt1=1.11111e+60 spmb=1.11111e+15 \
        spomb=0 spomb1=1.11111e+60
ends sar8p_clkbuf

subckt sar8p_delay_bbm A VDD VSS Y
R1 (B RC1 ) rupolym l=17.13u w=1u m=1 multi=(1)

R0 (A RC0 ) rupolym l=17.13u w=1u m=1 multi=(1)

    C1 (RC1 VSS) cfmom_2t nr=8 lr=2.5u w=50n s=50n stm=1 spm=3 multi=1 \
        mismatchflag=1
    C0 (RC0 VSS) cfmom_2t nr=8 lr=2.5u w=50n s=50n stm=1 spm=3 multi=1 \
        mismatchflag=1
    X006 (A VDD VSS AB) sar8p_inv
    X005 (RC1 VDD VSS Y) sar8p_inv
    X002 (RC0 VDD VSS B) sar8p_inv
    MN_CLEAR (RC0 AB VSS VSS) nch_mac l=30n w=2u multi=1 nf=1 sd=100n \
        ad=1.5e-13 as=1.5e-13 pd=4.15u ps=4.15u nrd=0.144730 nrs=0.144730 \
        sa=75.0n sb=75.0n sa1=75.0n sa2=75.0n sa3=75.0n sa4=75.0n \
        sb1=75.0n sb2=75.0n sb3=75.0n spa=100n spa1=100n spa2=100n \
        spa3=100n sap=91.9776n sapb=114.444n spba=115.715n spba1=117.043n \
        dfm_flag=0 spmt=1.11111e+15 spomt=0 spomt1=1.11111e+60 \
        spmb=1.11111e+15 spomb=0 spomb1=1.11111e+60
    MP_CLEAR (RC1 A VDD VDD) pch_mac l=30n w=3u multi=1 nf=1 sd=100n \
        ad=2.25e-13 as=2.25e-13 pd=6.15u ps=6.15u nrd=0.055246 \
        nrs=0.055246 sa=75.0n sb=75.0n sa1=75.0n sa2=75.0n sa3=75.0n \
        sa4=75.0n sb1=75.0n sb2=75.0n sb3=75.0n spa=100n spa1=100n \
        spa2=100n spa3=100n sap=91.9776n sapb=114.444n spba=115.715n \
        spba1=117.043n dfm_flag=0 spmt=1.11111e+15 spomt=0 \
        spomt1=1.11111e+60 spmb=1.11111e+15 spomb=0 spomb1=1.11111e+60
ends sar8p_delay_bbm

subckt sar8p_delay_valid A VDD VSS Y
R1 (B RC1 ) rupolym l=17.13u w=1u m=1 multi=(1)

R0 (A RC0 ) rupolym l=17.13u w=1u m=1 multi=(1)

    C1 (RC1 VSS) cfmom_2t nr=8 lr=2.5u w=50n s=50n stm=1 spm=3 multi=1 \
        mismatchflag=1
    C0 (RC0 VSS) cfmom_2t nr=8 lr=2.5u w=50n s=50n stm=1 spm=3 multi=1 \
        mismatchflag=1
    X006 (A VDD VSS AB) sar8p_inv
    X005 (RC1 VDD VSS Y) sar8p_inv
    X002 (RC0 VDD VSS B) sar8p_inv
    MN_CLEAR (RC0 AB VSS VSS) nch_mac l=30n w=2u multi=1 nf=1 sd=100n \
        ad=1.5e-13 as=1.5e-13 pd=4.15u ps=4.15u nrd=0.144730 nrs=0.144730 \
        sa=75.0n sb=75.0n sa1=75.0n sa2=75.0n sa3=75.0n sa4=75.0n \
        sb1=75.0n sb2=75.0n sb3=75.0n spa=100n spa1=100n spa2=100n \
        spa3=100n sap=91.9776n sapb=114.444n spba=115.715n spba1=117.043n \
        dfm_flag=0 spmt=1.11111e+15 spomt=0 spomt1=1.11111e+60 \
        spmb=1.11111e+15 spomb=0 spomb1=1.11111e+60
    MP_CLEAR (RC1 A VDD VDD) pch_mac l=30n w=3u multi=1 nf=1 sd=100n \
        ad=2.25e-13 as=2.25e-13 pd=6.15u ps=6.15u nrd=0.055246 \
        nrs=0.055246 sa=75.0n sb=75.0n sa1=75.0n sa2=75.0n sa3=75.0n \
        sa4=75.0n sb1=75.0n sb2=75.0n sb3=75.0n spa=100n spa1=100n \
        spa2=100n spa3=100n sap=91.9776n sapb=114.444n spba=115.715n \
        spba1=117.043n dfm_flag=0 spmt=1.11111e+15 spomt=0 \
        spomt1=1.11111e+60 spmb=1.11111e+15 spomb=0 spomb1=1.11111e+60
ends sar8p_delay_valid

subckt sar8p_delay_write A VDD VSS Y
R1 (B RC1 ) rupolym l=17.13u w=1u m=1 multi=(1)

R0 (A RC0 ) rupolym l=17.13u w=1u m=1 multi=(1)

    C1 (RC1 VSS) cfmom_2t nr=8 lr=2.5u w=50n s=50n stm=1 spm=3 multi=4 \
        mismatchflag=1
    C0 (RC0 VSS) cfmom_2t nr=8 lr=2.5u w=50n s=50n stm=1 spm=3 multi=4 \
        mismatchflag=1
    X006 (A VDD VSS AB) sar8p_inv
    X005 (RC1 VDD VSS Y) sar8p_inv
    X002 (RC0 VDD VSS B) sar8p_inv
    MN_CLEAR (RC0 AB VSS VSS) nch_mac l=30n w=2u multi=1 nf=1 sd=100n \
        ad=1.5e-13 as=1.5e-13 pd=4.15u ps=4.15u nrd=0.144730 nrs=0.144730 \
        sa=75.0n sb=75.0n sa1=75.0n sa2=75.0n sa3=75.0n sa4=75.0n \
        sb1=75.0n sb2=75.0n sb3=75.0n spa=100n spa1=100n spa2=100n \
        spa3=100n sap=91.9776n sapb=114.444n spba=115.715n spba1=117.043n \
        dfm_flag=0 spmt=1.11111e+15 spomt=0 spomt1=1.11111e+60 \
        spmb=1.11111e+15 spomb=0 spomb1=1.11111e+60
    MP_CLEAR (RC1 A VDD VDD) pch_mac l=30n w=3u multi=1 nf=1 sd=100n \
        ad=2.25e-13 as=2.25e-13 pd=6.15u ps=6.15u nrd=0.055246 \
        nrs=0.055246 sa=75.0n sb=75.0n sa1=75.0n sa2=75.0n sa3=75.0n \
        sa4=75.0n sb1=75.0n sb2=75.0n sb3=75.0n spa=100n spa1=100n \
        spa2=100n spa3=100n sap=91.9776n sapb=114.444n spba=115.715n \
        spba1=117.043n dfm_flag=0 spmt=1.11111e+15 spomt=0 \
        spomt1=1.11111e+60 spmb=1.11111e+15 spomb=0 spomb1=1.11111e+60
ends sar8p_delay_write

subckt sar8p_dffr CK D Q RST VDD VSS
    X013 (SB VDD VSS Q) sar8p_inv
    X007 (MB VDD VSS MQ) sar8p_inv
    X001 (RST VDD VSS RN) sar8p_inv
    X000 (CK VDD VSS CKB) sar8p_inv
    MN_SF (S CKB Q VSS) nch_mac l=30n w=1u multi=1 nf=1 sd=100n ad=7.5e-14 \
        as=7.5e-14 pd=2.15u ps=2.15u nrd=0.289519 nrs=0.289519 sa=75.0n \
        sb=75.0n sa1=75.0n sa2=75.0n sa3=75.0n sa4=75.0n sb1=75.0n \
        sb2=75.0n sb3=75.0n spa=100n spa1=100n spa2=100n spa3=100n \
        sap=91.9776n sapb=114.444n spba=115.715n spba1=117.043n dfm_flag=0 \
        spmt=1.11111e+15 spomt=0 spomt1=1.11111e+60 spmb=1.11111e+15 \
        spomb=0 spomb1=1.11111e+60
    MN_SI (S CK MQ VSS) nch_mac l=30n w=1u multi=1 nf=1 sd=100n ad=7.5e-14 \
        as=7.5e-14 pd=2.15u ps=2.15u nrd=0.289519 nrs=0.289519 sa=75.0n \
        sb=75.0n sa1=75.0n sa2=75.0n sa3=75.0n sa4=75.0n sb1=75.0n \
        sb2=75.0n sb3=75.0n spa=100n spa1=100n spa2=100n spa3=100n \
        sap=91.9776n sapb=114.444n spba=115.715n spba1=117.043n dfm_flag=0 \
        spmt=1.11111e+15 spomt=0 spomt1=1.11111e+60 spmb=1.11111e+15 \
        spomb=0 spomb1=1.11111e+60
    MN_MF (M CK MQ VSS) nch_mac l=30n w=1u multi=1 nf=1 sd=100n ad=7.5e-14 \
        as=7.5e-14 pd=2.15u ps=2.15u nrd=0.289519 nrs=0.289519 sa=75.0n \
        sb=75.0n sa1=75.0n sa2=75.0n sa3=75.0n sa4=75.0n sb1=75.0n \
        sb2=75.0n sb3=75.0n spa=100n spa1=100n spa2=100n spa3=100n \
        sap=91.9776n sapb=114.444n spba=115.715n spba1=117.043n dfm_flag=0 \
        spmt=1.11111e+15 spomt=0 spomt1=1.11111e+60 spmb=1.11111e+15 \
        spomb=0 spomb1=1.11111e+60
    MN_MI (M CKB D VSS) nch_mac l=30n w=1u multi=1 nf=1 sd=100n ad=7.5e-14 \
        as=7.5e-14 pd=2.15u ps=2.15u nrd=0.289519 nrs=0.289519 sa=75.0n \
        sb=75.0n sa1=75.0n sa2=75.0n sa3=75.0n sa4=75.0n sb1=75.0n \
        sb2=75.0n sb3=75.0n spa=100n spa1=100n spa2=100n spa3=100n \
        sap=91.9776n sapb=114.444n spba=115.715n spba1=117.043n dfm_flag=0 \
        spmt=1.11111e+15 spomt=0 spomt1=1.11111e+60 spmb=1.11111e+15 \
        spomb=0 spomb1=1.11111e+60
    MP_SF (S CK Q VDD) pch_mac l=30n w=2u multi=1 nf=1 sd=100n ad=1.5e-13 \
        as=1.5e-13 pd=4.15u ps=4.15u nrd=0.082877 nrs=0.082877 sa=75.0n \
        sb=75.0n sa1=75.0n sa2=75.0n sa3=75.0n sa4=75.0n sb1=75.0n \
        sb2=75.0n sb3=75.0n spa=100n spa1=100n spa2=100n spa3=100n \
        sap=91.9776n sapb=114.444n spba=115.715n spba1=117.043n dfm_flag=0 \
        spmt=1.11111e+15 spomt=0 spomt1=1.11111e+60 spmb=1.11111e+15 \
        spomb=0 spomb1=1.11111e+60
    MP_SI (S CKB MQ VDD) pch_mac l=30n w=2u multi=1 nf=1 sd=100n \
        ad=1.5e-13 as=1.5e-13 pd=4.15u ps=4.15u nrd=0.082877 nrs=0.082877 \
        sa=75.0n sb=75.0n sa1=75.0n sa2=75.0n sa3=75.0n sa4=75.0n \
        sb1=75.0n sb2=75.0n sb3=75.0n spa=100n spa1=100n spa2=100n \
        spa3=100n sap=91.9776n sapb=114.444n spba=115.715n spba1=117.043n \
        dfm_flag=0 spmt=1.11111e+15 spomt=0 spomt1=1.11111e+60 \
        spmb=1.11111e+15 spomb=0 spomb1=1.11111e+60
    MP_MF (M CKB MQ VDD) pch_mac l=30n w=2u multi=1 nf=1 sd=100n \
        ad=1.5e-13 as=1.5e-13 pd=4.15u ps=4.15u nrd=0.082877 nrs=0.082877 \
        sa=75.0n sb=75.0n sa1=75.0n sa2=75.0n sa3=75.0n sa4=75.0n \
        sb1=75.0n sb2=75.0n sb3=75.0n spa=100n spa1=100n spa2=100n \
        spa3=100n sap=91.9776n sapb=114.444n spba=115.715n spba1=117.043n \
        dfm_flag=0 spmt=1.11111e+15 spomt=0 spomt1=1.11111e+60 \
        spmb=1.11111e+15 spomb=0 spomb1=1.11111e+60
    MP_MI (M CK D VDD) pch_mac l=30n w=2u multi=1 nf=1 sd=100n ad=1.5e-13 \
        as=1.5e-13 pd=4.15u ps=4.15u nrd=0.082877 nrs=0.082877 sa=75.0n \
        sb=75.0n sa1=75.0n sa2=75.0n sa3=75.0n sa4=75.0n sb1=75.0n \
        sb2=75.0n sb3=75.0n spa=100n spa1=100n spa2=100n spa3=100n \
        sap=91.9776n sapb=114.444n spba=115.715n spba1=117.043n dfm_flag=0 \
        spmt=1.11111e+15 spomt=0 spomt1=1.11111e+60 spmb=1.11111e+15 \
        spomb=0 spomb1=1.11111e+60
    X012 (S RN VDD VSS SB) sar8p_nand2
    X006 (M RN VDD VSS MB) sar8p_nand2
    CSTORE_S (S VSS) cfmom_2t nr=8 lr=2.5u w=50n s=50n stm=1 spm=3 multi=1 \
        mismatchflag=1
    CSTORE_M (M VSS) cfmom_2t nr=8 lr=2.5u w=50n s=50n stm=1 spm=3 multi=1 \
        mismatchflag=1
ends sar8p_dffr

subckt sar8p_inv A VDD VSS Y
    MP (Y A VDD VDD) pch_mac l=30n w=1u multi=1 nf=1 sd=100n ad=7.5e-14 \
        as=7.5e-14 pd=2.15u ps=2.15u nrd=0.165806 nrs=0.165806 sa=75.0n \
        sb=75.0n sa1=75.0n sa2=75.0n sa3=75.0n sa4=75.0n sb1=75.0n \
        sb2=75.0n sb3=75.0n spa=100n spa1=100n spa2=100n spa3=100n \
        sap=91.9776n sapb=114.444n spba=115.715n spba1=117.043n dfm_flag=0 \
        spmt=1.11111e+15 spomt=0 spomt1=1.11111e+60 spmb=1.11111e+15 \
        spomb=0 spomb1=1.11111e+60
    MN (Y A VSS VSS) nch_mac l=30n w=500n multi=1 nf=1 sd=100n ad=3.75e-14 \
        as=3.75e-14 pd=1.15u ps=1.15u nrd=0.662935 nrs=0.662935 sa=75.0n \
        sb=75.0n sa1=75.0n sa2=75.0n sa3=75.0n sa4=75.0n sb1=75.0n \
        sb2=75.0n sb3=75.0n spa=100n spa1=100n spa2=100n spa3=100n \
        sap=91.9776n sapb=114.444n spba=115.715n spba1=117.043n dfm_flag=0 \
        spmt=1.11111e+15 spomt=0 spomt1=1.11111e+60 spmb=1.11111e+15 \
        spomb=0 spomb1=1.11111e+60
ends sar8p_inv

subckt sar8p_mux2 D0 D1 SEL VDD VSS Y
    X000 (SEL VDD VSS SB) sar8p_inv
    X003 (N0 N1 VDD VSS Y) sar8p_nand2
    X002 (D1 SEL VDD VSS N1) sar8p_nand2
    X001 (D0 SB VDD VSS N0) sar8p_nand2
ends sar8p_mux2

subckt sar8p_nand2 A B VDD VSS Y
    MP1 (Y B VDD VDD) pch_mac l=30n w=1u multi=1 nf=1 sd=100n ad=7.5e-14 \
        as=7.5e-14 pd=2.15u ps=2.15u nrd=0.165806 nrs=0.165806 sa=75.0n \
        sb=75.0n sa1=75.0n sa2=75.0n sa3=75.0n sa4=75.0n sb1=75.0n \
        sb2=75.0n sb3=75.0n spa=100n spa1=100n spa2=100n spa3=100n \
        sap=91.9776n sapb=114.444n spba=115.715n spba1=117.043n dfm_flag=0 \
        spmt=1.11111e+15 spomt=0 spomt1=1.11111e+60 spmb=1.11111e+15 \
        spomb=0 spomb1=1.11111e+60
    MP0 (Y A VDD VDD) pch_mac l=30n w=1u multi=1 nf=1 sd=100n ad=7.5e-14 \
        as=7.5e-14 pd=2.15u ps=2.15u nrd=0.165806 nrs=0.165806 sa=75.0n \
        sb=75.0n sa1=75.0n sa2=75.0n sa3=75.0n sa4=75.0n sb1=75.0n \
        sb2=75.0n sb3=75.0n spa=100n spa1=100n spa2=100n spa3=100n \
        sap=91.9776n sapb=114.444n spba=115.715n spba1=117.043n dfm_flag=0 \
        spmt=1.11111e+15 spomt=0 spomt1=1.11111e+60 spmb=1.11111e+15 \
        spomb=0 spomb1=1.11111e+60
    MN1 (MID B VSS VSS) nch_mac l=30n w=1u multi=1 nf=1 sd=100n ad=7.5e-14 \
        as=7.5e-14 pd=2.15u ps=2.15u nrd=0.289519 nrs=0.289519 sa=75.0n \
        sb=75.0n sa1=75.0n sa2=75.0n sa3=75.0n sa4=75.0n sb1=75.0n \
        sb2=75.0n sb3=75.0n spa=100n spa1=100n spa2=100n spa3=100n \
        sap=91.9776n sapb=114.444n spba=115.715n spba1=117.043n dfm_flag=0 \
        spmt=1.11111e+15 spomt=0 spomt1=1.11111e+60 spmb=1.11111e+15 \
        spomb=0 spomb1=1.11111e+60
    MN0 (Y A MID VSS) nch_mac l=30n w=1u multi=1 nf=1 sd=100n ad=7.5e-14 \
        as=7.5e-14 pd=2.15u ps=2.15u nrd=0.289519 nrs=0.289519 sa=75.0n \
        sb=75.0n sa1=75.0n sa2=75.0n sa3=75.0n sa4=75.0n sb1=75.0n \
        sb2=75.0n sb3=75.0n spa=100n spa1=100n spa2=100n spa3=100n \
        sap=91.9776n sapb=114.444n spba=115.715n spba1=117.043n dfm_flag=0 \
        spmt=1.11111e+15 spomt=0 spomt1=1.11111e+60 spmb=1.11111e+15 \
        spomb=0 spomb1=1.11111e+60
    CMID (MID VSS) cfmom_2t nr=8 lr=2.5u w=50n s=50n stm=1 spm=3 multi=2 \
        mismatchflag=1
ends sar8p_nand2

subckt sar8p_nonoverlap CODE H L VDD VSS
    X000 (CODE VDD VSS CB) sar8p_inv
    XD_LD (CB VDD VSS LD) sar8p_delay_bbm
    XD_HD (CODE VDD VSS HD) sar8p_delay_bbm
    X004 (CB LD VDD VSS L) sar8p_and2
    X002 (CODE HD VDD VSS H) sar8p_and2
ends sar8p_nonoverlap

subckt sar8p_or2 A B VDD VSS Y
    X001 (B VDD VSS BB) sar8p_inv
    X000 (A VDD VSS AB) sar8p_inv
    X002 (AB BB VDD VSS Y) sar8p_nand2
ends sar8p_or2

subckt sar8p_refdrv_b0 GNN GNP GPN GPP H L VDD VSS
    GNNCN (GNNDRV GNN_CG VSS VSS) nch_mac l=30n w=500n multi=1 nf=1 sd=100n \
        ad=3.75e-14 as=3.75e-14 pd=1.15u ps=1.15u nrd=0.662935 \
        nrs=0.662935 sa=75.0n sb=75.0n sa1=75.0n sa2=75.0n sa3=75.0n \
        sa4=75.0n sb1=75.0n sb2=75.0n sb3=75.0n spa=100n spa1=100n \
        spa2=100n spa3=100n sap=91.9776n sapb=114.444n spba=115.715n \
        spba1=117.043n dfm_flag=0 spmt=1.11111e+15 spomt=0 \
        spomt1=1.11111e+60 spmb=1.11111e+15 spomb=0 spomb1=1.11111e+60
    GNNBN (GNNB GNNA VSS VSS) nch_mac l=30n w=500n multi=1 nf=1 sd=100n \
        ad=3.75e-14 as=3.75e-14 pd=1.15u ps=1.15u nrd=0.662935 \
        nrs=0.662935 sa=75.0n sb=75.0n sa1=75.0n sa2=75.0n sa3=75.0n \
        sa4=75.0n sb1=75.0n sb2=75.0n sb3=75.0n spa=100n spa1=100n \
        spa2=100n spa3=100n sap=91.9776n sapb=114.444n spba=115.715n \
        spba1=117.043n dfm_flag=0 spmt=1.11111e+15 spomt=0 \
        spomt1=1.11111e+60 spmb=1.11111e+15 spomb=0 spomb1=1.11111e+60
    GNNAN (GNNA GNNPRE VSS VSS) nch_mac l=30n w=500n multi=1 nf=1 sd=100n \
        ad=3.75e-14 as=3.75e-14 pd=1.15u ps=1.15u nrd=0.662935 \
        nrs=0.662935 sa=75.0n sb=75.0n sa1=75.0n sa2=75.0n sa3=75.0n \
        sa4=75.0n sb1=75.0n sb2=75.0n sb3=75.0n spa=100n spa1=100n \
        spa2=100n spa3=100n sap=91.9776n sapb=114.444n spba=115.715n \
        spba1=117.043n dfm_flag=0 spmt=1.11111e+15 spomt=0 \
        spomt1=1.11111e+60 spmb=1.11111e+15 spomb=0 spomb1=1.11111e+60
    GNPCN (GNPDRV GNPB VSS VSS) nch_mac l=30n w=500n multi=1 nf=1 sd=100n \
        ad=3.75e-14 as=3.75e-14 pd=1.15u ps=1.15u nrd=0.662935 \
        nrs=0.662935 sa=75.0n sb=75.0n sa1=75.0n sa2=75.0n sa3=75.0n \
        sa4=75.0n sb1=75.0n sb2=75.0n sb3=75.0n spa=100n spa1=100n \
        spa2=100n spa3=100n sap=91.9776n sapb=114.444n spba=115.715n \
        spba1=117.043n dfm_flag=0 spmt=1.11111e+15 spomt=0 \
        spomt1=1.11111e+60 spmb=1.11111e+15 spomb=0 spomb1=1.11111e+60
    GNPBN (GNPB GNPA VSS VSS) nch_mac l=30n w=500n multi=1 nf=1 sd=100n \
        ad=3.75e-14 as=3.75e-14 pd=1.15u ps=1.15u nrd=0.662935 \
        nrs=0.662935 sa=75.0n sb=75.0n sa1=75.0n sa2=75.0n sa3=75.0n \
        sa4=75.0n sb1=75.0n sb2=75.0n sb3=75.0n spa=100n spa1=100n \
        spa2=100n spa3=100n sap=91.9776n sapb=114.444n spba=115.715n \
        spba1=117.043n dfm_flag=0 spmt=1.11111e+15 spomt=0 \
        spomt1=1.11111e+60 spmb=1.11111e+15 spomb=0 spomb1=1.11111e+60
    GNPAN (GNPA H VSS VSS) nch_mac l=30n w=500n multi=1 nf=1 sd=100n \
        ad=3.75e-14 as=3.75e-14 pd=1.15u ps=1.15u nrd=0.662935 \
        nrs=0.662935 sa=75.0n sb=75.0n sa1=75.0n sa2=75.0n sa3=75.0n \
        sa4=75.0n sb1=75.0n sb2=75.0n sb3=75.0n spa=100n spa1=100n \
        spa2=100n spa3=100n sap=91.9776n sapb=114.444n spba=115.715n \
        spba1=117.043n dfm_flag=0 spmt=1.11111e+15 spomt=0 \
        spomt1=1.11111e+60 spmb=1.11111e+15 spomb=0 spomb1=1.11111e+60
    GPNCN (GPNDRV GPNB VSS VSS) nch_mac l=30n w=500n multi=1 nf=1 sd=100n \
        ad=3.75e-14 as=3.75e-14 pd=1.15u ps=1.15u nrd=0.662935 \
        nrs=0.662935 sa=75.0n sb=75.0n sa1=75.0n sa2=75.0n sa3=75.0n \
        sa4=75.0n sb1=75.0n sb2=75.0n sb3=75.0n spa=100n spa1=100n \
        spa2=100n spa3=100n sap=91.9776n sapb=114.444n spba=115.715n \
        spba1=117.043n dfm_flag=0 spmt=1.11111e+15 spomt=0 \
        spomt1=1.11111e+60 spmb=1.11111e+15 spomb=0 spomb1=1.11111e+60
    GPNBN (GPNB GPNA VSS VSS) nch_mac l=30n w=500n multi=1 nf=1 sd=100n \
        ad=3.75e-14 as=3.75e-14 pd=1.15u ps=1.15u nrd=0.662935 \
        nrs=0.662935 sa=75.0n sb=75.0n sa1=75.0n sa2=75.0n sa3=75.0n \
        sa4=75.0n sb1=75.0n sb2=75.0n sb3=75.0n spa=100n spa1=100n \
        spa2=100n spa3=100n sap=91.9776n sapb=114.444n spba=115.715n \
        spba1=117.043n dfm_flag=0 spmt=1.11111e+15 spomt=0 \
        spomt1=1.11111e+60 spmb=1.11111e+15 spomb=0 spomb1=1.11111e+60
    GPNAN (GPNA GPNPRE VSS VSS) nch_mac l=30n w=500n multi=1 nf=1 sd=100n \
        ad=3.75e-14 as=3.75e-14 pd=1.15u ps=1.15u nrd=0.662935 \
        nrs=0.662935 sa=75.0n sb=75.0n sa1=75.0n sa2=75.0n sa3=75.0n \
        sa4=75.0n sb1=75.0n sb2=75.0n sb3=75.0n spa=100n spa1=100n \
        spa2=100n spa3=100n sap=91.9776n sapb=114.444n spba=115.715n \
        spba1=117.043n dfm_flag=0 spmt=1.11111e+15 spomt=0 \
        spomt1=1.11111e+60 spmb=1.11111e+15 spomb=0 spomb1=1.11111e+60
    GPPCN (GPPDRV GPPB VSS VSS) nch_mac l=30n w=500n multi=1 nf=1 sd=100n \
        ad=3.75e-14 as=3.75e-14 pd=1.15u ps=1.15u nrd=0.662935 \
        nrs=0.662935 sa=75.0n sb=75.0n sa1=75.0n sa2=75.0n sa3=75.0n \
        sa4=75.0n sb1=75.0n sb2=75.0n sb3=75.0n spa=100n spa1=100n \
        spa2=100n spa3=100n sap=91.9776n sapb=114.444n spba=115.715n \
        spba1=117.043n dfm_flag=0 spmt=1.11111e+15 spomt=0 \
        spomt1=1.11111e+60 spmb=1.11111e+15 spomb=0 spomb1=1.11111e+60
    GPPBN (GPPB GPPA VSS VSS) nch_mac l=30n w=500n multi=1 nf=1 sd=100n \
        ad=3.75e-14 as=3.75e-14 pd=1.15u ps=1.15u nrd=0.662935 \
        nrs=0.662935 sa=75.0n sb=75.0n sa1=75.0n sa2=75.0n sa3=75.0n \
        sa4=75.0n sb1=75.0n sb2=75.0n sb3=75.0n spa=100n spa1=100n \
        spa2=100n spa3=100n sap=91.9776n sapb=114.444n spba=115.715n \
        spba1=117.043n dfm_flag=0 spmt=1.11111e+15 spomt=0 \
        spomt1=1.11111e+60 spmb=1.11111e+15 spomb=0 spomb1=1.11111e+60
    GPPAN (GPPA L VSS VSS) nch_mac l=30n w=500n multi=1 nf=1 sd=100n \
        ad=3.75e-14 as=3.75e-14 pd=1.15u ps=1.15u nrd=0.662935 \
        nrs=0.662935 sa=75.0n sb=75.0n sa1=75.0n sa2=75.0n sa3=75.0n \
        sa4=75.0n sb1=75.0n sb2=75.0n sb3=75.0n spa=100n spa1=100n \
        spa2=100n spa3=100n sap=91.9776n sapb=114.444n spba=115.715n \
        spba1=117.043n dfm_flag=0 spmt=1.11111e+15 spomt=0 \
        spomt1=1.11111e+60 spmb=1.11111e+15 spomb=0 spomb1=1.11111e+60
    GNNCP (GNNDRV GNN_CG VDD VDD) pch_mac l=30n w=1u multi=1 nf=1 sd=100n \
        ad=7.5e-14 as=7.5e-14 pd=2.15u ps=2.15u nrd=0.165806 nrs=0.165806 \
        sa=75.0n sb=75.0n sa1=75.0n sa2=75.0n sa3=75.0n sa4=75.0n \
        sb1=75.0n sb2=75.0n sb3=75.0n spa=100n spa1=100n spa2=100n \
        spa3=100n sap=91.9776n sapb=114.444n spba=115.715n spba1=117.043n \
        dfm_flag=0 spmt=1.11111e+15 spomt=0 spomt1=1.11111e+60 \
        spmb=1.11111e+15 spomb=0 spomb1=1.11111e+60
    GNNBP (GNNB GNNA VDD VDD) pch_mac l=30n w=1u multi=1 nf=1 sd=100n \
        ad=7.5e-14 as=7.5e-14 pd=2.15u ps=2.15u nrd=0.165806 nrs=0.165806 \
        sa=75.0n sb=75.0n sa1=75.0n sa2=75.0n sa3=75.0n sa4=75.0n \
        sb1=75.0n sb2=75.0n sb3=75.0n spa=100n spa1=100n spa2=100n \
        spa3=100n sap=91.9776n sapb=114.444n spba=115.715n spba1=117.043n \
        dfm_flag=0 spmt=1.11111e+15 spomt=0 spomt1=1.11111e+60 \
        spmb=1.11111e+15 spomb=0 spomb1=1.11111e+60
    GNNAP (GNNA GNNPRE VDD VDD) pch_mac l=30n w=1u multi=1 nf=1 sd=100n \
        ad=7.5e-14 as=7.5e-14 pd=2.15u ps=2.15u nrd=0.165806 nrs=0.165806 \
        sa=75.0n sb=75.0n sa1=75.0n sa2=75.0n sa3=75.0n sa4=75.0n \
        sb1=75.0n sb2=75.0n sb3=75.0n spa=100n spa1=100n spa2=100n \
        spa3=100n sap=91.9776n sapb=114.444n spba=115.715n spba1=117.043n \
        dfm_flag=0 spmt=1.11111e+15 spomt=0 spomt1=1.11111e+60 \
        spmb=1.11111e+15 spomb=0 spomb1=1.11111e+60
    GNPCP (GNPDRV GNPB VDD VDD) pch_mac l=30n w=1u multi=1 nf=1 sd=100n \
        ad=7.5e-14 as=7.5e-14 pd=2.15u ps=2.15u nrd=0.165806 nrs=0.165806 \
        sa=75.0n sb=75.0n sa1=75.0n sa2=75.0n sa3=75.0n sa4=75.0n \
        sb1=75.0n sb2=75.0n sb3=75.0n spa=100n spa1=100n spa2=100n \
        spa3=100n sap=91.9776n sapb=114.444n spba=115.715n spba1=117.043n \
        dfm_flag=0 spmt=1.11111e+15 spomt=0 spomt1=1.11111e+60 \
        spmb=1.11111e+15 spomb=0 spomb1=1.11111e+60
    GNPBP (GNPB GNPA VDD VDD) pch_mac l=30n w=1u multi=1 nf=1 sd=100n \
        ad=7.5e-14 as=7.5e-14 pd=2.15u ps=2.15u nrd=0.165806 nrs=0.165806 \
        sa=75.0n sb=75.0n sa1=75.0n sa2=75.0n sa3=75.0n sa4=75.0n \
        sb1=75.0n sb2=75.0n sb3=75.0n spa=100n spa1=100n spa2=100n \
        spa3=100n sap=91.9776n sapb=114.444n spba=115.715n spba1=117.043n \
        dfm_flag=0 spmt=1.11111e+15 spomt=0 spomt1=1.11111e+60 \
        spmb=1.11111e+15 spomb=0 spomb1=1.11111e+60
    GNPAP (GNPA H VDD VDD) pch_mac l=30n w=1u multi=1 nf=1 sd=100n \
        ad=7.5e-14 as=7.5e-14 pd=2.15u ps=2.15u nrd=0.165806 nrs=0.165806 \
        sa=75.0n sb=75.0n sa1=75.0n sa2=75.0n sa3=75.0n sa4=75.0n \
        sb1=75.0n sb2=75.0n sb3=75.0n spa=100n spa1=100n spa2=100n \
        spa3=100n sap=91.9776n sapb=114.444n spba=115.715n spba1=117.043n \
        dfm_flag=0 spmt=1.11111e+15 spomt=0 spomt1=1.11111e+60 \
        spmb=1.11111e+15 spomb=0 spomb1=1.11111e+60
    GPNCP (GPNDRV GPNB VDD VDD) pch_mac l=30n w=1u multi=1 nf=1 sd=100n \
        ad=7.5e-14 as=7.5e-14 pd=2.15u ps=2.15u nrd=0.165806 nrs=0.165806 \
        sa=75.0n sb=75.0n sa1=75.0n sa2=75.0n sa3=75.0n sa4=75.0n \
        sb1=75.0n sb2=75.0n sb3=75.0n spa=100n spa1=100n spa2=100n \
        spa3=100n sap=91.9776n sapb=114.444n spba=115.715n spba1=117.043n \
        dfm_flag=0 spmt=1.11111e+15 spomt=0 spomt1=1.11111e+60 \
        spmb=1.11111e+15 spomb=0 spomb1=1.11111e+60
    GPNBP (GPNB GPNA VDD VDD) pch_mac l=30n w=1u multi=1 nf=1 sd=100n \
        ad=7.5e-14 as=7.5e-14 pd=2.15u ps=2.15u nrd=0.165806 nrs=0.165806 \
        sa=75.0n sb=75.0n sa1=75.0n sa2=75.0n sa3=75.0n sa4=75.0n \
        sb1=75.0n sb2=75.0n sb3=75.0n spa=100n spa1=100n spa2=100n \
        spa3=100n sap=91.9776n sapb=114.444n spba=115.715n spba1=117.043n \
        dfm_flag=0 spmt=1.11111e+15 spomt=0 spomt1=1.11111e+60 \
        spmb=1.11111e+15 spomb=0 spomb1=1.11111e+60
    GPNAP (GPNA GPNPRE VDD VDD) pch_mac l=30n w=1u multi=1 nf=1 sd=100n \
        ad=7.5e-14 as=7.5e-14 pd=2.15u ps=2.15u nrd=0.165806 nrs=0.165806 \
        sa=75.0n sb=75.0n sa1=75.0n sa2=75.0n sa3=75.0n sa4=75.0n \
        sb1=75.0n sb2=75.0n sb3=75.0n spa=100n spa1=100n spa2=100n \
        spa3=100n sap=91.9776n sapb=114.444n spba=115.715n spba1=117.043n \
        dfm_flag=0 spmt=1.11111e+15 spomt=0 spomt1=1.11111e+60 \
        spmb=1.11111e+15 spomb=0 spomb1=1.11111e+60
    GPPCP (GPPDRV GPPB VDD VDD) pch_mac l=30n w=1u multi=1 nf=1 sd=100n \
        ad=7.5e-14 as=7.5e-14 pd=2.15u ps=2.15u nrd=0.165806 nrs=0.165806 \
        sa=75.0n sb=75.0n sa1=75.0n sa2=75.0n sa3=75.0n sa4=75.0n \
        sb1=75.0n sb2=75.0n sb3=75.0n spa=100n spa1=100n spa2=100n \
        spa3=100n sap=91.9776n sapb=114.444n spba=115.715n spba1=117.043n \
        dfm_flag=0 spmt=1.11111e+15 spomt=0 spomt1=1.11111e+60 \
        spmb=1.11111e+15 spomb=0 spomb1=1.11111e+60
    GPPBP (GPPB GPPA VDD VDD) pch_mac l=30n w=1u multi=1 nf=1 sd=100n \
        ad=7.5e-14 as=7.5e-14 pd=2.15u ps=2.15u nrd=0.165806 nrs=0.165806 \
        sa=75.0n sb=75.0n sa1=75.0n sa2=75.0n sa3=75.0n sa4=75.0n \
        sb1=75.0n sb2=75.0n sb3=75.0n spa=100n spa1=100n spa2=100n \
        spa3=100n sap=91.9776n sapb=114.444n spba=115.715n spba1=117.043n \
        dfm_flag=0 spmt=1.11111e+15 spomt=0 spomt1=1.11111e+60 \
        spmb=1.11111e+15 spomb=0 spomb1=1.11111e+60
    GPPAP (GPPA L VDD VDD) pch_mac l=30n w=1u multi=1 nf=1 sd=100n \
        ad=7.5e-14 as=7.5e-14 pd=2.15u ps=2.15u nrd=0.165806 nrs=0.165806 \
        sa=75.0n sb=75.0n sa1=75.0n sa2=75.0n sa3=75.0n sa4=75.0n \
        sb1=75.0n sb2=75.0n sb3=75.0n spa=100n spa1=100n spa2=100n \
        spa3=100n sap=91.9776n sapb=114.444n spba=115.715n spba1=117.043n \
        dfm_flag=0 spmt=1.11111e+15 spomt=0 spomt1=1.11111e+60 \
        spmb=1.11111e+15 spomb=0 spomb1=1.11111e+60
//Series configuration of RGNN1
RGNN1  (GNNRG RGNN1_1__dmy0 ) rupolym l=17.13u w=1u m=1 multi=(1)
RGNN1_2__dmy0  (RGNN1_1__dmy0 RGNN1_2__dmy0 ) rupolym l=17.13u w=1u m=1 \
        multi=(1)
RGNN1_3__dmy0  (RGNN1_2__dmy0 RGNN1_3__dmy0 ) rupolym l=17.13u w=1u m=1 \
        multi=(1)
RGNN1_4__dmy0  (RGNN1_3__dmy0 RGNN1_4__dmy0 ) rupolym l=17.13u w=1u m=1 \
        multi=(1)
RGNN1_5__dmy0  (RGNN1_4__dmy0 GNN ) rupolym l=17.13u w=1u m=1 multi=(1)
//End of RGNN1

//Series configuration of RGNN0
RGNN0  (GNNDRV RGNN0_1__dmy0 ) rupolym l=17.13u w=1u m=1 multi=(1)
RGNN0_2__dmy0  (RGNN0_1__dmy0 RGNN0_2__dmy0 ) rupolym l=17.13u w=1u m=1 \
        multi=(1)
RGNN0_3__dmy0  (RGNN0_2__dmy0 RGNN0_3__dmy0 ) rupolym l=17.13u w=1u m=1 \
        multi=(1)
RGNN0_4__dmy0  (RGNN0_3__dmy0 RGNN0_4__dmy0 ) rupolym l=17.13u w=1u m=1 \
        multi=(1)
RGNN0_5__dmy0  (RGNN0_4__dmy0 GNNRG ) rupolym l=17.13u w=1u m=1 multi=(1)
//End of RGNN0

//Series configuration of RGNP1
RGNP1  (GNPRG RGNP1_1__dmy0 ) rupolym l=17.13u w=1u m=1 multi=(1)
RGNP1_2__dmy0  (RGNP1_1__dmy0 RGNP1_2__dmy0 ) rupolym l=17.13u w=1u m=1 \
        multi=(1)
RGNP1_3__dmy0  (RGNP1_2__dmy0 RGNP1_3__dmy0 ) rupolym l=17.13u w=1u m=1 \
        multi=(1)
RGNP1_4__dmy0  (RGNP1_3__dmy0 RGNP1_4__dmy0 ) rupolym l=17.13u w=1u m=1 \
        multi=(1)
RGNP1_5__dmy0  (RGNP1_4__dmy0 GNP ) rupolym l=17.13u w=1u m=1 multi=(1)
//End of RGNP1

//Series configuration of RGNP0
RGNP0  (GNPDRV RGNP0_1__dmy0 ) rupolym l=17.13u w=1u m=1 multi=(1)
RGNP0_2__dmy0  (RGNP0_1__dmy0 RGNP0_2__dmy0 ) rupolym l=17.13u w=1u m=1 \
        multi=(1)
RGNP0_3__dmy0  (RGNP0_2__dmy0 RGNP0_3__dmy0 ) rupolym l=17.13u w=1u m=1 \
        multi=(1)
RGNP0_4__dmy0  (RGNP0_3__dmy0 RGNP0_4__dmy0 ) rupolym l=17.13u w=1u m=1 \
        multi=(1)
RGNP0_5__dmy0  (RGNP0_4__dmy0 GNPRG ) rupolym l=17.13u w=1u m=1 multi=(1)
//End of RGNP0

//Series configuration of RGPN1
RGPN1  (GPNRG RGPN1_1__dmy0 ) rupolym l=17.13u w=1u m=1 multi=(1)
RGPN1_2__dmy0  (RGPN1_1__dmy0 RGPN1_2__dmy0 ) rupolym l=17.13u w=1u m=1 \
        multi=(1)
RGPN1_3__dmy0  (RGPN1_2__dmy0 RGPN1_3__dmy0 ) rupolym l=17.13u w=1u m=1 \
        multi=(1)
RGPN1_4__dmy0  (RGPN1_3__dmy0 RGPN1_4__dmy0 ) rupolym l=17.13u w=1u m=1 \
        multi=(1)
RGPN1_5__dmy0  (RGPN1_4__dmy0 GPN ) rupolym l=17.13u w=1u m=1 multi=(1)
//End of RGPN1

//Series configuration of RGPN0
RGPN0  (GPNDRV RGPN0_1__dmy0 ) rupolym l=17.13u w=1u m=1 multi=(1)
RGPN0_2__dmy0  (RGPN0_1__dmy0 RGPN0_2__dmy0 ) rupolym l=17.13u w=1u m=1 \
        multi=(1)
RGPN0_3__dmy0  (RGPN0_2__dmy0 RGPN0_3__dmy0 ) rupolym l=17.13u w=1u m=1 \
        multi=(1)
RGPN0_4__dmy0  (RGPN0_3__dmy0 RGPN0_4__dmy0 ) rupolym l=17.13u w=1u m=1 \
        multi=(1)
RGPN0_5__dmy0  (RGPN0_4__dmy0 GPNRG ) rupolym l=17.13u w=1u m=1 multi=(1)
//End of RGPN0

//Series configuration of RGPP1
RGPP1  (GPPRG RGPP1_1__dmy0 ) rupolym l=17.13u w=1u m=1 multi=(1)
RGPP1_2__dmy0  (RGPP1_1__dmy0 RGPP1_2__dmy0 ) rupolym l=17.13u w=1u m=1 \
        multi=(1)
RGPP1_3__dmy0  (RGPP1_2__dmy0 RGPP1_3__dmy0 ) rupolym l=17.13u w=1u m=1 \
        multi=(1)
RGPP1_4__dmy0  (RGPP1_3__dmy0 RGPP1_4__dmy0 ) rupolym l=17.13u w=1u m=1 \
        multi=(1)
RGPP1_5__dmy0  (RGPP1_4__dmy0 GPP ) rupolym l=17.13u w=1u m=1 multi=(1)
//End of RGPP1

//Series configuration of RGPP0
RGPP0  (GPPDRV RGPP0_1__dmy0 ) rupolym l=17.13u w=1u m=1 multi=(1)
RGPP0_2__dmy0  (RGPP0_1__dmy0 RGPP0_2__dmy0 ) rupolym l=17.13u w=1u m=1 \
        multi=(1)
RGPP0_3__dmy0  (RGPP0_2__dmy0 RGPP0_3__dmy0 ) rupolym l=17.13u w=1u m=1 \
        multi=(1)
RGPP0_4__dmy0  (RGPP0_3__dmy0 RGPP0_4__dmy0 ) rupolym l=17.13u w=1u m=1 \
        multi=(1)
RGPP0_5__dmy0  (RGPP0_4__dmy0 GPPRG ) rupolym l=17.13u w=1u m=1 multi=(1)
//End of RGPP0

    X025 (L VDD VSS GNNPRE) sar8p_inv
    X008 (H VDD VSS GPNPRE) sar8p_inv
    R_CIN (GNNB GNN_CG) resistor r=1k
ends sar8p_refdrv_b0

subckt sar8p_refdrv_b1 GNN GNP GPN GPP H L VDD VSS
    GNNCN (GNNDRV GNNB VSS VSS) nch_mac l=30n w=500n multi=1 nf=1 sd=100n \
        ad=3.75e-14 as=3.75e-14 pd=1.15u ps=1.15u nrd=0.662935 \
        nrs=0.662935 sa=75.0n sb=75.0n sa1=75.0n sa2=75.0n sa3=75.0n \
        sa4=75.0n sb1=75.0n sb2=75.0n sb3=75.0n spa=100n spa1=100n \
        spa2=100n spa3=100n sap=91.9776n sapb=114.444n spba=115.715n \
        spba1=117.043n dfm_flag=0 spmt=1.11111e+15 spomt=0 \
        spomt1=1.11111e+60 spmb=1.11111e+15 spomb=0 spomb1=1.11111e+60
    GNNBN (GNNB GNNA VSS VSS) nch_mac l=30n w=500n multi=1 nf=1 sd=100n \
        ad=3.75e-14 as=3.75e-14 pd=1.15u ps=1.15u nrd=0.662935 \
        nrs=0.662935 sa=75.0n sb=75.0n sa1=75.0n sa2=75.0n sa3=75.0n \
        sa4=75.0n sb1=75.0n sb2=75.0n sb3=75.0n spa=100n spa1=100n \
        spa2=100n spa3=100n sap=91.9776n sapb=114.444n spba=115.715n \
        spba1=117.043n dfm_flag=0 spmt=1.11111e+15 spomt=0 \
        spomt1=1.11111e+60 spmb=1.11111e+15 spomb=0 spomb1=1.11111e+60
    GNNAN (GNNA GNNPRE VSS VSS) nch_mac l=30n w=500n multi=1 nf=1 sd=100n \
        ad=3.75e-14 as=3.75e-14 pd=1.15u ps=1.15u nrd=0.662935 \
        nrs=0.662935 sa=75.0n sb=75.0n sa1=75.0n sa2=75.0n sa3=75.0n \
        sa4=75.0n sb1=75.0n sb2=75.0n sb3=75.0n spa=100n spa1=100n \
        spa2=100n spa3=100n sap=91.9776n sapb=114.444n spba=115.715n \
        spba1=117.043n dfm_flag=0 spmt=1.11111e+15 spomt=0 \
        spomt1=1.11111e+60 spmb=1.11111e+15 spomb=0 spomb1=1.11111e+60
    GNPCN (GNPDRV GNPB VSS VSS) nch_mac l=30n w=500n multi=1 nf=1 sd=100n \
        ad=3.75e-14 as=3.75e-14 pd=1.15u ps=1.15u nrd=0.662935 \
        nrs=0.662935 sa=75.0n sb=75.0n sa1=75.0n sa2=75.0n sa3=75.0n \
        sa4=75.0n sb1=75.0n sb2=75.0n sb3=75.0n spa=100n spa1=100n \
        spa2=100n spa3=100n sap=91.9776n sapb=114.444n spba=115.715n \
        spba1=117.043n dfm_flag=0 spmt=1.11111e+15 spomt=0 \
        spomt1=1.11111e+60 spmb=1.11111e+15 spomb=0 spomb1=1.11111e+60
    GNPBN (GNPB GNPA VSS VSS) nch_mac l=30n w=500n multi=1 nf=1 sd=100n \
        ad=3.75e-14 as=3.75e-14 pd=1.15u ps=1.15u nrd=0.662935 \
        nrs=0.662935 sa=75.0n sb=75.0n sa1=75.0n sa2=75.0n sa3=75.0n \
        sa4=75.0n sb1=75.0n sb2=75.0n sb3=75.0n spa=100n spa1=100n \
        spa2=100n spa3=100n sap=91.9776n sapb=114.444n spba=115.715n \
        spba1=117.043n dfm_flag=0 spmt=1.11111e+15 spomt=0 \
        spomt1=1.11111e+60 spmb=1.11111e+15 spomb=0 spomb1=1.11111e+60
    GNPAN (GNPA H VSS VSS) nch_mac l=30n w=500n multi=1 nf=1 sd=100n \
        ad=3.75e-14 as=3.75e-14 pd=1.15u ps=1.15u nrd=0.662935 \
        nrs=0.662935 sa=75.0n sb=75.0n sa1=75.0n sa2=75.0n sa3=75.0n \
        sa4=75.0n sb1=75.0n sb2=75.0n sb3=75.0n spa=100n spa1=100n \
        spa2=100n spa3=100n sap=91.9776n sapb=114.444n spba=115.715n \
        spba1=117.043n dfm_flag=0 spmt=1.11111e+15 spomt=0 \
        spomt1=1.11111e+60 spmb=1.11111e+15 spomb=0 spomb1=1.11111e+60
    GPNCN (GPNDRV GPNB VSS VSS) nch_mac l=30n w=500n multi=1 nf=1 sd=100n \
        ad=3.75e-14 as=3.75e-14 pd=1.15u ps=1.15u nrd=0.662935 \
        nrs=0.662935 sa=75.0n sb=75.0n sa1=75.0n sa2=75.0n sa3=75.0n \
        sa4=75.0n sb1=75.0n sb2=75.0n sb3=75.0n spa=100n spa1=100n \
        spa2=100n spa3=100n sap=91.9776n sapb=114.444n spba=115.715n \
        spba1=117.043n dfm_flag=0 spmt=1.11111e+15 spomt=0 \
        spomt1=1.11111e+60 spmb=1.11111e+15 spomb=0 spomb1=1.11111e+60
    GPNBN (GPNB GPNA VSS VSS) nch_mac l=30n w=500n multi=1 nf=1 sd=100n \
        ad=3.75e-14 as=3.75e-14 pd=1.15u ps=1.15u nrd=0.662935 \
        nrs=0.662935 sa=75.0n sb=75.0n sa1=75.0n sa2=75.0n sa3=75.0n \
        sa4=75.0n sb1=75.0n sb2=75.0n sb3=75.0n spa=100n spa1=100n \
        spa2=100n spa3=100n sap=91.9776n sapb=114.444n spba=115.715n \
        spba1=117.043n dfm_flag=0 spmt=1.11111e+15 spomt=0 \
        spomt1=1.11111e+60 spmb=1.11111e+15 spomb=0 spomb1=1.11111e+60
    GPNAN (GPNA GPNPRE VSS VSS) nch_mac l=30n w=500n multi=1 nf=1 sd=100n \
        ad=3.75e-14 as=3.75e-14 pd=1.15u ps=1.15u nrd=0.662935 \
        nrs=0.662935 sa=75.0n sb=75.0n sa1=75.0n sa2=75.0n sa3=75.0n \
        sa4=75.0n sb1=75.0n sb2=75.0n sb3=75.0n spa=100n spa1=100n \
        spa2=100n spa3=100n sap=91.9776n sapb=114.444n spba=115.715n \
        spba1=117.043n dfm_flag=0 spmt=1.11111e+15 spomt=0 \
        spomt1=1.11111e+60 spmb=1.11111e+15 spomb=0 spomb1=1.11111e+60
    GPPCN (GPPDRV GPPB VSS VSS) nch_mac l=30n w=500n multi=1 nf=1 sd=100n \
        ad=3.75e-14 as=3.75e-14 pd=1.15u ps=1.15u nrd=0.662935 \
        nrs=0.662935 sa=75.0n sb=75.0n sa1=75.0n sa2=75.0n sa3=75.0n \
        sa4=75.0n sb1=75.0n sb2=75.0n sb3=75.0n spa=100n spa1=100n \
        spa2=100n spa3=100n sap=91.9776n sapb=114.444n spba=115.715n \
        spba1=117.043n dfm_flag=0 spmt=1.11111e+15 spomt=0 \
        spomt1=1.11111e+60 spmb=1.11111e+15 spomb=0 spomb1=1.11111e+60
    GPPBN (GPPB GPPA VSS VSS) nch_mac l=30n w=500n multi=1 nf=1 sd=100n \
        ad=3.75e-14 as=3.75e-14 pd=1.15u ps=1.15u nrd=0.662935 \
        nrs=0.662935 sa=75.0n sb=75.0n sa1=75.0n sa2=75.0n sa3=75.0n \
        sa4=75.0n sb1=75.0n sb2=75.0n sb3=75.0n spa=100n spa1=100n \
        spa2=100n spa3=100n sap=91.9776n sapb=114.444n spba=115.715n \
        spba1=117.043n dfm_flag=0 spmt=1.11111e+15 spomt=0 \
        spomt1=1.11111e+60 spmb=1.11111e+15 spomb=0 spomb1=1.11111e+60
    GPPAN (GPPA L VSS VSS) nch_mac l=30n w=500n multi=1 nf=1 sd=100n \
        ad=3.75e-14 as=3.75e-14 pd=1.15u ps=1.15u nrd=0.662935 \
        nrs=0.662935 sa=75.0n sb=75.0n sa1=75.0n sa2=75.0n sa3=75.0n \
        sa4=75.0n sb1=75.0n sb2=75.0n sb3=75.0n spa=100n spa1=100n \
        spa2=100n spa3=100n sap=91.9776n sapb=114.444n spba=115.715n \
        spba1=117.043n dfm_flag=0 spmt=1.11111e+15 spomt=0 \
        spomt1=1.11111e+60 spmb=1.11111e+15 spomb=0 spomb1=1.11111e+60
    GNNCP (GNNDRV GNNB VDD VDD) pch_mac l=30n w=1u multi=1 nf=1 sd=100n \
        ad=7.5e-14 as=7.5e-14 pd=2.15u ps=2.15u nrd=0.165806 nrs=0.165806 \
        sa=75.0n sb=75.0n sa1=75.0n sa2=75.0n sa3=75.0n sa4=75.0n \
        sb1=75.0n sb2=75.0n sb3=75.0n spa=100n spa1=100n spa2=100n \
        spa3=100n sap=91.9776n sapb=114.444n spba=115.715n spba1=117.043n \
        dfm_flag=0 spmt=1.11111e+15 spomt=0 spomt1=1.11111e+60 \
        spmb=1.11111e+15 spomb=0 spomb1=1.11111e+60
    GNNBP (GNNB GNNA VDD VDD) pch_mac l=30n w=1u multi=1 nf=1 sd=100n \
        ad=7.5e-14 as=7.5e-14 pd=2.15u ps=2.15u nrd=0.165806 nrs=0.165806 \
        sa=75.0n sb=75.0n sa1=75.0n sa2=75.0n sa3=75.0n sa4=75.0n \
        sb1=75.0n sb2=75.0n sb3=75.0n spa=100n spa1=100n spa2=100n \
        spa3=100n sap=91.9776n sapb=114.444n spba=115.715n spba1=117.043n \
        dfm_flag=0 spmt=1.11111e+15 spomt=0 spomt1=1.11111e+60 \
        spmb=1.11111e+15 spomb=0 spomb1=1.11111e+60
    GNNAP (GNNA GNNPRE VDD VDD) pch_mac l=30n w=1u multi=1 nf=1 sd=100n \
        ad=7.5e-14 as=7.5e-14 pd=2.15u ps=2.15u nrd=0.165806 nrs=0.165806 \
        sa=75.0n sb=75.0n sa1=75.0n sa2=75.0n sa3=75.0n sa4=75.0n \
        sb1=75.0n sb2=75.0n sb3=75.0n spa=100n spa1=100n spa2=100n \
        spa3=100n sap=91.9776n sapb=114.444n spba=115.715n spba1=117.043n \
        dfm_flag=0 spmt=1.11111e+15 spomt=0 spomt1=1.11111e+60 \
        spmb=1.11111e+15 spomb=0 spomb1=1.11111e+60
    GNPCP (GNPDRV GNPB VDD VDD) pch_mac l=30n w=1u multi=1 nf=1 sd=100n \
        ad=7.5e-14 as=7.5e-14 pd=2.15u ps=2.15u nrd=0.165806 nrs=0.165806 \
        sa=75.0n sb=75.0n sa1=75.0n sa2=75.0n sa3=75.0n sa4=75.0n \
        sb1=75.0n sb2=75.0n sb3=75.0n spa=100n spa1=100n spa2=100n \
        spa3=100n sap=91.9776n sapb=114.444n spba=115.715n spba1=117.043n \
        dfm_flag=0 spmt=1.11111e+15 spomt=0 spomt1=1.11111e+60 \
        spmb=1.11111e+15 spomb=0 spomb1=1.11111e+60
    GNPBP (GNPB GNPA VDD VDD) pch_mac l=30n w=1u multi=1 nf=1 sd=100n \
        ad=7.5e-14 as=7.5e-14 pd=2.15u ps=2.15u nrd=0.165806 nrs=0.165806 \
        sa=75.0n sb=75.0n sa1=75.0n sa2=75.0n sa3=75.0n sa4=75.0n \
        sb1=75.0n sb2=75.0n sb3=75.0n spa=100n spa1=100n spa2=100n \
        spa3=100n sap=91.9776n sapb=114.444n spba=115.715n spba1=117.043n \
        dfm_flag=0 spmt=1.11111e+15 spomt=0 spomt1=1.11111e+60 \
        spmb=1.11111e+15 spomb=0 spomb1=1.11111e+60
    GNPAP (GNPA H VDD VDD) pch_mac l=30n w=1u multi=1 nf=1 sd=100n \
        ad=7.5e-14 as=7.5e-14 pd=2.15u ps=2.15u nrd=0.165806 nrs=0.165806 \
        sa=75.0n sb=75.0n sa1=75.0n sa2=75.0n sa3=75.0n sa4=75.0n \
        sb1=75.0n sb2=75.0n sb3=75.0n spa=100n spa1=100n spa2=100n \
        spa3=100n sap=91.9776n sapb=114.444n spba=115.715n spba1=117.043n \
        dfm_flag=0 spmt=1.11111e+15 spomt=0 spomt1=1.11111e+60 \
        spmb=1.11111e+15 spomb=0 spomb1=1.11111e+60
    GPNCP (GPNDRV GPNB VDD VDD) pch_mac l=30n w=1u multi=1 nf=1 sd=100n \
        ad=7.5e-14 as=7.5e-14 pd=2.15u ps=2.15u nrd=0.165806 nrs=0.165806 \
        sa=75.0n sb=75.0n sa1=75.0n sa2=75.0n sa3=75.0n sa4=75.0n \
        sb1=75.0n sb2=75.0n sb3=75.0n spa=100n spa1=100n spa2=100n \
        spa3=100n sap=91.9776n sapb=114.444n spba=115.715n spba1=117.043n \
        dfm_flag=0 spmt=1.11111e+15 spomt=0 spomt1=1.11111e+60 \
        spmb=1.11111e+15 spomb=0 spomb1=1.11111e+60
    GPNBP (GPNB GPNA VDD VDD) pch_mac l=30n w=1u multi=1 nf=1 sd=100n \
        ad=7.5e-14 as=7.5e-14 pd=2.15u ps=2.15u nrd=0.165806 nrs=0.165806 \
        sa=75.0n sb=75.0n sa1=75.0n sa2=75.0n sa3=75.0n sa4=75.0n \
        sb1=75.0n sb2=75.0n sb3=75.0n spa=100n spa1=100n spa2=100n \
        spa3=100n sap=91.9776n sapb=114.444n spba=115.715n spba1=117.043n \
        dfm_flag=0 spmt=1.11111e+15 spomt=0 spomt1=1.11111e+60 \
        spmb=1.11111e+15 spomb=0 spomb1=1.11111e+60
    GPNAP (GPNA GPNPRE VDD VDD) pch_mac l=30n w=1u multi=1 nf=1 sd=100n \
        ad=7.5e-14 as=7.5e-14 pd=2.15u ps=2.15u nrd=0.165806 nrs=0.165806 \
        sa=75.0n sb=75.0n sa1=75.0n sa2=75.0n sa3=75.0n sa4=75.0n \
        sb1=75.0n sb2=75.0n sb3=75.0n spa=100n spa1=100n spa2=100n \
        spa3=100n sap=91.9776n sapb=114.444n spba=115.715n spba1=117.043n \
        dfm_flag=0 spmt=1.11111e+15 spomt=0 spomt1=1.11111e+60 \
        spmb=1.11111e+15 spomb=0 spomb1=1.11111e+60
    GPPCP (GPPDRV GPPB VDD VDD) pch_mac l=30n w=1u multi=1 nf=1 sd=100n \
        ad=7.5e-14 as=7.5e-14 pd=2.15u ps=2.15u nrd=0.165806 nrs=0.165806 \
        sa=75.0n sb=75.0n sa1=75.0n sa2=75.0n sa3=75.0n sa4=75.0n \
        sb1=75.0n sb2=75.0n sb3=75.0n spa=100n spa1=100n spa2=100n \
        spa3=100n sap=91.9776n sapb=114.444n spba=115.715n spba1=117.043n \
        dfm_flag=0 spmt=1.11111e+15 spomt=0 spomt1=1.11111e+60 \
        spmb=1.11111e+15 spomb=0 spomb1=1.11111e+60
    GPPBP (GPPB GPPA VDD VDD) pch_mac l=30n w=1u multi=1 nf=1 sd=100n \
        ad=7.5e-14 as=7.5e-14 pd=2.15u ps=2.15u nrd=0.165806 nrs=0.165806 \
        sa=75.0n sb=75.0n sa1=75.0n sa2=75.0n sa3=75.0n sa4=75.0n \
        sb1=75.0n sb2=75.0n sb3=75.0n spa=100n spa1=100n spa2=100n \
        spa3=100n sap=91.9776n sapb=114.444n spba=115.715n spba1=117.043n \
        dfm_flag=0 spmt=1.11111e+15 spomt=0 spomt1=1.11111e+60 \
        spmb=1.11111e+15 spomb=0 spomb1=1.11111e+60
    GPPAP (GPPA L VDD VDD) pch_mac l=30n w=1u multi=1 nf=1 sd=100n \
        ad=7.5e-14 as=7.5e-14 pd=2.15u ps=2.15u nrd=0.165806 nrs=0.165806 \
        sa=75.0n sb=75.0n sa1=75.0n sa2=75.0n sa3=75.0n sa4=75.0n \
        sb1=75.0n sb2=75.0n sb3=75.0n spa=100n spa1=100n spa2=100n \
        spa3=100n sap=91.9776n sapb=114.444n spba=115.715n spba1=117.043n \
        dfm_flag=0 spmt=1.11111e+15 spomt=0 spomt1=1.11111e+60 \
        spmb=1.11111e+15 spomb=0 spomb1=1.11111e+60
//Series configuration of RGNN1
RGNN1  (GNNRG RGNN1_1__dmy0 ) rupolym l=17.13u w=1u m=2 multi=(1)
RGNN1_2__dmy0  (RGNN1_1__dmy0 RGNN1_2__dmy0 ) rupolym l=17.13u w=1u m=2 \
        multi=(1)
RGNN1_3__dmy0  (RGNN1_2__dmy0 RGNN1_3__dmy0 ) rupolym l=17.13u w=1u m=2 \
        multi=(1)
RGNN1_4__dmy0  (RGNN1_3__dmy0 RGNN1_4__dmy0 ) rupolym l=17.13u w=1u m=2 \
        multi=(1)
RGNN1_5__dmy0  (RGNN1_4__dmy0 GNN ) rupolym l=17.13u w=1u m=2 multi=(1)
//End of RGNN1

//Series configuration of RGNN0
RGNN0  (GNNDRV RGNN0_1__dmy0 ) rupolym l=17.13u w=1u m=2 multi=(1)
RGNN0_2__dmy0  (RGNN0_1__dmy0 RGNN0_2__dmy0 ) rupolym l=17.13u w=1u m=2 \
        multi=(1)
RGNN0_3__dmy0  (RGNN0_2__dmy0 RGNN0_3__dmy0 ) rupolym l=17.13u w=1u m=2 \
        multi=(1)
RGNN0_4__dmy0  (RGNN0_3__dmy0 RGNN0_4__dmy0 ) rupolym l=17.13u w=1u m=2 \
        multi=(1)
RGNN0_5__dmy0  (RGNN0_4__dmy0 GNNRG ) rupolym l=17.13u w=1u m=2 multi=(1)
//End of RGNN0

//Series configuration of RGNP1
RGNP1  (GNPRG RGNP1_1__dmy0 ) rupolym l=17.13u w=1u m=2 multi=(1)
RGNP1_2__dmy0  (RGNP1_1__dmy0 RGNP1_2__dmy0 ) rupolym l=17.13u w=1u m=2 \
        multi=(1)
RGNP1_3__dmy0  (RGNP1_2__dmy0 RGNP1_3__dmy0 ) rupolym l=17.13u w=1u m=2 \
        multi=(1)
RGNP1_4__dmy0  (RGNP1_3__dmy0 RGNP1_4__dmy0 ) rupolym l=17.13u w=1u m=2 \
        multi=(1)
RGNP1_5__dmy0  (RGNP1_4__dmy0 GNP ) rupolym l=17.13u w=1u m=2 multi=(1)
//End of RGNP1

//Series configuration of RGNP0
RGNP0  (GNPDRV RGNP0_1__dmy0 ) rupolym l=17.13u w=1u m=2 multi=(1)
RGNP0_2__dmy0  (RGNP0_1__dmy0 RGNP0_2__dmy0 ) rupolym l=17.13u w=1u m=2 \
        multi=(1)
RGNP0_3__dmy0  (RGNP0_2__dmy0 RGNP0_3__dmy0 ) rupolym l=17.13u w=1u m=2 \
        multi=(1)
RGNP0_4__dmy0  (RGNP0_3__dmy0 RGNP0_4__dmy0 ) rupolym l=17.13u w=1u m=2 \
        multi=(1)
RGNP0_5__dmy0  (RGNP0_4__dmy0 GNPRG ) rupolym l=17.13u w=1u m=2 multi=(1)
//End of RGNP0

//Series configuration of RGPN1
RGPN1  (GPNRG RGPN1_1__dmy0 ) rupolym l=17.13u w=1u m=2 multi=(1)
RGPN1_2__dmy0  (RGPN1_1__dmy0 RGPN1_2__dmy0 ) rupolym l=17.13u w=1u m=2 \
        multi=(1)
RGPN1_3__dmy0  (RGPN1_2__dmy0 RGPN1_3__dmy0 ) rupolym l=17.13u w=1u m=2 \
        multi=(1)
RGPN1_4__dmy0  (RGPN1_3__dmy0 RGPN1_4__dmy0 ) rupolym l=17.13u w=1u m=2 \
        multi=(1)
RGPN1_5__dmy0  (RGPN1_4__dmy0 GPN ) rupolym l=17.13u w=1u m=2 multi=(1)
//End of RGPN1

//Series configuration of RGPN0
RGPN0  (GPNDRV RGPN0_1__dmy0 ) rupolym l=17.13u w=1u m=2 multi=(1)
RGPN0_2__dmy0  (RGPN0_1__dmy0 RGPN0_2__dmy0 ) rupolym l=17.13u w=1u m=2 \
        multi=(1)
RGPN0_3__dmy0  (RGPN0_2__dmy0 RGPN0_3__dmy0 ) rupolym l=17.13u w=1u m=2 \
        multi=(1)
RGPN0_4__dmy0  (RGPN0_3__dmy0 RGPN0_4__dmy0 ) rupolym l=17.13u w=1u m=2 \
        multi=(1)
RGPN0_5__dmy0  (RGPN0_4__dmy0 GPNRG ) rupolym l=17.13u w=1u m=2 multi=(1)
//End of RGPN0

//Series configuration of RGPP1
RGPP1  (GPPRG RGPP1_1__dmy0 ) rupolym l=17.13u w=1u m=2 multi=(1)
RGPP1_2__dmy0  (RGPP1_1__dmy0 RGPP1_2__dmy0 ) rupolym l=17.13u w=1u m=2 \
        multi=(1)
RGPP1_3__dmy0  (RGPP1_2__dmy0 RGPP1_3__dmy0 ) rupolym l=17.13u w=1u m=2 \
        multi=(1)
RGPP1_4__dmy0  (RGPP1_3__dmy0 RGPP1_4__dmy0 ) rupolym l=17.13u w=1u m=2 \
        multi=(1)
RGPP1_5__dmy0  (RGPP1_4__dmy0 GPP ) rupolym l=17.13u w=1u m=2 multi=(1)
//End of RGPP1

//Series configuration of RGPP0
RGPP0  (GPPDRV RGPP0_1__dmy0 ) rupolym l=17.13u w=1u m=2 multi=(1)
RGPP0_2__dmy0  (RGPP0_1__dmy0 RGPP0_2__dmy0 ) rupolym l=17.13u w=1u m=2 \
        multi=(1)
RGPP0_3__dmy0  (RGPP0_2__dmy0 RGPP0_3__dmy0 ) rupolym l=17.13u w=1u m=2 \
        multi=(1)
RGPP0_4__dmy0  (RGPP0_3__dmy0 RGPP0_4__dmy0 ) rupolym l=17.13u w=1u m=2 \
        multi=(1)
RGPP0_5__dmy0  (RGPP0_4__dmy0 GPPRG ) rupolym l=17.13u w=1u m=2 multi=(1)
//End of RGPP0

    X025 (L VDD VSS GNNPRE) sar8p_inv
    X008 (H VDD VSS GPNPRE) sar8p_inv
ends sar8p_refdrv_b1

subckt sar8p_refdrv_b2 GNN GNP GPN GPP H L VDD VSS
    GNNCN (GNNDRV GNNB VSS VSS) nch_mac l=30n w=500n multi=1 nf=1 sd=100n \
        ad=3.75e-14 as=3.75e-14 pd=1.15u ps=1.15u nrd=0.662935 \
        nrs=0.662935 sa=75.0n sb=75.0n sa1=75.0n sa2=75.0n sa3=75.0n \
        sa4=75.0n sb1=75.0n sb2=75.0n sb3=75.0n spa=100n spa1=100n \
        spa2=100n spa3=100n sap=91.9776n sapb=114.444n spba=115.715n \
        spba1=117.043n dfm_flag=0 spmt=1.11111e+15 spomt=0 \
        spomt1=1.11111e+60 spmb=1.11111e+15 spomb=0 spomb1=1.11111e+60
    GNNBN (GNNB GNNA VSS VSS) nch_mac l=30n w=500n multi=1 nf=1 sd=100n \
        ad=3.75e-14 as=3.75e-14 pd=1.15u ps=1.15u nrd=0.662935 \
        nrs=0.662935 sa=75.0n sb=75.0n sa1=75.0n sa2=75.0n sa3=75.0n \
        sa4=75.0n sb1=75.0n sb2=75.0n sb3=75.0n spa=100n spa1=100n \
        spa2=100n spa3=100n sap=91.9776n sapb=114.444n spba=115.715n \
        spba1=117.043n dfm_flag=0 spmt=1.11111e+15 spomt=0 \
        spomt1=1.11111e+60 spmb=1.11111e+15 spomb=0 spomb1=1.11111e+60
    GNNAN (GNNA GNNPRE VSS VSS) nch_mac l=30n w=500n multi=1 nf=1 sd=100n \
        ad=3.75e-14 as=3.75e-14 pd=1.15u ps=1.15u nrd=0.662935 \
        nrs=0.662935 sa=75.0n sb=75.0n sa1=75.0n sa2=75.0n sa3=75.0n \
        sa4=75.0n sb1=75.0n sb2=75.0n sb3=75.0n spa=100n spa1=100n \
        spa2=100n spa3=100n sap=91.9776n sapb=114.444n spba=115.715n \
        spba1=117.043n dfm_flag=0 spmt=1.11111e+15 spomt=0 \
        spomt1=1.11111e+60 spmb=1.11111e+15 spomb=0 spomb1=1.11111e+60
    GNPCN (GNPDRV GNPB VSS VSS) nch_mac l=30n w=500n multi=1 nf=1 sd=100n \
        ad=3.75e-14 as=3.75e-14 pd=1.15u ps=1.15u nrd=0.662935 \
        nrs=0.662935 sa=75.0n sb=75.0n sa1=75.0n sa2=75.0n sa3=75.0n \
        sa4=75.0n sb1=75.0n sb2=75.0n sb3=75.0n spa=100n spa1=100n \
        spa2=100n spa3=100n sap=91.9776n sapb=114.444n spba=115.715n \
        spba1=117.043n dfm_flag=0 spmt=1.11111e+15 spomt=0 \
        spomt1=1.11111e+60 spmb=1.11111e+15 spomb=0 spomb1=1.11111e+60
    GNPBN (GNPB GNPA VSS VSS) nch_mac l=30n w=500n multi=1 nf=1 sd=100n \
        ad=3.75e-14 as=3.75e-14 pd=1.15u ps=1.15u nrd=0.662935 \
        nrs=0.662935 sa=75.0n sb=75.0n sa1=75.0n sa2=75.0n sa3=75.0n \
        sa4=75.0n sb1=75.0n sb2=75.0n sb3=75.0n spa=100n spa1=100n \
        spa2=100n spa3=100n sap=91.9776n sapb=114.444n spba=115.715n \
        spba1=117.043n dfm_flag=0 spmt=1.11111e+15 spomt=0 \
        spomt1=1.11111e+60 spmb=1.11111e+15 spomb=0 spomb1=1.11111e+60
    GNPAN (GNPA H VSS VSS) nch_mac l=30n w=500n multi=1 nf=1 sd=100n \
        ad=3.75e-14 as=3.75e-14 pd=1.15u ps=1.15u nrd=0.662935 \
        nrs=0.662935 sa=75.0n sb=75.0n sa1=75.0n sa2=75.0n sa3=75.0n \
        sa4=75.0n sb1=75.0n sb2=75.0n sb3=75.0n spa=100n spa1=100n \
        spa2=100n spa3=100n sap=91.9776n sapb=114.444n spba=115.715n \
        spba1=117.043n dfm_flag=0 spmt=1.11111e+15 spomt=0 \
        spomt1=1.11111e+60 spmb=1.11111e+15 spomb=0 spomb1=1.11111e+60
    GPNCN (GPNDRV GPNB VSS VSS) nch_mac l=30n w=500n multi=1 nf=1 sd=100n \
        ad=3.75e-14 as=3.75e-14 pd=1.15u ps=1.15u nrd=0.662935 \
        nrs=0.662935 sa=75.0n sb=75.0n sa1=75.0n sa2=75.0n sa3=75.0n \
        sa4=75.0n sb1=75.0n sb2=75.0n sb3=75.0n spa=100n spa1=100n \
        spa2=100n spa3=100n sap=91.9776n sapb=114.444n spba=115.715n \
        spba1=117.043n dfm_flag=0 spmt=1.11111e+15 spomt=0 \
        spomt1=1.11111e+60 spmb=1.11111e+15 spomb=0 spomb1=1.11111e+60
    GPNBN (GPNB GPNA VSS VSS) nch_mac l=30n w=500n multi=1 nf=1 sd=100n \
        ad=3.75e-14 as=3.75e-14 pd=1.15u ps=1.15u nrd=0.662935 \
        nrs=0.662935 sa=75.0n sb=75.0n sa1=75.0n sa2=75.0n sa3=75.0n \
        sa4=75.0n sb1=75.0n sb2=75.0n sb3=75.0n spa=100n spa1=100n \
        spa2=100n spa3=100n sap=91.9776n sapb=114.444n spba=115.715n \
        spba1=117.043n dfm_flag=0 spmt=1.11111e+15 spomt=0 \
        spomt1=1.11111e+60 spmb=1.11111e+15 spomb=0 spomb1=1.11111e+60
    GPNAN (GPNA GPNPRE VSS VSS) nch_mac l=30n w=500n multi=1 nf=1 sd=100n \
        ad=3.75e-14 as=3.75e-14 pd=1.15u ps=1.15u nrd=0.662935 \
        nrs=0.662935 sa=75.0n sb=75.0n sa1=75.0n sa2=75.0n sa3=75.0n \
        sa4=75.0n sb1=75.0n sb2=75.0n sb3=75.0n spa=100n spa1=100n \
        spa2=100n spa3=100n sap=91.9776n sapb=114.444n spba=115.715n \
        spba1=117.043n dfm_flag=0 spmt=1.11111e+15 spomt=0 \
        spomt1=1.11111e+60 spmb=1.11111e+15 spomb=0 spomb1=1.11111e+60
    GPPCN (GPPDRV GPPB VSS VSS) nch_mac l=30n w=500n multi=1 nf=1 sd=100n \
        ad=3.75e-14 as=3.75e-14 pd=1.15u ps=1.15u nrd=0.662935 \
        nrs=0.662935 sa=75.0n sb=75.0n sa1=75.0n sa2=75.0n sa3=75.0n \
        sa4=75.0n sb1=75.0n sb2=75.0n sb3=75.0n spa=100n spa1=100n \
        spa2=100n spa3=100n sap=91.9776n sapb=114.444n spba=115.715n \
        spba1=117.043n dfm_flag=0 spmt=1.11111e+15 spomt=0 \
        spomt1=1.11111e+60 spmb=1.11111e+15 spomb=0 spomb1=1.11111e+60
    GPPBN (GPPB GPPA VSS VSS) nch_mac l=30n w=500n multi=1 nf=1 sd=100n \
        ad=3.75e-14 as=3.75e-14 pd=1.15u ps=1.15u nrd=0.662935 \
        nrs=0.662935 sa=75.0n sb=75.0n sa1=75.0n sa2=75.0n sa3=75.0n \
        sa4=75.0n sb1=75.0n sb2=75.0n sb3=75.0n spa=100n spa1=100n \
        spa2=100n spa3=100n sap=91.9776n sapb=114.444n spba=115.715n \
        spba1=117.043n dfm_flag=0 spmt=1.11111e+15 spomt=0 \
        spomt1=1.11111e+60 spmb=1.11111e+15 spomb=0 spomb1=1.11111e+60
    GPPAN (GPPA L VSS VSS) nch_mac l=30n w=500n multi=1 nf=1 sd=100n \
        ad=3.75e-14 as=3.75e-14 pd=1.15u ps=1.15u nrd=0.662935 \
        nrs=0.662935 sa=75.0n sb=75.0n sa1=75.0n sa2=75.0n sa3=75.0n \
        sa4=75.0n sb1=75.0n sb2=75.0n sb3=75.0n spa=100n spa1=100n \
        spa2=100n spa3=100n sap=91.9776n sapb=114.444n spba=115.715n \
        spba1=117.043n dfm_flag=0 spmt=1.11111e+15 spomt=0 \
        spomt1=1.11111e+60 spmb=1.11111e+15 spomb=0 spomb1=1.11111e+60
    GNNCP (GNNDRV GNNB VDD VDD) pch_mac l=30n w=1u multi=1 nf=1 sd=100n \
        ad=7.5e-14 as=7.5e-14 pd=2.15u ps=2.15u nrd=0.165806 nrs=0.165806 \
        sa=75.0n sb=75.0n sa1=75.0n sa2=75.0n sa3=75.0n sa4=75.0n \
        sb1=75.0n sb2=75.0n sb3=75.0n spa=100n spa1=100n spa2=100n \
        spa3=100n sap=91.9776n sapb=114.444n spba=115.715n spba1=117.043n \
        dfm_flag=0 spmt=1.11111e+15 spomt=0 spomt1=1.11111e+60 \
        spmb=1.11111e+15 spomb=0 spomb1=1.11111e+60
    GNNBP (GNNB GNNA VDD VDD) pch_mac l=30n w=1u multi=1 nf=1 sd=100n \
        ad=7.5e-14 as=7.5e-14 pd=2.15u ps=2.15u nrd=0.165806 nrs=0.165806 \
        sa=75.0n sb=75.0n sa1=75.0n sa2=75.0n sa3=75.0n sa4=75.0n \
        sb1=75.0n sb2=75.0n sb3=75.0n spa=100n spa1=100n spa2=100n \
        spa3=100n sap=91.9776n sapb=114.444n spba=115.715n spba1=117.043n \
        dfm_flag=0 spmt=1.11111e+15 spomt=0 spomt1=1.11111e+60 \
        spmb=1.11111e+15 spomb=0 spomb1=1.11111e+60
    GNNAP (GNNA GNNPRE VDD VDD) pch_mac l=30n w=1u multi=1 nf=1 sd=100n \
        ad=7.5e-14 as=7.5e-14 pd=2.15u ps=2.15u nrd=0.165806 nrs=0.165806 \
        sa=75.0n sb=75.0n sa1=75.0n sa2=75.0n sa3=75.0n sa4=75.0n \
        sb1=75.0n sb2=75.0n sb3=75.0n spa=100n spa1=100n spa2=100n \
        spa3=100n sap=91.9776n sapb=114.444n spba=115.715n spba1=117.043n \
        dfm_flag=0 spmt=1.11111e+15 spomt=0 spomt1=1.11111e+60 \
        spmb=1.11111e+15 spomb=0 spomb1=1.11111e+60
    GNPCP (GNPDRV GNPB VDD VDD) pch_mac l=30n w=1u multi=1 nf=1 sd=100n \
        ad=7.5e-14 as=7.5e-14 pd=2.15u ps=2.15u nrd=0.165806 nrs=0.165806 \
        sa=75.0n sb=75.0n sa1=75.0n sa2=75.0n sa3=75.0n sa4=75.0n \
        sb1=75.0n sb2=75.0n sb3=75.0n spa=100n spa1=100n spa2=100n \
        spa3=100n sap=91.9776n sapb=114.444n spba=115.715n spba1=117.043n \
        dfm_flag=0 spmt=1.11111e+15 spomt=0 spomt1=1.11111e+60 \
        spmb=1.11111e+15 spomb=0 spomb1=1.11111e+60
    GNPBP (GNPB GNPA VDD VDD) pch_mac l=30n w=1u multi=1 nf=1 sd=100n \
        ad=7.5e-14 as=7.5e-14 pd=2.15u ps=2.15u nrd=0.165806 nrs=0.165806 \
        sa=75.0n sb=75.0n sa1=75.0n sa2=75.0n sa3=75.0n sa4=75.0n \
        sb1=75.0n sb2=75.0n sb3=75.0n spa=100n spa1=100n spa2=100n \
        spa3=100n sap=91.9776n sapb=114.444n spba=115.715n spba1=117.043n \
        dfm_flag=0 spmt=1.11111e+15 spomt=0 spomt1=1.11111e+60 \
        spmb=1.11111e+15 spomb=0 spomb1=1.11111e+60
    GNPAP (GNPA H VDD VDD) pch_mac l=30n w=1u multi=1 nf=1 sd=100n \
        ad=7.5e-14 as=7.5e-14 pd=2.15u ps=2.15u nrd=0.165806 nrs=0.165806 \
        sa=75.0n sb=75.0n sa1=75.0n sa2=75.0n sa3=75.0n sa4=75.0n \
        sb1=75.0n sb2=75.0n sb3=75.0n spa=100n spa1=100n spa2=100n \
        spa3=100n sap=91.9776n sapb=114.444n spba=115.715n spba1=117.043n \
        dfm_flag=0 spmt=1.11111e+15 spomt=0 spomt1=1.11111e+60 \
        spmb=1.11111e+15 spomb=0 spomb1=1.11111e+60
    GPNCP (GPNDRV GPNB VDD VDD) pch_mac l=30n w=1u multi=1 nf=1 sd=100n \
        ad=7.5e-14 as=7.5e-14 pd=2.15u ps=2.15u nrd=0.165806 nrs=0.165806 \
        sa=75.0n sb=75.0n sa1=75.0n sa2=75.0n sa3=75.0n sa4=75.0n \
        sb1=75.0n sb2=75.0n sb3=75.0n spa=100n spa1=100n spa2=100n \
        spa3=100n sap=91.9776n sapb=114.444n spba=115.715n spba1=117.043n \
        dfm_flag=0 spmt=1.11111e+15 spomt=0 spomt1=1.11111e+60 \
        spmb=1.11111e+15 spomb=0 spomb1=1.11111e+60
    GPNBP (GPNB GPNA VDD VDD) pch_mac l=30n w=1u multi=1 nf=1 sd=100n \
        ad=7.5e-14 as=7.5e-14 pd=2.15u ps=2.15u nrd=0.165806 nrs=0.165806 \
        sa=75.0n sb=75.0n sa1=75.0n sa2=75.0n sa3=75.0n sa4=75.0n \
        sb1=75.0n sb2=75.0n sb3=75.0n spa=100n spa1=100n spa2=100n \
        spa3=100n sap=91.9776n sapb=114.444n spba=115.715n spba1=117.043n \
        dfm_flag=0 spmt=1.11111e+15 spomt=0 spomt1=1.11111e+60 \
        spmb=1.11111e+15 spomb=0 spomb1=1.11111e+60
    GPNAP (GPNA GPNPRE VDD VDD) pch_mac l=30n w=1u multi=1 nf=1 sd=100n \
        ad=7.5e-14 as=7.5e-14 pd=2.15u ps=2.15u nrd=0.165806 nrs=0.165806 \
        sa=75.0n sb=75.0n sa1=75.0n sa2=75.0n sa3=75.0n sa4=75.0n \
        sb1=75.0n sb2=75.0n sb3=75.0n spa=100n spa1=100n spa2=100n \
        spa3=100n sap=91.9776n sapb=114.444n spba=115.715n spba1=117.043n \
        dfm_flag=0 spmt=1.11111e+15 spomt=0 spomt1=1.11111e+60 \
        spmb=1.11111e+15 spomb=0 spomb1=1.11111e+60
    GPPCP (GPPDRV GPPB VDD VDD) pch_mac l=30n w=1u multi=1 nf=1 sd=100n \
        ad=7.5e-14 as=7.5e-14 pd=2.15u ps=2.15u nrd=0.165806 nrs=0.165806 \
        sa=75.0n sb=75.0n sa1=75.0n sa2=75.0n sa3=75.0n sa4=75.0n \
        sb1=75.0n sb2=75.0n sb3=75.0n spa=100n spa1=100n spa2=100n \
        spa3=100n sap=91.9776n sapb=114.444n spba=115.715n spba1=117.043n \
        dfm_flag=0 spmt=1.11111e+15 spomt=0 spomt1=1.11111e+60 \
        spmb=1.11111e+15 spomb=0 spomb1=1.11111e+60
    GPPBP (GPPB GPPA VDD VDD) pch_mac l=30n w=1u multi=1 nf=1 sd=100n \
        ad=7.5e-14 as=7.5e-14 pd=2.15u ps=2.15u nrd=0.165806 nrs=0.165806 \
        sa=75.0n sb=75.0n sa1=75.0n sa2=75.0n sa3=75.0n sa4=75.0n \
        sb1=75.0n sb2=75.0n sb3=75.0n spa=100n spa1=100n spa2=100n \
        spa3=100n sap=91.9776n sapb=114.444n spba=115.715n spba1=117.043n \
        dfm_flag=0 spmt=1.11111e+15 spomt=0 spomt1=1.11111e+60 \
        spmb=1.11111e+15 spomb=0 spomb1=1.11111e+60
    GPPAP (GPPA L VDD VDD) pch_mac l=30n w=1u multi=1 nf=1 sd=100n \
        ad=7.5e-14 as=7.5e-14 pd=2.15u ps=2.15u nrd=0.165806 nrs=0.165806 \
        sa=75.0n sb=75.0n sa1=75.0n sa2=75.0n sa3=75.0n sa4=75.0n \
        sb1=75.0n sb2=75.0n sb3=75.0n spa=100n spa1=100n spa2=100n \
        spa3=100n sap=91.9776n sapb=114.444n spba=115.715n spba1=117.043n \
        dfm_flag=0 spmt=1.11111e+15 spomt=0 spomt1=1.11111e+60 \
        spmb=1.11111e+15 spomb=0 spomb1=1.11111e+60
//Series configuration of RGNN1
RGNN1  (GNNRG RGNN1_1__dmy0 ) rupolym l=17.13u w=1u m=4 multi=(1)
RGNN1_2__dmy0  (RGNN1_1__dmy0 RGNN1_2__dmy0 ) rupolym l=17.13u w=1u m=4 \
        multi=(1)
RGNN1_3__dmy0  (RGNN1_2__dmy0 RGNN1_3__dmy0 ) rupolym l=17.13u w=1u m=4 \
        multi=(1)
RGNN1_4__dmy0  (RGNN1_3__dmy0 RGNN1_4__dmy0 ) rupolym l=17.13u w=1u m=4 \
        multi=(1)
RGNN1_5__dmy0  (RGNN1_4__dmy0 GNN ) rupolym l=17.13u w=1u m=4 multi=(1)
//End of RGNN1

//Series configuration of RGNN0
RGNN0  (GNNDRV RGNN0_1__dmy0 ) rupolym l=17.13u w=1u m=4 multi=(1)
RGNN0_2__dmy0  (RGNN0_1__dmy0 RGNN0_2__dmy0 ) rupolym l=17.13u w=1u m=4 \
        multi=(1)
RGNN0_3__dmy0  (RGNN0_2__dmy0 RGNN0_3__dmy0 ) rupolym l=17.13u w=1u m=4 \
        multi=(1)
RGNN0_4__dmy0  (RGNN0_3__dmy0 RGNN0_4__dmy0 ) rupolym l=17.13u w=1u m=4 \
        multi=(1)
RGNN0_5__dmy0  (RGNN0_4__dmy0 GNNRG ) rupolym l=17.13u w=1u m=4 multi=(1)
//End of RGNN0

//Series configuration of RGNP1
RGNP1  (GNPRG RGNP1_1__dmy0 ) rupolym l=17.13u w=1u m=4 multi=(1)
RGNP1_2__dmy0  (RGNP1_1__dmy0 RGNP1_2__dmy0 ) rupolym l=17.13u w=1u m=4 \
        multi=(1)
RGNP1_3__dmy0  (RGNP1_2__dmy0 RGNP1_3__dmy0 ) rupolym l=17.13u w=1u m=4 \
        multi=(1)
RGNP1_4__dmy0  (RGNP1_3__dmy0 RGNP1_4__dmy0 ) rupolym l=17.13u w=1u m=4 \
        multi=(1)
RGNP1_5__dmy0  (RGNP1_4__dmy0 GNP ) rupolym l=17.13u w=1u m=4 multi=(1)
//End of RGNP1

//Series configuration of RGNP0
RGNP0  (GNPDRV RGNP0_1__dmy0 ) rupolym l=17.13u w=1u m=4 multi=(1)
RGNP0_2__dmy0  (RGNP0_1__dmy0 RGNP0_2__dmy0 ) rupolym l=17.13u w=1u m=4 \
        multi=(1)
RGNP0_3__dmy0  (RGNP0_2__dmy0 RGNP0_3__dmy0 ) rupolym l=17.13u w=1u m=4 \
        multi=(1)
RGNP0_4__dmy0  (RGNP0_3__dmy0 RGNP0_4__dmy0 ) rupolym l=17.13u w=1u m=4 \
        multi=(1)
RGNP0_5__dmy0  (RGNP0_4__dmy0 GNPRG ) rupolym l=17.13u w=1u m=4 multi=(1)
//End of RGNP0

//Series configuration of RGPN1
RGPN1  (GPNRG RGPN1_1__dmy0 ) rupolym l=17.13u w=1u m=4 multi=(1)
RGPN1_2__dmy0  (RGPN1_1__dmy0 RGPN1_2__dmy0 ) rupolym l=17.13u w=1u m=4 \
        multi=(1)
RGPN1_3__dmy0  (RGPN1_2__dmy0 RGPN1_3__dmy0 ) rupolym l=17.13u w=1u m=4 \
        multi=(1)
RGPN1_4__dmy0  (RGPN1_3__dmy0 RGPN1_4__dmy0 ) rupolym l=17.13u w=1u m=4 \
        multi=(1)
RGPN1_5__dmy0  (RGPN1_4__dmy0 GPN ) rupolym l=17.13u w=1u m=4 multi=(1)
//End of RGPN1

//Series configuration of RGPN0
RGPN0  (GPNDRV RGPN0_1__dmy0 ) rupolym l=17.13u w=1u m=4 multi=(1)
RGPN0_2__dmy0  (RGPN0_1__dmy0 RGPN0_2__dmy0 ) rupolym l=17.13u w=1u m=4 \
        multi=(1)
RGPN0_3__dmy0  (RGPN0_2__dmy0 RGPN0_3__dmy0 ) rupolym l=17.13u w=1u m=4 \
        multi=(1)
RGPN0_4__dmy0  (RGPN0_3__dmy0 RGPN0_4__dmy0 ) rupolym l=17.13u w=1u m=4 \
        multi=(1)
RGPN0_5__dmy0  (RGPN0_4__dmy0 GPNRG ) rupolym l=17.13u w=1u m=4 multi=(1)
//End of RGPN0

//Series configuration of RGPP1
RGPP1  (GPPRG RGPP1_1__dmy0 ) rupolym l=17.13u w=1u m=4 multi=(1)
RGPP1_2__dmy0  (RGPP1_1__dmy0 RGPP1_2__dmy0 ) rupolym l=17.13u w=1u m=4 \
        multi=(1)
RGPP1_3__dmy0  (RGPP1_2__dmy0 RGPP1_3__dmy0 ) rupolym l=17.13u w=1u m=4 \
        multi=(1)
RGPP1_4__dmy0  (RGPP1_3__dmy0 RGPP1_4__dmy0 ) rupolym l=17.13u w=1u m=4 \
        multi=(1)
RGPP1_5__dmy0  (RGPP1_4__dmy0 GPP ) rupolym l=17.13u w=1u m=4 multi=(1)
//End of RGPP1

//Series configuration of RGPP0
RGPP0  (GPPDRV RGPP0_1__dmy0 ) rupolym l=17.13u w=1u m=4 multi=(1)
RGPP0_2__dmy0  (RGPP0_1__dmy0 RGPP0_2__dmy0 ) rupolym l=17.13u w=1u m=4 \
        multi=(1)
RGPP0_3__dmy0  (RGPP0_2__dmy0 RGPP0_3__dmy0 ) rupolym l=17.13u w=1u m=4 \
        multi=(1)
RGPP0_4__dmy0  (RGPP0_3__dmy0 RGPP0_4__dmy0 ) rupolym l=17.13u w=1u m=4 \
        multi=(1)
RGPP0_5__dmy0  (RGPP0_4__dmy0 GPPRG ) rupolym l=17.13u w=1u m=4 multi=(1)
//End of RGPP0

    X025 (L VDD VSS GNNPRE) sar8p_inv
    X008 (H VDD VSS GPNPRE) sar8p_inv
ends sar8p_refdrv_b2

subckt sar8p_refdrv_b3 GNN GNP GPN GPP H L VDD VSS
    GNNCN (GNNDRV GNNB VSS VSS) nch_mac l=30n w=500n multi=1 nf=1 sd=100n \
        ad=3.75e-14 as=3.75e-14 pd=1.15u ps=1.15u nrd=0.662935 \
        nrs=0.662935 sa=75.0n sb=75.0n sa1=75.0n sa2=75.0n sa3=75.0n \
        sa4=75.0n sb1=75.0n sb2=75.0n sb3=75.0n spa=100n spa1=100n \
        spa2=100n spa3=100n sap=91.9776n sapb=114.444n spba=115.715n \
        spba1=117.043n dfm_flag=0 spmt=1.11111e+15 spomt=0 \
        spomt1=1.11111e+60 spmb=1.11111e+15 spomb=0 spomb1=1.11111e+60
    GNNBN (GNNB GNNA VSS VSS) nch_mac l=30n w=500n multi=1 nf=1 sd=100n \
        ad=3.75e-14 as=3.75e-14 pd=1.15u ps=1.15u nrd=0.662935 \
        nrs=0.662935 sa=75.0n sb=75.0n sa1=75.0n sa2=75.0n sa3=75.0n \
        sa4=75.0n sb1=75.0n sb2=75.0n sb3=75.0n spa=100n spa1=100n \
        spa2=100n spa3=100n sap=91.9776n sapb=114.444n spba=115.715n \
        spba1=117.043n dfm_flag=0 spmt=1.11111e+15 spomt=0 \
        spomt1=1.11111e+60 spmb=1.11111e+15 spomb=0 spomb1=1.11111e+60
    GNNAN (GNNA GNNPRE VSS VSS) nch_mac l=30n w=500n multi=1 nf=1 sd=100n \
        ad=3.75e-14 as=3.75e-14 pd=1.15u ps=1.15u nrd=0.662935 \
        nrs=0.662935 sa=75.0n sb=75.0n sa1=75.0n sa2=75.0n sa3=75.0n \
        sa4=75.0n sb1=75.0n sb2=75.0n sb3=75.0n spa=100n spa1=100n \
        spa2=100n spa3=100n sap=91.9776n sapb=114.444n spba=115.715n \
        spba1=117.043n dfm_flag=0 spmt=1.11111e+15 spomt=0 \
        spomt1=1.11111e+60 spmb=1.11111e+15 spomb=0 spomb1=1.11111e+60
    GNPCN (GNPDRV GNPB VSS VSS) nch_mac l=30n w=500n multi=1 nf=1 sd=100n \
        ad=3.75e-14 as=3.75e-14 pd=1.15u ps=1.15u nrd=0.662935 \
        nrs=0.662935 sa=75.0n sb=75.0n sa1=75.0n sa2=75.0n sa3=75.0n \
        sa4=75.0n sb1=75.0n sb2=75.0n sb3=75.0n spa=100n spa1=100n \
        spa2=100n spa3=100n sap=91.9776n sapb=114.444n spba=115.715n \
        spba1=117.043n dfm_flag=0 spmt=1.11111e+15 spomt=0 \
        spomt1=1.11111e+60 spmb=1.11111e+15 spomb=0 spomb1=1.11111e+60
    GNPBN (GNPB GNPA VSS VSS) nch_mac l=30n w=500n multi=1 nf=1 sd=100n \
        ad=3.75e-14 as=3.75e-14 pd=1.15u ps=1.15u nrd=0.662935 \
        nrs=0.662935 sa=75.0n sb=75.0n sa1=75.0n sa2=75.0n sa3=75.0n \
        sa4=75.0n sb1=75.0n sb2=75.0n sb3=75.0n spa=100n spa1=100n \
        spa2=100n spa3=100n sap=91.9776n sapb=114.444n spba=115.715n \
        spba1=117.043n dfm_flag=0 spmt=1.11111e+15 spomt=0 \
        spomt1=1.11111e+60 spmb=1.11111e+15 spomb=0 spomb1=1.11111e+60
    GNPAN (GNPA H VSS VSS) nch_mac l=30n w=500n multi=1 nf=1 sd=100n \
        ad=3.75e-14 as=3.75e-14 pd=1.15u ps=1.15u nrd=0.662935 \
        nrs=0.662935 sa=75.0n sb=75.0n sa1=75.0n sa2=75.0n sa3=75.0n \
        sa4=75.0n sb1=75.0n sb2=75.0n sb3=75.0n spa=100n spa1=100n \
        spa2=100n spa3=100n sap=91.9776n sapb=114.444n spba=115.715n \
        spba1=117.043n dfm_flag=0 spmt=1.11111e+15 spomt=0 \
        spomt1=1.11111e+60 spmb=1.11111e+15 spomb=0 spomb1=1.11111e+60
    GPNCN (GPNDRV GPNB VSS VSS) nch_mac l=30n w=500n multi=1 nf=1 sd=100n \
        ad=3.75e-14 as=3.75e-14 pd=1.15u ps=1.15u nrd=0.662935 \
        nrs=0.662935 sa=75.0n sb=75.0n sa1=75.0n sa2=75.0n sa3=75.0n \
        sa4=75.0n sb1=75.0n sb2=75.0n sb3=75.0n spa=100n spa1=100n \
        spa2=100n spa3=100n sap=91.9776n sapb=114.444n spba=115.715n \
        spba1=117.043n dfm_flag=0 spmt=1.11111e+15 spomt=0 \
        spomt1=1.11111e+60 spmb=1.11111e+15 spomb=0 spomb1=1.11111e+60
    GPNBN (GPNB GPNA VSS VSS) nch_mac l=30n w=500n multi=1 nf=1 sd=100n \
        ad=3.75e-14 as=3.75e-14 pd=1.15u ps=1.15u nrd=0.662935 \
        nrs=0.662935 sa=75.0n sb=75.0n sa1=75.0n sa2=75.0n sa3=75.0n \
        sa4=75.0n sb1=75.0n sb2=75.0n sb3=75.0n spa=100n spa1=100n \
        spa2=100n spa3=100n sap=91.9776n sapb=114.444n spba=115.715n \
        spba1=117.043n dfm_flag=0 spmt=1.11111e+15 spomt=0 \
        spomt1=1.11111e+60 spmb=1.11111e+15 spomb=0 spomb1=1.11111e+60
    GPNAN (GPNA GPNPRE VSS VSS) nch_mac l=30n w=500n multi=1 nf=1 sd=100n \
        ad=3.75e-14 as=3.75e-14 pd=1.15u ps=1.15u nrd=0.662935 \
        nrs=0.662935 sa=75.0n sb=75.0n sa1=75.0n sa2=75.0n sa3=75.0n \
        sa4=75.0n sb1=75.0n sb2=75.0n sb3=75.0n spa=100n spa1=100n \
        spa2=100n spa3=100n sap=91.9776n sapb=114.444n spba=115.715n \
        spba1=117.043n dfm_flag=0 spmt=1.11111e+15 spomt=0 \
        spomt1=1.11111e+60 spmb=1.11111e+15 spomb=0 spomb1=1.11111e+60
    GPPCN (GPPDRV GPPB VSS VSS) nch_mac l=30n w=500n multi=1 nf=1 sd=100n \
        ad=3.75e-14 as=3.75e-14 pd=1.15u ps=1.15u nrd=0.662935 \
        nrs=0.662935 sa=75.0n sb=75.0n sa1=75.0n sa2=75.0n sa3=75.0n \
        sa4=75.0n sb1=75.0n sb2=75.0n sb3=75.0n spa=100n spa1=100n \
        spa2=100n spa3=100n sap=91.9776n sapb=114.444n spba=115.715n \
        spba1=117.043n dfm_flag=0 spmt=1.11111e+15 spomt=0 \
        spomt1=1.11111e+60 spmb=1.11111e+15 spomb=0 spomb1=1.11111e+60
    GPPBN (GPPB GPPA VSS VSS) nch_mac l=30n w=500n multi=1 nf=1 sd=100n \
        ad=3.75e-14 as=3.75e-14 pd=1.15u ps=1.15u nrd=0.662935 \
        nrs=0.662935 sa=75.0n sb=75.0n sa1=75.0n sa2=75.0n sa3=75.0n \
        sa4=75.0n sb1=75.0n sb2=75.0n sb3=75.0n spa=100n spa1=100n \
        spa2=100n spa3=100n sap=91.9776n sapb=114.444n spba=115.715n \
        spba1=117.043n dfm_flag=0 spmt=1.11111e+15 spomt=0 \
        spomt1=1.11111e+60 spmb=1.11111e+15 spomb=0 spomb1=1.11111e+60
    GPPAN (GPPA L VSS VSS) nch_mac l=30n w=500n multi=1 nf=1 sd=100n \
        ad=3.75e-14 as=3.75e-14 pd=1.15u ps=1.15u nrd=0.662935 \
        nrs=0.662935 sa=75.0n sb=75.0n sa1=75.0n sa2=75.0n sa3=75.0n \
        sa4=75.0n sb1=75.0n sb2=75.0n sb3=75.0n spa=100n spa1=100n \
        spa2=100n spa3=100n sap=91.9776n sapb=114.444n spba=115.715n \
        spba1=117.043n dfm_flag=0 spmt=1.11111e+15 spomt=0 \
        spomt1=1.11111e+60 spmb=1.11111e+15 spomb=0 spomb1=1.11111e+60
    GNNCP (GNNDRV GNNB VDD VDD) pch_mac l=30n w=1u multi=1 nf=1 sd=100n \
        ad=7.5e-14 as=7.5e-14 pd=2.15u ps=2.15u nrd=0.165806 nrs=0.165806 \
        sa=75.0n sb=75.0n sa1=75.0n sa2=75.0n sa3=75.0n sa4=75.0n \
        sb1=75.0n sb2=75.0n sb3=75.0n spa=100n spa1=100n spa2=100n \
        spa3=100n sap=91.9776n sapb=114.444n spba=115.715n spba1=117.043n \
        dfm_flag=0 spmt=1.11111e+15 spomt=0 spomt1=1.11111e+60 \
        spmb=1.11111e+15 spomb=0 spomb1=1.11111e+60
    GNNBP (GNNB GNNA VDD VDD) pch_mac l=30n w=1u multi=1 nf=1 sd=100n \
        ad=7.5e-14 as=7.5e-14 pd=2.15u ps=2.15u nrd=0.165806 nrs=0.165806 \
        sa=75.0n sb=75.0n sa1=75.0n sa2=75.0n sa3=75.0n sa4=75.0n \
        sb1=75.0n sb2=75.0n sb3=75.0n spa=100n spa1=100n spa2=100n \
        spa3=100n sap=91.9776n sapb=114.444n spba=115.715n spba1=117.043n \
        dfm_flag=0 spmt=1.11111e+15 spomt=0 spomt1=1.11111e+60 \
        spmb=1.11111e+15 spomb=0 spomb1=1.11111e+60
    GNNAP (GNNA GNNPRE VDD VDD) pch_mac l=30n w=1u multi=1 nf=1 sd=100n \
        ad=7.5e-14 as=7.5e-14 pd=2.15u ps=2.15u nrd=0.165806 nrs=0.165806 \
        sa=75.0n sb=75.0n sa1=75.0n sa2=75.0n sa3=75.0n sa4=75.0n \
        sb1=75.0n sb2=75.0n sb3=75.0n spa=100n spa1=100n spa2=100n \
        spa3=100n sap=91.9776n sapb=114.444n spba=115.715n spba1=117.043n \
        dfm_flag=0 spmt=1.11111e+15 spomt=0 spomt1=1.11111e+60 \
        spmb=1.11111e+15 spomb=0 spomb1=1.11111e+60
    GNPCP (GNPDRV GNPB VDD VDD) pch_mac l=30n w=1u multi=1 nf=1 sd=100n \
        ad=7.5e-14 as=7.5e-14 pd=2.15u ps=2.15u nrd=0.165806 nrs=0.165806 \
        sa=75.0n sb=75.0n sa1=75.0n sa2=75.0n sa3=75.0n sa4=75.0n \
        sb1=75.0n sb2=75.0n sb3=75.0n spa=100n spa1=100n spa2=100n \
        spa3=100n sap=91.9776n sapb=114.444n spba=115.715n spba1=117.043n \
        dfm_flag=0 spmt=1.11111e+15 spomt=0 spomt1=1.11111e+60 \
        spmb=1.11111e+15 spomb=0 spomb1=1.11111e+60
    GNPBP (GNPB GNPA VDD VDD) pch_mac l=30n w=1u multi=1 nf=1 sd=100n \
        ad=7.5e-14 as=7.5e-14 pd=2.15u ps=2.15u nrd=0.165806 nrs=0.165806 \
        sa=75.0n sb=75.0n sa1=75.0n sa2=75.0n sa3=75.0n sa4=75.0n \
        sb1=75.0n sb2=75.0n sb3=75.0n spa=100n spa1=100n spa2=100n \
        spa3=100n sap=91.9776n sapb=114.444n spba=115.715n spba1=117.043n \
        dfm_flag=0 spmt=1.11111e+15 spomt=0 spomt1=1.11111e+60 \
        spmb=1.11111e+15 spomb=0 spomb1=1.11111e+60
    GNPAP (GNPA H VDD VDD) pch_mac l=30n w=1u multi=1 nf=1 sd=100n \
        ad=7.5e-14 as=7.5e-14 pd=2.15u ps=2.15u nrd=0.165806 nrs=0.165806 \
        sa=75.0n sb=75.0n sa1=75.0n sa2=75.0n sa3=75.0n sa4=75.0n \
        sb1=75.0n sb2=75.0n sb3=75.0n spa=100n spa1=100n spa2=100n \
        spa3=100n sap=91.9776n sapb=114.444n spba=115.715n spba1=117.043n \
        dfm_flag=0 spmt=1.11111e+15 spomt=0 spomt1=1.11111e+60 \
        spmb=1.11111e+15 spomb=0 spomb1=1.11111e+60
    GPNCP (GPNDRV GPNB VDD VDD) pch_mac l=30n w=1u multi=1 nf=1 sd=100n \
        ad=7.5e-14 as=7.5e-14 pd=2.15u ps=2.15u nrd=0.165806 nrs=0.165806 \
        sa=75.0n sb=75.0n sa1=75.0n sa2=75.0n sa3=75.0n sa4=75.0n \
        sb1=75.0n sb2=75.0n sb3=75.0n spa=100n spa1=100n spa2=100n \
        spa3=100n sap=91.9776n sapb=114.444n spba=115.715n spba1=117.043n \
        dfm_flag=0 spmt=1.11111e+15 spomt=0 spomt1=1.11111e+60 \
        spmb=1.11111e+15 spomb=0 spomb1=1.11111e+60
    GPNBP (GPNB GPNA VDD VDD) pch_mac l=30n w=1u multi=1 nf=1 sd=100n \
        ad=7.5e-14 as=7.5e-14 pd=2.15u ps=2.15u nrd=0.165806 nrs=0.165806 \
        sa=75.0n sb=75.0n sa1=75.0n sa2=75.0n sa3=75.0n sa4=75.0n \
        sb1=75.0n sb2=75.0n sb3=75.0n spa=100n spa1=100n spa2=100n \
        spa3=100n sap=91.9776n sapb=114.444n spba=115.715n spba1=117.043n \
        dfm_flag=0 spmt=1.11111e+15 spomt=0 spomt1=1.11111e+60 \
        spmb=1.11111e+15 spomb=0 spomb1=1.11111e+60
    GPNAP (GPNA GPNPRE VDD VDD) pch_mac l=30n w=1u multi=1 nf=1 sd=100n \
        ad=7.5e-14 as=7.5e-14 pd=2.15u ps=2.15u nrd=0.165806 nrs=0.165806 \
        sa=75.0n sb=75.0n sa1=75.0n sa2=75.0n sa3=75.0n sa4=75.0n \
        sb1=75.0n sb2=75.0n sb3=75.0n spa=100n spa1=100n spa2=100n \
        spa3=100n sap=91.9776n sapb=114.444n spba=115.715n spba1=117.043n \
        dfm_flag=0 spmt=1.11111e+15 spomt=0 spomt1=1.11111e+60 \
        spmb=1.11111e+15 spomb=0 spomb1=1.11111e+60
    GPPCP (GPPDRV GPPB VDD VDD) pch_mac l=30n w=1u multi=1 nf=1 sd=100n \
        ad=7.5e-14 as=7.5e-14 pd=2.15u ps=2.15u nrd=0.165806 nrs=0.165806 \
        sa=75.0n sb=75.0n sa1=75.0n sa2=75.0n sa3=75.0n sa4=75.0n \
        sb1=75.0n sb2=75.0n sb3=75.0n spa=100n spa1=100n spa2=100n \
        spa3=100n sap=91.9776n sapb=114.444n spba=115.715n spba1=117.043n \
        dfm_flag=0 spmt=1.11111e+15 spomt=0 spomt1=1.11111e+60 \
        spmb=1.11111e+15 spomb=0 spomb1=1.11111e+60
    GPPBP (GPPB GPPA VDD VDD) pch_mac l=30n w=1u multi=1 nf=1 sd=100n \
        ad=7.5e-14 as=7.5e-14 pd=2.15u ps=2.15u nrd=0.165806 nrs=0.165806 \
        sa=75.0n sb=75.0n sa1=75.0n sa2=75.0n sa3=75.0n sa4=75.0n \
        sb1=75.0n sb2=75.0n sb3=75.0n spa=100n spa1=100n spa2=100n \
        spa3=100n sap=91.9776n sapb=114.444n spba=115.715n spba1=117.043n \
        dfm_flag=0 spmt=1.11111e+15 spomt=0 spomt1=1.11111e+60 \
        spmb=1.11111e+15 spomb=0 spomb1=1.11111e+60
    GPPAP (GPPA L VDD VDD) pch_mac l=30n w=1u multi=1 nf=1 sd=100n \
        ad=7.5e-14 as=7.5e-14 pd=2.15u ps=2.15u nrd=0.165806 nrs=0.165806 \
        sa=75.0n sb=75.0n sa1=75.0n sa2=75.0n sa3=75.0n sa4=75.0n \
        sb1=75.0n sb2=75.0n sb3=75.0n spa=100n spa1=100n spa2=100n \
        spa3=100n sap=91.9776n sapb=114.444n spba=115.715n spba1=117.043n \
        dfm_flag=0 spmt=1.11111e+15 spomt=0 spomt1=1.11111e+60 \
        spmb=1.11111e+15 spomb=0 spomb1=1.11111e+60
//Series configuration of RGNN1
RGNN1  (GNNRG RGNN1_1__dmy0 ) rupolym l=17.13u w=1u m=8 multi=(1)
RGNN1_2__dmy0  (RGNN1_1__dmy0 RGNN1_2__dmy0 ) rupolym l=17.13u w=1u m=8 \
        multi=(1)
RGNN1_3__dmy0  (RGNN1_2__dmy0 RGNN1_3__dmy0 ) rupolym l=17.13u w=1u m=8 \
        multi=(1)
RGNN1_4__dmy0  (RGNN1_3__dmy0 RGNN1_4__dmy0 ) rupolym l=17.13u w=1u m=8 \
        multi=(1)
RGNN1_5__dmy0  (RGNN1_4__dmy0 GNN ) rupolym l=17.13u w=1u m=8 multi=(1)
//End of RGNN1

//Series configuration of RGNN0
RGNN0  (GNNDRV RGNN0_1__dmy0 ) rupolym l=17.13u w=1u m=8 multi=(1)
RGNN0_2__dmy0  (RGNN0_1__dmy0 RGNN0_2__dmy0 ) rupolym l=17.13u w=1u m=8 \
        multi=(1)
RGNN0_3__dmy0  (RGNN0_2__dmy0 RGNN0_3__dmy0 ) rupolym l=17.13u w=1u m=8 \
        multi=(1)
RGNN0_4__dmy0  (RGNN0_3__dmy0 RGNN0_4__dmy0 ) rupolym l=17.13u w=1u m=8 \
        multi=(1)
RGNN0_5__dmy0  (RGNN0_4__dmy0 GNNRG ) rupolym l=17.13u w=1u m=8 multi=(1)
//End of RGNN0

//Series configuration of RGNP1
RGNP1  (GNPRG RGNP1_1__dmy0 ) rupolym l=17.13u w=1u m=8 multi=(1)
RGNP1_2__dmy0  (RGNP1_1__dmy0 RGNP1_2__dmy0 ) rupolym l=17.13u w=1u m=8 \
        multi=(1)
RGNP1_3__dmy0  (RGNP1_2__dmy0 RGNP1_3__dmy0 ) rupolym l=17.13u w=1u m=8 \
        multi=(1)
RGNP1_4__dmy0  (RGNP1_3__dmy0 RGNP1_4__dmy0 ) rupolym l=17.13u w=1u m=8 \
        multi=(1)
RGNP1_5__dmy0  (RGNP1_4__dmy0 GNP ) rupolym l=17.13u w=1u m=8 multi=(1)
//End of RGNP1

//Series configuration of RGNP0
RGNP0  (GNPDRV RGNP0_1__dmy0 ) rupolym l=17.13u w=1u m=8 multi=(1)
RGNP0_2__dmy0  (RGNP0_1__dmy0 RGNP0_2__dmy0 ) rupolym l=17.13u w=1u m=8 \
        multi=(1)
RGNP0_3__dmy0  (RGNP0_2__dmy0 RGNP0_3__dmy0 ) rupolym l=17.13u w=1u m=8 \
        multi=(1)
RGNP0_4__dmy0  (RGNP0_3__dmy0 RGNP0_4__dmy0 ) rupolym l=17.13u w=1u m=8 \
        multi=(1)
RGNP0_5__dmy0  (RGNP0_4__dmy0 GNPRG ) rupolym l=17.13u w=1u m=8 multi=(1)
//End of RGNP0

//Series configuration of RGPN1
RGPN1  (GPNRG RGPN1_1__dmy0 ) rupolym l=17.13u w=1u m=8 multi=(1)
RGPN1_2__dmy0  (RGPN1_1__dmy0 RGPN1_2__dmy0 ) rupolym l=17.13u w=1u m=8 \
        multi=(1)
RGPN1_3__dmy0  (RGPN1_2__dmy0 RGPN1_3__dmy0 ) rupolym l=17.13u w=1u m=8 \
        multi=(1)
RGPN1_4__dmy0  (RGPN1_3__dmy0 RGPN1_4__dmy0 ) rupolym l=17.13u w=1u m=8 \
        multi=(1)
RGPN1_5__dmy0  (RGPN1_4__dmy0 GPN ) rupolym l=17.13u w=1u m=8 multi=(1)
//End of RGPN1

//Series configuration of RGPN0
RGPN0  (GPNDRV RGPN0_1__dmy0 ) rupolym l=17.13u w=1u m=8 multi=(1)
RGPN0_2__dmy0  (RGPN0_1__dmy0 RGPN0_2__dmy0 ) rupolym l=17.13u w=1u m=8 \
        multi=(1)
RGPN0_3__dmy0  (RGPN0_2__dmy0 RGPN0_3__dmy0 ) rupolym l=17.13u w=1u m=8 \
        multi=(1)
RGPN0_4__dmy0  (RGPN0_3__dmy0 RGPN0_4__dmy0 ) rupolym l=17.13u w=1u m=8 \
        multi=(1)
RGPN0_5__dmy0  (RGPN0_4__dmy0 GPNRG ) rupolym l=17.13u w=1u m=8 multi=(1)
//End of RGPN0

//Series configuration of RGPP1
RGPP1  (GPPRG RGPP1_1__dmy0 ) rupolym l=17.13u w=1u m=8 multi=(1)
RGPP1_2__dmy0  (RGPP1_1__dmy0 RGPP1_2__dmy0 ) rupolym l=17.13u w=1u m=8 \
        multi=(1)
RGPP1_3__dmy0  (RGPP1_2__dmy0 RGPP1_3__dmy0 ) rupolym l=17.13u w=1u m=8 \
        multi=(1)
RGPP1_4__dmy0  (RGPP1_3__dmy0 RGPP1_4__dmy0 ) rupolym l=17.13u w=1u m=8 \
        multi=(1)
RGPP1_5__dmy0  (RGPP1_4__dmy0 GPP ) rupolym l=17.13u w=1u m=8 multi=(1)
//End of RGPP1

//Series configuration of RGPP0
RGPP0  (GPPDRV RGPP0_1__dmy0 ) rupolym l=17.13u w=1u m=8 multi=(1)
RGPP0_2__dmy0  (RGPP0_1__dmy0 RGPP0_2__dmy0 ) rupolym l=17.13u w=1u m=8 \
        multi=(1)
RGPP0_3__dmy0  (RGPP0_2__dmy0 RGPP0_3__dmy0 ) rupolym l=17.13u w=1u m=8 \
        multi=(1)
RGPP0_4__dmy0  (RGPP0_3__dmy0 RGPP0_4__dmy0 ) rupolym l=17.13u w=1u m=8 \
        multi=(1)
RGPP0_5__dmy0  (RGPP0_4__dmy0 GPPRG ) rupolym l=17.13u w=1u m=8 multi=(1)
//End of RGPP0

    X025 (L VDD VSS GNNPRE) sar8p_inv
    X008 (H VDD VSS GPNPRE) sar8p_inv
ends sar8p_refdrv_b3

subckt sar8p_refdrv_b4 GNN GNP GPN GPP H L VDD VSS
    GNNCN (GNNDRV GNNB VSS VSS) nch_mac l=30n w=500n multi=2 nf=1 sd=100n \
        ad=3.75e-14 as=3.75e-14 pd=1.15u ps=1.15u nrd=0.662935 \
        nrs=0.662935 sa=75.0n sb=75.0n sa1=75.0n sa2=75.0n sa3=75.0n \
        sa4=75.0n sb1=75.0n sb2=75.0n sb3=75.0n spa=100n spa1=100n \
        spa2=100n spa3=100n sap=91.9776n sapb=114.444n spba=115.715n \
        spba1=117.043n dfm_flag=0 spmt=1.11111e+15 spomt=0 \
        spomt1=1.11111e+60 spmb=1.11111e+15 spomb=0 spomb1=1.11111e+60
    GNNBN (GNNB GNNA VSS VSS) nch_mac l=30n w=500n multi=1 nf=1 sd=100n \
        ad=3.75e-14 as=3.75e-14 pd=1.15u ps=1.15u nrd=0.662935 \
        nrs=0.662935 sa=75.0n sb=75.0n sa1=75.0n sa2=75.0n sa3=75.0n \
        sa4=75.0n sb1=75.0n sb2=75.0n sb3=75.0n spa=100n spa1=100n \
        spa2=100n spa3=100n sap=91.9776n sapb=114.444n spba=115.715n \
        spba1=117.043n dfm_flag=0 spmt=1.11111e+15 spomt=0 \
        spomt1=1.11111e+60 spmb=1.11111e+15 spomb=0 spomb1=1.11111e+60
    GNNAN (GNNA GNNPRE VSS VSS) nch_mac l=30n w=500n multi=1 nf=1 sd=100n \
        ad=3.75e-14 as=3.75e-14 pd=1.15u ps=1.15u nrd=0.662935 \
        nrs=0.662935 sa=75.0n sb=75.0n sa1=75.0n sa2=75.0n sa3=75.0n \
        sa4=75.0n sb1=75.0n sb2=75.0n sb3=75.0n spa=100n spa1=100n \
        spa2=100n spa3=100n sap=91.9776n sapb=114.444n spba=115.715n \
        spba1=117.043n dfm_flag=0 spmt=1.11111e+15 spomt=0 \
        spomt1=1.11111e+60 spmb=1.11111e+15 spomb=0 spomb1=1.11111e+60
    GNPCN (GNPDRV GNPB VSS VSS) nch_mac l=30n w=500n multi=2 nf=1 sd=100n \
        ad=3.75e-14 as=3.75e-14 pd=1.15u ps=1.15u nrd=0.662935 \
        nrs=0.662935 sa=75.0n sb=75.0n sa1=75.0n sa2=75.0n sa3=75.0n \
        sa4=75.0n sb1=75.0n sb2=75.0n sb3=75.0n spa=100n spa1=100n \
        spa2=100n spa3=100n sap=91.9776n sapb=114.444n spba=115.715n \
        spba1=117.043n dfm_flag=0 spmt=1.11111e+15 spomt=0 \
        spomt1=1.11111e+60 spmb=1.11111e+15 spomb=0 spomb1=1.11111e+60
    GNPBN (GNPB GNPA VSS VSS) nch_mac l=30n w=500n multi=1 nf=1 sd=100n \
        ad=3.75e-14 as=3.75e-14 pd=1.15u ps=1.15u nrd=0.662935 \
        nrs=0.662935 sa=75.0n sb=75.0n sa1=75.0n sa2=75.0n sa3=75.0n \
        sa4=75.0n sb1=75.0n sb2=75.0n sb3=75.0n spa=100n spa1=100n \
        spa2=100n spa3=100n sap=91.9776n sapb=114.444n spba=115.715n \
        spba1=117.043n dfm_flag=0 spmt=1.11111e+15 spomt=0 \
        spomt1=1.11111e+60 spmb=1.11111e+15 spomb=0 spomb1=1.11111e+60
    GNPAN (GNPA H VSS VSS) nch_mac l=30n w=500n multi=1 nf=1 sd=100n \
        ad=3.75e-14 as=3.75e-14 pd=1.15u ps=1.15u nrd=0.662935 \
        nrs=0.662935 sa=75.0n sb=75.0n sa1=75.0n sa2=75.0n sa3=75.0n \
        sa4=75.0n sb1=75.0n sb2=75.0n sb3=75.0n spa=100n spa1=100n \
        spa2=100n spa3=100n sap=91.9776n sapb=114.444n spba=115.715n \
        spba1=117.043n dfm_flag=0 spmt=1.11111e+15 spomt=0 \
        spomt1=1.11111e+60 spmb=1.11111e+15 spomb=0 spomb1=1.11111e+60
    GPNCN (GPNDRV GPNB VSS VSS) nch_mac l=30n w=500n multi=2 nf=1 sd=100n \
        ad=3.75e-14 as=3.75e-14 pd=1.15u ps=1.15u nrd=0.662935 \
        nrs=0.662935 sa=75.0n sb=75.0n sa1=75.0n sa2=75.0n sa3=75.0n \
        sa4=75.0n sb1=75.0n sb2=75.0n sb3=75.0n spa=100n spa1=100n \
        spa2=100n spa3=100n sap=91.9776n sapb=114.444n spba=115.715n \
        spba1=117.043n dfm_flag=0 spmt=1.11111e+15 spomt=0 \
        spomt1=1.11111e+60 spmb=1.11111e+15 spomb=0 spomb1=1.11111e+60
    GPNBN (GPNB GPNA VSS VSS) nch_mac l=30n w=500n multi=1 nf=1 sd=100n \
        ad=3.75e-14 as=3.75e-14 pd=1.15u ps=1.15u nrd=0.662935 \
        nrs=0.662935 sa=75.0n sb=75.0n sa1=75.0n sa2=75.0n sa3=75.0n \
        sa4=75.0n sb1=75.0n sb2=75.0n sb3=75.0n spa=100n spa1=100n \
        spa2=100n spa3=100n sap=91.9776n sapb=114.444n spba=115.715n \
        spba1=117.043n dfm_flag=0 spmt=1.11111e+15 spomt=0 \
        spomt1=1.11111e+60 spmb=1.11111e+15 spomb=0 spomb1=1.11111e+60
    GPNAN (GPNA GPNPRE VSS VSS) nch_mac l=30n w=500n multi=1 nf=1 sd=100n \
        ad=3.75e-14 as=3.75e-14 pd=1.15u ps=1.15u nrd=0.662935 \
        nrs=0.662935 sa=75.0n sb=75.0n sa1=75.0n sa2=75.0n sa3=75.0n \
        sa4=75.0n sb1=75.0n sb2=75.0n sb3=75.0n spa=100n spa1=100n \
        spa2=100n spa3=100n sap=91.9776n sapb=114.444n spba=115.715n \
        spba1=117.043n dfm_flag=0 spmt=1.11111e+15 spomt=0 \
        spomt1=1.11111e+60 spmb=1.11111e+15 spomb=0 spomb1=1.11111e+60
    GPPCN (GPPDRV GPPB VSS VSS) nch_mac l=30n w=500n multi=2 nf=1 sd=100n \
        ad=3.75e-14 as=3.75e-14 pd=1.15u ps=1.15u nrd=0.662935 \
        nrs=0.662935 sa=75.0n sb=75.0n sa1=75.0n sa2=75.0n sa3=75.0n \
        sa4=75.0n sb1=75.0n sb2=75.0n sb3=75.0n spa=100n spa1=100n \
        spa2=100n spa3=100n sap=91.9776n sapb=114.444n spba=115.715n \
        spba1=117.043n dfm_flag=0 spmt=1.11111e+15 spomt=0 \
        spomt1=1.11111e+60 spmb=1.11111e+15 spomb=0 spomb1=1.11111e+60
    GPPBN (GPPB GPPA VSS VSS) nch_mac l=30n w=500n multi=1 nf=1 sd=100n \
        ad=3.75e-14 as=3.75e-14 pd=1.15u ps=1.15u nrd=0.662935 \
        nrs=0.662935 sa=75.0n sb=75.0n sa1=75.0n sa2=75.0n sa3=75.0n \
        sa4=75.0n sb1=75.0n sb2=75.0n sb3=75.0n spa=100n spa1=100n \
        spa2=100n spa3=100n sap=91.9776n sapb=114.444n spba=115.715n \
        spba1=117.043n dfm_flag=0 spmt=1.11111e+15 spomt=0 \
        spomt1=1.11111e+60 spmb=1.11111e+15 spomb=0 spomb1=1.11111e+60
    GPPAN (GPPA L VSS VSS) nch_mac l=30n w=500n multi=1 nf=1 sd=100n \
        ad=3.75e-14 as=3.75e-14 pd=1.15u ps=1.15u nrd=0.662935 \
        nrs=0.662935 sa=75.0n sb=75.0n sa1=75.0n sa2=75.0n sa3=75.0n \
        sa4=75.0n sb1=75.0n sb2=75.0n sb3=75.0n spa=100n spa1=100n \
        spa2=100n spa3=100n sap=91.9776n sapb=114.444n spba=115.715n \
        spba1=117.043n dfm_flag=0 spmt=1.11111e+15 spomt=0 \
        spomt1=1.11111e+60 spmb=1.11111e+15 spomb=0 spomb1=1.11111e+60
    GNNCP (GNNDRV GNNB VDD VDD) pch_mac l=30n w=1u multi=2 nf=1 sd=100n \
        ad=7.5e-14 as=7.5e-14 pd=2.15u ps=2.15u nrd=0.165806 nrs=0.165806 \
        sa=75.0n sb=75.0n sa1=75.0n sa2=75.0n sa3=75.0n sa4=75.0n \
        sb1=75.0n sb2=75.0n sb3=75.0n spa=100n spa1=100n spa2=100n \
        spa3=100n sap=91.9776n sapb=114.444n spba=115.715n spba1=117.043n \
        dfm_flag=0 spmt=1.11111e+15 spomt=0 spomt1=1.11111e+60 \
        spmb=1.11111e+15 spomb=0 spomb1=1.11111e+60
    GNNBP (GNNB GNNA VDD VDD) pch_mac l=30n w=1u multi=1 nf=1 sd=100n \
        ad=7.5e-14 as=7.5e-14 pd=2.15u ps=2.15u nrd=0.165806 nrs=0.165806 \
        sa=75.0n sb=75.0n sa1=75.0n sa2=75.0n sa3=75.0n sa4=75.0n \
        sb1=75.0n sb2=75.0n sb3=75.0n spa=100n spa1=100n spa2=100n \
        spa3=100n sap=91.9776n sapb=114.444n spba=115.715n spba1=117.043n \
        dfm_flag=0 spmt=1.11111e+15 spomt=0 spomt1=1.11111e+60 \
        spmb=1.11111e+15 spomb=0 spomb1=1.11111e+60
    GNNAP (GNNA GNNPRE VDD VDD) pch_mac l=30n w=1u multi=1 nf=1 sd=100n \
        ad=7.5e-14 as=7.5e-14 pd=2.15u ps=2.15u nrd=0.165806 nrs=0.165806 \
        sa=75.0n sb=75.0n sa1=75.0n sa2=75.0n sa3=75.0n sa4=75.0n \
        sb1=75.0n sb2=75.0n sb3=75.0n spa=100n spa1=100n spa2=100n \
        spa3=100n sap=91.9776n sapb=114.444n spba=115.715n spba1=117.043n \
        dfm_flag=0 spmt=1.11111e+15 spomt=0 spomt1=1.11111e+60 \
        spmb=1.11111e+15 spomb=0 spomb1=1.11111e+60
    GNPCP (GNPDRV GNPB VDD VDD) pch_mac l=30n w=1u multi=2 nf=1 sd=100n \
        ad=7.5e-14 as=7.5e-14 pd=2.15u ps=2.15u nrd=0.165806 nrs=0.165806 \
        sa=75.0n sb=75.0n sa1=75.0n sa2=75.0n sa3=75.0n sa4=75.0n \
        sb1=75.0n sb2=75.0n sb3=75.0n spa=100n spa1=100n spa2=100n \
        spa3=100n sap=91.9776n sapb=114.444n spba=115.715n spba1=117.043n \
        dfm_flag=0 spmt=1.11111e+15 spomt=0 spomt1=1.11111e+60 \
        spmb=1.11111e+15 spomb=0 spomb1=1.11111e+60
    GNPBP (GNPB GNPA VDD VDD) pch_mac l=30n w=1u multi=1 nf=1 sd=100n \
        ad=7.5e-14 as=7.5e-14 pd=2.15u ps=2.15u nrd=0.165806 nrs=0.165806 \
        sa=75.0n sb=75.0n sa1=75.0n sa2=75.0n sa3=75.0n sa4=75.0n \
        sb1=75.0n sb2=75.0n sb3=75.0n spa=100n spa1=100n spa2=100n \
        spa3=100n sap=91.9776n sapb=114.444n spba=115.715n spba1=117.043n \
        dfm_flag=0 spmt=1.11111e+15 spomt=0 spomt1=1.11111e+60 \
        spmb=1.11111e+15 spomb=0 spomb1=1.11111e+60
    GNPAP (GNPA H VDD VDD) pch_mac l=30n w=1u multi=1 nf=1 sd=100n \
        ad=7.5e-14 as=7.5e-14 pd=2.15u ps=2.15u nrd=0.165806 nrs=0.165806 \
        sa=75.0n sb=75.0n sa1=75.0n sa2=75.0n sa3=75.0n sa4=75.0n \
        sb1=75.0n sb2=75.0n sb3=75.0n spa=100n spa1=100n spa2=100n \
        spa3=100n sap=91.9776n sapb=114.444n spba=115.715n spba1=117.043n \
        dfm_flag=0 spmt=1.11111e+15 spomt=0 spomt1=1.11111e+60 \
        spmb=1.11111e+15 spomb=0 spomb1=1.11111e+60
    GPNCP (GPNDRV GPNB VDD VDD) pch_mac l=30n w=1u multi=2 nf=1 sd=100n \
        ad=7.5e-14 as=7.5e-14 pd=2.15u ps=2.15u nrd=0.165806 nrs=0.165806 \
        sa=75.0n sb=75.0n sa1=75.0n sa2=75.0n sa3=75.0n sa4=75.0n \
        sb1=75.0n sb2=75.0n sb3=75.0n spa=100n spa1=100n spa2=100n \
        spa3=100n sap=91.9776n sapb=114.444n spba=115.715n spba1=117.043n \
        dfm_flag=0 spmt=1.11111e+15 spomt=0 spomt1=1.11111e+60 \
        spmb=1.11111e+15 spomb=0 spomb1=1.11111e+60
    GPNBP (GPNB GPNA VDD VDD) pch_mac l=30n w=1u multi=1 nf=1 sd=100n \
        ad=7.5e-14 as=7.5e-14 pd=2.15u ps=2.15u nrd=0.165806 nrs=0.165806 \
        sa=75.0n sb=75.0n sa1=75.0n sa2=75.0n sa3=75.0n sa4=75.0n \
        sb1=75.0n sb2=75.0n sb3=75.0n spa=100n spa1=100n spa2=100n \
        spa3=100n sap=91.9776n sapb=114.444n spba=115.715n spba1=117.043n \
        dfm_flag=0 spmt=1.11111e+15 spomt=0 spomt1=1.11111e+60 \
        spmb=1.11111e+15 spomb=0 spomb1=1.11111e+60
    GPNAP (GPNA GPNPRE VDD VDD) pch_mac l=30n w=1u multi=1 nf=1 sd=100n \
        ad=7.5e-14 as=7.5e-14 pd=2.15u ps=2.15u nrd=0.165806 nrs=0.165806 \
        sa=75.0n sb=75.0n sa1=75.0n sa2=75.0n sa3=75.0n sa4=75.0n \
        sb1=75.0n sb2=75.0n sb3=75.0n spa=100n spa1=100n spa2=100n \
        spa3=100n sap=91.9776n sapb=114.444n spba=115.715n spba1=117.043n \
        dfm_flag=0 spmt=1.11111e+15 spomt=0 spomt1=1.11111e+60 \
        spmb=1.11111e+15 spomb=0 spomb1=1.11111e+60
    GPPCP (GPPDRV GPPB VDD VDD) pch_mac l=30n w=1u multi=2 nf=1 sd=100n \
        ad=7.5e-14 as=7.5e-14 pd=2.15u ps=2.15u nrd=0.165806 nrs=0.165806 \
        sa=75.0n sb=75.0n sa1=75.0n sa2=75.0n sa3=75.0n sa4=75.0n \
        sb1=75.0n sb2=75.0n sb3=75.0n spa=100n spa1=100n spa2=100n \
        spa3=100n sap=91.9776n sapb=114.444n spba=115.715n spba1=117.043n \
        dfm_flag=0 spmt=1.11111e+15 spomt=0 spomt1=1.11111e+60 \
        spmb=1.11111e+15 spomb=0 spomb1=1.11111e+60
    GPPBP (GPPB GPPA VDD VDD) pch_mac l=30n w=1u multi=1 nf=1 sd=100n \
        ad=7.5e-14 as=7.5e-14 pd=2.15u ps=2.15u nrd=0.165806 nrs=0.165806 \
        sa=75.0n sb=75.0n sa1=75.0n sa2=75.0n sa3=75.0n sa4=75.0n \
        sb1=75.0n sb2=75.0n sb3=75.0n spa=100n spa1=100n spa2=100n \
        spa3=100n sap=91.9776n sapb=114.444n spba=115.715n spba1=117.043n \
        dfm_flag=0 spmt=1.11111e+15 spomt=0 spomt1=1.11111e+60 \
        spmb=1.11111e+15 spomb=0 spomb1=1.11111e+60
    GPPAP (GPPA L VDD VDD) pch_mac l=30n w=1u multi=1 nf=1 sd=100n \
        ad=7.5e-14 as=7.5e-14 pd=2.15u ps=2.15u nrd=0.165806 nrs=0.165806 \
        sa=75.0n sb=75.0n sa1=75.0n sa2=75.0n sa3=75.0n sa4=75.0n \
        sb1=75.0n sb2=75.0n sb3=75.0n spa=100n spa1=100n spa2=100n \
        spa3=100n sap=91.9776n sapb=114.444n spba=115.715n spba1=117.043n \
        dfm_flag=0 spmt=1.11111e+15 spomt=0 spomt1=1.11111e+60 \
        spmb=1.11111e+15 spomb=0 spomb1=1.11111e+60
//Series configuration of RGNN1
RGNN1  (GNNRG RGNN1_1__dmy0 ) rupolym l=17.13u w=1u m=16 multi=(1)
RGNN1_2__dmy0  (RGNN1_1__dmy0 RGNN1_2__dmy0 ) rupolym l=17.13u w=1u m=16 \
        multi=(1)
RGNN1_3__dmy0  (RGNN1_2__dmy0 RGNN1_3__dmy0 ) rupolym l=17.13u w=1u m=16 \
        multi=(1)
RGNN1_4__dmy0  (RGNN1_3__dmy0 RGNN1_4__dmy0 ) rupolym l=17.13u w=1u m=16 \
        multi=(1)
RGNN1_5__dmy0  (RGNN1_4__dmy0 GNN ) rupolym l=17.13u w=1u m=16 multi=(1)
//End of RGNN1

//Series configuration of RGNN0
RGNN0  (GNNDRV RGNN0_1__dmy0 ) rupolym l=17.13u w=1u m=16 multi=(1)
RGNN0_2__dmy0  (RGNN0_1__dmy0 RGNN0_2__dmy0 ) rupolym l=17.13u w=1u m=16 \
        multi=(1)
RGNN0_3__dmy0  (RGNN0_2__dmy0 RGNN0_3__dmy0 ) rupolym l=17.13u w=1u m=16 \
        multi=(1)
RGNN0_4__dmy0  (RGNN0_3__dmy0 RGNN0_4__dmy0 ) rupolym l=17.13u w=1u m=16 \
        multi=(1)
RGNN0_5__dmy0  (RGNN0_4__dmy0 GNNRG ) rupolym l=17.13u w=1u m=16 multi=(1)
//End of RGNN0

//Series configuration of RGNP1
RGNP1  (GNPRG RGNP1_1__dmy0 ) rupolym l=17.13u w=1u m=16 multi=(1)
RGNP1_2__dmy0  (RGNP1_1__dmy0 RGNP1_2__dmy0 ) rupolym l=17.13u w=1u m=16 \
        multi=(1)
RGNP1_3__dmy0  (RGNP1_2__dmy0 RGNP1_3__dmy0 ) rupolym l=17.13u w=1u m=16 \
        multi=(1)
RGNP1_4__dmy0  (RGNP1_3__dmy0 RGNP1_4__dmy0 ) rupolym l=17.13u w=1u m=16 \
        multi=(1)
RGNP1_5__dmy0  (RGNP1_4__dmy0 GNP ) rupolym l=17.13u w=1u m=16 multi=(1)
//End of RGNP1

//Series configuration of RGNP0
RGNP0  (GNPDRV RGNP0_1__dmy0 ) rupolym l=17.13u w=1u m=16 multi=(1)
RGNP0_2__dmy0  (RGNP0_1__dmy0 RGNP0_2__dmy0 ) rupolym l=17.13u w=1u m=16 \
        multi=(1)
RGNP0_3__dmy0  (RGNP0_2__dmy0 RGNP0_3__dmy0 ) rupolym l=17.13u w=1u m=16 \
        multi=(1)
RGNP0_4__dmy0  (RGNP0_3__dmy0 RGNP0_4__dmy0 ) rupolym l=17.13u w=1u m=16 \
        multi=(1)
RGNP0_5__dmy0  (RGNP0_4__dmy0 GNPRG ) rupolym l=17.13u w=1u m=16 multi=(1)
//End of RGNP0

//Series configuration of RGPN1
RGPN1  (GPNRG RGPN1_1__dmy0 ) rupolym l=17.13u w=1u m=16 multi=(1)
RGPN1_2__dmy0  (RGPN1_1__dmy0 RGPN1_2__dmy0 ) rupolym l=17.13u w=1u m=16 \
        multi=(1)
RGPN1_3__dmy0  (RGPN1_2__dmy0 RGPN1_3__dmy0 ) rupolym l=17.13u w=1u m=16 \
        multi=(1)
RGPN1_4__dmy0  (RGPN1_3__dmy0 RGPN1_4__dmy0 ) rupolym l=17.13u w=1u m=16 \
        multi=(1)
RGPN1_5__dmy0  (RGPN1_4__dmy0 GPN ) rupolym l=17.13u w=1u m=16 multi=(1)
//End of RGPN1

//Series configuration of RGPN0
RGPN0  (GPNDRV RGPN0_1__dmy0 ) rupolym l=17.13u w=1u m=16 multi=(1)
RGPN0_2__dmy0  (RGPN0_1__dmy0 RGPN0_2__dmy0 ) rupolym l=17.13u w=1u m=16 \
        multi=(1)
RGPN0_3__dmy0  (RGPN0_2__dmy0 RGPN0_3__dmy0 ) rupolym l=17.13u w=1u m=16 \
        multi=(1)
RGPN0_4__dmy0  (RGPN0_3__dmy0 RGPN0_4__dmy0 ) rupolym l=17.13u w=1u m=16 \
        multi=(1)
RGPN0_5__dmy0  (RGPN0_4__dmy0 GPNRG ) rupolym l=17.13u w=1u m=16 multi=(1)
//End of RGPN0

//Series configuration of RGPP1
RGPP1  (GPPRG RGPP1_1__dmy0 ) rupolym l=17.13u w=1u m=16 multi=(1)
RGPP1_2__dmy0  (RGPP1_1__dmy0 RGPP1_2__dmy0 ) rupolym l=17.13u w=1u m=16 \
        multi=(1)
RGPP1_3__dmy0  (RGPP1_2__dmy0 RGPP1_3__dmy0 ) rupolym l=17.13u w=1u m=16 \
        multi=(1)
RGPP1_4__dmy0  (RGPP1_3__dmy0 RGPP1_4__dmy0 ) rupolym l=17.13u w=1u m=16 \
        multi=(1)
RGPP1_5__dmy0  (RGPP1_4__dmy0 GPP ) rupolym l=17.13u w=1u m=16 multi=(1)
//End of RGPP1

//Series configuration of RGPP0
RGPP0  (GPPDRV RGPP0_1__dmy0 ) rupolym l=17.13u w=1u m=16 multi=(1)
RGPP0_2__dmy0  (RGPP0_1__dmy0 RGPP0_2__dmy0 ) rupolym l=17.13u w=1u m=16 \
        multi=(1)
RGPP0_3__dmy0  (RGPP0_2__dmy0 RGPP0_3__dmy0 ) rupolym l=17.13u w=1u m=16 \
        multi=(1)
RGPP0_4__dmy0  (RGPP0_3__dmy0 RGPP0_4__dmy0 ) rupolym l=17.13u w=1u m=16 \
        multi=(1)
RGPP0_5__dmy0  (RGPP0_4__dmy0 GPPRG ) rupolym l=17.13u w=1u m=16 multi=(1)
//End of RGPP0

    X025 (L VDD VSS GNNPRE) sar8p_inv
    X008 (H VDD VSS GPNPRE) sar8p_inv
ends sar8p_refdrv_b4

subckt sar8p_refdrv_b5 GNN GNP GPN GPP H L VDD VSS
    GNNCN (GNNDRV GNNB VSS VSS) nch_mac l=30n w=500n multi=4 nf=1 sd=100n \
        ad=3.75e-14 as=3.75e-14 pd=1.15u ps=1.15u nrd=0.662935 \
        nrs=0.662935 sa=75.0n sb=75.0n sa1=75.0n sa2=75.0n sa3=75.0n \
        sa4=75.0n sb1=75.0n sb2=75.0n sb3=75.0n spa=100n spa1=100n \
        spa2=100n spa3=100n sap=91.9776n sapb=114.444n spba=115.715n \
        spba1=117.043n dfm_flag=0 spmt=1.11111e+15 spomt=0 \
        spomt1=1.11111e+60 spmb=1.11111e+15 spomb=0 spomb1=1.11111e+60
    GNNBN (GNNB GNNA VSS VSS) nch_mac l=30n w=500n multi=1 nf=1 sd=100n \
        ad=3.75e-14 as=3.75e-14 pd=1.15u ps=1.15u nrd=0.662935 \
        nrs=0.662935 sa=75.0n sb=75.0n sa1=75.0n sa2=75.0n sa3=75.0n \
        sa4=75.0n sb1=75.0n sb2=75.0n sb3=75.0n spa=100n spa1=100n \
        spa2=100n spa3=100n sap=91.9776n sapb=114.444n spba=115.715n \
        spba1=117.043n dfm_flag=0 spmt=1.11111e+15 spomt=0 \
        spomt1=1.11111e+60 spmb=1.11111e+15 spomb=0 spomb1=1.11111e+60
    GNNAN (GNNA GNNPRE VSS VSS) nch_mac l=30n w=500n multi=1 nf=1 sd=100n \
        ad=3.75e-14 as=3.75e-14 pd=1.15u ps=1.15u nrd=0.662935 \
        nrs=0.662935 sa=75.0n sb=75.0n sa1=75.0n sa2=75.0n sa3=75.0n \
        sa4=75.0n sb1=75.0n sb2=75.0n sb3=75.0n spa=100n spa1=100n \
        spa2=100n spa3=100n sap=91.9776n sapb=114.444n spba=115.715n \
        spba1=117.043n dfm_flag=0 spmt=1.11111e+15 spomt=0 \
        spomt1=1.11111e+60 spmb=1.11111e+15 spomb=0 spomb1=1.11111e+60
    GNPCN (GNPDRV GNPB VSS VSS) nch_mac l=30n w=500n multi=4 nf=1 sd=100n \
        ad=3.75e-14 as=3.75e-14 pd=1.15u ps=1.15u nrd=0.662935 \
        nrs=0.662935 sa=75.0n sb=75.0n sa1=75.0n sa2=75.0n sa3=75.0n \
        sa4=75.0n sb1=75.0n sb2=75.0n sb3=75.0n spa=100n spa1=100n \
        spa2=100n spa3=100n sap=91.9776n sapb=114.444n spba=115.715n \
        spba1=117.043n dfm_flag=0 spmt=1.11111e+15 spomt=0 \
        spomt1=1.11111e+60 spmb=1.11111e+15 spomb=0 spomb1=1.11111e+60
    GNPBN (GNPB GNPA VSS VSS) nch_mac l=30n w=500n multi=1 nf=1 sd=100n \
        ad=3.75e-14 as=3.75e-14 pd=1.15u ps=1.15u nrd=0.662935 \
        nrs=0.662935 sa=75.0n sb=75.0n sa1=75.0n sa2=75.0n sa3=75.0n \
        sa4=75.0n sb1=75.0n sb2=75.0n sb3=75.0n spa=100n spa1=100n \
        spa2=100n spa3=100n sap=91.9776n sapb=114.444n spba=115.715n \
        spba1=117.043n dfm_flag=0 spmt=1.11111e+15 spomt=0 \
        spomt1=1.11111e+60 spmb=1.11111e+15 spomb=0 spomb1=1.11111e+60
    GNPAN (GNPA H VSS VSS) nch_mac l=30n w=500n multi=1 nf=1 sd=100n \
        ad=3.75e-14 as=3.75e-14 pd=1.15u ps=1.15u nrd=0.662935 \
        nrs=0.662935 sa=75.0n sb=75.0n sa1=75.0n sa2=75.0n sa3=75.0n \
        sa4=75.0n sb1=75.0n sb2=75.0n sb3=75.0n spa=100n spa1=100n \
        spa2=100n spa3=100n sap=91.9776n sapb=114.444n spba=115.715n \
        spba1=117.043n dfm_flag=0 spmt=1.11111e+15 spomt=0 \
        spomt1=1.11111e+60 spmb=1.11111e+15 spomb=0 spomb1=1.11111e+60
    GPNCN (GPNDRV GPNB VSS VSS) nch_mac l=30n w=500n multi=4 nf=1 sd=100n \
        ad=3.75e-14 as=3.75e-14 pd=1.15u ps=1.15u nrd=0.662935 \
        nrs=0.662935 sa=75.0n sb=75.0n sa1=75.0n sa2=75.0n sa3=75.0n \
        sa4=75.0n sb1=75.0n sb2=75.0n sb3=75.0n spa=100n spa1=100n \
        spa2=100n spa3=100n sap=91.9776n sapb=114.444n spba=115.715n \
        spba1=117.043n dfm_flag=0 spmt=1.11111e+15 spomt=0 \
        spomt1=1.11111e+60 spmb=1.11111e+15 spomb=0 spomb1=1.11111e+60
    GPNBN (GPNB GPNA VSS VSS) nch_mac l=30n w=500n multi=1 nf=1 sd=100n \
        ad=3.75e-14 as=3.75e-14 pd=1.15u ps=1.15u nrd=0.662935 \
        nrs=0.662935 sa=75.0n sb=75.0n sa1=75.0n sa2=75.0n sa3=75.0n \
        sa4=75.0n sb1=75.0n sb2=75.0n sb3=75.0n spa=100n spa1=100n \
        spa2=100n spa3=100n sap=91.9776n sapb=114.444n spba=115.715n \
        spba1=117.043n dfm_flag=0 spmt=1.11111e+15 spomt=0 \
        spomt1=1.11111e+60 spmb=1.11111e+15 spomb=0 spomb1=1.11111e+60
    GPNAN (GPNA GPNPRE VSS VSS) nch_mac l=30n w=500n multi=1 nf=1 sd=100n \
        ad=3.75e-14 as=3.75e-14 pd=1.15u ps=1.15u nrd=0.662935 \
        nrs=0.662935 sa=75.0n sb=75.0n sa1=75.0n sa2=75.0n sa3=75.0n \
        sa4=75.0n sb1=75.0n sb2=75.0n sb3=75.0n spa=100n spa1=100n \
        spa2=100n spa3=100n sap=91.9776n sapb=114.444n spba=115.715n \
        spba1=117.043n dfm_flag=0 spmt=1.11111e+15 spomt=0 \
        spomt1=1.11111e+60 spmb=1.11111e+15 spomb=0 spomb1=1.11111e+60
    GPPCN (GPPDRV GPPB VSS VSS) nch_mac l=30n w=500n multi=4 nf=1 sd=100n \
        ad=3.75e-14 as=3.75e-14 pd=1.15u ps=1.15u nrd=0.662935 \
        nrs=0.662935 sa=75.0n sb=75.0n sa1=75.0n sa2=75.0n sa3=75.0n \
        sa4=75.0n sb1=75.0n sb2=75.0n sb3=75.0n spa=100n spa1=100n \
        spa2=100n spa3=100n sap=91.9776n sapb=114.444n spba=115.715n \
        spba1=117.043n dfm_flag=0 spmt=1.11111e+15 spomt=0 \
        spomt1=1.11111e+60 spmb=1.11111e+15 spomb=0 spomb1=1.11111e+60
    GPPBN (GPPB GPPA VSS VSS) nch_mac l=30n w=500n multi=1 nf=1 sd=100n \
        ad=3.75e-14 as=3.75e-14 pd=1.15u ps=1.15u nrd=0.662935 \
        nrs=0.662935 sa=75.0n sb=75.0n sa1=75.0n sa2=75.0n sa3=75.0n \
        sa4=75.0n sb1=75.0n sb2=75.0n sb3=75.0n spa=100n spa1=100n \
        spa2=100n spa3=100n sap=91.9776n sapb=114.444n spba=115.715n \
        spba1=117.043n dfm_flag=0 spmt=1.11111e+15 spomt=0 \
        spomt1=1.11111e+60 spmb=1.11111e+15 spomb=0 spomb1=1.11111e+60
    GPPAN (GPPA L VSS VSS) nch_mac l=30n w=500n multi=1 nf=1 sd=100n \
        ad=3.75e-14 as=3.75e-14 pd=1.15u ps=1.15u nrd=0.662935 \
        nrs=0.662935 sa=75.0n sb=75.0n sa1=75.0n sa2=75.0n sa3=75.0n \
        sa4=75.0n sb1=75.0n sb2=75.0n sb3=75.0n spa=100n spa1=100n \
        spa2=100n spa3=100n sap=91.9776n sapb=114.444n spba=115.715n \
        spba1=117.043n dfm_flag=0 spmt=1.11111e+15 spomt=0 \
        spomt1=1.11111e+60 spmb=1.11111e+15 spomb=0 spomb1=1.11111e+60
    GNNCP (GNNDRV GNNB VDD VDD) pch_mac l=30n w=1u multi=4 nf=1 sd=100n \
        ad=7.5e-14 as=7.5e-14 pd=2.15u ps=2.15u nrd=0.165806 nrs=0.165806 \
        sa=75.0n sb=75.0n sa1=75.0n sa2=75.0n sa3=75.0n sa4=75.0n \
        sb1=75.0n sb2=75.0n sb3=75.0n spa=100n spa1=100n spa2=100n \
        spa3=100n sap=91.9776n sapb=114.444n spba=115.715n spba1=117.043n \
        dfm_flag=0 spmt=1.11111e+15 spomt=0 spomt1=1.11111e+60 \
        spmb=1.11111e+15 spomb=0 spomb1=1.11111e+60
    GNNBP (GNNB GNNA VDD VDD) pch_mac l=30n w=1u multi=1 nf=1 sd=100n \
        ad=7.5e-14 as=7.5e-14 pd=2.15u ps=2.15u nrd=0.165806 nrs=0.165806 \
        sa=75.0n sb=75.0n sa1=75.0n sa2=75.0n sa3=75.0n sa4=75.0n \
        sb1=75.0n sb2=75.0n sb3=75.0n spa=100n spa1=100n spa2=100n \
        spa3=100n sap=91.9776n sapb=114.444n spba=115.715n spba1=117.043n \
        dfm_flag=0 spmt=1.11111e+15 spomt=0 spomt1=1.11111e+60 \
        spmb=1.11111e+15 spomb=0 spomb1=1.11111e+60
    GNNAP (GNNA GNNPRE VDD VDD) pch_mac l=30n w=1u multi=1 nf=1 sd=100n \
        ad=7.5e-14 as=7.5e-14 pd=2.15u ps=2.15u nrd=0.165806 nrs=0.165806 \
        sa=75.0n sb=75.0n sa1=75.0n sa2=75.0n sa3=75.0n sa4=75.0n \
        sb1=75.0n sb2=75.0n sb3=75.0n spa=100n spa1=100n spa2=100n \
        spa3=100n sap=91.9776n sapb=114.444n spba=115.715n spba1=117.043n \
        dfm_flag=0 spmt=1.11111e+15 spomt=0 spomt1=1.11111e+60 \
        spmb=1.11111e+15 spomb=0 spomb1=1.11111e+60
    GNPCP (GNPDRV GNPB VDD VDD) pch_mac l=30n w=1u multi=4 nf=1 sd=100n \
        ad=7.5e-14 as=7.5e-14 pd=2.15u ps=2.15u nrd=0.165806 nrs=0.165806 \
        sa=75.0n sb=75.0n sa1=75.0n sa2=75.0n sa3=75.0n sa4=75.0n \
        sb1=75.0n sb2=75.0n sb3=75.0n spa=100n spa1=100n spa2=100n \
        spa3=100n sap=91.9776n sapb=114.444n spba=115.715n spba1=117.043n \
        dfm_flag=0 spmt=1.11111e+15 spomt=0 spomt1=1.11111e+60 \
        spmb=1.11111e+15 spomb=0 spomb1=1.11111e+60
    GNPBP (GNPB GNPA VDD VDD) pch_mac l=30n w=1u multi=1 nf=1 sd=100n \
        ad=7.5e-14 as=7.5e-14 pd=2.15u ps=2.15u nrd=0.165806 nrs=0.165806 \
        sa=75.0n sb=75.0n sa1=75.0n sa2=75.0n sa3=75.0n sa4=75.0n \
        sb1=75.0n sb2=75.0n sb3=75.0n spa=100n spa1=100n spa2=100n \
        spa3=100n sap=91.9776n sapb=114.444n spba=115.715n spba1=117.043n \
        dfm_flag=0 spmt=1.11111e+15 spomt=0 spomt1=1.11111e+60 \
        spmb=1.11111e+15 spomb=0 spomb1=1.11111e+60
    GNPAP (GNPA H VDD VDD) pch_mac l=30n w=1u multi=1 nf=1 sd=100n \
        ad=7.5e-14 as=7.5e-14 pd=2.15u ps=2.15u nrd=0.165806 nrs=0.165806 \
        sa=75.0n sb=75.0n sa1=75.0n sa2=75.0n sa3=75.0n sa4=75.0n \
        sb1=75.0n sb2=75.0n sb3=75.0n spa=100n spa1=100n spa2=100n \
        spa3=100n sap=91.9776n sapb=114.444n spba=115.715n spba1=117.043n \
        dfm_flag=0 spmt=1.11111e+15 spomt=0 spomt1=1.11111e+60 \
        spmb=1.11111e+15 spomb=0 spomb1=1.11111e+60
    GPNCP (GPNDRV GPNB VDD VDD) pch_mac l=30n w=1u multi=4 nf=1 sd=100n \
        ad=7.5e-14 as=7.5e-14 pd=2.15u ps=2.15u nrd=0.165806 nrs=0.165806 \
        sa=75.0n sb=75.0n sa1=75.0n sa2=75.0n sa3=75.0n sa4=75.0n \
        sb1=75.0n sb2=75.0n sb3=75.0n spa=100n spa1=100n spa2=100n \
        spa3=100n sap=91.9776n sapb=114.444n spba=115.715n spba1=117.043n \
        dfm_flag=0 spmt=1.11111e+15 spomt=0 spomt1=1.11111e+60 \
        spmb=1.11111e+15 spomb=0 spomb1=1.11111e+60
    GPNBP (GPNB GPNA VDD VDD) pch_mac l=30n w=1u multi=1 nf=1 sd=100n \
        ad=7.5e-14 as=7.5e-14 pd=2.15u ps=2.15u nrd=0.165806 nrs=0.165806 \
        sa=75.0n sb=75.0n sa1=75.0n sa2=75.0n sa3=75.0n sa4=75.0n \
        sb1=75.0n sb2=75.0n sb3=75.0n spa=100n spa1=100n spa2=100n \
        spa3=100n sap=91.9776n sapb=114.444n spba=115.715n spba1=117.043n \
        dfm_flag=0 spmt=1.11111e+15 spomt=0 spomt1=1.11111e+60 \
        spmb=1.11111e+15 spomb=0 spomb1=1.11111e+60
    GPNAP (GPNA GPNPRE VDD VDD) pch_mac l=30n w=1u multi=1 nf=1 sd=100n \
        ad=7.5e-14 as=7.5e-14 pd=2.15u ps=2.15u nrd=0.165806 nrs=0.165806 \
        sa=75.0n sb=75.0n sa1=75.0n sa2=75.0n sa3=75.0n sa4=75.0n \
        sb1=75.0n sb2=75.0n sb3=75.0n spa=100n spa1=100n spa2=100n \
        spa3=100n sap=91.9776n sapb=114.444n spba=115.715n spba1=117.043n \
        dfm_flag=0 spmt=1.11111e+15 spomt=0 spomt1=1.11111e+60 \
        spmb=1.11111e+15 spomb=0 spomb1=1.11111e+60
    GPPCP (GPPDRV GPPB VDD VDD) pch_mac l=30n w=1u multi=4 nf=1 sd=100n \
        ad=7.5e-14 as=7.5e-14 pd=2.15u ps=2.15u nrd=0.165806 nrs=0.165806 \
        sa=75.0n sb=75.0n sa1=75.0n sa2=75.0n sa3=75.0n sa4=75.0n \
        sb1=75.0n sb2=75.0n sb3=75.0n spa=100n spa1=100n spa2=100n \
        spa3=100n sap=91.9776n sapb=114.444n spba=115.715n spba1=117.043n \
        dfm_flag=0 spmt=1.11111e+15 spomt=0 spomt1=1.11111e+60 \
        spmb=1.11111e+15 spomb=0 spomb1=1.11111e+60
    GPPBP (GPPB GPPA VDD VDD) pch_mac l=30n w=1u multi=1 nf=1 sd=100n \
        ad=7.5e-14 as=7.5e-14 pd=2.15u ps=2.15u nrd=0.165806 nrs=0.165806 \
        sa=75.0n sb=75.0n sa1=75.0n sa2=75.0n sa3=75.0n sa4=75.0n \
        sb1=75.0n sb2=75.0n sb3=75.0n spa=100n spa1=100n spa2=100n \
        spa3=100n sap=91.9776n sapb=114.444n spba=115.715n spba1=117.043n \
        dfm_flag=0 spmt=1.11111e+15 spomt=0 spomt1=1.11111e+60 \
        spmb=1.11111e+15 spomb=0 spomb1=1.11111e+60
    GPPAP (GPPA L VDD VDD) pch_mac l=30n w=1u multi=1 nf=1 sd=100n \
        ad=7.5e-14 as=7.5e-14 pd=2.15u ps=2.15u nrd=0.165806 nrs=0.165806 \
        sa=75.0n sb=75.0n sa1=75.0n sa2=75.0n sa3=75.0n sa4=75.0n \
        sb1=75.0n sb2=75.0n sb3=75.0n spa=100n spa1=100n spa2=100n \
        spa3=100n sap=91.9776n sapb=114.444n spba=115.715n spba1=117.043n \
        dfm_flag=0 spmt=1.11111e+15 spomt=0 spomt1=1.11111e+60 \
        spmb=1.11111e+15 spomb=0 spomb1=1.11111e+60
//Series configuration of RGNN1
RGNN1  (GNNRG RGNN1_1__dmy0 ) rupolym l=17.13u w=1u m=32 multi=(1)
RGNN1_2__dmy0  (RGNN1_1__dmy0 RGNN1_2__dmy0 ) rupolym l=17.13u w=1u m=32 \
        multi=(1)
RGNN1_3__dmy0  (RGNN1_2__dmy0 RGNN1_3__dmy0 ) rupolym l=17.13u w=1u m=32 \
        multi=(1)
RGNN1_4__dmy0  (RGNN1_3__dmy0 RGNN1_4__dmy0 ) rupolym l=17.13u w=1u m=32 \
        multi=(1)
RGNN1_5__dmy0  (RGNN1_4__dmy0 GNN ) rupolym l=17.13u w=1u m=32 multi=(1)
//End of RGNN1

//Series configuration of RGNN0
RGNN0  (GNNDRV RGNN0_1__dmy0 ) rupolym l=17.13u w=1u m=32 multi=(1)
RGNN0_2__dmy0  (RGNN0_1__dmy0 RGNN0_2__dmy0 ) rupolym l=17.13u w=1u m=32 \
        multi=(1)
RGNN0_3__dmy0  (RGNN0_2__dmy0 RGNN0_3__dmy0 ) rupolym l=17.13u w=1u m=32 \
        multi=(1)
RGNN0_4__dmy0  (RGNN0_3__dmy0 RGNN0_4__dmy0 ) rupolym l=17.13u w=1u m=32 \
        multi=(1)
RGNN0_5__dmy0  (RGNN0_4__dmy0 GNNRG ) rupolym l=17.13u w=1u m=32 multi=(1)
//End of RGNN0

//Series configuration of RGNP1
RGNP1  (GNPRG RGNP1_1__dmy0 ) rupolym l=17.13u w=1u m=32 multi=(1)
RGNP1_2__dmy0  (RGNP1_1__dmy0 RGNP1_2__dmy0 ) rupolym l=17.13u w=1u m=32 \
        multi=(1)
RGNP1_3__dmy0  (RGNP1_2__dmy0 RGNP1_3__dmy0 ) rupolym l=17.13u w=1u m=32 \
        multi=(1)
RGNP1_4__dmy0  (RGNP1_3__dmy0 RGNP1_4__dmy0 ) rupolym l=17.13u w=1u m=32 \
        multi=(1)
RGNP1_5__dmy0  (RGNP1_4__dmy0 GNP ) rupolym l=17.13u w=1u m=32 multi=(1)
//End of RGNP1

//Series configuration of RGNP0
RGNP0  (GNPDRV RGNP0_1__dmy0 ) rupolym l=17.13u w=1u m=32 multi=(1)
RGNP0_2__dmy0  (RGNP0_1__dmy0 RGNP0_2__dmy0 ) rupolym l=17.13u w=1u m=32 \
        multi=(1)
RGNP0_3__dmy0  (RGNP0_2__dmy0 RGNP0_3__dmy0 ) rupolym l=17.13u w=1u m=32 \
        multi=(1)
RGNP0_4__dmy0  (RGNP0_3__dmy0 RGNP0_4__dmy0 ) rupolym l=17.13u w=1u m=32 \
        multi=(1)
RGNP0_5__dmy0  (RGNP0_4__dmy0 GNPRG ) rupolym l=17.13u w=1u m=32 multi=(1)
//End of RGNP0

//Series configuration of RGPN1
RGPN1  (GPNRG RGPN1_1__dmy0 ) rupolym l=17.13u w=1u m=32 multi=(1)
RGPN1_2__dmy0  (RGPN1_1__dmy0 RGPN1_2__dmy0 ) rupolym l=17.13u w=1u m=32 \
        multi=(1)
RGPN1_3__dmy0  (RGPN1_2__dmy0 RGPN1_3__dmy0 ) rupolym l=17.13u w=1u m=32 \
        multi=(1)
RGPN1_4__dmy0  (RGPN1_3__dmy0 RGPN1_4__dmy0 ) rupolym l=17.13u w=1u m=32 \
        multi=(1)
RGPN1_5__dmy0  (RGPN1_4__dmy0 GPN ) rupolym l=17.13u w=1u m=32 multi=(1)
//End of RGPN1

//Series configuration of RGPN0
RGPN0  (GPNDRV RGPN0_1__dmy0 ) rupolym l=17.13u w=1u m=32 multi=(1)
RGPN0_2__dmy0  (RGPN0_1__dmy0 RGPN0_2__dmy0 ) rupolym l=17.13u w=1u m=32 \
        multi=(1)
RGPN0_3__dmy0  (RGPN0_2__dmy0 RGPN0_3__dmy0 ) rupolym l=17.13u w=1u m=32 \
        multi=(1)
RGPN0_4__dmy0  (RGPN0_3__dmy0 RGPN0_4__dmy0 ) rupolym l=17.13u w=1u m=32 \
        multi=(1)
RGPN0_5__dmy0  (RGPN0_4__dmy0 GPNRG ) rupolym l=17.13u w=1u m=32 multi=(1)
//End of RGPN0

//Series configuration of RGPP1
RGPP1  (GPPRG RGPP1_1__dmy0 ) rupolym l=17.13u w=1u m=32 multi=(1)
RGPP1_2__dmy0  (RGPP1_1__dmy0 RGPP1_2__dmy0 ) rupolym l=17.13u w=1u m=32 \
        multi=(1)
RGPP1_3__dmy0  (RGPP1_2__dmy0 RGPP1_3__dmy0 ) rupolym l=17.13u w=1u m=32 \
        multi=(1)
RGPP1_4__dmy0  (RGPP1_3__dmy0 RGPP1_4__dmy0 ) rupolym l=17.13u w=1u m=32 \
        multi=(1)
RGPP1_5__dmy0  (RGPP1_4__dmy0 GPP ) rupolym l=17.13u w=1u m=32 multi=(1)
//End of RGPP1

//Series configuration of RGPP0
RGPP0  (GPPDRV RGPP0_1__dmy0 ) rupolym l=17.13u w=1u m=32 multi=(1)
RGPP0_2__dmy0  (RGPP0_1__dmy0 RGPP0_2__dmy0 ) rupolym l=17.13u w=1u m=32 \
        multi=(1)
RGPP0_3__dmy0  (RGPP0_2__dmy0 RGPP0_3__dmy0 ) rupolym l=17.13u w=1u m=32 \
        multi=(1)
RGPP0_4__dmy0  (RGPP0_3__dmy0 RGPP0_4__dmy0 ) rupolym l=17.13u w=1u m=32 \
        multi=(1)
RGPP0_5__dmy0  (RGPP0_4__dmy0 GPPRG ) rupolym l=17.13u w=1u m=32 multi=(1)
//End of RGPP0

    X025 (L VDD VSS GNNPRE) sar8p_inv
    X008 (H VDD VSS GPNPRE) sar8p_inv
ends sar8p_refdrv_b5

subckt sar8p_refdrv_b6 GNN GNP GPN GPP H L VDD VSS
    GNNCN (GNNDRV GNNB VSS VSS) nch_mac l=30n w=500n multi=8 nf=1 sd=100n \
        ad=3.75e-14 as=3.75e-14 pd=1.15u ps=1.15u nrd=0.662935 \
        nrs=0.662935 sa=75.0n sb=75.0n sa1=75.0n sa2=75.0n sa3=75.0n \
        sa4=75.0n sb1=75.0n sb2=75.0n sb3=75.0n spa=100n spa1=100n \
        spa2=100n spa3=100n sap=91.9776n sapb=114.444n spba=115.715n \
        spba1=117.043n dfm_flag=0 spmt=1.11111e+15 spomt=0 \
        spomt1=1.11111e+60 spmb=1.11111e+15 spomb=0 spomb1=1.11111e+60
    GNNBN (GNNB GNNA VSS VSS) nch_mac l=30n w=500n multi=2 nf=1 sd=100n \
        ad=3.75e-14 as=3.75e-14 pd=1.15u ps=1.15u nrd=0.662935 \
        nrs=0.662935 sa=75.0n sb=75.0n sa1=75.0n sa2=75.0n sa3=75.0n \
        sa4=75.0n sb1=75.0n sb2=75.0n sb3=75.0n spa=100n spa1=100n \
        spa2=100n spa3=100n sap=91.9776n sapb=114.444n spba=115.715n \
        spba1=117.043n dfm_flag=0 spmt=1.11111e+15 spomt=0 \
        spomt1=1.11111e+60 spmb=1.11111e+15 spomb=0 spomb1=1.11111e+60
    GNNAN (GNNA GNNPRE VSS VSS) nch_mac l=30n w=500n multi=1 nf=1 sd=100n \
        ad=3.75e-14 as=3.75e-14 pd=1.15u ps=1.15u nrd=0.662935 \
        nrs=0.662935 sa=75.0n sb=75.0n sa1=75.0n sa2=75.0n sa3=75.0n \
        sa4=75.0n sb1=75.0n sb2=75.0n sb3=75.0n spa=100n spa1=100n \
        spa2=100n spa3=100n sap=91.9776n sapb=114.444n spba=115.715n \
        spba1=117.043n dfm_flag=0 spmt=1.11111e+15 spomt=0 \
        spomt1=1.11111e+60 spmb=1.11111e+15 spomb=0 spomb1=1.11111e+60
    GNPCN (GNPDRV GNPB VSS VSS) nch_mac l=30n w=500n multi=8 nf=1 sd=100n \
        ad=3.75e-14 as=3.75e-14 pd=1.15u ps=1.15u nrd=0.662935 \
        nrs=0.662935 sa=75.0n sb=75.0n sa1=75.0n sa2=75.0n sa3=75.0n \
        sa4=75.0n sb1=75.0n sb2=75.0n sb3=75.0n spa=100n spa1=100n \
        spa2=100n spa3=100n sap=91.9776n sapb=114.444n spba=115.715n \
        spba1=117.043n dfm_flag=0 spmt=1.11111e+15 spomt=0 \
        spomt1=1.11111e+60 spmb=1.11111e+15 spomb=0 spomb1=1.11111e+60
    GNPBN (GNPB GNPA VSS VSS) nch_mac l=30n w=500n multi=2 nf=1 sd=100n \
        ad=3.75e-14 as=3.75e-14 pd=1.15u ps=1.15u nrd=0.662935 \
        nrs=0.662935 sa=75.0n sb=75.0n sa1=75.0n sa2=75.0n sa3=75.0n \
        sa4=75.0n sb1=75.0n sb2=75.0n sb3=75.0n spa=100n spa1=100n \
        spa2=100n spa3=100n sap=91.9776n sapb=114.444n spba=115.715n \
        spba1=117.043n dfm_flag=0 spmt=1.11111e+15 spomt=0 \
        spomt1=1.11111e+60 spmb=1.11111e+15 spomb=0 spomb1=1.11111e+60
    GNPAN (GNPA H VSS VSS) nch_mac l=30n w=500n multi=1 nf=1 sd=100n \
        ad=3.75e-14 as=3.75e-14 pd=1.15u ps=1.15u nrd=0.662935 \
        nrs=0.662935 sa=75.0n sb=75.0n sa1=75.0n sa2=75.0n sa3=75.0n \
        sa4=75.0n sb1=75.0n sb2=75.0n sb3=75.0n spa=100n spa1=100n \
        spa2=100n spa3=100n sap=91.9776n sapb=114.444n spba=115.715n \
        spba1=117.043n dfm_flag=0 spmt=1.11111e+15 spomt=0 \
        spomt1=1.11111e+60 spmb=1.11111e+15 spomb=0 spomb1=1.11111e+60
    GPNCN (GPNDRV GPNB VSS VSS) nch_mac l=30n w=500n multi=8 nf=1 sd=100n \
        ad=3.75e-14 as=3.75e-14 pd=1.15u ps=1.15u nrd=0.662935 \
        nrs=0.662935 sa=75.0n sb=75.0n sa1=75.0n sa2=75.0n sa3=75.0n \
        sa4=75.0n sb1=75.0n sb2=75.0n sb3=75.0n spa=100n spa1=100n \
        spa2=100n spa3=100n sap=91.9776n sapb=114.444n spba=115.715n \
        spba1=117.043n dfm_flag=0 spmt=1.11111e+15 spomt=0 \
        spomt1=1.11111e+60 spmb=1.11111e+15 spomb=0 spomb1=1.11111e+60
    GPNBN (GPNB GPNA VSS VSS) nch_mac l=30n w=500n multi=2 nf=1 sd=100n \
        ad=3.75e-14 as=3.75e-14 pd=1.15u ps=1.15u nrd=0.662935 \
        nrs=0.662935 sa=75.0n sb=75.0n sa1=75.0n sa2=75.0n sa3=75.0n \
        sa4=75.0n sb1=75.0n sb2=75.0n sb3=75.0n spa=100n spa1=100n \
        spa2=100n spa3=100n sap=91.9776n sapb=114.444n spba=115.715n \
        spba1=117.043n dfm_flag=0 spmt=1.11111e+15 spomt=0 \
        spomt1=1.11111e+60 spmb=1.11111e+15 spomb=0 spomb1=1.11111e+60
    GPNAN (GPNA GPNPRE VSS VSS) nch_mac l=30n w=500n multi=1 nf=1 sd=100n \
        ad=3.75e-14 as=3.75e-14 pd=1.15u ps=1.15u nrd=0.662935 \
        nrs=0.662935 sa=75.0n sb=75.0n sa1=75.0n sa2=75.0n sa3=75.0n \
        sa4=75.0n sb1=75.0n sb2=75.0n sb3=75.0n spa=100n spa1=100n \
        spa2=100n spa3=100n sap=91.9776n sapb=114.444n spba=115.715n \
        spba1=117.043n dfm_flag=0 spmt=1.11111e+15 spomt=0 \
        spomt1=1.11111e+60 spmb=1.11111e+15 spomb=0 spomb1=1.11111e+60
    GPPCN (GPPDRV GPPB VSS VSS) nch_mac l=30n w=500n multi=8 nf=1 sd=100n \
        ad=3.75e-14 as=3.75e-14 pd=1.15u ps=1.15u nrd=0.662935 \
        nrs=0.662935 sa=75.0n sb=75.0n sa1=75.0n sa2=75.0n sa3=75.0n \
        sa4=75.0n sb1=75.0n sb2=75.0n sb3=75.0n spa=100n spa1=100n \
        spa2=100n spa3=100n sap=91.9776n sapb=114.444n spba=115.715n \
        spba1=117.043n dfm_flag=0 spmt=1.11111e+15 spomt=0 \
        spomt1=1.11111e+60 spmb=1.11111e+15 spomb=0 spomb1=1.11111e+60
    GPPBN (GPPB GPPA VSS VSS) nch_mac l=30n w=500n multi=2 nf=1 sd=100n \
        ad=3.75e-14 as=3.75e-14 pd=1.15u ps=1.15u nrd=0.662935 \
        nrs=0.662935 sa=75.0n sb=75.0n sa1=75.0n sa2=75.0n sa3=75.0n \
        sa4=75.0n sb1=75.0n sb2=75.0n sb3=75.0n spa=100n spa1=100n \
        spa2=100n spa3=100n sap=91.9776n sapb=114.444n spba=115.715n \
        spba1=117.043n dfm_flag=0 spmt=1.11111e+15 spomt=0 \
        spomt1=1.11111e+60 spmb=1.11111e+15 spomb=0 spomb1=1.11111e+60
    GPPAN (GPPA L VSS VSS) nch_mac l=30n w=500n multi=1 nf=1 sd=100n \
        ad=3.75e-14 as=3.75e-14 pd=1.15u ps=1.15u nrd=0.662935 \
        nrs=0.662935 sa=75.0n sb=75.0n sa1=75.0n sa2=75.0n sa3=75.0n \
        sa4=75.0n sb1=75.0n sb2=75.0n sb3=75.0n spa=100n spa1=100n \
        spa2=100n spa3=100n sap=91.9776n sapb=114.444n spba=115.715n \
        spba1=117.043n dfm_flag=0 spmt=1.11111e+15 spomt=0 \
        spomt1=1.11111e+60 spmb=1.11111e+15 spomb=0 spomb1=1.11111e+60
    GNNCP (GNNDRV GNNB VDD VDD) pch_mac l=30n w=1u multi=8 nf=1 sd=100n \
        ad=7.5e-14 as=7.5e-14 pd=2.15u ps=2.15u nrd=0.165806 nrs=0.165806 \
        sa=75.0n sb=75.0n sa1=75.0n sa2=75.0n sa3=75.0n sa4=75.0n \
        sb1=75.0n sb2=75.0n sb3=75.0n spa=100n spa1=100n spa2=100n \
        spa3=100n sap=91.9776n sapb=114.444n spba=115.715n spba1=117.043n \
        dfm_flag=0 spmt=1.11111e+15 spomt=0 spomt1=1.11111e+60 \
        spmb=1.11111e+15 spomb=0 spomb1=1.11111e+60
    GNNBP (GNNB GNNA VDD VDD) pch_mac l=30n w=1u multi=2 nf=1 sd=100n \
        ad=7.5e-14 as=7.5e-14 pd=2.15u ps=2.15u nrd=0.165806 nrs=0.165806 \
        sa=75.0n sb=75.0n sa1=75.0n sa2=75.0n sa3=75.0n sa4=75.0n \
        sb1=75.0n sb2=75.0n sb3=75.0n spa=100n spa1=100n spa2=100n \
        spa3=100n sap=91.9776n sapb=114.444n spba=115.715n spba1=117.043n \
        dfm_flag=0 spmt=1.11111e+15 spomt=0 spomt1=1.11111e+60 \
        spmb=1.11111e+15 spomb=0 spomb1=1.11111e+60
    GNNAP (GNNA GNNPRE VDD VDD) pch_mac l=30n w=1u multi=1 nf=1 sd=100n \
        ad=7.5e-14 as=7.5e-14 pd=2.15u ps=2.15u nrd=0.165806 nrs=0.165806 \
        sa=75.0n sb=75.0n sa1=75.0n sa2=75.0n sa3=75.0n sa4=75.0n \
        sb1=75.0n sb2=75.0n sb3=75.0n spa=100n spa1=100n spa2=100n \
        spa3=100n sap=91.9776n sapb=114.444n spba=115.715n spba1=117.043n \
        dfm_flag=0 spmt=1.11111e+15 spomt=0 spomt1=1.11111e+60 \
        spmb=1.11111e+15 spomb=0 spomb1=1.11111e+60
    GNPCP (GNPDRV GNPB VDD VDD) pch_mac l=30n w=1u multi=8 nf=1 sd=100n \
        ad=7.5e-14 as=7.5e-14 pd=2.15u ps=2.15u nrd=0.165806 nrs=0.165806 \
        sa=75.0n sb=75.0n sa1=75.0n sa2=75.0n sa3=75.0n sa4=75.0n \
        sb1=75.0n sb2=75.0n sb3=75.0n spa=100n spa1=100n spa2=100n \
        spa3=100n sap=91.9776n sapb=114.444n spba=115.715n spba1=117.043n \
        dfm_flag=0 spmt=1.11111e+15 spomt=0 spomt1=1.11111e+60 \
        spmb=1.11111e+15 spomb=0 spomb1=1.11111e+60
    GNPBP (GNPB GNPA VDD VDD) pch_mac l=30n w=1u multi=2 nf=1 sd=100n \
        ad=7.5e-14 as=7.5e-14 pd=2.15u ps=2.15u nrd=0.165806 nrs=0.165806 \
        sa=75.0n sb=75.0n sa1=75.0n sa2=75.0n sa3=75.0n sa4=75.0n \
        sb1=75.0n sb2=75.0n sb3=75.0n spa=100n spa1=100n spa2=100n \
        spa3=100n sap=91.9776n sapb=114.444n spba=115.715n spba1=117.043n \
        dfm_flag=0 spmt=1.11111e+15 spomt=0 spomt1=1.11111e+60 \
        spmb=1.11111e+15 spomb=0 spomb1=1.11111e+60
    GNPAP (GNPA H VDD VDD) pch_mac l=30n w=1u multi=1 nf=1 sd=100n \
        ad=7.5e-14 as=7.5e-14 pd=2.15u ps=2.15u nrd=0.165806 nrs=0.165806 \
        sa=75.0n sb=75.0n sa1=75.0n sa2=75.0n sa3=75.0n sa4=75.0n \
        sb1=75.0n sb2=75.0n sb3=75.0n spa=100n spa1=100n spa2=100n \
        spa3=100n sap=91.9776n sapb=114.444n spba=115.715n spba1=117.043n \
        dfm_flag=0 spmt=1.11111e+15 spomt=0 spomt1=1.11111e+60 \
        spmb=1.11111e+15 spomb=0 spomb1=1.11111e+60
    GPNCP (GPNDRV GPNB VDD VDD) pch_mac l=30n w=1u multi=8 nf=1 sd=100n \
        ad=7.5e-14 as=7.5e-14 pd=2.15u ps=2.15u nrd=0.165806 nrs=0.165806 \
        sa=75.0n sb=75.0n sa1=75.0n sa2=75.0n sa3=75.0n sa4=75.0n \
        sb1=75.0n sb2=75.0n sb3=75.0n spa=100n spa1=100n spa2=100n \
        spa3=100n sap=91.9776n sapb=114.444n spba=115.715n spba1=117.043n \
        dfm_flag=0 spmt=1.11111e+15 spomt=0 spomt1=1.11111e+60 \
        spmb=1.11111e+15 spomb=0 spomb1=1.11111e+60
    GPNBP (GPNB GPNA VDD VDD) pch_mac l=30n w=1u multi=2 nf=1 sd=100n \
        ad=7.5e-14 as=7.5e-14 pd=2.15u ps=2.15u nrd=0.165806 nrs=0.165806 \
        sa=75.0n sb=75.0n sa1=75.0n sa2=75.0n sa3=75.0n sa4=75.0n \
        sb1=75.0n sb2=75.0n sb3=75.0n spa=100n spa1=100n spa2=100n \
        spa3=100n sap=91.9776n sapb=114.444n spba=115.715n spba1=117.043n \
        dfm_flag=0 spmt=1.11111e+15 spomt=0 spomt1=1.11111e+60 \
        spmb=1.11111e+15 spomb=0 spomb1=1.11111e+60
    GPNAP (GPNA GPNPRE VDD VDD) pch_mac l=30n w=1u multi=1 nf=1 sd=100n \
        ad=7.5e-14 as=7.5e-14 pd=2.15u ps=2.15u nrd=0.165806 nrs=0.165806 \
        sa=75.0n sb=75.0n sa1=75.0n sa2=75.0n sa3=75.0n sa4=75.0n \
        sb1=75.0n sb2=75.0n sb3=75.0n spa=100n spa1=100n spa2=100n \
        spa3=100n sap=91.9776n sapb=114.444n spba=115.715n spba1=117.043n \
        dfm_flag=0 spmt=1.11111e+15 spomt=0 spomt1=1.11111e+60 \
        spmb=1.11111e+15 spomb=0 spomb1=1.11111e+60
    GPPCP (GPPDRV GPPB VDD VDD) pch_mac l=30n w=1u multi=8 nf=1 sd=100n \
        ad=7.5e-14 as=7.5e-14 pd=2.15u ps=2.15u nrd=0.165806 nrs=0.165806 \
        sa=75.0n sb=75.0n sa1=75.0n sa2=75.0n sa3=75.0n sa4=75.0n \
        sb1=75.0n sb2=75.0n sb3=75.0n spa=100n spa1=100n spa2=100n \
        spa3=100n sap=91.9776n sapb=114.444n spba=115.715n spba1=117.043n \
        dfm_flag=0 spmt=1.11111e+15 spomt=0 spomt1=1.11111e+60 \
        spmb=1.11111e+15 spomb=0 spomb1=1.11111e+60
    GPPBP (GPPB GPPA VDD VDD) pch_mac l=30n w=1u multi=2 nf=1 sd=100n \
        ad=7.5e-14 as=7.5e-14 pd=2.15u ps=2.15u nrd=0.165806 nrs=0.165806 \
        sa=75.0n sb=75.0n sa1=75.0n sa2=75.0n sa3=75.0n sa4=75.0n \
        sb1=75.0n sb2=75.0n sb3=75.0n spa=100n spa1=100n spa2=100n \
        spa3=100n sap=91.9776n sapb=114.444n spba=115.715n spba1=117.043n \
        dfm_flag=0 spmt=1.11111e+15 spomt=0 spomt1=1.11111e+60 \
        spmb=1.11111e+15 spomb=0 spomb1=1.11111e+60
    GPPAP (GPPA L VDD VDD) pch_mac l=30n w=1u multi=1 nf=1 sd=100n \
        ad=7.5e-14 as=7.5e-14 pd=2.15u ps=2.15u nrd=0.165806 nrs=0.165806 \
        sa=75.0n sb=75.0n sa1=75.0n sa2=75.0n sa3=75.0n sa4=75.0n \
        sb1=75.0n sb2=75.0n sb3=75.0n spa=100n spa1=100n spa2=100n \
        spa3=100n sap=91.9776n sapb=114.444n spba=115.715n spba1=117.043n \
        dfm_flag=0 spmt=1.11111e+15 spomt=0 spomt1=1.11111e+60 \
        spmb=1.11111e+15 spomb=0 spomb1=1.11111e+60
//Series configuration of RGNN1
RGNN1  (GNNRG RGNN1_1__dmy0 ) rupolym l=17.13u w=1u m=64 multi=(1)
RGNN1_2__dmy0  (RGNN1_1__dmy0 RGNN1_2__dmy0 ) rupolym l=17.13u w=1u m=64 \
        multi=(1)
RGNN1_3__dmy0  (RGNN1_2__dmy0 RGNN1_3__dmy0 ) rupolym l=17.13u w=1u m=64 \
        multi=(1)
RGNN1_4__dmy0  (RGNN1_3__dmy0 RGNN1_4__dmy0 ) rupolym l=17.13u w=1u m=64 \
        multi=(1)
RGNN1_5__dmy0  (RGNN1_4__dmy0 GNN ) rupolym l=17.13u w=1u m=64 multi=(1)
//End of RGNN1

//Series configuration of RGNN0
RGNN0  (GNNDRV RGNN0_1__dmy0 ) rupolym l=17.13u w=1u m=64 multi=(1)
RGNN0_2__dmy0  (RGNN0_1__dmy0 RGNN0_2__dmy0 ) rupolym l=17.13u w=1u m=64 \
        multi=(1)
RGNN0_3__dmy0  (RGNN0_2__dmy0 RGNN0_3__dmy0 ) rupolym l=17.13u w=1u m=64 \
        multi=(1)
RGNN0_4__dmy0  (RGNN0_3__dmy0 RGNN0_4__dmy0 ) rupolym l=17.13u w=1u m=64 \
        multi=(1)
RGNN0_5__dmy0  (RGNN0_4__dmy0 GNNRG ) rupolym l=17.13u w=1u m=64 multi=(1)
//End of RGNN0

//Series configuration of RGNP1
RGNP1  (GNPRG RGNP1_1__dmy0 ) rupolym l=17.13u w=1u m=64 multi=(1)
RGNP1_2__dmy0  (RGNP1_1__dmy0 RGNP1_2__dmy0 ) rupolym l=17.13u w=1u m=64 \
        multi=(1)
RGNP1_3__dmy0  (RGNP1_2__dmy0 RGNP1_3__dmy0 ) rupolym l=17.13u w=1u m=64 \
        multi=(1)
RGNP1_4__dmy0  (RGNP1_3__dmy0 RGNP1_4__dmy0 ) rupolym l=17.13u w=1u m=64 \
        multi=(1)
RGNP1_5__dmy0  (RGNP1_4__dmy0 GNP ) rupolym l=17.13u w=1u m=64 multi=(1)
//End of RGNP1

//Series configuration of RGNP0
RGNP0  (GNPDRV RGNP0_1__dmy0 ) rupolym l=17.13u w=1u m=64 multi=(1)
RGNP0_2__dmy0  (RGNP0_1__dmy0 RGNP0_2__dmy0 ) rupolym l=17.13u w=1u m=64 \
        multi=(1)
RGNP0_3__dmy0  (RGNP0_2__dmy0 RGNP0_3__dmy0 ) rupolym l=17.13u w=1u m=64 \
        multi=(1)
RGNP0_4__dmy0  (RGNP0_3__dmy0 RGNP0_4__dmy0 ) rupolym l=17.13u w=1u m=64 \
        multi=(1)
RGNP0_5__dmy0  (RGNP0_4__dmy0 GNPRG ) rupolym l=17.13u w=1u m=64 multi=(1)
//End of RGNP0

//Series configuration of RGPN1
RGPN1  (GPNRG RGPN1_1__dmy0 ) rupolym l=17.13u w=1u m=64 multi=(1)
RGPN1_2__dmy0  (RGPN1_1__dmy0 RGPN1_2__dmy0 ) rupolym l=17.13u w=1u m=64 \
        multi=(1)
RGPN1_3__dmy0  (RGPN1_2__dmy0 RGPN1_3__dmy0 ) rupolym l=17.13u w=1u m=64 \
        multi=(1)
RGPN1_4__dmy0  (RGPN1_3__dmy0 RGPN1_4__dmy0 ) rupolym l=17.13u w=1u m=64 \
        multi=(1)
RGPN1_5__dmy0  (RGPN1_4__dmy0 GPN ) rupolym l=17.13u w=1u m=64 multi=(1)
//End of RGPN1

//Series configuration of RGPN0
RGPN0  (GPNDRV RGPN0_1__dmy0 ) rupolym l=17.13u w=1u m=64 multi=(1)
RGPN0_2__dmy0  (RGPN0_1__dmy0 RGPN0_2__dmy0 ) rupolym l=17.13u w=1u m=64 \
        multi=(1)
RGPN0_3__dmy0  (RGPN0_2__dmy0 RGPN0_3__dmy0 ) rupolym l=17.13u w=1u m=64 \
        multi=(1)
RGPN0_4__dmy0  (RGPN0_3__dmy0 RGPN0_4__dmy0 ) rupolym l=17.13u w=1u m=64 \
        multi=(1)
RGPN0_5__dmy0  (RGPN0_4__dmy0 GPNRG ) rupolym l=17.13u w=1u m=64 multi=(1)
//End of RGPN0

//Series configuration of RGPP1
RGPP1  (GPPRG RGPP1_1__dmy0 ) rupolym l=17.13u w=1u m=64 multi=(1)
RGPP1_2__dmy0  (RGPP1_1__dmy0 RGPP1_2__dmy0 ) rupolym l=17.13u w=1u m=64 \
        multi=(1)
RGPP1_3__dmy0  (RGPP1_2__dmy0 RGPP1_3__dmy0 ) rupolym l=17.13u w=1u m=64 \
        multi=(1)
RGPP1_4__dmy0  (RGPP1_3__dmy0 RGPP1_4__dmy0 ) rupolym l=17.13u w=1u m=64 \
        multi=(1)
RGPP1_5__dmy0  (RGPP1_4__dmy0 GPP ) rupolym l=17.13u w=1u m=64 multi=(1)
//End of RGPP1

//Series configuration of RGPP0
RGPP0  (GPPDRV RGPP0_1__dmy0 ) rupolym l=17.13u w=1u m=64 multi=(1)
RGPP0_2__dmy0  (RGPP0_1__dmy0 RGPP0_2__dmy0 ) rupolym l=17.13u w=1u m=64 \
        multi=(1)
RGPP0_3__dmy0  (RGPP0_2__dmy0 RGPP0_3__dmy0 ) rupolym l=17.13u w=1u m=64 \
        multi=(1)
RGPP0_4__dmy0  (RGPP0_3__dmy0 RGPP0_4__dmy0 ) rupolym l=17.13u w=1u m=64 \
        multi=(1)
RGPP0_5__dmy0  (RGPP0_4__dmy0 GPPRG ) rupolym l=17.13u w=1u m=64 multi=(1)
//End of RGPP0

    X025 (L VDD VSS GNNPRE) sar8p_inv
    X008 (H VDD VSS GPNPRE) sar8p_inv
ends sar8p_refdrv_b6

subckt sar8p_refdrv_b7 GNN GNP GPN GPP H L VDD VSS
    GNNCN (GNNDRV GNNB VSS VSS) nch_mac l=30n w=500n multi=16 nf=1 sd=100n \
        ad=3.75e-14 as=3.75e-14 pd=1.15u ps=1.15u nrd=0.662935 \
        nrs=0.662935 sa=75.0n sb=75.0n sa1=75.0n sa2=75.0n sa3=75.0n \
        sa4=75.0n sb1=75.0n sb2=75.0n sb3=75.0n spa=100n spa1=100n \
        spa2=100n spa3=100n sap=91.9776n sapb=114.444n spba=115.715n \
        spba1=117.043n dfm_flag=0 spmt=1.11111e+15 spomt=0 \
        spomt1=1.11111e+60 spmb=1.11111e+15 spomb=0 spomb1=1.11111e+60
    GNNBN (GNNB GNNA VSS VSS) nch_mac l=30n w=500n multi=4 nf=1 sd=100n \
        ad=3.75e-14 as=3.75e-14 pd=1.15u ps=1.15u nrd=0.662935 \
        nrs=0.662935 sa=75.0n sb=75.0n sa1=75.0n sa2=75.0n sa3=75.0n \
        sa4=75.0n sb1=75.0n sb2=75.0n sb3=75.0n spa=100n spa1=100n \
        spa2=100n spa3=100n sap=91.9776n sapb=114.444n spba=115.715n \
        spba1=117.043n dfm_flag=0 spmt=1.11111e+15 spomt=0 \
        spomt1=1.11111e+60 spmb=1.11111e+15 spomb=0 spomb1=1.11111e+60
    GNNAN (GNNA GNNPRE VSS VSS) nch_mac l=30n w=500n multi=1 nf=1 sd=100n \
        ad=3.75e-14 as=3.75e-14 pd=1.15u ps=1.15u nrd=0.662935 \
        nrs=0.662935 sa=75.0n sb=75.0n sa1=75.0n sa2=75.0n sa3=75.0n \
        sa4=75.0n sb1=75.0n sb2=75.0n sb3=75.0n spa=100n spa1=100n \
        spa2=100n spa3=100n sap=91.9776n sapb=114.444n spba=115.715n \
        spba1=117.043n dfm_flag=0 spmt=1.11111e+15 spomt=0 \
        spomt1=1.11111e+60 spmb=1.11111e+15 spomb=0 spomb1=1.11111e+60
    GNPCN (GNPDRV GNPB VSS VSS) nch_mac l=30n w=500n multi=16 nf=1 sd=100n \
        ad=3.75e-14 as=3.75e-14 pd=1.15u ps=1.15u nrd=0.662935 \
        nrs=0.662935 sa=75.0n sb=75.0n sa1=75.0n sa2=75.0n sa3=75.0n \
        sa4=75.0n sb1=75.0n sb2=75.0n sb3=75.0n spa=100n spa1=100n \
        spa2=100n spa3=100n sap=91.9776n sapb=114.444n spba=115.715n \
        spba1=117.043n dfm_flag=0 spmt=1.11111e+15 spomt=0 \
        spomt1=1.11111e+60 spmb=1.11111e+15 spomb=0 spomb1=1.11111e+60
    GNPBN (GNPB GNPA VSS VSS) nch_mac l=30n w=500n multi=4 nf=1 sd=100n \
        ad=3.75e-14 as=3.75e-14 pd=1.15u ps=1.15u nrd=0.662935 \
        nrs=0.662935 sa=75.0n sb=75.0n sa1=75.0n sa2=75.0n sa3=75.0n \
        sa4=75.0n sb1=75.0n sb2=75.0n sb3=75.0n spa=100n spa1=100n \
        spa2=100n spa3=100n sap=91.9776n sapb=114.444n spba=115.715n \
        spba1=117.043n dfm_flag=0 spmt=1.11111e+15 spomt=0 \
        spomt1=1.11111e+60 spmb=1.11111e+15 spomb=0 spomb1=1.11111e+60
    GNPAN (GNPA H VSS VSS) nch_mac l=30n w=500n multi=1 nf=1 sd=100n \
        ad=3.75e-14 as=3.75e-14 pd=1.15u ps=1.15u nrd=0.662935 \
        nrs=0.662935 sa=75.0n sb=75.0n sa1=75.0n sa2=75.0n sa3=75.0n \
        sa4=75.0n sb1=75.0n sb2=75.0n sb3=75.0n spa=100n spa1=100n \
        spa2=100n spa3=100n sap=91.9776n sapb=114.444n spba=115.715n \
        spba1=117.043n dfm_flag=0 spmt=1.11111e+15 spomt=0 \
        spomt1=1.11111e+60 spmb=1.11111e+15 spomb=0 spomb1=1.11111e+60
    GPNCN (GPNDRV GPNB VSS VSS) nch_mac l=30n w=500n multi=16 nf=1 sd=100n \
        ad=3.75e-14 as=3.75e-14 pd=1.15u ps=1.15u nrd=0.662935 \
        nrs=0.662935 sa=75.0n sb=75.0n sa1=75.0n sa2=75.0n sa3=75.0n \
        sa4=75.0n sb1=75.0n sb2=75.0n sb3=75.0n spa=100n spa1=100n \
        spa2=100n spa3=100n sap=91.9776n sapb=114.444n spba=115.715n \
        spba1=117.043n dfm_flag=0 spmt=1.11111e+15 spomt=0 \
        spomt1=1.11111e+60 spmb=1.11111e+15 spomb=0 spomb1=1.11111e+60
    GPNBN (GPNB GPNA VSS VSS) nch_mac l=30n w=500n multi=4 nf=1 sd=100n \
        ad=3.75e-14 as=3.75e-14 pd=1.15u ps=1.15u nrd=0.662935 \
        nrs=0.662935 sa=75.0n sb=75.0n sa1=75.0n sa2=75.0n sa3=75.0n \
        sa4=75.0n sb1=75.0n sb2=75.0n sb3=75.0n spa=100n spa1=100n \
        spa2=100n spa3=100n sap=91.9776n sapb=114.444n spba=115.715n \
        spba1=117.043n dfm_flag=0 spmt=1.11111e+15 spomt=0 \
        spomt1=1.11111e+60 spmb=1.11111e+15 spomb=0 spomb1=1.11111e+60
    GPNAN (GPNA GPNPRE VSS VSS) nch_mac l=30n w=500n multi=1 nf=1 sd=100n \
        ad=3.75e-14 as=3.75e-14 pd=1.15u ps=1.15u nrd=0.662935 \
        nrs=0.662935 sa=75.0n sb=75.0n sa1=75.0n sa2=75.0n sa3=75.0n \
        sa4=75.0n sb1=75.0n sb2=75.0n sb3=75.0n spa=100n spa1=100n \
        spa2=100n spa3=100n sap=91.9776n sapb=114.444n spba=115.715n \
        spba1=117.043n dfm_flag=0 spmt=1.11111e+15 spomt=0 \
        spomt1=1.11111e+60 spmb=1.11111e+15 spomb=0 spomb1=1.11111e+60
    GPPCN (GPPDRV GPPB VSS VSS) nch_mac l=30n w=500n multi=16 nf=1 sd=100n \
        ad=3.75e-14 as=3.75e-14 pd=1.15u ps=1.15u nrd=0.662935 \
        nrs=0.662935 sa=75.0n sb=75.0n sa1=75.0n sa2=75.0n sa3=75.0n \
        sa4=75.0n sb1=75.0n sb2=75.0n sb3=75.0n spa=100n spa1=100n \
        spa2=100n spa3=100n sap=91.9776n sapb=114.444n spba=115.715n \
        spba1=117.043n dfm_flag=0 spmt=1.11111e+15 spomt=0 \
        spomt1=1.11111e+60 spmb=1.11111e+15 spomb=0 spomb1=1.11111e+60
    GPPBN (GPPB GPPA VSS VSS) nch_mac l=30n w=500n multi=4 nf=1 sd=100n \
        ad=3.75e-14 as=3.75e-14 pd=1.15u ps=1.15u nrd=0.662935 \
        nrs=0.662935 sa=75.0n sb=75.0n sa1=75.0n sa2=75.0n sa3=75.0n \
        sa4=75.0n sb1=75.0n sb2=75.0n sb3=75.0n spa=100n spa1=100n \
        spa2=100n spa3=100n sap=91.9776n sapb=114.444n spba=115.715n \
        spba1=117.043n dfm_flag=0 spmt=1.11111e+15 spomt=0 \
        spomt1=1.11111e+60 spmb=1.11111e+15 spomb=0 spomb1=1.11111e+60
    GPPAN (GPPA L VSS VSS) nch_mac l=30n w=500n multi=1 nf=1 sd=100n \
        ad=3.75e-14 as=3.75e-14 pd=1.15u ps=1.15u nrd=0.662935 \
        nrs=0.662935 sa=75.0n sb=75.0n sa1=75.0n sa2=75.0n sa3=75.0n \
        sa4=75.0n sb1=75.0n sb2=75.0n sb3=75.0n spa=100n spa1=100n \
        spa2=100n spa3=100n sap=91.9776n sapb=114.444n spba=115.715n \
        spba1=117.043n dfm_flag=0 spmt=1.11111e+15 spomt=0 \
        spomt1=1.11111e+60 spmb=1.11111e+15 spomb=0 spomb1=1.11111e+60
    GNNCP (GNNDRV GNNB VDD VDD) pch_mac l=30n w=1u multi=16 nf=1 sd=100n \
        ad=7.5e-14 as=7.5e-14 pd=2.15u ps=2.15u nrd=0.165806 nrs=0.165806 \
        sa=75.0n sb=75.0n sa1=75.0n sa2=75.0n sa3=75.0n sa4=75.0n \
        sb1=75.0n sb2=75.0n sb3=75.0n spa=100n spa1=100n spa2=100n \
        spa3=100n sap=91.9776n sapb=114.444n spba=115.715n spba1=117.043n \
        dfm_flag=0 spmt=1.11111e+15 spomt=0 spomt1=1.11111e+60 \
        spmb=1.11111e+15 spomb=0 spomb1=1.11111e+60
    GNNBP (GNNB GNNA VDD VDD) pch_mac l=30n w=1u multi=4 nf=1 sd=100n \
        ad=7.5e-14 as=7.5e-14 pd=2.15u ps=2.15u nrd=0.165806 nrs=0.165806 \
        sa=75.0n sb=75.0n sa1=75.0n sa2=75.0n sa3=75.0n sa4=75.0n \
        sb1=75.0n sb2=75.0n sb3=75.0n spa=100n spa1=100n spa2=100n \
        spa3=100n sap=91.9776n sapb=114.444n spba=115.715n spba1=117.043n \
        dfm_flag=0 spmt=1.11111e+15 spomt=0 spomt1=1.11111e+60 \
        spmb=1.11111e+15 spomb=0 spomb1=1.11111e+60
    GNNAP (GNNA GNNPRE VDD VDD) pch_mac l=30n w=1u multi=1 nf=1 sd=100n \
        ad=7.5e-14 as=7.5e-14 pd=2.15u ps=2.15u nrd=0.165806 nrs=0.165806 \
        sa=75.0n sb=75.0n sa1=75.0n sa2=75.0n sa3=75.0n sa4=75.0n \
        sb1=75.0n sb2=75.0n sb3=75.0n spa=100n spa1=100n spa2=100n \
        spa3=100n sap=91.9776n sapb=114.444n spba=115.715n spba1=117.043n \
        dfm_flag=0 spmt=1.11111e+15 spomt=0 spomt1=1.11111e+60 \
        spmb=1.11111e+15 spomb=0 spomb1=1.11111e+60
    GNPCP (GNPDRV GNPB VDD VDD) pch_mac l=30n w=1u multi=16 nf=1 sd=100n \
        ad=7.5e-14 as=7.5e-14 pd=2.15u ps=2.15u nrd=0.165806 nrs=0.165806 \
        sa=75.0n sb=75.0n sa1=75.0n sa2=75.0n sa3=75.0n sa4=75.0n \
        sb1=75.0n sb2=75.0n sb3=75.0n spa=100n spa1=100n spa2=100n \
        spa3=100n sap=91.9776n sapb=114.444n spba=115.715n spba1=117.043n \
        dfm_flag=0 spmt=1.11111e+15 spomt=0 spomt1=1.11111e+60 \
        spmb=1.11111e+15 spomb=0 spomb1=1.11111e+60
    GNPBP (GNPB GNPA VDD VDD) pch_mac l=30n w=1u multi=4 nf=1 sd=100n \
        ad=7.5e-14 as=7.5e-14 pd=2.15u ps=2.15u nrd=0.165806 nrs=0.165806 \
        sa=75.0n sb=75.0n sa1=75.0n sa2=75.0n sa3=75.0n sa4=75.0n \
        sb1=75.0n sb2=75.0n sb3=75.0n spa=100n spa1=100n spa2=100n \
        spa3=100n sap=91.9776n sapb=114.444n spba=115.715n spba1=117.043n \
        dfm_flag=0 spmt=1.11111e+15 spomt=0 spomt1=1.11111e+60 \
        spmb=1.11111e+15 spomb=0 spomb1=1.11111e+60
    GNPAP (GNPA H VDD VDD) pch_mac l=30n w=1u multi=1 nf=1 sd=100n \
        ad=7.5e-14 as=7.5e-14 pd=2.15u ps=2.15u nrd=0.165806 nrs=0.165806 \
        sa=75.0n sb=75.0n sa1=75.0n sa2=75.0n sa3=75.0n sa4=75.0n \
        sb1=75.0n sb2=75.0n sb3=75.0n spa=100n spa1=100n spa2=100n \
        spa3=100n sap=91.9776n sapb=114.444n spba=115.715n spba1=117.043n \
        dfm_flag=0 spmt=1.11111e+15 spomt=0 spomt1=1.11111e+60 \
        spmb=1.11111e+15 spomb=0 spomb1=1.11111e+60
    GPNCP (GPNDRV GPNB VDD VDD) pch_mac l=30n w=1u multi=16 nf=1 sd=100n \
        ad=7.5e-14 as=7.5e-14 pd=2.15u ps=2.15u nrd=0.165806 nrs=0.165806 \
        sa=75.0n sb=75.0n sa1=75.0n sa2=75.0n sa3=75.0n sa4=75.0n \
        sb1=75.0n sb2=75.0n sb3=75.0n spa=100n spa1=100n spa2=100n \
        spa3=100n sap=91.9776n sapb=114.444n spba=115.715n spba1=117.043n \
        dfm_flag=0 spmt=1.11111e+15 spomt=0 spomt1=1.11111e+60 \
        spmb=1.11111e+15 spomb=0 spomb1=1.11111e+60
    GPNBP (GPNB GPNA VDD VDD) pch_mac l=30n w=1u multi=4 nf=1 sd=100n \
        ad=7.5e-14 as=7.5e-14 pd=2.15u ps=2.15u nrd=0.165806 nrs=0.165806 \
        sa=75.0n sb=75.0n sa1=75.0n sa2=75.0n sa3=75.0n sa4=75.0n \
        sb1=75.0n sb2=75.0n sb3=75.0n spa=100n spa1=100n spa2=100n \
        spa3=100n sap=91.9776n sapb=114.444n spba=115.715n spba1=117.043n \
        dfm_flag=0 spmt=1.11111e+15 spomt=0 spomt1=1.11111e+60 \
        spmb=1.11111e+15 spomb=0 spomb1=1.11111e+60
    GPNAP (GPNA GPNPRE VDD VDD) pch_mac l=30n w=1u multi=1 nf=1 sd=100n \
        ad=7.5e-14 as=7.5e-14 pd=2.15u ps=2.15u nrd=0.165806 nrs=0.165806 \
        sa=75.0n sb=75.0n sa1=75.0n sa2=75.0n sa3=75.0n sa4=75.0n \
        sb1=75.0n sb2=75.0n sb3=75.0n spa=100n spa1=100n spa2=100n \
        spa3=100n sap=91.9776n sapb=114.444n spba=115.715n spba1=117.043n \
        dfm_flag=0 spmt=1.11111e+15 spomt=0 spomt1=1.11111e+60 \
        spmb=1.11111e+15 spomb=0 spomb1=1.11111e+60
    GPPCP (GPPDRV GPPB VDD VDD) pch_mac l=30n w=1u multi=16 nf=1 sd=100n \
        ad=7.5e-14 as=7.5e-14 pd=2.15u ps=2.15u nrd=0.165806 nrs=0.165806 \
        sa=75.0n sb=75.0n sa1=75.0n sa2=75.0n sa3=75.0n sa4=75.0n \
        sb1=75.0n sb2=75.0n sb3=75.0n spa=100n spa1=100n spa2=100n \
        spa3=100n sap=91.9776n sapb=114.444n spba=115.715n spba1=117.043n \
        dfm_flag=0 spmt=1.11111e+15 spomt=0 spomt1=1.11111e+60 \
        spmb=1.11111e+15 spomb=0 spomb1=1.11111e+60
    GPPBP (GPPB GPPA VDD VDD) pch_mac l=30n w=1u multi=4 nf=1 sd=100n \
        ad=7.5e-14 as=7.5e-14 pd=2.15u ps=2.15u nrd=0.165806 nrs=0.165806 \
        sa=75.0n sb=75.0n sa1=75.0n sa2=75.0n sa3=75.0n sa4=75.0n \
        sb1=75.0n sb2=75.0n sb3=75.0n spa=100n spa1=100n spa2=100n \
        spa3=100n sap=91.9776n sapb=114.444n spba=115.715n spba1=117.043n \
        dfm_flag=0 spmt=1.11111e+15 spomt=0 spomt1=1.11111e+60 \
        spmb=1.11111e+15 spomb=0 spomb1=1.11111e+60
    GPPAP (GPPA L VDD VDD) pch_mac l=30n w=1u multi=1 nf=1 sd=100n \
        ad=7.5e-14 as=7.5e-14 pd=2.15u ps=2.15u nrd=0.165806 nrs=0.165806 \
        sa=75.0n sb=75.0n sa1=75.0n sa2=75.0n sa3=75.0n sa4=75.0n \
        sb1=75.0n sb2=75.0n sb3=75.0n spa=100n spa1=100n spa2=100n \
        spa3=100n sap=91.9776n sapb=114.444n spba=115.715n spba1=117.043n \
        dfm_flag=0 spmt=1.11111e+15 spomt=0 spomt1=1.11111e+60 \
        spmb=1.11111e+15 spomb=0 spomb1=1.11111e+60
//Series configuration of RGNN1
RGNN1  (GNNRG RGNN1_1__dmy0 ) rupolym l=17.13u w=1u m=128 multi=(1)
RGNN1_2__dmy0  (RGNN1_1__dmy0 RGNN1_2__dmy0 ) rupolym l=17.13u w=1u m=128 \
        multi=(1)
RGNN1_3__dmy0  (RGNN1_2__dmy0 RGNN1_3__dmy0 ) rupolym l=17.13u w=1u m=128 \
        multi=(1)
RGNN1_4__dmy0  (RGNN1_3__dmy0 RGNN1_4__dmy0 ) rupolym l=17.13u w=1u m=128 \
        multi=(1)
RGNN1_5__dmy0  (RGNN1_4__dmy0 GNN ) rupolym l=17.13u w=1u m=128 multi=(1)
//End of RGNN1

//Series configuration of RGNN0
RGNN0  (GNNDRV RGNN0_1__dmy0 ) rupolym l=17.13u w=1u m=128 multi=(1)
RGNN0_2__dmy0  (RGNN0_1__dmy0 RGNN0_2__dmy0 ) rupolym l=17.13u w=1u m=128 \
        multi=(1)
RGNN0_3__dmy0  (RGNN0_2__dmy0 RGNN0_3__dmy0 ) rupolym l=17.13u w=1u m=128 \
        multi=(1)
RGNN0_4__dmy0  (RGNN0_3__dmy0 RGNN0_4__dmy0 ) rupolym l=17.13u w=1u m=128 \
        multi=(1)
RGNN0_5__dmy0  (RGNN0_4__dmy0 GNNRG ) rupolym l=17.13u w=1u m=128 \
        multi=(1)
//End of RGNN0

//Series configuration of RGNP1
RGNP1  (GNPRG RGNP1_1__dmy0 ) rupolym l=17.13u w=1u m=128 multi=(1)
RGNP1_2__dmy0  (RGNP1_1__dmy0 RGNP1_2__dmy0 ) rupolym l=17.13u w=1u m=128 \
        multi=(1)
RGNP1_3__dmy0  (RGNP1_2__dmy0 RGNP1_3__dmy0 ) rupolym l=17.13u w=1u m=128 \
        multi=(1)
RGNP1_4__dmy0  (RGNP1_3__dmy0 RGNP1_4__dmy0 ) rupolym l=17.13u w=1u m=128 \
        multi=(1)
RGNP1_5__dmy0  (RGNP1_4__dmy0 GNP ) rupolym l=17.13u w=1u m=128 multi=(1)
//End of RGNP1

//Series configuration of RGNP0
RGNP0  (GNPDRV RGNP0_1__dmy0 ) rupolym l=17.13u w=1u m=128 multi=(1)
RGNP0_2__dmy0  (RGNP0_1__dmy0 RGNP0_2__dmy0 ) rupolym l=17.13u w=1u m=128 \
        multi=(1)
RGNP0_3__dmy0  (RGNP0_2__dmy0 RGNP0_3__dmy0 ) rupolym l=17.13u w=1u m=128 \
        multi=(1)
RGNP0_4__dmy0  (RGNP0_3__dmy0 RGNP0_4__dmy0 ) rupolym l=17.13u w=1u m=128 \
        multi=(1)
RGNP0_5__dmy0  (RGNP0_4__dmy0 GNPRG ) rupolym l=17.13u w=1u m=128 \
        multi=(1)
//End of RGNP0

//Series configuration of RGPN1
RGPN1  (GPNRG RGPN1_1__dmy0 ) rupolym l=17.13u w=1u m=128 multi=(1)
RGPN1_2__dmy0  (RGPN1_1__dmy0 RGPN1_2__dmy0 ) rupolym l=17.13u w=1u m=128 \
        multi=(1)
RGPN1_3__dmy0  (RGPN1_2__dmy0 RGPN1_3__dmy0 ) rupolym l=17.13u w=1u m=128 \
        multi=(1)
RGPN1_4__dmy0  (RGPN1_3__dmy0 RGPN1_4__dmy0 ) rupolym l=17.13u w=1u m=128 \
        multi=(1)
RGPN1_5__dmy0  (RGPN1_4__dmy0 GPN ) rupolym l=17.13u w=1u m=128 multi=(1)
//End of RGPN1

//Series configuration of RGPN0
RGPN0  (GPNDRV RGPN0_1__dmy0 ) rupolym l=17.13u w=1u m=128 multi=(1)
RGPN0_2__dmy0  (RGPN0_1__dmy0 RGPN0_2__dmy0 ) rupolym l=17.13u w=1u m=128 \
        multi=(1)
RGPN0_3__dmy0  (RGPN0_2__dmy0 RGPN0_3__dmy0 ) rupolym l=17.13u w=1u m=128 \
        multi=(1)
RGPN0_4__dmy0  (RGPN0_3__dmy0 RGPN0_4__dmy0 ) rupolym l=17.13u w=1u m=128 \
        multi=(1)
RGPN0_5__dmy0  (RGPN0_4__dmy0 GPNRG ) rupolym l=17.13u w=1u m=128 \
        multi=(1)
//End of RGPN0

//Series configuration of RGPP1
RGPP1  (GPPRG RGPP1_1__dmy0 ) rupolym l=17.13u w=1u m=128 multi=(1)
RGPP1_2__dmy0  (RGPP1_1__dmy0 RGPP1_2__dmy0 ) rupolym l=17.13u w=1u m=128 \
        multi=(1)
RGPP1_3__dmy0  (RGPP1_2__dmy0 RGPP1_3__dmy0 ) rupolym l=17.13u w=1u m=128 \
        multi=(1)
RGPP1_4__dmy0  (RGPP1_3__dmy0 RGPP1_4__dmy0 ) rupolym l=17.13u w=1u m=128 \
        multi=(1)
RGPP1_5__dmy0  (RGPP1_4__dmy0 GPP ) rupolym l=17.13u w=1u m=128 multi=(1)
//End of RGPP1

//Series configuration of RGPP0
RGPP0  (GPPDRV RGPP0_1__dmy0 ) rupolym l=17.13u w=1u m=128 multi=(1)
RGPP0_2__dmy0  (RGPP0_1__dmy0 RGPP0_2__dmy0 ) rupolym l=17.13u w=1u m=128 \
        multi=(1)
RGPP0_3__dmy0  (RGPP0_2__dmy0 RGPP0_3__dmy0 ) rupolym l=17.13u w=1u m=128 \
        multi=(1)
RGPP0_4__dmy0  (RGPP0_3__dmy0 RGPP0_4__dmy0 ) rupolym l=17.13u w=1u m=128 \
        multi=(1)
RGPP0_5__dmy0  (RGPP0_4__dmy0 GPPRG ) rupolym l=17.13u w=1u m=128 \
        multi=(1)
//End of RGPP0

    X025 (L VDD VSS GNNPRE) sar8p_inv
    X008 (H VDD VSS GPNPRE) sar8p_inv
ends sar8p_refdrv_b7

subckt sar8p_xor2 A B VDD VSS Y
    X003 (NA NB VDD VSS Y) sar8p_nand2
    X002 (B N VDD VSS NB) sar8p_nand2
    X001 (A N VDD VSS NA) sar8p_nand2
    X000 (A B VDD VSS N) sar8p_nand2
ends sar8p_xor2

subckt sar_bootstrap_flat_8b_p CLKS VOUT Vin
    Mmain (VOUT G Vin 0) nch_18_mac l=150.0n w=1u multi=1 nf=1 sd=180.0n \
        ad=1.55e-13 as=1.55e-13 pd=2.31u ps=2.31u nrd=0 nrs=0 sa=155.00n \
        sb=155.00n sa1=155.00n sa2=155.00n sa3=155.00n sa4=155.00n \
        sb1=155.00n sb2=155.00n sb3=155.00n spa=180.0n spa1=180.0n \
        spa2=180.0n spa3=180.0n sap=172.362n sapb=242.67n spba=233.666n \
        spba1=239.844n spmt=1.11111e+15 spomt=0 spomt1=1.11111e+60 \
        spmb=1.11111e+15 spomb=0 spomb1=1.11111e+60
    Mmain_U1 (VOUT G Vin 0) nch_18_mac l=150.0n w=1u multi=1 nf=1 sd=180.0n \
        ad=1.55e-13 as=1.55e-13 pd=2.31u ps=2.31u nrd=0 nrs=0 sa=155.00n \
        sb=155.00n sa1=155.00n sa2=155.00n sa3=155.00n sa4=155.00n \
        sb1=155.00n sb2=155.00n sb3=155.00n spa=180.0n spa1=180.0n \
        spa2=180.0n spa3=180.0n sap=172.362n sapb=242.67n spba=233.666n \
        spba1=239.844n spmt=1.11111e+15 spomt=0 spomt1=1.11111e+60 \
        spmb=1.11111e+15 spomb=0 spomb1=1.11111e+60
    M4C (CTRL CLKS BBOT 0) nch_18_mac l=150.0n w=1u multi=1 nf=1 sd=180.0n \
        ad=1.55e-13 as=1.55e-13 pd=2.31u ps=2.31u nrd=0 nrs=0 sa=155.00n \
        sb=155.00n sa1=155.00n sa2=155.00n sa3=155.00n sa4=155.00n \
        sb1=155.00n sb2=155.00n sb3=155.00n spa=180.0n spa1=180.0n \
        spa2=180.0n spa3=180.0n sap=172.362n sapb=242.67n spba=233.666n \
        spba1=239.844n spmt=1.11111e+15 spomt=0 spomt1=1.11111e+60 \
        spmb=1.11111e+15 spomb=0 spomb1=1.11111e+60
    Msin (BBOT G Vin 0) nch_18_mac l=150.0n w=1u multi=1 nf=1 sd=180.0n \
        ad=1.55e-13 as=1.55e-13 pd=2.31u ps=2.31u nrd=0 nrs=0 sa=155.00n \
        sb=155.00n sa1=155.00n sa2=155.00n sa3=155.00n sa4=155.00n \
        sb1=155.00n sb2=155.00n sb3=155.00n spa=180.0n spa1=180.0n \
        spa2=180.0n spa3=180.0n sap=172.362n sapb=242.67n spba=233.666n \
        spba1=239.844n spmt=1.11111e+15 spomt=0 spomt1=1.11111e+60 \
        spmb=1.11111e+15 spomb=0 spomb1=1.11111e+60
    Maux (G VDD! GRESET 0) nch_18_mac l=150.0n w=1u multi=1 nf=1 sd=180.0n \
        ad=1.55e-13 as=1.55e-13 pd=2.31u ps=2.31u nrd=0 nrs=0 sa=155.00n \
        sb=155.00n sa1=155.00n sa2=155.00n sa3=155.00n sa4=155.00n \
        sb1=155.00n sb2=155.00n sb3=155.00n spa=180.0n spa1=180.0n \
        spa2=180.0n spa3=180.0n sap=172.362n sapb=242.67n spba=233.666n \
        spba1=239.844n spmt=1.11111e+15 spomt=0 spomt1=1.11111e+60 \
        spmb=1.11111e+15 spomb=0 spomb1=1.11111e+60
    MRSTG (GRESET CLKSB 0 0) nch_18_mac l=150.0n w=1u multi=1 nf=1 \
        sd=180.0n ad=1.55e-13 as=1.55e-13 pd=2.31u ps=2.31u nrd=0 nrs=0 \
        sa=155.00n sb=155.00n sa1=155.00n sa2=155.00n sa3=155.00n \
        sa4=155.00n sb1=155.00n sb2=155.00n sb3=155.00n spa=180.0n \
        spa1=180.0n spa2=180.0n spa3=180.0n sap=172.362n sapb=242.67n \
        spba=233.666n spba1=239.844n spmt=1.11111e+15 spomt=0 \
        spomt1=1.11111e+60 spmb=1.11111e+15 spomb=0 spomb1=1.11111e+60
    M4A (CTRL G BBOT 0) nch_18_mac l=150.0n w=1u multi=1 nf=1 sd=180.0n \
        ad=1.55e-13 as=1.55e-13 pd=2.31u ps=2.31u nrd=0 nrs=0 sa=155.00n \
        sb=155.00n sa1=155.00n sa2=155.00n sa3=155.00n sa4=155.00n \
        sb1=155.00n sb2=155.00n sb3=155.00n spa=180.0n spa1=180.0n \
        spa2=180.0n spa3=180.0n sap=172.362n sapb=242.67n spba=233.666n \
        spba1=239.844n spmt=1.11111e+15 spomt=0 spomt1=1.11111e+60 \
        spmb=1.11111e+15 spomb=0 spomb1=1.11111e+60
    M8 (BBOT CLKSB 0 0) nch_18_mac l=150.0n w=1u multi=1 nf=1 sd=180.0n \
        ad=1.55e-13 as=1.55e-13 pd=2.31u ps=2.31u nrd=0 nrs=0 sa=155.00n \
        sb=155.00n sa1=155.00n sa2=155.00n sa3=155.00n sa4=155.00n \
        sb1=155.00n sb2=155.00n sb3=155.00n spa=180.0n spa1=180.0n \
        spa2=180.0n spa3=180.0n sap=172.362n sapb=242.67n spba=233.666n \
        spba1=239.844n spmt=1.11111e+15 spomt=0 spomt1=1.11111e+60 \
        spmb=1.11111e+15 spomb=0 spomb1=1.11111e+60
    MNCLK (CLKSB CLKS 0 0) nch_18_mac l=150.0n w=1u multi=1 nf=1 sd=180.0n \
        ad=1.55e-13 as=1.55e-13 pd=2.31u ps=2.31u nrd=0 nrs=0 sa=155.00n \
        sb=155.00n sa1=155.00n sa2=155.00n sa3=155.00n sa4=155.00n \
        sb1=155.00n sb2=155.00n sb3=155.00n spa=180.0n spa1=180.0n \
        spa2=180.0n spa3=180.0n sap=172.362n sapb=242.67n spba=233.666n \
        spba1=239.844n spmt=1.11111e+15 spomt=0 spomt1=1.11111e+60 \
        spmb=1.11111e+15 spomb=0 spomb1=1.11111e+60
    M2 (BTOP G VDD! BTOP) pch_18_mac l=150.0n w=1u multi=1 nf=1 sd=180.0n \
        ad=1.55e-13 as=1.55e-13 pd=2.31u ps=2.31u nrd=0 nrs=0 sa=155.00n \
        sb=155.00n sa1=155.00n sa2=155.00n sa3=155.00n sa4=155.00n \
        sb1=155.00n sb2=155.00n sb3=155.00n spa=180.0n spa1=180.0n \
        spa2=180.0n spa3=180.0n sap=172.362n sapb=242.67n spba=233.666n \
        spba1=239.844n spmt=1.11111e+15 spomt=0 spomt1=1.11111e+60 \
        spmb=1.11111e+15 spomb=0 spomb1=1.11111e+60
    M4 (G CTRL BTOP BTOP) pch_18_mac l=150.0n w=1u multi=1 nf=1 sd=180.0n \
        ad=1.55e-13 as=1.55e-13 pd=2.31u ps=2.31u nrd=0 nrs=0 sa=155.00n \
        sb=155.00n sa1=155.00n sa2=155.00n sa3=155.00n sa4=155.00n \
        sb1=155.00n sb2=155.00n sb3=155.00n spa=180.0n spa1=180.0n \
        spa2=180.0n spa3=180.0n sap=172.362n sapb=242.67n spba=233.666n \
        spba1=239.844n spmt=1.11111e+15 spomt=0 spomt1=1.11111e+60 \
        spmb=1.11111e+15 spomb=0 spomb1=1.11111e+60
    M4B (CTRL CLKS VDD! VDD!) pch_18_mac l=150.0n w=1u multi=1 nf=1 \
        sd=180.0n ad=1.55e-13 as=1.55e-13 pd=2.31u ps=2.31u nrd=0 nrs=0 \
        sa=155.00n sb=155.00n sa1=155.00n sa2=155.00n sa3=155.00n \
        sa4=155.00n sb1=155.00n sb2=155.00n sb3=155.00n spa=180.0n \
        spa1=180.0n spa2=180.0n spa3=180.0n sap=172.362n sapb=242.67n \
        spba=233.666n spba1=239.844n spmt=1.11111e+15 spomt=0 \
        spomt1=1.11111e+60 spmb=1.11111e+15 spomb=0 spomb1=1.11111e+60
    MPCLK (CLKSB CLKS VDD! VDD!) pch_18_mac l=150.0n w=1u multi=1 nf=1 \
        sd=180.0n ad=1.55e-13 as=1.55e-13 pd=2.31u ps=2.31u nrd=0 nrs=0 \
        sa=155.00n sb=155.00n sa1=155.00n sa2=155.00n sa3=155.00n \
        sa4=155.00n sb1=155.00n sb2=155.00n sb3=155.00n spa=180.0n \
        spa1=180.0n spa2=180.0n spa3=180.0n sap=172.362n sapb=242.67n \
        spba=233.666n spba1=239.844n spmt=1.11111e+15 spomt=0 \
        spomt1=1.11111e+60 spmb=1.11111e+15 spomb=0 spomb1=1.11111e+60
    Cboot (BTOP BBOT) cfmom_2t nr=8 lr=2.5u w=50n s=50n stm=1 spm=3 \
        multi=200 mismatchflag=1
ends sar_bootstrap_flat_8b_p

subckt sar_strongarm_t28 CLK OUTN OUTP VDD VINN VINP VSS
    MNLATN (OUTN OUTP Y VSS) nch_mac l=30n w=500n multi=1 nf=1 sd=100n \
        ad=3.75e-14 as=3.75e-14 pd=1.15u ps=1.15u nrd=0.662935 \
        nrs=0.662935 sa=75.0n sb=75.0n sa1=75.0n sa2=75.0n sa3=75.0n \
        sa4=75.0n sb1=75.0n sb2=75.0n sb3=75.0n spa=100n spa1=100n \
        spa2=100n spa3=100n sap=91.9776n sapb=114.444n spba=115.715n \
        spba1=117.043n dfm_flag=0 spmt=1.11111e+15 spomt=0 \
        spomt1=1.11111e+60 spmb=1.11111e+15 spomb=0 spomb1=1.11111e+60
    MNLATP (OUTP OUTN X VSS) nch_mac l=30n w=500n multi=1 nf=1 sd=100n \
        ad=3.75e-14 as=3.75e-14 pd=1.15u ps=1.15u nrd=0.662935 \
        nrs=0.662935 sa=75.0n sb=75.0n sa1=75.0n sa2=75.0n sa3=75.0n \
        sa4=75.0n sb1=75.0n sb2=75.0n sb3=75.0n spa=100n spa1=100n \
        spa2=100n spa3=100n sap=91.9776n sapb=114.444n spba=115.715n \
        spba1=117.043n dfm_flag=0 spmt=1.11111e+15 spomt=0 \
        spomt1=1.11111e+60 spmb=1.11111e+15 spomb=0 spomb1=1.11111e+60
    MNINN (X VINN TAIL VSS) nch_mac l=30n w=1u multi=1 nf=1 sd=100n \
        ad=7.5e-14 as=7.5e-14 pd=2.15u ps=2.15u nrd=0.289519 nrs=0.289519 \
        sa=75.0n sb=75.0n sa1=75.0n sa2=75.0n sa3=75.0n sa4=75.0n \
        sb1=75.0n sb2=75.0n sb3=75.0n spa=100n spa1=100n spa2=100n \
        spa3=100n sap=91.9776n sapb=114.444n spba=115.715n spba1=117.043n \
        dfm_flag=0 spmt=1.11111e+15 spomt=0 spomt1=1.11111e+60 \
        spmb=1.11111e+15 spomb=0 spomb1=1.11111e+60
    MNINP (Y VINP TAIL VSS) nch_mac l=30n w=1u multi=1 nf=1 sd=100n \
        ad=7.5e-14 as=7.5e-14 pd=2.15u ps=2.15u nrd=0.289519 nrs=0.289519 \
        sa=75.0n sb=75.0n sa1=75.0n sa2=75.0n sa3=75.0n sa4=75.0n \
        sb1=75.0n sb2=75.0n sb3=75.0n spa=100n spa1=100n spa2=100n \
        spa3=100n sap=91.9776n sapb=114.444n spba=115.715n spba1=117.043n \
        dfm_flag=0 spmt=1.11111e+15 spomt=0 spomt1=1.11111e+60 \
        spmb=1.11111e+15 spomb=0 spomb1=1.11111e+60
    MNTAIL (TAIL CLK VSS VSS) nch_mac l=30n w=1u multi=1 nf=1 sd=100n \
        ad=7.5e-14 as=7.5e-14 pd=2.15u ps=2.15u nrd=0.289519 nrs=0.289519 \
        sa=75.0n sb=75.0n sa1=75.0n sa2=75.0n sa3=75.0n sa4=75.0n \
        sb1=75.0n sb2=75.0n sb3=75.0n spa=100n spa1=100n spa2=100n \
        spa3=100n sap=91.9776n sapb=114.444n spba=115.715n spba1=117.043n \
        dfm_flag=0 spmt=1.11111e+15 spomt=0 spomt1=1.11111e+60 \
        spmb=1.11111e+15 spomb=0 spomb1=1.11111e+60
    MPRSTN (OUTN CLK VDD VDD) pch_mac l=30n w=500n multi=1 nf=1 sd=100n \
        ad=3.75e-14 as=3.75e-14 pd=1.15u ps=1.15u nrd=0.383209 \
        nrs=0.383209 sa=75.0n sb=75.0n sa1=75.0n sa2=75.0n sa3=75.0n \
        sa4=75.0n sb1=75.0n sb2=75.0n sb3=75.0n spa=100n spa1=100n \
        spa2=100n spa3=100n sap=91.9776n sapb=114.444n spba=115.715n \
        spba1=117.043n dfm_flag=0 spmt=1.11111e+15 spomt=0 \
        spomt1=1.11111e+60 spmb=1.11111e+15 spomb=0 spomb1=1.11111e+60
    MPRSTP (OUTP CLK VDD VDD) pch_mac l=30n w=500n multi=1 nf=1 sd=100n \
        ad=3.75e-14 as=3.75e-14 pd=1.15u ps=1.15u nrd=0.383209 \
        nrs=0.383209 sa=75.0n sb=75.0n sa1=75.0n sa2=75.0n sa3=75.0n \
        sa4=75.0n sb1=75.0n sb2=75.0n sb3=75.0n spa=100n spa1=100n \
        spa2=100n spa3=100n sap=91.9776n sapb=114.444n spba=115.715n \
        spba1=117.043n dfm_flag=0 spmt=1.11111e+15 spomt=0 \
        spomt1=1.11111e+60 spmb=1.11111e+15 spomb=0 spomb1=1.11111e+60
    MPRSTY (Y CLK VDD VDD) pch_mac l=30n w=500n multi=1 nf=1 sd=100n \
        ad=3.75e-14 as=3.75e-14 pd=1.15u ps=1.15u nrd=0.383209 \
        nrs=0.383209 sa=75.0n sb=75.0n sa1=75.0n sa2=75.0n sa3=75.0n \
        sa4=75.0n sb1=75.0n sb2=75.0n sb3=75.0n spa=100n spa1=100n \
        spa2=100n spa3=100n sap=91.9776n sapb=114.444n spba=115.715n \
        spba1=117.043n dfm_flag=0 spmt=1.11111e+15 spomt=0 \
        spomt1=1.11111e+60 spmb=1.11111e+15 spomb=0 spomb1=1.11111e+60
    MPRSTX (X CLK VDD VDD) pch_mac l=30n w=500n multi=1 nf=1 sd=100n \
        ad=3.75e-14 as=3.75e-14 pd=1.15u ps=1.15u nrd=0.383209 \
        nrs=0.383209 sa=75.0n sb=75.0n sa1=75.0n sa2=75.0n sa3=75.0n \
        sa4=75.0n sb1=75.0n sb2=75.0n sb3=75.0n spa=100n spa1=100n \
        spa2=100n spa3=100n sap=91.9776n sapb=114.444n spba=115.715n \
        spba1=117.043n dfm_flag=0 spmt=1.11111e+15 spomt=0 \
        spomt1=1.11111e+60 spmb=1.11111e+15 spomb=0 spomb1=1.11111e+60
    MPLATN (OUTN OUTP VDD VDD) pch_mac l=30n w=500n multi=1 nf=1 sd=100n \
        ad=3.75e-14 as=3.75e-14 pd=1.15u ps=1.15u nrd=0.383209 \
        nrs=0.383209 sa=75.0n sb=75.0n sa1=75.0n sa2=75.0n sa3=75.0n \
        sa4=75.0n sb1=75.0n sb2=75.0n sb3=75.0n spa=100n spa1=100n \
        spa2=100n spa3=100n sap=91.9776n sapb=114.444n spba=115.715n \
        spba1=117.043n dfm_flag=0 spmt=1.11111e+15 spomt=0 \
        spomt1=1.11111e+60 spmb=1.11111e+15 spomb=0 spomb1=1.11111e+60
    MPLATP (OUTP OUTN VDD VDD) pch_mac l=30n w=500n multi=1 nf=1 sd=100n \
        ad=3.75e-14 as=3.75e-14 pd=1.15u ps=1.15u nrd=0.383209 \
        nrs=0.383209 sa=75.0n sb=75.0n sa1=75.0n sa2=75.0n sa3=75.0n \
        sa4=75.0n sb1=75.0n sb2=75.0n sb3=75.0n spa=100n spa1=100n \
        spa2=100n spa3=100n sap=91.9776n sapb=114.444n spba=115.715n \
        spba1=117.043n dfm_flag=0 spmt=1.11111e+15 spomt=0 \
        spomt1=1.11111e+60 spmb=1.11111e+15 spomb=0 spomb1=1.11111e+60
ends sar_strongarm_t28
