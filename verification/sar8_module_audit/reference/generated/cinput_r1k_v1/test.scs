// APPROXIMATE REPLAY CANDIDATE: local only, parent review required before dispatch.
simulator lang=spectre
global 0 VDD!
parameters SUP=0.99
include "/home/process/tsmc28n/PDK_mmWave/iPDK_CRN28HPC+ULL_v1.8_2p2a_20190531/tsmcN28/../models/spectre/crn28ull_1d8_elk_v1d8_2p2_shrink0d9_embedded_usage.scs" section=pre_simu
include "/home/process/tsmc28n/PDK_mmWave/iPDK_CRN28HPC+ULL_v1.8_2p2a_20190531/tsmcN28/../models/spectre/crn28ull_1d8_elk_v1d8_2p2_shrink0d9_embedded_usage.scs" section=noise_worst
include "/home/process/tsmc28n/PDK_mmWave/iPDK_CRN28HPC+ULL_v1.8_2p2a_20190531/tsmcN28/../models/spectre/crn28ull_1d8_elk_v1d8_2p2_shrink0d9_embedded_usage.scs" section=ffmacro_mos_moscap
include "/home/process/tsmc28n/PDK_mmWave/iPDK_CRN28HPC+ULL_v1.8_2p2a_20190531/tsmcN28/../models/spectre/crn28ull_1d8_elk_v1d8_2p2_shrink0d9_embedded_usage.scs" section=tt_res_bip_dio_disres
include "/home/process/tsmc28n/PDK_mmWave/iPDK_CRN28HPC+ULL_v1.8_2p2a_20190531/tsmcN28/../models/spectre/crn28ull_1d8_elk_v1d8_2p2_shrink0d9_embedded_usage.scs" section=tt_mom
include "/home/process/tsmc28n/PDK_mmWave/iPDK_CRN28HPC+ULL_v1.8_2p2a_20190531/tsmcN28/../models/spectre/crn28ull_1d8_elk_v1d8_2p2_shrink0d9_embedded_usage.scs" section=tt_ind_jvar
include "/home/process/tsmc28n/PDK_mmWave/iPDK_CRN28HPC+ULL_v1.8_2p2a_20190531/tsmcN28/../models/spectre/crn28ull_1d8_elk_v1d8_2p2_shrink0d9_embedded_usage.scs" section=tt_r_metal
include "dut.scs"
include "boundary_sources_approximate.scs"
XDUT (REPLAY_XDUT_PHI_U REPLAY_XDUT_XREF_CAP_REQ REPLAY_XDUT_SAMPLE_INT REPLAY_XDUT_SEQ_SAMPLE REPLAY_XDUT_CMP_CLK REPLAY_XDUT_XREF_RST0 REPLAY_XDUT_XREF_RST1 REPLAY_XDUT_XREF_RST2 REPLAY_XDUT_XREF_RST3 REPLAY_XDUT_XREF_RST4 REPLAY_XDUT_XREF_RST5 REPLAY_XDUT_XREF_RST6 REPLAY_XDUT_XREF_RST7 REPLAY_D0 REPLAY_D1 REPLAY_D2 REPLAY_D3 REPLAY_D4 REPLAY_D5 REPLAY_D6 REPLAY_D7 REPLAY_XDUT_CODE0 REPLAY_XDUT_CODE1 REPLAY_XDUT_CODE2 REPLAY_XDUT_CODE3 REPLAY_XDUT_CODE4 REPLAY_XDUT_CODE5 REPLAY_XDUT_CODE6 REPLAY_XDUT_CODE7 VDD! VINN VINP VREFN VREFP 0) sar8_reference_isolation_v1
VVINN (VINN_SRC 0) vsource type=pwl wave=[0n 0.045 100.2n 0.045 100.3n 0.855 200.2n 0.855 200.3n 0.45 300.2n 0.45 300.3n 0.44912109375 400.2n 0.44912109375 400.3n 0.45087890625 500.2n 0.45087890625 500.3n 0.3884765625]
VVINP (VINP_SRC 0) vsource type=pwl wave=[0n 0.855 100.2n 0.855 100.3n 0.045 200.2n 0.045 200.3n 0.45 300.2n 0.45 300.3n 0.45087890625 400.2n 0.45087890625 400.3n 0.44912109375 500.2n 0.44912109375 500.3n 0.5115234375]
VREFLOW (VREFN_SRC 0) vsource dc=0 type=dc
VREFHIGH (VREFP_SRC 0) vsource dc=0.9 type=dc
VVDD (VDD! 0) vsource dc=SUP type=dc
RREFN (VREFN_SRC VREFN) resistor r=50
RREFP (VREFP_SRC VREFP) resistor r=50
RINN (VINN_SRC VINN) resistor r=50
RINP (VINP_SRC VINP) resistor r=50
CREFN (VREFN 0) capacitor c=4p
CREFP (VREFP 0) capacitor c=4p
simulatorOptions options psfversion="1.4.0" method=gear2only reltol=1e-6 vabstol=1e-8      iabstol=1e-13 temp=-40 tnom=27 scalem=1.0 scale=1.0 gmin=1e-12 rforce=1      maxnotes=5 maxwarns=5 digits=5 cols=80 pivrel=1e-3 checklimitdest=psf
saveOptions options save=selected currents=selected subcktiprobes=no useprobes=no
tran_repro tran stop=6.5996504234270155e-08 maxstep=10p errpreset=conservative lteratio=10 strobeperiod=1n strobeoutput=all outputstart=0n
save CREFN:1
save CREFP:1
save REPLAY_D0
save REPLAY_D1
save REPLAY_D2
save REPLAY_D3
save REPLAY_D4
save REPLAY_D5
save REPLAY_D6
save REPLAY_D7
save REPLAY_XDUT_CMP_CLK
save REPLAY_XDUT_CODE0
save REPLAY_XDUT_CODE1
save REPLAY_XDUT_CODE2
save REPLAY_XDUT_CODE3
save REPLAY_XDUT_CODE4
save REPLAY_XDUT_CODE5
save REPLAY_XDUT_CODE6
save REPLAY_XDUT_CODE7
save REPLAY_XDUT_PHI_U
save REPLAY_XDUT_SAMPLE_INT
save REPLAY_XDUT_SEQ_SAMPLE
save REPLAY_XDUT_XREF_CAP_REQ
save REPLAY_XDUT_XREF_RST0
save REPLAY_XDUT_XREF_RST1
save REPLAY_XDUT_XREF_RST2
save REPLAY_XDUT_XREF_RST3
save REPLAY_XDUT_XREF_RST4
save REPLAY_XDUT_XREF_RST5
save REPLAY_XDUT_XREF_RST6
save REPLAY_XDUT_XREF_RST7
save RREFN:1
save RREFP:1
save VDD!
save VINN
save VINP
save VREFHIGH:1
save VREFLOW:1
save VREFN
save VREFP
save VVDD:1
save XDUT.COMP_N
save XDUT.COMP_P
save XDUT.GNN0
save XDUT.GNP0
save XDUT.GPN0
save XDUT.GPP0
save XDUT.TOPN
save XDUT.TOPP
save XDUT.XBOOTN.G
save XDUT.XBOOTN.Mmain:1
save XDUT.XBOOTN.Mmain:2
save XDUT.XBOOTN.Mmain:3
save XDUT.XBOOTN.Mmain:4
save XDUT.XBOOTN.Mmain_U1:1
save XDUT.XBOOTN.Mmain_U1:2
save XDUT.XBOOTN.Mmain_U1:3
save XDUT.XBOOTN.Mmain_U1:4
save XDUT.XBOOTP.G
save XDUT.XBOOTP.Mmain:1
save XDUT.XBOOTP.Mmain:2
save XDUT.XBOOTP.Mmain:3
save XDUT.XBOOTP.Mmain:4
save XDUT.XBOOTP.Mmain_U1:1
save XDUT.XBOOTP.Mmain_U1:2
save XDUT.XBOOTP.Mmain_U1:3
save XDUT.XBOOTP.Mmain_U1:4
save XDUT.XCDAC.BN0
save XDUT.XCDAC.BN1
save XDUT.XCDAC.BN2
save XDUT.XCDAC.BN3
save XDUT.XCDAC.BN4
save XDUT.XCDAC.BN5
save XDUT.XCDAC.BN6
save XDUT.XCDAC.BN7
save XDUT.XCDAC.BP0
save XDUT.XCDAC.BP1
save XDUT.XCDAC.BP2
save XDUT.XCDAC.BP3
save XDUT.XCDAC.BP4
save XDUT.XCDAC.BP5
save XDUT.XCDAC.BP6
save XDUT.XCDAC.BP7
save XDUT.XCDAC.CMOMN0:1
save XDUT.XCDAC.CMOMN0:2
save XDUT.XCDAC.CMOMN1:1
save XDUT.XCDAC.CMOMN1:2
save XDUT.XCDAC.CMOMN2:1
save XDUT.XCDAC.CMOMN2:2
save XDUT.XCDAC.CMOMN3:1
save XDUT.XCDAC.CMOMN3:2
save XDUT.XCDAC.CMOMN4:1
save XDUT.XCDAC.CMOMN4:2
save XDUT.XCDAC.CMOMN5:1
save XDUT.XCDAC.CMOMN5:2
save XDUT.XCDAC.CMOMN6:1
save XDUT.XCDAC.CMOMN6:2
save XDUT.XCDAC.CMOMN7:1
save XDUT.XCDAC.CMOMN7:2
save XDUT.XCDAC.CMOMN8:1
save XDUT.XCDAC.CMOMN8:2
save XDUT.XCDAC.CMOMP0:1
save XDUT.XCDAC.CMOMP0:2
save XDUT.XCDAC.CMOMP1:1
save XDUT.XCDAC.CMOMP1:2
save XDUT.XCDAC.CMOMP2:1
save XDUT.XCDAC.CMOMP2:2
save XDUT.XCDAC.CMOMP3:1
save XDUT.XCDAC.CMOMP3:2
save XDUT.XCDAC.CMOMP4:1
save XDUT.XCDAC.CMOMP4:2
save XDUT.XCDAC.CMOMP5:1
save XDUT.XCDAC.CMOMP5:2
save XDUT.XCDAC.CMOMP6:1
save XDUT.XCDAC.CMOMP6:2
save XDUT.XCDAC.CMOMP7:1
save XDUT.XCDAC.CMOMP7:2
save XDUT.XCDAC.CMOMP8:1
save XDUT.XCDAC.CMOMP8:2
save XDUT.XCDAC.XSN0.MN_LOW:1
save XDUT.XCDAC.XSN0.MN_LOW:2
save XDUT.XCDAC.XSN0.MN_LOW:3
save XDUT.XCDAC.XSN0.MN_LOW:4
save XDUT.XCDAC.XSN0.MP_HIGH:1
save XDUT.XCDAC.XSN0.MP_HIGH:2
save XDUT.XCDAC.XSN0.MP_HIGH:3
save XDUT.XCDAC.XSN0.MP_HIGH:4
save XDUT.XCDAC.XSP0.MN_LOW:1
save XDUT.XCDAC.XSP0.MN_LOW:2
save XDUT.XCDAC.XSP0.MN_LOW:3
save XDUT.XCDAC.XSP0.MN_LOW:4
save XDUT.XCDAC.XSP0.MP_HIGH:1
save XDUT.XCDAC.XSP0.MP_HIGH:2
save XDUT.XCDAC.XSP0.MP_HIGH:3
save XDUT.XCDAC.XSP0.MP_HIGH:4
save XDUT.XCOMP.MNINN:1
save XDUT.XCOMP.MNINN:2
save XDUT.XCOMP.MNINN:3
save XDUT.XCOMP.MNINN:4
save XDUT.XCOMP.MNINP:1
save XDUT.XCOMP.MNINP:2
save XDUT.XCOMP.MNINP:3
save XDUT.XCOMP.MNINP:4
save XDUT.XCOMP.TAIL
save XDUT.XCOMP.X
save XDUT.XCOMP.Y
save XDUT.XREF.CAP_CLK
save XDUT.XREF.H0
save XDUT.XREF.H1
save XDUT.XREF.H2
save XDUT.XREF.H3
save XDUT.XREF.H4
save XDUT.XREF.H5
save XDUT.XREF.H6
save XDUT.XREF.H7
save XDUT.XREF.L0
save XDUT.XREF.L1
save XDUT.XREF.L2
save XDUT.XREF.L3
save XDUT.XREF.L4
save XDUT.XREF.L5
save XDUT.XREF.L6
save XDUT.XREF.L7
save XDUT.XREF.Q0
save XDUT.XREF.Q1
save XDUT.XREF.Q2
save XDUT.XREF.Q3
save XDUT.XREF.Q4
save XDUT.XREF.Q5
save XDUT.XREF.Q6
save XDUT.XREF.Q7
save XDUT.XREF.XDRV0.GNNA
save XDUT.XREF.XDRV0.GNNAN:1
save XDUT.XREF.XDRV0.GNNAN:2
save XDUT.XREF.XDRV0.GNNAN:3
save XDUT.XREF.XDRV0.GNNAN:4
save XDUT.XREF.XDRV0.GNNAP:1
save XDUT.XREF.XDRV0.GNNAP:2
save XDUT.XREF.XDRV0.GNNAP:3
save XDUT.XREF.XDRV0.GNNAP:4
save XDUT.XREF.XDRV0.GNNB
save XDUT.XREF.XDRV0.GNNBN:1
save XDUT.XREF.XDRV0.GNNBN:2
save XDUT.XREF.XDRV0.GNNBN:3
save XDUT.XREF.XDRV0.GNNBN:4
save XDUT.XREF.XDRV0.GNNBP:1
save XDUT.XREF.XDRV0.GNNBP:2
save XDUT.XREF.XDRV0.GNNBP:3
save XDUT.XREF.XDRV0.GNNBP:4
save XDUT.XREF.XDRV0.GNNCN:1
save XDUT.XREF.XDRV0.GNNCN:2
save XDUT.XREF.XDRV0.GNNCN:3
save XDUT.XREF.XDRV0.GNNCN:4
save XDUT.XREF.XDRV0.GNNCP:1
save XDUT.XREF.XDRV0.GNNCP:2
save XDUT.XREF.XDRV0.GNNCP:3
save XDUT.XREF.XDRV0.GNNCP:4
save XDUT.XREF.XDRV0.GNNDRV
save XDUT.XREF.XDRV0.GNNPRE
save XDUT.XREF.XDRV0.GNNRG
save XDUT.XREF.XDRV0.GNN_CG
save XDUT.XREF.XDRV0.GNPA
save XDUT.XREF.XDRV0.GNPAN:1
save XDUT.XREF.XDRV0.GNPAN:2
save XDUT.XREF.XDRV0.GNPAN:3
save XDUT.XREF.XDRV0.GNPAN:4
save XDUT.XREF.XDRV0.GNPAP:1
save XDUT.XREF.XDRV0.GNPAP:2
save XDUT.XREF.XDRV0.GNPAP:3
save XDUT.XREF.XDRV0.GNPAP:4
save XDUT.XREF.XDRV0.GNPB
save XDUT.XREF.XDRV0.GNPBN:1
save XDUT.XREF.XDRV0.GNPBN:2
save XDUT.XREF.XDRV0.GNPBN:3
save XDUT.XREF.XDRV0.GNPBN:4
save XDUT.XREF.XDRV0.GNPBP:1
save XDUT.XREF.XDRV0.GNPBP:2
save XDUT.XREF.XDRV0.GNPBP:3
save XDUT.XREF.XDRV0.GNPBP:4
save XDUT.XREF.XDRV0.GNPCN:1
save XDUT.XREF.XDRV0.GNPCN:2
save XDUT.XREF.XDRV0.GNPCN:3
save XDUT.XREF.XDRV0.GNPCN:4
save XDUT.XREF.XDRV0.GNPCP:1
save XDUT.XREF.XDRV0.GNPCP:2
save XDUT.XREF.XDRV0.GNPCP:3
save XDUT.XREF.XDRV0.GNPCP:4
save XDUT.XREF.XDRV0.GNPDRV
save XDUT.XREF.XDRV0.GNPRG
save XDUT.XREF.XDRV0.GPNA
save XDUT.XREF.XDRV0.GPNAN:1
save XDUT.XREF.XDRV0.GPNAN:2
save XDUT.XREF.XDRV0.GPNAN:3
save XDUT.XREF.XDRV0.GPNAN:4
save XDUT.XREF.XDRV0.GPNAP:1
save XDUT.XREF.XDRV0.GPNAP:2
save XDUT.XREF.XDRV0.GPNAP:3
save XDUT.XREF.XDRV0.GPNAP:4
save XDUT.XREF.XDRV0.GPNB
save XDUT.XREF.XDRV0.GPNBN:1
save XDUT.XREF.XDRV0.GPNBN:2
save XDUT.XREF.XDRV0.GPNBN:3
save XDUT.XREF.XDRV0.GPNBN:4
save XDUT.XREF.XDRV0.GPNBP:1
save XDUT.XREF.XDRV0.GPNBP:2
save XDUT.XREF.XDRV0.GPNBP:3
save XDUT.XREF.XDRV0.GPNBP:4
save XDUT.XREF.XDRV0.GPNCN:1
save XDUT.XREF.XDRV0.GPNCN:2
save XDUT.XREF.XDRV0.GPNCN:3
save XDUT.XREF.XDRV0.GPNCN:4
save XDUT.XREF.XDRV0.GPNCP:1
save XDUT.XREF.XDRV0.GPNCP:2
save XDUT.XREF.XDRV0.GPNCP:3
save XDUT.XREF.XDRV0.GPNCP:4
save XDUT.XREF.XDRV0.GPNDRV
save XDUT.XREF.XDRV0.GPNPRE
save XDUT.XREF.XDRV0.GPNRG
save XDUT.XREF.XDRV0.GPPA
save XDUT.XREF.XDRV0.GPPAN:1
save XDUT.XREF.XDRV0.GPPAN:2
save XDUT.XREF.XDRV0.GPPAN:3
save XDUT.XREF.XDRV0.GPPAN:4
save XDUT.XREF.XDRV0.GPPAP:1
save XDUT.XREF.XDRV0.GPPAP:2
save XDUT.XREF.XDRV0.GPPAP:3
save XDUT.XREF.XDRV0.GPPAP:4
save XDUT.XREF.XDRV0.GPPB
save XDUT.XREF.XDRV0.GPPBN:1
save XDUT.XREF.XDRV0.GPPBN:2
save XDUT.XREF.XDRV0.GPPBN:3
save XDUT.XREF.XDRV0.GPPBN:4
save XDUT.XREF.XDRV0.GPPBP:1
save XDUT.XREF.XDRV0.GPPBP:2
save XDUT.XREF.XDRV0.GPPBP:3
save XDUT.XREF.XDRV0.GPPBP:4
save XDUT.XREF.XDRV0.GPPCN:1
save XDUT.XREF.XDRV0.GPPCN:2
save XDUT.XREF.XDRV0.GPPCN:3
save XDUT.XREF.XDRV0.GPPCN:4
save XDUT.XREF.XDRV0.GPPCP:1
save XDUT.XREF.XDRV0.GPPCP:2
save XDUT.XREF.XDRV0.GPPCP:3
save XDUT.XREF.XDRV0.GPPCP:4
save XDUT.XREF.XDRV0.GPPDRV
save XDUT.XREF.XDRV0.GPPRG
save XDUT.XREF.XDRV0.RGNN0:1
save XDUT.XREF.XDRV0.RGNN0:2
save XDUT.XREF.XDRV0.RGNN0_1__dmy0
save XDUT.XREF.XDRV0.RGNN0_2__dmy0
save XDUT.XREF.XDRV0.RGNN0_2__dmy0:1
save XDUT.XREF.XDRV0.RGNN0_2__dmy0:2
save XDUT.XREF.XDRV0.RGNN0_3__dmy0
save XDUT.XREF.XDRV0.RGNN0_3__dmy0:1
save XDUT.XREF.XDRV0.RGNN0_3__dmy0:2
save XDUT.XREF.XDRV0.RGNN0_4__dmy0
save XDUT.XREF.XDRV0.RGNN0_4__dmy0:1
save XDUT.XREF.XDRV0.RGNN0_4__dmy0:2
save XDUT.XREF.XDRV0.RGNN0_5__dmy0:1
save XDUT.XREF.XDRV0.RGNN0_5__dmy0:2
save XDUT.XREF.XDRV0.RGNN1:1
save XDUT.XREF.XDRV0.RGNN1:2
save XDUT.XREF.XDRV0.RGNN1_1__dmy0
save XDUT.XREF.XDRV0.RGNN1_2__dmy0
save XDUT.XREF.XDRV0.RGNN1_2__dmy0:1
save XDUT.XREF.XDRV0.RGNN1_2__dmy0:2
save XDUT.XREF.XDRV0.RGNN1_3__dmy0
save XDUT.XREF.XDRV0.RGNN1_3__dmy0:1
save XDUT.XREF.XDRV0.RGNN1_3__dmy0:2
save XDUT.XREF.XDRV0.RGNN1_4__dmy0
save XDUT.XREF.XDRV0.RGNN1_4__dmy0:1
save XDUT.XREF.XDRV0.RGNN1_4__dmy0:2
save XDUT.XREF.XDRV0.RGNN1_5__dmy0:1
save XDUT.XREF.XDRV0.RGNN1_5__dmy0:2
save XDUT.XREF.XDRV0.RGNP0:1
save XDUT.XREF.XDRV0.RGNP0:2
save XDUT.XREF.XDRV0.RGNP0_1__dmy0
save XDUT.XREF.XDRV0.RGNP0_2__dmy0
save XDUT.XREF.XDRV0.RGNP0_2__dmy0:1
save XDUT.XREF.XDRV0.RGNP0_2__dmy0:2
save XDUT.XREF.XDRV0.RGNP0_3__dmy0
save XDUT.XREF.XDRV0.RGNP0_3__dmy0:1
save XDUT.XREF.XDRV0.RGNP0_3__dmy0:2
save XDUT.XREF.XDRV0.RGNP0_4__dmy0
save XDUT.XREF.XDRV0.RGNP0_4__dmy0:1
save XDUT.XREF.XDRV0.RGNP0_4__dmy0:2
save XDUT.XREF.XDRV0.RGNP0_5__dmy0:1
save XDUT.XREF.XDRV0.RGNP0_5__dmy0:2
save XDUT.XREF.XDRV0.RGNP1:1
save XDUT.XREF.XDRV0.RGNP1:2
save XDUT.XREF.XDRV0.RGNP1_1__dmy0
save XDUT.XREF.XDRV0.RGNP1_2__dmy0
save XDUT.XREF.XDRV0.RGNP1_2__dmy0:1
save XDUT.XREF.XDRV0.RGNP1_2__dmy0:2
save XDUT.XREF.XDRV0.RGNP1_3__dmy0
save XDUT.XREF.XDRV0.RGNP1_3__dmy0:1
save XDUT.XREF.XDRV0.RGNP1_3__dmy0:2
save XDUT.XREF.XDRV0.RGNP1_4__dmy0
save XDUT.XREF.XDRV0.RGNP1_4__dmy0:1
save XDUT.XREF.XDRV0.RGNP1_4__dmy0:2
save XDUT.XREF.XDRV0.RGNP1_5__dmy0:1
save XDUT.XREF.XDRV0.RGNP1_5__dmy0:2
save XDUT.XREF.XDRV0.RGPN0:1
save XDUT.XREF.XDRV0.RGPN0:2
save XDUT.XREF.XDRV0.RGPN0_1__dmy0
save XDUT.XREF.XDRV0.RGPN0_2__dmy0
save XDUT.XREF.XDRV0.RGPN0_2__dmy0:1
save XDUT.XREF.XDRV0.RGPN0_2__dmy0:2
save XDUT.XREF.XDRV0.RGPN0_3__dmy0
save XDUT.XREF.XDRV0.RGPN0_3__dmy0:1
save XDUT.XREF.XDRV0.RGPN0_3__dmy0:2
save XDUT.XREF.XDRV0.RGPN0_4__dmy0
save XDUT.XREF.XDRV0.RGPN0_4__dmy0:1
save XDUT.XREF.XDRV0.RGPN0_4__dmy0:2
save XDUT.XREF.XDRV0.RGPN0_5__dmy0:1
save XDUT.XREF.XDRV0.RGPN0_5__dmy0:2
save XDUT.XREF.XDRV0.RGPN1:1
save XDUT.XREF.XDRV0.RGPN1:2
save XDUT.XREF.XDRV0.RGPN1_1__dmy0
save XDUT.XREF.XDRV0.RGPN1_2__dmy0
save XDUT.XREF.XDRV0.RGPN1_2__dmy0:1
save XDUT.XREF.XDRV0.RGPN1_2__dmy0:2
save XDUT.XREF.XDRV0.RGPN1_3__dmy0
save XDUT.XREF.XDRV0.RGPN1_3__dmy0:1
save XDUT.XREF.XDRV0.RGPN1_3__dmy0:2
save XDUT.XREF.XDRV0.RGPN1_4__dmy0
save XDUT.XREF.XDRV0.RGPN1_4__dmy0:1
save XDUT.XREF.XDRV0.RGPN1_4__dmy0:2
save XDUT.XREF.XDRV0.RGPN1_5__dmy0:1
save XDUT.XREF.XDRV0.RGPN1_5__dmy0:2
save XDUT.XREF.XDRV0.RGPP0:1
save XDUT.XREF.XDRV0.RGPP0:2
save XDUT.XREF.XDRV0.RGPP0_1__dmy0
save XDUT.XREF.XDRV0.RGPP0_2__dmy0
save XDUT.XREF.XDRV0.RGPP0_2__dmy0:1
save XDUT.XREF.XDRV0.RGPP0_2__dmy0:2
save XDUT.XREF.XDRV0.RGPP0_3__dmy0
save XDUT.XREF.XDRV0.RGPP0_3__dmy0:1
save XDUT.XREF.XDRV0.RGPP0_3__dmy0:2
save XDUT.XREF.XDRV0.RGPP0_4__dmy0
save XDUT.XREF.XDRV0.RGPP0_4__dmy0:1
save XDUT.XREF.XDRV0.RGPP0_4__dmy0:2
save XDUT.XREF.XDRV0.RGPP0_5__dmy0:1
save XDUT.XREF.XDRV0.RGPP0_5__dmy0:2
save XDUT.XREF.XDRV0.RGPP1:1
save XDUT.XREF.XDRV0.RGPP1:2
save XDUT.XREF.XDRV0.RGPP1_1__dmy0
save XDUT.XREF.XDRV0.RGPP1_2__dmy0
save XDUT.XREF.XDRV0.RGPP1_2__dmy0:1
save XDUT.XREF.XDRV0.RGPP1_2__dmy0:2
save XDUT.XREF.XDRV0.RGPP1_3__dmy0
save XDUT.XREF.XDRV0.RGPP1_3__dmy0:1
save XDUT.XREF.XDRV0.RGPP1_3__dmy0:2
save XDUT.XREF.XDRV0.RGPP1_4__dmy0
save XDUT.XREF.XDRV0.RGPP1_4__dmy0:1
save XDUT.XREF.XDRV0.RGPP1_4__dmy0:2
save XDUT.XREF.XDRV0.RGPP1_5__dmy0:1
save XDUT.XREF.XDRV0.RGPP1_5__dmy0:2
save XDUT.XREF.XDRV0.R_CIN:1
save XDUT.XREF.XDRV0.R_CIN:2
save XDUT.XREF.XDRV0.X008.MN:1
save XDUT.XREF.XDRV0.X008.MN:2
save XDUT.XREF.XDRV0.X008.MN:3
save XDUT.XREF.XDRV0.X008.MN:4
save XDUT.XREF.XDRV0.X008.MP:1
save XDUT.XREF.XDRV0.X008.MP:2
save XDUT.XREF.XDRV0.X008.MP:3
save XDUT.XREF.XDRV0.X008.MP:4
save XDUT.XREF.XDRV0.X025.MN:1
save XDUT.XREF.XDRV0.X025.MN:2
save XDUT.XREF.XDRV0.X025.MN:3
save XDUT.XREF.XDRV0.X025.MN:4
save XDUT.XREF.XDRV0.X025.MP:1
save XDUT.XREF.XDRV0.X025.MP:2
save XDUT.XREF.XDRV0.X025.MP:3
save XDUT.XREF.XDRV0.X025.MP:4
