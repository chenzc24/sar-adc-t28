simulator lang=spectre
global 0 VDD!
include "/home/process/tsmc28n/PDK_mmWave/iPDK_CRN28HPC+ULL_v1.8_2p2a_20190531/tsmcN28/../models/spectre/crn28ull_1d8_elk_v1d8_2p2_shrink0d9_embedded_usage.scs" section=pre_simu
include "/home/process/tsmc28n/PDK_mmWave/iPDK_CRN28HPC+ULL_v1.8_2p2a_20190531/tsmcN28/../models/spectre/crn28ull_1d8_elk_v1d8_2p2_shrink0d9_embedded_usage.scs" section=noise_worst
include "/home/process/tsmc28n/PDK_mmWave/iPDK_CRN28HPC+ULL_v1.8_2p2a_20190531/tsmcN28/../models/spectre/crn28ull_1d8_elk_v1d8_2p2_shrink0d9_embedded_usage.scs" section=ffmacro_mos_moscap
include "/home/process/tsmc28n/PDK_mmWave/iPDK_CRN28HPC+ULL_v1.8_2p2a_20190531/tsmcN28/../models/spectre/crn28ull_1d8_elk_v1d8_2p2_shrink0d9_embedded_usage.scs" section=tt_res_bip_dio_disres
include "/home/process/tsmc28n/PDK_mmWave/iPDK_CRN28HPC+ULL_v1.8_2p2a_20190531/tsmcN28/../models/spectre/crn28ull_1d8_elk_v1d8_2p2_shrink0d9_embedded_usage.scs" section=tt_mom
include "/home/process/tsmc28n/PDK_mmWave/iPDK_CRN28HPC+ULL_v1.8_2p2a_20190531/tsmcN28/../models/spectre/crn28ull_1d8_elk_v1d8_2p2_shrink0d9_embedded_usage.scs" section=tt_ind_jvar
include "/home/process/tsmc28n/PDK_mmWave/iPDK_CRN28HPC+ULL_v1.8_2p2a_20190531/tsmcN28/../models/spectre/crn28ull_1d8_elk_v1d8_2p2_shrink0d9_embedded_usage.scs" section=tt_r_metal
simulator lang=spice
.include "/home/process/tsmc28n/STD_CELL/tcbn28hpcplusbwp12t30p140_190a/tcbn28hpcplusbwp12t30p140_170a_spi/TSMCHOME/digital/Back_End/spice/tcbn28hpcplusbwp12t30p140_170a/tcbn28hpcplusbwp12t30p140_170a.spi"
simulator lang=spectre
include "dut.scs"
VVDD (VDD! 0) vsource dc=0.98999999999999999
VSR_R (SR_R 0) vsource type=pwl file="pwl/sr_r.pwl"
VSR_S (SR_S 0) vsource type=pwl file="pwl/sr_s.pwl"
VFF_CK (FF_CK 0) vsource type=pwl file="pwl/ff_ck.pwl"
VFF_D (FF_D 0) vsource type=pwl file="pwl/ff_d.pwl"
VFF_RST (FF_RST 0) vsource type=pwl file="pwl/ff_rst.pwl"
VCONTEXT (CONTEXT 0) vsource type=pwl file="pwl/context.pwl"
XDUT (VDD! 0 SR_R SR_S FF_CK FF_D FF_RST CONTEXT) sar8audit_std_storage
simulatorOptions options psfversion="1.4.0" method=gear2only reltol=1e-6 vabstol=1e-8 iabstol=1e-13 temp=-40 tnom=27 scalem=1 scale=1 gmin=1e-12 rforce=1 checklimitdest=psf
saveOptions options save=selected currents=selected subcktiprobes=no useprobes=no
tran_first tran stop=20n maxstep=10p errpreset=conservative lteratio=10
save CONTEXT
save FF_CK
save FF_D
save FF_RST
save SR_R
save SR_S
save VCONTEXT:1
save VDD!
save VFF_CK:1
save VFF_D:1
save VFF_RST:1
save VSR_R:1
save VSR_S:1
save VVDD:1
save XDUT.U00_L0_Y
save XDUT.U00_Q
save XDUT.U00_R
save XDUT.U00_S
save XDUT.U01_CK
save XDUT.U01_D
save XDUT.U01_L0_Y
save XDUT.U01_L1_Y
save XDUT.U01_L2_Y
save XDUT.U01_Q
save XDUT.U01_RST
save XDUT.U02_CK
save XDUT.U02_D
save XDUT.U02_L0_Q
save XDUT.U02_L1_Y
save XDUT.U02_L2_Y
save XDUT.U02_L3_Y
save XDUT.U02_Q
save XDUT.U02_RST
save XDUT.U03_CK
save XDUT.U03_D
save XDUT.U03_L0_Q
save XDUT.U03_L1_Y
save XDUT.U03_L2_Y
save XDUT.U03_L3_Y
save XDUT.U03_Q
save XDUT.U03_RST
save XDUT.U04_CK
save XDUT.U04_D
save XDUT.U04_L0_Q
save XDUT.U04_L1_Y
save XDUT.U04_L2_Y
save XDUT.U04_L3_Y
save XDUT.U04_Q
save XDUT.U04_RST
save XDUT.U05_CK
save XDUT.U05_D
save XDUT.U05_L0_Q
save XDUT.U05_L1_Y
save XDUT.U05_L2_Y
save XDUT.U05_L3_Y
save XDUT.U05_Q
save XDUT.U05_RST
save XDUT.U06_CK
save XDUT.U06_D
save XDUT.U06_L0_Q
save XDUT.U06_L1_Y
save XDUT.U06_L2_Y
save XDUT.U06_L3_Y
save XDUT.U06_Q
save XDUT.U06_RST
save XDUT.U07_CK
save XDUT.U07_D
save XDUT.U07_L0_Q
save XDUT.U07_L1_Y
save XDUT.U07_L2_Y
save XDUT.U07_L3_Y
save XDUT.U07_Q
save XDUT.U07_RST
save XDUT.U08_CK
save XDUT.U08_D
save XDUT.U08_L0_Y
save XDUT.U08_Q
save XDUT.U08_RST
save XDUT.U09_CK
save XDUT.U09_D
save XDUT.U09_L0_Y
save XDUT.U09_L1_Y
save XDUT.U09_L2_Y
save XDUT.U09_Q
save XDUT.U09_RST
save XDUT.U10_CK
save XDUT.U10_D
save XDUT.U10_L0_Y
save XDUT.U10_L1_Y
save XDUT.U10_L2_Y
save XDUT.U10_Q
save XDUT.U10_RST
save XDUT.U11_CK
save XDUT.U11_D
save XDUT.U11_L0_Y
save XDUT.U11_L1_Y
save XDUT.U11_L2_Y
save XDUT.U11_Q
save XDUT.U11_RST
save XDUT.U12_CK
save XDUT.U12_D
save XDUT.U12_L0_Y
save XDUT.U12_L1_Y
save XDUT.U12_L2_Y
save XDUT.U12_Q
save XDUT.U12_RST
save XDUT.U13_CK
save XDUT.U13_D
save XDUT.U13_L0_Y
save XDUT.U13_L1_Y
save XDUT.U13_L2_Y
save XDUT.U13_Q
save XDUT.U13_RST
save XDUT.U14_CK
save XDUT.U14_D
save XDUT.U14_L0_Y
save XDUT.U14_L1_Y
save XDUT.U14_L2_Y
save XDUT.U14_Q
save XDUT.U14_RST
save XDUT.U15_CK
save XDUT.U15_D
save XDUT.U15_L0_Y
save XDUT.U15_L1_Y
save XDUT.U15_L2_Y
save XDUT.U15_Q
save XDUT.U15_RST
save XDUT.U16_CK
save XDUT.U16_D
save XDUT.U16_L0_Y
save XDUT.U16_L1_Y
save XDUT.U16_L2_Y
save XDUT.U16_Q
save XDUT.U16_RST
save XDUT.U17_L0_Y
save XDUT.U17_Q
save XDUT.U17_R
save XDUT.U17_S
save XDUT.U18_CK
save XDUT.U18_D
save XDUT.U18_L0_Y
save XDUT.U18_Q
save XDUT.U18_RST
save XDUT.U19_CK
save XDUT.U19_D
save XDUT.U19_L0_Y
save XDUT.U19_L1_Y
save XDUT.U19_L2_Y
save XDUT.U19_Q
save XDUT.U19_RST
save XDUT.U20_CK
save XDUT.U20_D
save XDUT.U20_L0_Y
save XDUT.U20_L1_Y
save XDUT.U20_L2_Y
save XDUT.U20_Q
save XDUT.U20_RST
save XDUT.U21_CK
save XDUT.U21_D
save XDUT.U21_L0_Y
save XDUT.U21_L1_Y
save XDUT.U21_L2_Y
save XDUT.U21_Q
save XDUT.U21_RST
save XDUT.U22_CK
save XDUT.U22_D
save XDUT.U22_L0_Y
save XDUT.U22_L1_Y
save XDUT.U22_L2_Y
save XDUT.U22_Q
save XDUT.U22_RST
save XDUT.U23_CK
save XDUT.U23_D
save XDUT.U23_L0_Y
save XDUT.U23_L1_Y
save XDUT.U23_L2_Y
save XDUT.U23_Q
save XDUT.U23_RST
save XDUT.U24_CK
save XDUT.U24_D
save XDUT.U24_L0_Y
save XDUT.U24_L1_Y
save XDUT.U24_L2_Y
save XDUT.U24_Q
save XDUT.U24_RST
save XDUT.U25_CK
save XDUT.U25_D
save XDUT.U25_L0_Y
save XDUT.U25_L1_Y
save XDUT.U25_L2_Y
save XDUT.U25_Q
save XDUT.U25_RST
save XDUT.XCU01.AB
save XDUT.XCU02.AB
save XDUT.XCU03.AB
save XDUT.XCU04.AB
save XDUT.XCU05.AB
save XDUT.XCU06.AB
save XDUT.XCU07.AB
save XDUT.XCU08.AB
save XDUT.XCU09.AB
save XDUT.XCU10.AB
save XDUT.XCU11.AB
save XDUT.XCU12.AB
save XDUT.XCU13.AB
save XDUT.XCU14.AB
save XDUT.XCU15.AB
save XDUT.XCU16.AB
save XDUT.XCU18.AB
save XDUT.XCU19.AB
save XDUT.XCU20.AB
save XDUT.XCU21.AB
save XDUT.XCU22.AB
save XDUT.XCU23.AB
save XDUT.XCU24.AB
save XDUT.XCU25.AB
save XDUT.XDU01.N
save XDUT.XDU02.N
save XDUT.XDU03.N
save XDUT.XDU04.N
save XDUT.XDU05.N
save XDUT.XDU06.N
save XDUT.XDU07.N
save XDUT.XDU08.N
save XDUT.XDU09.N
save XDUT.XDU10.N
save XDUT.XDU11.N
save XDUT.XDU12.N
save XDUT.XDU13.N
save XDUT.XDU14.N
save XDUT.XDU15.N
save XDUT.XDU16.N
save XDUT.XDU18.N
save XDUT.XDU19.N
save XDUT.XDU20.N
save XDUT.XDU21.N
save XDUT.XDU22.N
save XDUT.XDU23.N
save XDUT.XDU24.N
save XDUT.XDU25.N
save XDUT.XLU00_0.N
save XDUT.XLU01_0.N0
save XDUT.XLU01_0.N1
save XDUT.XLU01_0.SB
save XDUT.XLU01_0.X001.XLIB.net10
save XDUT.XLU01_0.X002.XLIB.net10
save XDUT.XLU01_0.X003.XLIB.net10
save XDUT.XLU01_1.AB
save XDUT.XLU01_1.BB
save XDUT.XLU01_1.X002.XLIB.net10
save XDUT.XLU01_2.AB
save XDUT.XLU01_2.BB
save XDUT.XLU01_2.X002.XLIB.net10
save XDUT.XLU02_0.RN
save XDUT.XLU02_0.XFF.clkb
save XDUT.XLU02_0.XFF.clkbb
save XDUT.XLU02_0.XFF.mq
save XDUT.XLU02_0.XFF.mq_x
save XDUT.XLU02_0.XFF.net0138
save XDUT.XLU02_0.XFF.net0152
save XDUT.XLU02_0.XFF.net093
save XDUT.XLU02_0.XFF.net103
save XDUT.XLU02_0.XFF.net176
save XDUT.XLU02_0.XFF.net184
save XDUT.XLU02_0.XFF.net208
save XDUT.XLU02_0.XFF.net212
save XDUT.XLU02_0.XFF.qf
save XDUT.XLU02_0.XFF.qf_x
save XDUT.XLU02_1.N0
save XDUT.XLU02_1.N1
save XDUT.XLU02_1.SB
save XDUT.XLU02_1.X001.XLIB.net10
save XDUT.XLU02_1.X002.XLIB.net10
save XDUT.XLU02_1.X003.XLIB.net10
save XDUT.XLU02_2.AB
save XDUT.XLU02_2.BB
save XDUT.XLU02_2.X002.XLIB.net10
save XDUT.XLU02_3.AB
save XDUT.XLU02_3.BB
save XDUT.XLU02_3.X002.XLIB.net10
save XDUT.XLU03_0.RN
save XDUT.XLU03_0.XFF.clkb
save XDUT.XLU03_0.XFF.clkbb
save XDUT.XLU03_0.XFF.mq
save XDUT.XLU03_0.XFF.mq_x
save XDUT.XLU03_0.XFF.net0138
save XDUT.XLU03_0.XFF.net0152
save XDUT.XLU03_0.XFF.net093
save XDUT.XLU03_0.XFF.net103
save XDUT.XLU03_0.XFF.net176
save XDUT.XLU03_0.XFF.net184
save XDUT.XLU03_0.XFF.net208
save XDUT.XLU03_0.XFF.net212
save XDUT.XLU03_0.XFF.qf
save XDUT.XLU03_0.XFF.qf_x
save XDUT.XLU03_1.N0
save XDUT.XLU03_1.N1
save XDUT.XLU03_1.SB
save XDUT.XLU03_1.X001.XLIB.net10
save XDUT.XLU03_1.X002.XLIB.net10
save XDUT.XLU03_1.X003.XLIB.net10
save XDUT.XLU03_2.AB
save XDUT.XLU03_2.BB
save XDUT.XLU03_2.X002.XLIB.net10
save XDUT.XLU03_3.AB
save XDUT.XLU03_3.BB
save XDUT.XLU03_3.X002.XLIB.net10
save XDUT.XLU04_0.RN
save XDUT.XLU04_0.XFF.clkb
save XDUT.XLU04_0.XFF.clkbb
save XDUT.XLU04_0.XFF.mq
save XDUT.XLU04_0.XFF.mq_x
save XDUT.XLU04_0.XFF.net0138
save XDUT.XLU04_0.XFF.net0152
save XDUT.XLU04_0.XFF.net093
save XDUT.XLU04_0.XFF.net103
save XDUT.XLU04_0.XFF.net176
save XDUT.XLU04_0.XFF.net184
save XDUT.XLU04_0.XFF.net208
save XDUT.XLU04_0.XFF.net212
save XDUT.XLU04_0.XFF.qf
save XDUT.XLU04_0.XFF.qf_x
save XDUT.XLU04_1.N0
save XDUT.XLU04_1.N1
save XDUT.XLU04_1.SB
save XDUT.XLU04_1.X001.XLIB.net10
save XDUT.XLU04_1.X002.XLIB.net10
save XDUT.XLU04_1.X003.XLIB.net10
save XDUT.XLU04_2.AB
save XDUT.XLU04_2.BB
save XDUT.XLU04_2.X002.XLIB.net10
save XDUT.XLU04_3.AB
save XDUT.XLU04_3.BB
save XDUT.XLU04_3.X002.XLIB.net10
save XDUT.XLU05_0.RN
save XDUT.XLU05_0.XFF.clkb
save XDUT.XLU05_0.XFF.clkbb
save XDUT.XLU05_0.XFF.mq
save XDUT.XLU05_0.XFF.mq_x
save XDUT.XLU05_0.XFF.net0138
save XDUT.XLU05_0.XFF.net0152
save XDUT.XLU05_0.XFF.net093
save XDUT.XLU05_0.XFF.net103
save XDUT.XLU05_0.XFF.net176
save XDUT.XLU05_0.XFF.net184
save XDUT.XLU05_0.XFF.net208
save XDUT.XLU05_0.XFF.net212
save XDUT.XLU05_0.XFF.qf
save XDUT.XLU05_0.XFF.qf_x
save XDUT.XLU05_1.N0
save XDUT.XLU05_1.N1
save XDUT.XLU05_1.SB
save XDUT.XLU05_1.X001.XLIB.net10
save XDUT.XLU05_1.X002.XLIB.net10
save XDUT.XLU05_1.X003.XLIB.net10
save XDUT.XLU05_2.AB
save XDUT.XLU05_2.BB
save XDUT.XLU05_2.X002.XLIB.net10
save XDUT.XLU05_3.AB
save XDUT.XLU05_3.BB
save XDUT.XLU05_3.X002.XLIB.net10
save XDUT.XLU06_0.RN
save XDUT.XLU06_0.XFF.clkb
save XDUT.XLU06_0.XFF.clkbb
save XDUT.XLU06_0.XFF.mq
save XDUT.XLU06_0.XFF.mq_x
save XDUT.XLU06_0.XFF.net0138
save XDUT.XLU06_0.XFF.net0152
save XDUT.XLU06_0.XFF.net093
save XDUT.XLU06_0.XFF.net103
save XDUT.XLU06_0.XFF.net176
save XDUT.XLU06_0.XFF.net184
save XDUT.XLU06_0.XFF.net208
save XDUT.XLU06_0.XFF.net212
save XDUT.XLU06_0.XFF.qf
save XDUT.XLU06_0.XFF.qf_x
save XDUT.XLU06_1.N0
save XDUT.XLU06_1.N1
save XDUT.XLU06_1.SB
save XDUT.XLU06_1.X001.XLIB.net10
save XDUT.XLU06_1.X002.XLIB.net10
save XDUT.XLU06_1.X003.XLIB.net10
save XDUT.XLU06_2.AB
save XDUT.XLU06_2.BB
save XDUT.XLU06_2.X002.XLIB.net10
save XDUT.XLU06_3.AB
save XDUT.XLU06_3.BB
save XDUT.XLU06_3.X002.XLIB.net10
save XDUT.XLU07_0.RN
save XDUT.XLU07_0.XFF.clkb
save XDUT.XLU07_0.XFF.clkbb
save XDUT.XLU07_0.XFF.mq
save XDUT.XLU07_0.XFF.mq_x
save XDUT.XLU07_0.XFF.net0138
save XDUT.XLU07_0.XFF.net0152
save XDUT.XLU07_0.XFF.net093
save XDUT.XLU07_0.XFF.net103
save XDUT.XLU07_0.XFF.net176
save XDUT.XLU07_0.XFF.net184
save XDUT.XLU07_0.XFF.net208
save XDUT.XLU07_0.XFF.net212
save XDUT.XLU07_0.XFF.qf
save XDUT.XLU07_0.XFF.qf_x
save XDUT.XLU07_1.N0
save XDUT.XLU07_1.N1
save XDUT.XLU07_1.SB
save XDUT.XLU07_1.X001.XLIB.net10
save XDUT.XLU07_1.X002.XLIB.net10
save XDUT.XLU07_1.X003.XLIB.net10
save XDUT.XLU07_2.AB
save XDUT.XLU07_2.BB
save XDUT.XLU07_2.X002.XLIB.net10
save XDUT.XLU07_3.AB
save XDUT.XLU07_3.BB
save XDUT.XLU07_3.X002.XLIB.net10
save XDUT.XLU09_0.N0
save XDUT.XLU09_0.N1
save XDUT.XLU09_0.SB
save XDUT.XLU09_0.X001.XLIB.net10
save XDUT.XLU09_0.X002.XLIB.net10
save XDUT.XLU09_0.X003.XLIB.net10
save XDUT.XLU09_1.AB
save XDUT.XLU09_1.BB
save XDUT.XLU09_1.X002.XLIB.net10
save XDUT.XLU09_2.N0
save XDUT.XLU09_2.N1
save XDUT.XLU09_2.SB
save XDUT.XLU09_2.X001.XLIB.net10
save XDUT.XLU09_2.X002.XLIB.net10
save XDUT.XLU09_2.X003.XLIB.net10
save XDUT.XLU10_0.N0
save XDUT.XLU10_0.N1
save XDUT.XLU10_0.SB
save XDUT.XLU10_0.X001.XLIB.net10
save XDUT.XLU10_0.X002.XLIB.net10
save XDUT.XLU10_0.X003.XLIB.net10
save XDUT.XLU10_1.AB
save XDUT.XLU10_1.BB
save XDUT.XLU10_1.X002.XLIB.net10
save XDUT.XLU10_2.N0
save XDUT.XLU10_2.N1
save XDUT.XLU10_2.SB
save XDUT.XLU10_2.X001.XLIB.net10
save XDUT.XLU10_2.X002.XLIB.net10
save XDUT.XLU10_2.X003.XLIB.net10
save XDUT.XLU11_0.N0
save XDUT.XLU11_0.N1
save XDUT.XLU11_0.SB
save XDUT.XLU11_0.X001.XLIB.net10
save XDUT.XLU11_0.X002.XLIB.net10
save XDUT.XLU11_0.X003.XLIB.net10
save XDUT.XLU11_1.AB
save XDUT.XLU11_1.BB
save XDUT.XLU11_1.X002.XLIB.net10
save XDUT.XLU11_2.N0
save XDUT.XLU11_2.N1
save XDUT.XLU11_2.SB
save XDUT.XLU11_2.X001.XLIB.net10
save XDUT.XLU11_2.X002.XLIB.net10
save XDUT.XLU11_2.X003.XLIB.net10
save XDUT.XLU12_0.N0
save XDUT.XLU12_0.N1
save XDUT.XLU12_0.SB
save XDUT.XLU12_0.X001.XLIB.net10
save XDUT.XLU12_0.X002.XLIB.net10
save XDUT.XLU12_0.X003.XLIB.net10
save XDUT.XLU12_1.AB
save XDUT.XLU12_1.BB
save XDUT.XLU12_1.X002.XLIB.net10
save XDUT.XLU12_2.N0
save XDUT.XLU12_2.N1
save XDUT.XLU12_2.SB
save XDUT.XLU12_2.X001.XLIB.net10
save XDUT.XLU12_2.X002.XLIB.net10
save XDUT.XLU12_2.X003.XLIB.net10
save XDUT.XLU13_0.N0
save XDUT.XLU13_0.N1
save XDUT.XLU13_0.SB
save XDUT.XLU13_0.X001.XLIB.net10
save XDUT.XLU13_0.X002.XLIB.net10
save XDUT.XLU13_0.X003.XLIB.net10
save XDUT.XLU13_1.AB
save XDUT.XLU13_1.BB
save XDUT.XLU13_1.X002.XLIB.net10
save XDUT.XLU13_2.N0
save XDUT.XLU13_2.N1
save XDUT.XLU13_2.SB
save XDUT.XLU13_2.X001.XLIB.net10
save XDUT.XLU13_2.X002.XLIB.net10
save XDUT.XLU13_2.X003.XLIB.net10
save XDUT.XLU14_0.N0
save XDUT.XLU14_0.N1
save XDUT.XLU14_0.SB
save XDUT.XLU14_0.X001.XLIB.net10
save XDUT.XLU14_0.X002.XLIB.net10
save XDUT.XLU14_0.X003.XLIB.net10
save XDUT.XLU14_1.AB
save XDUT.XLU14_1.BB
save XDUT.XLU14_1.X002.XLIB.net10
save XDUT.XLU14_2.N0
save XDUT.XLU14_2.N1
save XDUT.XLU14_2.SB
save XDUT.XLU14_2.X001.XLIB.net10
save XDUT.XLU14_2.X002.XLIB.net10
save XDUT.XLU14_2.X003.XLIB.net10
save XDUT.XLU15_0.N0
save XDUT.XLU15_0.N1
save XDUT.XLU15_0.SB
save XDUT.XLU15_0.X001.XLIB.net10
save XDUT.XLU15_0.X002.XLIB.net10
save XDUT.XLU15_0.X003.XLIB.net10
save XDUT.XLU15_1.AB
save XDUT.XLU15_1.BB
save XDUT.XLU15_1.X002.XLIB.net10
save XDUT.XLU15_2.N0
save XDUT.XLU15_2.N1
save XDUT.XLU15_2.SB
save XDUT.XLU15_2.X001.XLIB.net10
save XDUT.XLU15_2.X002.XLIB.net10
save XDUT.XLU15_2.X003.XLIB.net10
save XDUT.XLU16_0.N0
save XDUT.XLU16_0.N1
save XDUT.XLU16_0.SB
save XDUT.XLU16_0.X001.XLIB.net10
save XDUT.XLU16_0.X002.XLIB.net10
save XDUT.XLU16_0.X003.XLIB.net10
save XDUT.XLU16_1.AB
save XDUT.XLU16_1.BB
save XDUT.XLU16_1.X002.XLIB.net10
save XDUT.XLU16_2.N0
save XDUT.XLU16_2.N1
save XDUT.XLU16_2.SB
save XDUT.XLU16_2.X001.XLIB.net10
save XDUT.XLU16_2.X002.XLIB.net10
save XDUT.XLU16_2.X003.XLIB.net10
save XDUT.XLU17_0.AB
save XDUT.XLU17_0.B
save XDUT.XLU17_0.C0:1
save XDUT.XLU17_0.C1:1
save XDUT.XLU17_0.MN_CLEAR:1
save XDUT.XLU17_0.MP_CLEAR:1
save XDUT.XLU17_0.R0:1
save XDUT.XLU17_0.R1:1
save XDUT.XLU17_0.RC0
save XDUT.XLU17_0.RC1
save XDUT.XLU19_1.AB
save XDUT.XLU19_1.B
save XDUT.XLU19_1.C0:1
save XDUT.XLU19_1.C1:1
save XDUT.XLU19_1.MN_CLEAR:1
save XDUT.XLU19_1.MP_CLEAR:1
save XDUT.XLU19_1.R0:1
save XDUT.XLU19_1.R1:1
save XDUT.XLU19_1.RC0
save XDUT.XLU19_1.RC1
save XDUT.XLU19_2.N
save XDUT.XLU19_2.X000.XLIB.net10
save XDUT.XLU20_1.AB
save XDUT.XLU20_1.B
save XDUT.XLU20_1.C0:1
save XDUT.XLU20_1.C1:1
save XDUT.XLU20_1.MN_CLEAR:1
save XDUT.XLU20_1.MP_CLEAR:1
save XDUT.XLU20_1.R0:1
save XDUT.XLU20_1.R1:1
save XDUT.XLU20_1.RC0
save XDUT.XLU20_1.RC1
save XDUT.XLU20_2.N
save XDUT.XLU20_2.X000.XLIB.net10
save XDUT.XLU21_1.AB
save XDUT.XLU21_1.B
save XDUT.XLU21_1.C0:1
save XDUT.XLU21_1.C1:1
save XDUT.XLU21_1.MN_CLEAR:1
save XDUT.XLU21_1.MP_CLEAR:1
save XDUT.XLU21_1.R0:1
save XDUT.XLU21_1.R1:1
save XDUT.XLU21_1.RC0
save XDUT.XLU21_1.RC1
save XDUT.XLU21_2.N
save XDUT.XLU21_2.X000.XLIB.net10
save XDUT.XLU22_1.AB
save XDUT.XLU22_1.B
save XDUT.XLU22_1.C0:1
save XDUT.XLU22_1.C1:1
save XDUT.XLU22_1.MN_CLEAR:1
save XDUT.XLU22_1.MP_CLEAR:1
save XDUT.XLU22_1.R0:1
save XDUT.XLU22_1.R1:1
save XDUT.XLU22_1.RC0
save XDUT.XLU22_1.RC1
save XDUT.XLU22_2.N
save XDUT.XLU22_2.X000.XLIB.net10
save XDUT.XLU23_1.AB
save XDUT.XLU23_1.B
save XDUT.XLU23_1.C0:1
save XDUT.XLU23_1.C1:1
save XDUT.XLU23_1.MN_CLEAR:1
save XDUT.XLU23_1.MP_CLEAR:1
save XDUT.XLU23_1.R0:1
save XDUT.XLU23_1.R1:1
save XDUT.XLU23_1.RC0
save XDUT.XLU23_1.RC1
save XDUT.XLU23_2.N
save XDUT.XLU23_2.X000.XLIB.net10
save XDUT.XLU24_1.AB
save XDUT.XLU24_1.B
save XDUT.XLU24_1.C0:1
save XDUT.XLU24_1.C1:1
save XDUT.XLU24_1.MN_CLEAR:1
save XDUT.XLU24_1.MP_CLEAR:1
save XDUT.XLU24_1.R0:1
save XDUT.XLU24_1.R1:1
save XDUT.XLU24_1.RC0
save XDUT.XLU24_1.RC1
save XDUT.XLU24_2.N
save XDUT.XLU24_2.X000.XLIB.net10
save XDUT.XLU25_1.AB
save XDUT.XLU25_1.B
save XDUT.XLU25_1.C0:1
save XDUT.XLU25_1.C1:1
save XDUT.XLU25_1.MN_CLEAR:1
save XDUT.XLU25_1.MP_CLEAR:1
save XDUT.XLU25_1.R0:1
save XDUT.XLU25_1.R1:1
save XDUT.XLU25_1.RC0
save XDUT.XLU25_1.RC1
save XDUT.XLU25_2.N
save XDUT.XLU25_2.X000.XLIB.net10
save XDUT.XRU00.AB
save XDUT.XRU00.BB
save XDUT.XRU00.X002.XLIB.net10
save XDUT.XRU01.N
save XDUT.XRU02.N
save XDUT.XRU03.N
save XDUT.XRU04.N
save XDUT.XRU05.N
save XDUT.XRU06.N
save XDUT.XRU07.N
save XDUT.XRU08.N
save XDUT.XRU09.N
save XDUT.XRU10.N
save XDUT.XRU11.N
save XDUT.XRU12.N
save XDUT.XRU13.N
save XDUT.XRU14.N
save XDUT.XRU15.N
save XDUT.XRU16.N
save XDUT.XRU17.AB
save XDUT.XRU17.BB
save XDUT.XRU17.X002.XLIB.net10
save XDUT.XRU18.N
save XDUT.XRU19.N
save XDUT.XRU20.N
save XDUT.XRU21.N
save XDUT.XRU22.N
save XDUT.XRU23.N
save XDUT.XRU24.N
save XDUT.XRU25.N
save XDUT.XSU00.N
save XDUT.XSU00.X000.XLIB.net10
save XDUT.XSU17.N
save XDUT.XSU17.X000.XLIB.net10
save XDUT.XU00.CQB:1
save XDUT.XU00.QB
save XDUT.XU00.RB
save XDUT.XU00.SN
save XDUT.XU00.X000.XLIB.MM0:1
save XDUT.XU00.X000.XLIB.MM1:1
save XDUT.XU00.X001.XLIB.MM1:1
save XDUT.XU00.X001.XLIB.MM2:1
save XDUT.XU00.X001.XLIB.MM4:1
save XDUT.XU00.X001.XLIB.MM9:1
save XDUT.XU00.X001.XLIB.net10
save XDUT.XU00.X002.XLIB.MM1:1
save XDUT.XU00.X002.XLIB.MM2:1
save XDUT.XU00.X002.XLIB.MM4:1
save XDUT.XU00.X002.XLIB.MM4:3
save XDUT.XU00.X002.XLIB.MM9:1
save XDUT.XU00.X002.XLIB.net10
save XDUT.XU00.X003.XLIB.MM1:1
save XDUT.XU00.X003.XLIB.MM2:1
save XDUT.XU00.X003.XLIB.MM4:1
save XDUT.XU00.X003.XLIB.MM4:3
save XDUT.XU00.X003.XLIB.MM9:1
save XDUT.XU00.X003.XLIB.net10
save XDUT.XU01.RN
save XDUT.XU01.XFF.clkb
save XDUT.XU01.XFF.clkbb
save XDUT.XU01.XFF.mq
save XDUT.XU01.XFF.mq_x
save XDUT.XU01.XFF.net0138
save XDUT.XU01.XFF.net0152
save XDUT.XU01.XFF.net093
save XDUT.XU01.XFF.net103
save XDUT.XU01.XFF.net176
save XDUT.XU01.XFF.net184
save XDUT.XU01.XFF.net208
save XDUT.XU01.XFF.net212
save XDUT.XU01.XFF.qf
save XDUT.XU01.XFF.qf_x
save XDUT.XU02.RN
save XDUT.XU02.XFF.clkb
save XDUT.XU02.XFF.clkbb
save XDUT.XU02.XFF.mq
save XDUT.XU02.XFF.mq_x
save XDUT.XU02.XFF.net0138
save XDUT.XU02.XFF.net0152
save XDUT.XU02.XFF.net093
save XDUT.XU02.XFF.net103
save XDUT.XU02.XFF.net176
save XDUT.XU02.XFF.net184
save XDUT.XU02.XFF.net208
save XDUT.XU02.XFF.net212
save XDUT.XU02.XFF.qf
save XDUT.XU02.XFF.qf_x
save XDUT.XU03.RN
save XDUT.XU03.XFF.clkb
save XDUT.XU03.XFF.clkbb
save XDUT.XU03.XFF.mq
save XDUT.XU03.XFF.mq_x
save XDUT.XU03.XFF.net0138
save XDUT.XU03.XFF.net0152
save XDUT.XU03.XFF.net093
save XDUT.XU03.XFF.net103
save XDUT.XU03.XFF.net176
save XDUT.XU03.XFF.net184
save XDUT.XU03.XFF.net208
save XDUT.XU03.XFF.net212
save XDUT.XU03.XFF.qf
save XDUT.XU03.XFF.qf_x
save XDUT.XU04.RN
save XDUT.XU04.XFF.clkb
save XDUT.XU04.XFF.clkbb
save XDUT.XU04.XFF.mq
save XDUT.XU04.XFF.mq_x
save XDUT.XU04.XFF.net0138
save XDUT.XU04.XFF.net0152
save XDUT.XU04.XFF.net093
save XDUT.XU04.XFF.net103
save XDUT.XU04.XFF.net176
save XDUT.XU04.XFF.net184
save XDUT.XU04.XFF.net208
save XDUT.XU04.XFF.net212
save XDUT.XU04.XFF.qf
save XDUT.XU04.XFF.qf_x
save XDUT.XU05.RN
save XDUT.XU05.XFF.clkb
save XDUT.XU05.XFF.clkbb
save XDUT.XU05.XFF.mq
save XDUT.XU05.XFF.mq_x
save XDUT.XU05.XFF.net0138
save XDUT.XU05.XFF.net0152
save XDUT.XU05.XFF.net093
save XDUT.XU05.XFF.net103
save XDUT.XU05.XFF.net176
save XDUT.XU05.XFF.net184
save XDUT.XU05.XFF.net208
save XDUT.XU05.XFF.net212
save XDUT.XU05.XFF.qf
save XDUT.XU05.XFF.qf_x
save XDUT.XU06.RN
save XDUT.XU06.XFF.clkb
save XDUT.XU06.XFF.clkbb
save XDUT.XU06.XFF.mq
save XDUT.XU06.XFF.mq_x
save XDUT.XU06.XFF.net0138
save XDUT.XU06.XFF.net0152
save XDUT.XU06.XFF.net093
save XDUT.XU06.XFF.net103
save XDUT.XU06.XFF.net176
save XDUT.XU06.XFF.net184
save XDUT.XU06.XFF.net208
save XDUT.XU06.XFF.net212
save XDUT.XU06.XFF.qf
save XDUT.XU06.XFF.qf_x
save XDUT.XU07.RN
save XDUT.XU07.XFF.clkb
save XDUT.XU07.XFF.clkbb
save XDUT.XU07.XFF.mq
save XDUT.XU07.XFF.mq_x
save XDUT.XU07.XFF.net0138
save XDUT.XU07.XFF.net0152
save XDUT.XU07.XFF.net093
save XDUT.XU07.XFF.net103
save XDUT.XU07.XFF.net176
save XDUT.XU07.XFF.net184
save XDUT.XU07.XFF.net208
save XDUT.XU07.XFF.net212
save XDUT.XU07.XFF.qf
save XDUT.XU07.XFF.qf_x
save XDUT.XU08.RN
save XDUT.XU08.XFF.clkb
save XDUT.XU08.XFF.clkbb
save XDUT.XU08.XFF.mq
save XDUT.XU08.XFF.mq_x
save XDUT.XU08.XFF.net0138
save XDUT.XU08.XFF.net0152
save XDUT.XU08.XFF.net093
save XDUT.XU08.XFF.net103
save XDUT.XU08.XFF.net176
save XDUT.XU08.XFF.net184
save XDUT.XU08.XFF.net208
save XDUT.XU08.XFF.net212
save XDUT.XU08.XFF.qf
save XDUT.XU08.XFF.qf_x
save XDUT.XU09.RN
save XDUT.XU09.XFF.clkb
save XDUT.XU09.XFF.clkbb
save XDUT.XU09.XFF.mq
save XDUT.XU09.XFF.mq_x
save XDUT.XU09.XFF.net0138
save XDUT.XU09.XFF.net0152
save XDUT.XU09.XFF.net093
save XDUT.XU09.XFF.net103
save XDUT.XU09.XFF.net176
save XDUT.XU09.XFF.net184
save XDUT.XU09.XFF.net208
save XDUT.XU09.XFF.net212
save XDUT.XU09.XFF.qf
save XDUT.XU09.XFF.qf_x
save XDUT.XU10.RN
save XDUT.XU10.XFF.clkb
save XDUT.XU10.XFF.clkbb
save XDUT.XU10.XFF.mq
save XDUT.XU10.XFF.mq_x
save XDUT.XU10.XFF.net0138
save XDUT.XU10.XFF.net0152
save XDUT.XU10.XFF.net093
save XDUT.XU10.XFF.net103
save XDUT.XU10.XFF.net176
save XDUT.XU10.XFF.net184
save XDUT.XU10.XFF.net208
save XDUT.XU10.XFF.net212
save XDUT.XU10.XFF.qf
save XDUT.XU10.XFF.qf_x
save XDUT.XU11.RN
save XDUT.XU11.XFF.clkb
save XDUT.XU11.XFF.clkbb
save XDUT.XU11.XFF.mq
save XDUT.XU11.XFF.mq_x
save XDUT.XU11.XFF.net0138
save XDUT.XU11.XFF.net0152
save XDUT.XU11.XFF.net093
save XDUT.XU11.XFF.net103
save XDUT.XU11.XFF.net176
save XDUT.XU11.XFF.net184
save XDUT.XU11.XFF.net208
save XDUT.XU11.XFF.net212
save XDUT.XU11.XFF.qf
save XDUT.XU11.XFF.qf_x
save XDUT.XU12.RN
save XDUT.XU12.XFF.clkb
save XDUT.XU12.XFF.clkbb
save XDUT.XU12.XFF.mq
save XDUT.XU12.XFF.mq_x
save XDUT.XU12.XFF.net0138
save XDUT.XU12.XFF.net0152
save XDUT.XU12.XFF.net093
save XDUT.XU12.XFF.net103
save XDUT.XU12.XFF.net176
save XDUT.XU12.XFF.net184
save XDUT.XU12.XFF.net208
save XDUT.XU12.XFF.net212
save XDUT.XU12.XFF.qf
save XDUT.XU12.XFF.qf_x
save XDUT.XU13.RN
save XDUT.XU13.XFF.clkb
save XDUT.XU13.XFF.clkbb
save XDUT.XU13.XFF.mq
save XDUT.XU13.XFF.mq_x
save XDUT.XU13.XFF.net0138
save XDUT.XU13.XFF.net0152
save XDUT.XU13.XFF.net093
save XDUT.XU13.XFF.net103
save XDUT.XU13.XFF.net176
save XDUT.XU13.XFF.net184
save XDUT.XU13.XFF.net208
save XDUT.XU13.XFF.net212
save XDUT.XU13.XFF.qf
save XDUT.XU13.XFF.qf_x
save XDUT.XU14.RN
save XDUT.XU14.XFF.clkb
save XDUT.XU14.XFF.clkbb
save XDUT.XU14.XFF.mq
save XDUT.XU14.XFF.mq_x
save XDUT.XU14.XFF.net0138
save XDUT.XU14.XFF.net0152
save XDUT.XU14.XFF.net093
save XDUT.XU14.XFF.net103
save XDUT.XU14.XFF.net176
save XDUT.XU14.XFF.net184
save XDUT.XU14.XFF.net208
save XDUT.XU14.XFF.net212
save XDUT.XU14.XFF.qf
save XDUT.XU14.XFF.qf_x
save XDUT.XU15.RN
save XDUT.XU15.XFF.clkb
save XDUT.XU15.XFF.clkbb
save XDUT.XU15.XFF.mq
save XDUT.XU15.XFF.mq_x
save XDUT.XU15.XFF.net0138
save XDUT.XU15.XFF.net0152
save XDUT.XU15.XFF.net093
save XDUT.XU15.XFF.net103
save XDUT.XU15.XFF.net176
save XDUT.XU15.XFF.net184
save XDUT.XU15.XFF.net208
save XDUT.XU15.XFF.net212
save XDUT.XU15.XFF.qf
save XDUT.XU15.XFF.qf_x
save XDUT.XU16.RN
save XDUT.XU16.XFF.clkb
save XDUT.XU16.XFF.clkbb
save XDUT.XU16.XFF.mq
save XDUT.XU16.XFF.mq_x
save XDUT.XU16.XFF.net0138
save XDUT.XU16.XFF.net0152
save XDUT.XU16.XFF.net093
save XDUT.XU16.XFF.net103
save XDUT.XU16.XFF.net176
save XDUT.XU16.XFF.net184
save XDUT.XU16.XFF.net208
save XDUT.XU16.XFF.net212
save XDUT.XU16.XFF.qf
save XDUT.XU16.XFF.qf_x
save XDUT.XU17.CQB:1
save XDUT.XU17.QB
save XDUT.XU17.RB
save XDUT.XU17.SN
save XDUT.XU17.X000.XLIB.MM0:1
save XDUT.XU17.X000.XLIB.MM1:1
save XDUT.XU17.X001.XLIB.MM1:1
save XDUT.XU17.X001.XLIB.MM2:1
save XDUT.XU17.X001.XLIB.MM4:1
save XDUT.XU17.X001.XLIB.MM9:1
save XDUT.XU17.X001.XLIB.net10
save XDUT.XU17.X002.XLIB.MM1:1
save XDUT.XU17.X002.XLIB.MM2:1
save XDUT.XU17.X002.XLIB.MM4:1
save XDUT.XU17.X002.XLIB.MM4:3
save XDUT.XU17.X002.XLIB.MM9:1
save XDUT.XU17.X002.XLIB.net10
save XDUT.XU17.X003.XLIB.MM1:1
save XDUT.XU17.X003.XLIB.MM2:1
save XDUT.XU17.X003.XLIB.MM4:1
save XDUT.XU17.X003.XLIB.MM4:3
save XDUT.XU17.X003.XLIB.MM9:1
save XDUT.XU17.X003.XLIB.net10
save XDUT.XU18.RN
save XDUT.XU18.XFF.clkb
save XDUT.XU18.XFF.clkbb
save XDUT.XU18.XFF.mq
save XDUT.XU18.XFF.mq_x
save XDUT.XU18.XFF.net0138
save XDUT.XU18.XFF.net0152
save XDUT.XU18.XFF.net093
save XDUT.XU18.XFF.net103
save XDUT.XU18.XFF.net176
save XDUT.XU18.XFF.net184
save XDUT.XU18.XFF.net208
save XDUT.XU18.XFF.net212
save XDUT.XU18.XFF.qf
save XDUT.XU18.XFF.qf_x
save XDUT.XU19.RN
save XDUT.XU19.XFF.clkb
save XDUT.XU19.XFF.clkbb
save XDUT.XU19.XFF.mq
save XDUT.XU19.XFF.mq_x
save XDUT.XU19.XFF.net0138
save XDUT.XU19.XFF.net0152
save XDUT.XU19.XFF.net093
save XDUT.XU19.XFF.net103
save XDUT.XU19.XFF.net176
save XDUT.XU19.XFF.net184
save XDUT.XU19.XFF.net208
save XDUT.XU19.XFF.net212
save XDUT.XU19.XFF.qf
save XDUT.XU19.XFF.qf_x
save XDUT.XU20.RN
save XDUT.XU20.XFF.clkb
save XDUT.XU20.XFF.clkbb
save XDUT.XU20.XFF.mq
save XDUT.XU20.XFF.mq_x
save XDUT.XU20.XFF.net0138
save XDUT.XU20.XFF.net0152
save XDUT.XU20.XFF.net093
save XDUT.XU20.XFF.net103
save XDUT.XU20.XFF.net176
save XDUT.XU20.XFF.net184
save XDUT.XU20.XFF.net208
save XDUT.XU20.XFF.net212
save XDUT.XU20.XFF.qf
save XDUT.XU20.XFF.qf_x
save XDUT.XU21.RN
save XDUT.XU21.XFF.clkb
save XDUT.XU21.XFF.clkbb
save XDUT.XU21.XFF.mq
save XDUT.XU21.XFF.mq_x
save XDUT.XU21.XFF.net0138
save XDUT.XU21.XFF.net0152
save XDUT.XU21.XFF.net093
save XDUT.XU21.XFF.net103
save XDUT.XU21.XFF.net176
save XDUT.XU21.XFF.net184
save XDUT.XU21.XFF.net208
save XDUT.XU21.XFF.net212
save XDUT.XU21.XFF.qf
save XDUT.XU21.XFF.qf_x
save XDUT.XU22.RN
save XDUT.XU22.XFF.clkb
save XDUT.XU22.XFF.clkbb
save XDUT.XU22.XFF.mq
save XDUT.XU22.XFF.mq_x
save XDUT.XU22.XFF.net0138
save XDUT.XU22.XFF.net0152
save XDUT.XU22.XFF.net093
save XDUT.XU22.XFF.net103
save XDUT.XU22.XFF.net176
save XDUT.XU22.XFF.net184
save XDUT.XU22.XFF.net208
save XDUT.XU22.XFF.net212
save XDUT.XU22.XFF.qf
save XDUT.XU22.XFF.qf_x
save XDUT.XU23.RN
save XDUT.XU23.XFF.clkb
save XDUT.XU23.XFF.clkbb
save XDUT.XU23.XFF.mq
save XDUT.XU23.XFF.mq_x
save XDUT.XU23.XFF.net0138
save XDUT.XU23.XFF.net0152
save XDUT.XU23.XFF.net093
save XDUT.XU23.XFF.net103
save XDUT.XU23.XFF.net176
save XDUT.XU23.XFF.net184
save XDUT.XU23.XFF.net208
save XDUT.XU23.XFF.net212
save XDUT.XU23.XFF.qf
save XDUT.XU23.XFF.qf_x
save XDUT.XU24.RN
save XDUT.XU24.XFF.clkb
save XDUT.XU24.XFF.clkbb
save XDUT.XU24.XFF.mq
save XDUT.XU24.XFF.mq_x
save XDUT.XU24.XFF.net0138
save XDUT.XU24.XFF.net0152
save XDUT.XU24.XFF.net093
save XDUT.XU24.XFF.net103
save XDUT.XU24.XFF.net176
save XDUT.XU24.XFF.net184
save XDUT.XU24.XFF.net208
save XDUT.XU24.XFF.net212
save XDUT.XU24.XFF.qf
save XDUT.XU24.XFF.qf_x
save XDUT.XU25.RN
save XDUT.XU25.XFF.clkb
save XDUT.XU25.XFF.clkbb
save XDUT.XU25.XFF.mq
save XDUT.XU25.XFF.mq_x
save XDUT.XU25.XFF.net0138
save XDUT.XU25.XFF.net0152
save XDUT.XU25.XFF.net093
save XDUT.XU25.XFF.net103
save XDUT.XU25.XFF.net176
save XDUT.XU25.XFF.net184
save XDUT.XU25.XFF.net208
save XDUT.XU25.XFF.net212
save XDUT.XU25.XFF.qf
save XDUT.XU25.XFF.qf_x
