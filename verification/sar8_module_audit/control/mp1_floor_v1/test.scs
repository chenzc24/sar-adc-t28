// One added positive-floor branch, unchanged external sampling/supply.
// Local suppression experiment: one copied PDK poly resistor in X020 MP1 gate.
// First-event isolation only: native device/geometry preserved.
simulator lang=spectre
global 0 VDD!
include "/home/process/tsmc28n/PDK_mmWave/iPDK_CRN28HPC+ULL_v1.8_2p2a_20190531/tsmcN28/../models/spectre/crn28ull_1d8_elk_v1d8_2p2_shrink0d9_embedded_usage.scs" section=pre_simu
include "/home/process/tsmc28n/PDK_mmWave/iPDK_CRN28HPC+ULL_v1.8_2p2a_20190531/tsmcN28/../models/spectre/crn28ull_1d8_elk_v1d8_2p2_shrink0d9_embedded_usage.scs" section=noise_worst
include "/home/process/tsmc28n/PDK_mmWave/iPDK_CRN28HPC+ULL_v1.8_2p2a_20190531/tsmcN28/../models/spectre/crn28ull_1d8_elk_v1d8_2p2_shrink0d9_embedded_usage.scs" section=ffmacro_mos_moscap
include "/home/process/tsmc28n/PDK_mmWave/iPDK_CRN28HPC+ULL_v1.8_2p2a_20190531/tsmcN28/../models/spectre/crn28ull_1d8_elk_v1d8_2p2_shrink0d9_embedded_usage.scs" section=tt_res_bip_dio_disres
include "/home/process/tsmc28n/PDK_mmWave/iPDK_CRN28HPC+ULL_v1.8_2p2a_20190531/tsmcN28/../models/spectre/crn28ull_1d8_elk_v1d8_2p2_shrink0d9_embedded_usage.scs" section=tt_mom
include "/home/process/tsmc28n/PDK_mmWave/iPDK_CRN28HPC+ULL_v1.8_2p2a_20190531/tsmcN28/../models/spectre/crn28ull_1d8_elk_v1d8_2p2_shrink0d9_embedded_usage.scs" section=tt_ind_jvar
include "/home/process/tsmc28n/PDK_mmWave/iPDK_CRN28HPC+ULL_v1.8_2p2a_20190531/tsmcN28/../models/spectre/crn28ull_1d8_elk_v1d8_2p2_shrink0d9_embedded_usage.scs" section=tt_r_metal
include "dut.scs"
VVDD (VDD! 0) vsource dc=0.99 type=dc
XDUT (VDD! 0) sar8audit_ctrl_first_event
simulatorOptions options psfversion="1.4.0" method=gear2only reltol=1e-6 vabstol=1e-8 iabstol=1e-13 temp=-40 tnom=27 scalem=1 scale=1 gmin=1e-12 rforce=1 maxnotes=5 maxwarns=5 digits=5 cols=80 pivrel=1e-3 checklimitdest=psf
saveOptions options save=selected currents=selected subcktiprobes=no useprobes=no
tran_first tran stop=4.1590785650590448e-08 maxstep=10p errpreset=conservative lteratio=10
save VDD!
save VVDD:1
save XDUT.ACTIVE
save XDUT.CL_CMP_CLK:1
save XDUT.CL_COMP_N:1
save XDUT.CL_COMP_P:1
save XDUT.CMP_CLK
save XDUT.COMP_N
save XDUT.COMP_P
save XDUT.PHI_U
save XDUT.SAMPLE_INT
save XDUT.TOPN
save XDUT.TOPP
save XDUT.VREPLAY_ACTIVE:1
save XDUT.VREPLAY_PHI_U:1
save XDUT.VREPLAY_SAMPLE_INT:1
save XDUT.VREPLAY_TOPN:1
save XDUT.VREPLAY_TOPP:1
save XDUT.XCOMP.MNINN:1
save XDUT.XCOMP.MNINN:2
save XDUT.XCOMP.MNINN:3
save XDUT.XCOMP.MNINN:4
save XDUT.XCOMP.MNINP:1
save XDUT.XCOMP.MNINP:2
save XDUT.XCOMP.MNINP:3
save XDUT.XCOMP.MNINP:4
save XDUT.XCOMP.MNLATN:1
save XDUT.XCOMP.MNLATN:2
save XDUT.XCOMP.MNLATN:3
save XDUT.XCOMP.MNLATN:4
save XDUT.XCOMP.MNLATP:1
save XDUT.XCOMP.MNLATP:2
save XDUT.XCOMP.MNLATP:3
save XDUT.XCOMP.MNLATP:4
save XDUT.XCOMP.MNTAIL:1
save XDUT.XCOMP.MNTAIL:2
save XDUT.XCOMP.MNTAIL:3
save XDUT.XCOMP.MNTAIL:4
save XDUT.XCOMP.MPLATN:1
save XDUT.XCOMP.MPLATN:2
save XDUT.XCOMP.MPLATN:3
save XDUT.XCOMP.MPLATN:4
save XDUT.XCOMP.MPLATP:1
save XDUT.XCOMP.MPLATP:2
save XDUT.XCOMP.MPLATP:3
save XDUT.XCOMP.MPLATP:4
save XDUT.XCOMP.MPRSTN:1
save XDUT.XCOMP.MPRSTN:2
save XDUT.XCOMP.MPRSTN:3
save XDUT.XCOMP.MPRSTN:4
save XDUT.XCOMP.MPRSTP:1
save XDUT.XCOMP.MPRSTP:2
save XDUT.XCOMP.MPRSTP:3
save XDUT.XCOMP.MPRSTP:4
save XDUT.XCOMP.MPRSTX:1
save XDUT.XCOMP.MPRSTX:2
save XDUT.XCOMP.MPRSTX:3
save XDUT.XCOMP.MPRSTX:4
save XDUT.XCOMP.MPRSTY:1
save XDUT.XCOMP.MPRSTY:2
save XDUT.XCOMP.MPRSTY:3
save XDUT.XCOMP.MPRSTY:4
save XDUT.XCOMP.TAIL
save XDUT.XCOMP.X
save XDUT.XCOMP.Y
save XDUT.XCTRL.PHI_W
save XDUT.XCTRL.VREPLAY_PHI_W:1
save XDUT.XCTRL.XTIM.CLOCK_Q
save XDUT.XCTRL.XTIM.CLOCK_RESET
save XDUT.XCTRL.XTIM.CLOCK_SET
save XDUT.XCTRL.XTIM.CN
save XDUT.XCTRL.XTIM.DEC
save XDUT.XCTRL.XTIM.LIVE
save XDUT.XCTRL.XTIM.NR
save XDUT.XCTRL.XTIM.PR
save XDUT.XCTRL.XTIM.Q0
save XDUT.XCTRL.XTIM.Q1
save XDUT.XCTRL.XTIM.QUIET
save XDUT.XCTRL.XTIM.QUIET_D
save XDUT.XCTRL.XTIM.SN
save XDUT.XCTRL.XTIM.UN
save XDUT.XCTRL.XTIM.VREPLAY_DEC:1
save XDUT.XCTRL.XTIM.WD
save XDUT.XCTRL.XTIM.WN
save XDUT.XCTRL.XTIM.X000.MN:1
save XDUT.XCTRL.XTIM.X000.MN:2
save XDUT.XCTRL.XTIM.X000.MN:3
save XDUT.XCTRL.XTIM.X000.MN:4
save XDUT.XCTRL.XTIM.X000.MP:1
save XDUT.XCTRL.XTIM.X000.MP:2
save XDUT.XCTRL.XTIM.X000.MP:3
save XDUT.XCTRL.XTIM.X000.MP:4
save XDUT.XCTRL.XTIM.X001.N
save XDUT.XCTRL.XTIM.X001.X000.CMID:1
save XDUT.XCTRL.XTIM.X001.X000.MID
save XDUT.XCTRL.XTIM.X001.X000.MN0:1
save XDUT.XCTRL.XTIM.X001.X000.MN0:2
save XDUT.XCTRL.XTIM.X001.X000.MN0:3
save XDUT.XCTRL.XTIM.X001.X000.MN0:4
save XDUT.XCTRL.XTIM.X001.X000.MN1:1
save XDUT.XCTRL.XTIM.X001.X000.MN1:2
save XDUT.XCTRL.XTIM.X001.X000.MN1:3
save XDUT.XCTRL.XTIM.X001.X000.MN1:4
save XDUT.XCTRL.XTIM.X001.X000.MP0:1
save XDUT.XCTRL.XTIM.X001.X000.MP0:2
save XDUT.XCTRL.XTIM.X001.X000.MP0:3
save XDUT.XCTRL.XTIM.X001.X000.MP0:4
save XDUT.XCTRL.XTIM.X001.X000.MP1:1
save XDUT.XCTRL.XTIM.X001.X000.MP1:2
save XDUT.XCTRL.XTIM.X001.X000.MP1:3
save XDUT.XCTRL.XTIM.X001.X000.MP1:4
save XDUT.XCTRL.XTIM.X001.X001.MN:1
save XDUT.XCTRL.XTIM.X001.X001.MN:2
save XDUT.XCTRL.XTIM.X001.X001.MN:3
save XDUT.XCTRL.XTIM.X001.X001.MN:4
save XDUT.XCTRL.XTIM.X001.X001.MP:1
save XDUT.XCTRL.XTIM.X001.X001.MP:2
save XDUT.XCTRL.XTIM.X001.X001.MP:3
save XDUT.XCTRL.XTIM.X001.X001.MP:4
save XDUT.XCTRL.XTIM.X002.N
save XDUT.XCTRL.XTIM.X002.X000.MN:1
save XDUT.XCTRL.XTIM.X002.X000.MN:2
save XDUT.XCTRL.XTIM.X002.X000.MN:3
save XDUT.XCTRL.XTIM.X002.X000.MN:4
save XDUT.XCTRL.XTIM.X002.X000.MP:1
save XDUT.XCTRL.XTIM.X002.X000.MP:2
save XDUT.XCTRL.XTIM.X002.X000.MP:3
save XDUT.XCTRL.XTIM.X002.X000.MP:4
save XDUT.XCTRL.XTIM.X002.X001.MN:1
save XDUT.XCTRL.XTIM.X002.X001.MN:2
save XDUT.XCTRL.XTIM.X002.X001.MN:3
save XDUT.XCTRL.XTIM.X002.X001.MN:4
save XDUT.XCTRL.XTIM.X002.X001.MP:1
save XDUT.XCTRL.XTIM.X002.X001.MP:2
save XDUT.XCTRL.XTIM.X002.X001.MP:3
save XDUT.XCTRL.XTIM.X002.X001.MP:4
save XDUT.XCTRL.XTIM.X003.N
save XDUT.XCTRL.XTIM.X003.X000.MN:1
save XDUT.XCTRL.XTIM.X003.X000.MN:2
save XDUT.XCTRL.XTIM.X003.X000.MN:3
save XDUT.XCTRL.XTIM.X003.X000.MN:4
save XDUT.XCTRL.XTIM.X003.X000.MP:1
save XDUT.XCTRL.XTIM.X003.X000.MP:2
save XDUT.XCTRL.XTIM.X003.X000.MP:3
save XDUT.XCTRL.XTIM.X003.X000.MP:4
save XDUT.XCTRL.XTIM.X003.X001.MN:1
save XDUT.XCTRL.XTIM.X003.X001.MN:2
save XDUT.XCTRL.XTIM.X003.X001.MN:3
save XDUT.XCTRL.XTIM.X003.X001.MN:4
save XDUT.XCTRL.XTIM.X003.X001.MP:1
save XDUT.XCTRL.XTIM.X003.X001.MP:2
save XDUT.XCTRL.XTIM.X003.X001.MP:3
save XDUT.XCTRL.XTIM.X003.X001.MP:4
save XDUT.XCTRL.XTIM.X009.N
save XDUT.XCTRL.XTIM.X009.X000.CMID:1
save XDUT.XCTRL.XTIM.X009.X000.MID
save XDUT.XCTRL.XTIM.X009.X000.MN0:1
save XDUT.XCTRL.XTIM.X009.X000.MN0:2
save XDUT.XCTRL.XTIM.X009.X000.MN0:3
save XDUT.XCTRL.XTIM.X009.X000.MN0:4
save XDUT.XCTRL.XTIM.X009.X000.MN1:1
save XDUT.XCTRL.XTIM.X009.X000.MN1:2
save XDUT.XCTRL.XTIM.X009.X000.MN1:3
save XDUT.XCTRL.XTIM.X009.X000.MN1:4
save XDUT.XCTRL.XTIM.X009.X000.MP0:1
save XDUT.XCTRL.XTIM.X009.X000.MP0:2
save XDUT.XCTRL.XTIM.X009.X000.MP0:3
save XDUT.XCTRL.XTIM.X009.X000.MP0:4
save XDUT.XCTRL.XTIM.X009.X000.MP1:1
save XDUT.XCTRL.XTIM.X009.X000.MP1:2
save XDUT.XCTRL.XTIM.X009.X000.MP1:3
save XDUT.XCTRL.XTIM.X009.X000.MP1:4
save XDUT.XCTRL.XTIM.X009.X001.MN:1
save XDUT.XCTRL.XTIM.X009.X001.MN:2
save XDUT.XCTRL.XTIM.X009.X001.MN:3
save XDUT.XCTRL.XTIM.X009.X001.MN:4
save XDUT.XCTRL.XTIM.X009.X001.MP:1
save XDUT.XCTRL.XTIM.X009.X001.MP:2
save XDUT.XCTRL.XTIM.X009.X001.MP:3
save XDUT.XCTRL.XTIM.X009.X001.MP:4
save XDUT.XCTRL.XTIM.X015.MN:1
save XDUT.XCTRL.XTIM.X015.MN:2
save XDUT.XCTRL.XTIM.X015.MN:3
save XDUT.XCTRL.XTIM.X015.MN:4
save XDUT.XCTRL.XTIM.X015.MP:1
save XDUT.XCTRL.XTIM.X015.MP:2
save XDUT.XCTRL.XTIM.X015.MP:3
save XDUT.XCTRL.XTIM.X015.MP:4
save XDUT.XCTRL.XTIM.X016.MN:1
save XDUT.XCTRL.XTIM.X016.MN:2
save XDUT.XCTRL.XTIM.X016.MN:3
save XDUT.XCTRL.XTIM.X016.MN:4
save XDUT.XCTRL.XTIM.X016.MP:1
save XDUT.XCTRL.XTIM.X016.MP:2
save XDUT.XCTRL.XTIM.X016.MP:3
save XDUT.XCTRL.XTIM.X016.MP:4
save XDUT.XCTRL.XTIM.X017.MN:1
save XDUT.XCTRL.XTIM.X017.MN:2
save XDUT.XCTRL.XTIM.X017.MN:3
save XDUT.XCTRL.XTIM.X017.MN:4
save XDUT.XCTRL.XTIM.X017.MP:1
save XDUT.XCTRL.XTIM.X017.MP:2
save XDUT.XCTRL.XTIM.X017.MP:3
save XDUT.XCTRL.XTIM.X017.MP:4
save XDUT.XCTRL.XTIM.X018.N
save XDUT.XCTRL.XTIM.X018.X000.CMID:1
save XDUT.XCTRL.XTIM.X018.X000.MID
save XDUT.XCTRL.XTIM.X018.X000.MN0:1
save XDUT.XCTRL.XTIM.X018.X000.MN0:2
save XDUT.XCTRL.XTIM.X018.X000.MN0:3
save XDUT.XCTRL.XTIM.X018.X000.MN0:4
save XDUT.XCTRL.XTIM.X018.X000.MN1:1
save XDUT.XCTRL.XTIM.X018.X000.MN1:2
save XDUT.XCTRL.XTIM.X018.X000.MN1:3
save XDUT.XCTRL.XTIM.X018.X000.MN1:4
save XDUT.XCTRL.XTIM.X018.X000.MP0:1
save XDUT.XCTRL.XTIM.X018.X000.MP0:2
save XDUT.XCTRL.XTIM.X018.X000.MP0:3
save XDUT.XCTRL.XTIM.X018.X000.MP0:4
save XDUT.XCTRL.XTIM.X018.X000.MP1:1
save XDUT.XCTRL.XTIM.X018.X000.MP1:2
save XDUT.XCTRL.XTIM.X018.X000.MP1:3
save XDUT.XCTRL.XTIM.X018.X000.MP1:4
save XDUT.XCTRL.XTIM.X018.X001.MN:1
save XDUT.XCTRL.XTIM.X018.X001.MN:2
save XDUT.XCTRL.XTIM.X018.X001.MN:3
save XDUT.XCTRL.XTIM.X018.X001.MN:4
save XDUT.XCTRL.XTIM.X018.X001.MP:1
save XDUT.XCTRL.XTIM.X018.X001.MP:2
save XDUT.XCTRL.XTIM.X018.X001.MP:3
save XDUT.XCTRL.XTIM.X018.X001.MP:4
save XDUT.XCTRL.XTIM.X019.N
save XDUT.XCTRL.XTIM.X019.X000.CMID:1
save XDUT.XCTRL.XTIM.X019.X000.MID
save XDUT.XCTRL.XTIM.X019.X000.MN0:1
save XDUT.XCTRL.XTIM.X019.X000.MN0:2
save XDUT.XCTRL.XTIM.X019.X000.MN0:3
save XDUT.XCTRL.XTIM.X019.X000.MN0:4
save XDUT.XCTRL.XTIM.X019.X000.MN1:1
save XDUT.XCTRL.XTIM.X019.X000.MN1:2
save XDUT.XCTRL.XTIM.X019.X000.MN1:3
save XDUT.XCTRL.XTIM.X019.X000.MN1:4
save XDUT.XCTRL.XTIM.X019.X000.MP0:1
save XDUT.XCTRL.XTIM.X019.X000.MP0:2
save XDUT.XCTRL.XTIM.X019.X000.MP0:3
save XDUT.XCTRL.XTIM.X019.X000.MP0:4
save XDUT.XCTRL.XTIM.X019.X000.MP1:1
save XDUT.XCTRL.XTIM.X019.X000.MP1:2
save XDUT.XCTRL.XTIM.X019.X000.MP1:3
save XDUT.XCTRL.XTIM.X019.X000.MP1:4
save XDUT.XCTRL.XTIM.X019.X001.MN:1
save XDUT.XCTRL.XTIM.X019.X001.MN:2
save XDUT.XCTRL.XTIM.X019.X001.MN:3
save XDUT.XCTRL.XTIM.X019.X001.MN:4
save XDUT.XCTRL.XTIM.X019.X001.MP:1
save XDUT.XCTRL.XTIM.X019.X001.MP:2
save XDUT.XCTRL.XTIM.X019.X001.MP:3
save XDUT.XCTRL.XTIM.X019.X001.MP:4
save XDUT.XCTRL.XTIM.X020.N
save XDUT.XCTRL.XTIM.X020.X000.CMID:1
save XDUT.XCTRL.XTIM.X020.X000.MID
save XDUT.XCTRL.XTIM.X020.X000.MN0:1
save XDUT.XCTRL.XTIM.X020.X000.MN0:2
save XDUT.XCTRL.XTIM.X020.X000.MN0:3
save XDUT.XCTRL.XTIM.X020.X000.MN0:4
save XDUT.XCTRL.XTIM.X020.X000.MN1:1
save XDUT.XCTRL.XTIM.X020.X000.MN1:2
save XDUT.XCTRL.XTIM.X020.X000.MN1:3
save XDUT.XCTRL.XTIM.X020.X000.MN1:4
save XDUT.XCTRL.XTIM.X020.X000.MP0:1
save XDUT.XCTRL.XTIM.X020.X000.MP0:2
save XDUT.XCTRL.XTIM.X020.X000.MP0:3
save XDUT.XCTRL.XTIM.X020.X000.MP0:4
save XDUT.XCTRL.XTIM.X020.X000.MP1:1
save XDUT.XCTRL.XTIM.X020.X000.MP1:2
save XDUT.XCTRL.XTIM.X020.X000.MP1:3
save XDUT.XCTRL.XTIM.X020.X000.MP1:4
save XDUT.XCTRL.XTIM.X020.X001.MN:1
save XDUT.XCTRL.XTIM.X020.X001.MN:2
save XDUT.XCTRL.XTIM.X020.X001.MN:3
save XDUT.XCTRL.XTIM.X020.X001.MN:4
save XDUT.XCTRL.XTIM.X020.X001.MP:1
save XDUT.XCTRL.XTIM.X020.X001.MP:2
save XDUT.XCTRL.XTIM.X020.X001.MP:3
save XDUT.XCTRL.XTIM.X020.X001.MP:4
save XDUT.XCTRL.XTIM.X022.N
save XDUT.XCTRL.XTIM.X022.X000.CMID:1
save XDUT.XCTRL.XTIM.X022.X000.MID
save XDUT.XCTRL.XTIM.X022.X000.MN0:1
save XDUT.XCTRL.XTIM.X022.X000.MN0:2
save XDUT.XCTRL.XTIM.X022.X000.MN0:3
save XDUT.XCTRL.XTIM.X022.X000.MN0:4
save XDUT.XCTRL.XTIM.X022.X000.MN1:1
save XDUT.XCTRL.XTIM.X022.X000.MN1:2
save XDUT.XCTRL.XTIM.X022.X000.MN1:3
save XDUT.XCTRL.XTIM.X022.X000.MN1:4
save XDUT.XCTRL.XTIM.X022.X000.MP0:1
save XDUT.XCTRL.XTIM.X022.X000.MP0:2
save XDUT.XCTRL.XTIM.X022.X000.MP0:3
save XDUT.XCTRL.XTIM.X022.X000.MP0:4
save XDUT.XCTRL.XTIM.X022.X000.MP1:1
save XDUT.XCTRL.XTIM.X022.X000.MP1:2
save XDUT.XCTRL.XTIM.X022.X000.MP1:3
save XDUT.XCTRL.XTIM.X022.X000.MP1:4
save XDUT.XCTRL.XTIM.X022.X001.MN:1
save XDUT.XCTRL.XTIM.X022.X001.MN:2
save XDUT.XCTRL.XTIM.X022.X001.MN:3
save XDUT.XCTRL.XTIM.X022.X001.MN:4
save XDUT.XCTRL.XTIM.X022.X001.MP:1
save XDUT.XCTRL.XTIM.X022.X001.MP:2
save XDUT.XCTRL.XTIM.X022.X001.MP:3
save XDUT.XCTRL.XTIM.X022.X001.MP:4
save XDUT.XCTRL.XTIM.X023.AB
save XDUT.XCTRL.XTIM.X023.BB
save XDUT.XCTRL.XTIM.X023.X000.MN:1
save XDUT.XCTRL.XTIM.X023.X000.MN:2
save XDUT.XCTRL.XTIM.X023.X000.MN:3
save XDUT.XCTRL.XTIM.X023.X000.MN:4
save XDUT.XCTRL.XTIM.X023.X000.MP:1
save XDUT.XCTRL.XTIM.X023.X000.MP:2
save XDUT.XCTRL.XTIM.X023.X000.MP:3
save XDUT.XCTRL.XTIM.X023.X000.MP:4
save XDUT.XCTRL.XTIM.X023.X001.MN:1
save XDUT.XCTRL.XTIM.X023.X001.MN:2
save XDUT.XCTRL.XTIM.X023.X001.MN:3
save XDUT.XCTRL.XTIM.X023.X001.MN:4
save XDUT.XCTRL.XTIM.X023.X001.MP:1
save XDUT.XCTRL.XTIM.X023.X001.MP:2
save XDUT.XCTRL.XTIM.X023.X001.MP:3
save XDUT.XCTRL.XTIM.X023.X001.MP:4
save XDUT.XCTRL.XTIM.X023.X002.CMID:1
save XDUT.XCTRL.XTIM.X023.X002.MID
save XDUT.XCTRL.XTIM.X023.X002.MN0:1
save XDUT.XCTRL.XTIM.X023.X002.MN0:2
save XDUT.XCTRL.XTIM.X023.X002.MN0:3
save XDUT.XCTRL.XTIM.X023.X002.MN0:4
save XDUT.XCTRL.XTIM.X023.X002.MN1:1
save XDUT.XCTRL.XTIM.X023.X002.MN1:2
save XDUT.XCTRL.XTIM.X023.X002.MN1:3
save XDUT.XCTRL.XTIM.X023.X002.MN1:4
save XDUT.XCTRL.XTIM.X023.X002.MP0:1
save XDUT.XCTRL.XTIM.X023.X002.MP0:2
save XDUT.XCTRL.XTIM.X023.X002.MP0:3
save XDUT.XCTRL.XTIM.X023.X002.MP0:4
save XDUT.XCTRL.XTIM.X023.X002.MP1:1
save XDUT.XCTRL.XTIM.X023.X002.MP1:2
save XDUT.XCTRL.XTIM.X023.X002.MP1:3
save XDUT.XCTRL.XTIM.X023.X002.MP1:4
save XDUT.XCTRL.XTIM.X025.N
save XDUT.XCTRL.XTIM.X025.X000.MN:1
save XDUT.XCTRL.XTIM.X025.X000.MN:2
save XDUT.XCTRL.XTIM.X025.X000.MN:3
save XDUT.XCTRL.XTIM.X025.X000.MN:4
save XDUT.XCTRL.XTIM.X025.X000.MP:1
save XDUT.XCTRL.XTIM.X025.X000.MP:2
save XDUT.XCTRL.XTIM.X025.X000.MP:3
save XDUT.XCTRL.XTIM.X025.X000.MP:4
save XDUT.XCTRL.XTIM.X025.X001.MN:1
save XDUT.XCTRL.XTIM.X025.X001.MN:2
save XDUT.XCTRL.XTIM.X025.X001.MN:3
save XDUT.XCTRL.XTIM.X025.X001.MN:4
save XDUT.XCTRL.XTIM.X025.X001.MP:1
save XDUT.XCTRL.XTIM.X025.X001.MP:2
save XDUT.XCTRL.XTIM.X025.X001.MP:3
save XDUT.XCTRL.XTIM.X025.X001.MP:4
save XDUT.XCTRL.XTIM.XCLOCK.CQB:1
save XDUT.XCTRL.XTIM.XCLOCK.QB
save XDUT.XCTRL.XTIM.XCLOCK.RB
save XDUT.XCTRL.XTIM.XCLOCK.SN
save XDUT.XCTRL.XTIM.XCLOCK.X000.MN:1
save XDUT.XCTRL.XTIM.XCLOCK.X000.MN:2
save XDUT.XCTRL.XTIM.XCLOCK.X000.MN:3
save XDUT.XCTRL.XTIM.XCLOCK.X000.MN:4
save XDUT.XCTRL.XTIM.XCLOCK.X000.MP:1
save XDUT.XCTRL.XTIM.XCLOCK.X000.MP:2
save XDUT.XCTRL.XTIM.XCLOCK.X000.MP:3
save XDUT.XCTRL.XTIM.XCLOCK.X000.MP:4
save XDUT.XCTRL.XTIM.XCLOCK.X001.CMID:1
save XDUT.XCTRL.XTIM.XCLOCK.X001.MID
save XDUT.XCTRL.XTIM.XCLOCK.X001.MN0:1
save XDUT.XCTRL.XTIM.XCLOCK.X001.MN0:2
save XDUT.XCTRL.XTIM.XCLOCK.X001.MN0:3
save XDUT.XCTRL.XTIM.XCLOCK.X001.MN0:4
save XDUT.XCTRL.XTIM.XCLOCK.X001.MN1:1
save XDUT.XCTRL.XTIM.XCLOCK.X001.MN1:2
save XDUT.XCTRL.XTIM.XCLOCK.X001.MN1:3
save XDUT.XCTRL.XTIM.XCLOCK.X001.MN1:4
save XDUT.XCTRL.XTIM.XCLOCK.X001.MP0:1
save XDUT.XCTRL.XTIM.XCLOCK.X001.MP0:2
save XDUT.XCTRL.XTIM.XCLOCK.X001.MP0:3
save XDUT.XCTRL.XTIM.XCLOCK.X001.MP0:4
save XDUT.XCTRL.XTIM.XCLOCK.X001.MP1:1
save XDUT.XCTRL.XTIM.XCLOCK.X001.MP1:2
save XDUT.XCTRL.XTIM.XCLOCK.X001.MP1:3
save XDUT.XCTRL.XTIM.XCLOCK.X001.MP1:4
save XDUT.XCTRL.XTIM.XCLOCK.X002.CMID:1
save XDUT.XCTRL.XTIM.XCLOCK.X002.MID
save XDUT.XCTRL.XTIM.XCLOCK.X002.MN0:1
save XDUT.XCTRL.XTIM.XCLOCK.X002.MN0:2
save XDUT.XCTRL.XTIM.XCLOCK.X002.MN0:3
save XDUT.XCTRL.XTIM.XCLOCK.X002.MN0:4
save XDUT.XCTRL.XTIM.XCLOCK.X002.MN1:1
save XDUT.XCTRL.XTIM.XCLOCK.X002.MN1:2
save XDUT.XCTRL.XTIM.XCLOCK.X002.MN1:3
save XDUT.XCTRL.XTIM.XCLOCK.X002.MN1:4
save XDUT.XCTRL.XTIM.XCLOCK.X002.MP0:1
save XDUT.XCTRL.XTIM.XCLOCK.X002.MP0:2
save XDUT.XCTRL.XTIM.XCLOCK.X002.MP0:3
save XDUT.XCTRL.XTIM.XCLOCK.X002.MP0:4
save XDUT.XCTRL.XTIM.XCLOCK.X002.MP1:1
save XDUT.XCTRL.XTIM.XCLOCK.X002.MP1:2
save XDUT.XCTRL.XTIM.XCLOCK.X002.MP1:3
save XDUT.XCTRL.XTIM.XCLOCK.X002.MP1:4
save XDUT.XCTRL.XTIM.XCLOCK.X003.CMID:1
save XDUT.XCTRL.XTIM.XCLOCK.X003.MID
save XDUT.XCTRL.XTIM.XCLOCK.X003.MN0:1
save XDUT.XCTRL.XTIM.XCLOCK.X003.MN0:2
save XDUT.XCTRL.XTIM.XCLOCK.X003.MN0:3
save XDUT.XCTRL.XTIM.XCLOCK.X003.MN0:4
save XDUT.XCTRL.XTIM.XCLOCK.X003.MN1:1
save XDUT.XCTRL.XTIM.XCLOCK.X003.MN1:2
save XDUT.XCTRL.XTIM.XCLOCK.X003.MN1:3
save XDUT.XCTRL.XTIM.XCLOCK.X003.MN1:4
save XDUT.XCTRL.XTIM.XCLOCK.X003.MP0:1
save XDUT.XCTRL.XTIM.XCLOCK.X003.MP0:2
save XDUT.XCTRL.XTIM.XCLOCK.X003.MP0:3
save XDUT.XCTRL.XTIM.XCLOCK.X003.MP0:4
save XDUT.XCTRL.XTIM.XCLOCK.X003.MP1:1
save XDUT.XCTRL.XTIM.XCLOCK.X003.MP1:2
save XDUT.XCTRL.XTIM.XCLOCK.X003.MP1:3
save XDUT.XCTRL.XTIM.XCLOCK.X003.MP1:4
save XDUT.XCTRL.XTIM.XD_QUIET_D.AB
save XDUT.XCTRL.XTIM.XD_QUIET_D.B
save XDUT.XCTRL.XTIM.XD_QUIET_D.C0:1
save XDUT.XCTRL.XTIM.XD_QUIET_D.C1:1
save XDUT.XCTRL.XTIM.XD_QUIET_D.MN_CLEAR:1
save XDUT.XCTRL.XTIM.XD_QUIET_D.MN_CLEAR:2
save XDUT.XCTRL.XTIM.XD_QUIET_D.MN_CLEAR:3
save XDUT.XCTRL.XTIM.XD_QUIET_D.MN_CLEAR:4
save XDUT.XCTRL.XTIM.XD_QUIET_D.MP_CLEAR:1
save XDUT.XCTRL.XTIM.XD_QUIET_D.MP_CLEAR:2
save XDUT.XCTRL.XTIM.XD_QUIET_D.MP_CLEAR:3
save XDUT.XCTRL.XTIM.XD_QUIET_D.MP_CLEAR:4
save XDUT.XCTRL.XTIM.XD_QUIET_D.R0:1
save XDUT.XCTRL.XTIM.XD_QUIET_D.R0:2
save XDUT.XCTRL.XTIM.XD_QUIET_D.R1:1
save XDUT.XCTRL.XTIM.XD_QUIET_D.R1:2
save XDUT.XCTRL.XTIM.XD_QUIET_D.RC0
save XDUT.XCTRL.XTIM.XD_QUIET_D.RC1
save XDUT.XCTRL.XTIM.XD_QUIET_D.X002.MN:1
save XDUT.XCTRL.XTIM.XD_QUIET_D.X002.MN:2
save XDUT.XCTRL.XTIM.XD_QUIET_D.X002.MN:3
save XDUT.XCTRL.XTIM.XD_QUIET_D.X002.MN:4
save XDUT.XCTRL.XTIM.XD_QUIET_D.X002.MP:1
save XDUT.XCTRL.XTIM.XD_QUIET_D.X002.MP:2
save XDUT.XCTRL.XTIM.XD_QUIET_D.X002.MP:3
save XDUT.XCTRL.XTIM.XD_QUIET_D.X002.MP:4
save XDUT.XCTRL.XTIM.XD_QUIET_D.X005.MN:1
save XDUT.XCTRL.XTIM.XD_QUIET_D.X005.MN:2
save XDUT.XCTRL.XTIM.XD_QUIET_D.X005.MN:3
save XDUT.XCTRL.XTIM.XD_QUIET_D.X005.MN:4
save XDUT.XCTRL.XTIM.XD_QUIET_D.X005.MP:1
save XDUT.XCTRL.XTIM.XD_QUIET_D.X005.MP:2
save XDUT.XCTRL.XTIM.XD_QUIET_D.X005.MP:3
save XDUT.XCTRL.XTIM.XD_QUIET_D.X005.MP:4
save XDUT.XCTRL.XTIM.XD_QUIET_D.X006.MN:1
save XDUT.XCTRL.XTIM.XD_QUIET_D.X006.MN:2
save XDUT.XCTRL.XTIM.XD_QUIET_D.X006.MN:3
save XDUT.XCTRL.XTIM.XD_QUIET_D.X006.MN:4
save XDUT.XCTRL.XTIM.XD_QUIET_D.X006.MP:1
save XDUT.XCTRL.XTIM.XD_QUIET_D.X006.MP:2
save XDUT.XCTRL.XTIM.XD_QUIET_D.X006.MP:3
save XDUT.XCTRL.XTIM.XD_QUIET_D.X006.MP:4
save XDUT.XCTRL.XTIM.MSNLOAD10_MN1:1
save XDUT.XCTRL.XTIM.MSNLOAD10_MN1:2
save XDUT.XCTRL.XTIM.MSNLOAD10_MN1:3
save XDUT.XCTRL.XTIM.MSNLOAD10_MN1:4
save XDUT.XCTRL.XTIM.MSNLOAD10_MP1:1
save XDUT.XCTRL.XTIM.MSNLOAD10_MP1:2
save XDUT.XCTRL.XTIM.MSNLOAD10_MP1:3
save XDUT.XCTRL.XTIM.MSNLOAD10_MP1:4
save XDUT.XCTRL.XTIM.MSNLOAD14_MN1:1
save XDUT.XCTRL.XTIM.MSNLOAD14_MN1:2
save XDUT.XCTRL.XTIM.MSNLOAD14_MN1:3
save XDUT.XCTRL.XTIM.MSNLOAD14_MN1:4
save XDUT.XCTRL.XTIM.MSNLOAD14_MP1:1
save XDUT.XCTRL.XTIM.MSNLOAD14_MP1:2
save XDUT.XCTRL.XTIM.MSNLOAD14_MP1:3
save XDUT.XCTRL.XTIM.MSNLOAD14_MP1:4
save XDUT.XCTRL.XTIM.SNLOAD10_MID
save XDUT.XCTRL.XTIM.SNLOAD10_N
save XDUT.XCTRL.XTIM.SNLOAD14_MID
save XDUT.XCTRL.XTIM.SNLOAD14_N
save XDUT.XCTRL.XTIM.VBIAS10_MID:1
save XDUT.XCTRL.XTIM.VBIAS10_N:1
save XDUT.XCTRL.XTIM.VBIAS14_MID:1
save XDUT.XCTRL.XTIM.VBIAS14_N:1
save XDUT.XCTRL.XTIM.X020.X000.B_PM
save XDUT.XCTRL.XTIM.X020.X000.RSLEW:1
save XDUT.XCTRL.XTIM.X020.X000.RSLEW:2
save XDUT.XCTRL.XTIM.X020.X000.FLOOR1
save XDUT.XCTRL.XTIM.X020.X000.FLOOR2
save XDUT.XCTRL.XTIM.X020.X000.RPU0:1
save XDUT.XCTRL.XTIM.X020.X000.RPU0:2
save XDUT.XCTRL.XTIM.X020.X000.RPU1:1
save XDUT.XCTRL.XTIM.X020.X000.RPU1:2
save XDUT.XCTRL.XTIM.X020.X000.RPU2:1
save XDUT.XCTRL.XTIM.X020.X000.RPU2:2
