subckt sar8p_and2 A B VDD VSS Y
    X000 (A B VDD VSS N) sar8p_nand2
    X001 (N VDD VSS Y) sar8p_inv
ends sar8p_and2

subckt sar8p_buf A VDD VSS Y
    X001 (N VDD VSS Y) sar8p_inv
    X000 (A VDD VSS N) sar8p_inv
ends sar8p_buf

subckt sar8p_clkbuf A VDD VSS Y
    X000 (A VDD VSS AB) sar8p_inv
    XFINAL (AB VDD VSS Y) sar8p_inv
ends sar8p_clkbuf

subckt sar8p_delay_bbm A VDD VSS Y
R1 (B RC1 ) rupolym l=17.13u w=1u m=1 multi=(1)

R0 (A RC0 ) rupolym l=17.13u w=1u m=1 multi=(1)

    C1 (RC1 VSS) cfmom_2t nr=8 lr=2.5u w=50n s=50n stm=1 spm=3 multi=1 \
        mismatchflag=1
    C0 (RC0 VSS) cfmom_2t nr=8 lr=2.5u w=50n s=50n stm=1 spm=3 multi=1 \
        mismatchflag=1
    X006 (A VDD VSS AB) sar8p_inv
    X005 (RC1 VDD VSS Y) sar8p_inv
    X002 (RC0 VDD VSS B) sar8p_inv
    MN_CLEAR (RC0 AB VSS VSS) nch_mac l=30n w=2u multi=1 nf=1 sd=100n \
        ad=1.5e-13 as=1.5e-13 pd=4.15u ps=4.15u nrd=0.144730 nrs=0.144730 \
        sa=75.0n sb=75.0n sa1=75.0n sa2=75.0n sa3=75.0n sa4=75.0n \
        sb1=75.0n sb2=75.0n sb3=75.0n spa=100n spa1=100n spa2=100n \
        spa3=100n sap=91.9776n sapb=114.444n spba=115.715n spba1=117.043n \
        dfm_flag=0 spmt=1.11111e+15 spomt=0 spomt1=1.11111e+60 \
        spmb=1.11111e+15 spomb=0 spomb1=1.11111e+60
    MP_CLEAR (RC1 A VDD VDD) pch_mac l=30n w=3u multi=1 nf=1 sd=100n \
        ad=2.25e-13 as=2.25e-13 pd=6.15u ps=6.15u nrd=0.055246 \
        nrs=0.055246 sa=75.0n sb=75.0n sa1=75.0n sa2=75.0n sa3=75.0n \
        sa4=75.0n sb1=75.0n sb2=75.0n sb3=75.0n spa=100n spa1=100n \
        spa2=100n spa3=100n sap=91.9776n sapb=114.444n spba=115.715n \
        spba1=117.043n dfm_flag=0 spmt=1.11111e+15 spomt=0 \
        spomt1=1.11111e+60 spmb=1.11111e+15 spomb=0 spomb1=1.11111e+60
ends sar8p_delay_bbm

subckt sar8p_dffr CK D Q RST VDD VSS
    XRESET (RST RN VDD VSS) INVD1BWP12T30P140
    XFF (D CK RN Q VDD VSS) DFCNQD1BWP12T30P140
ends sar8p_dffr

subckt sar8p_inv A VDD VSS Y
    XLIB (A Y VDD VSS) INVD1BWP12T30P140
ends sar8p_inv

subckt sar8p_nand2 A B VDD VSS Y
    XLIB (A B Y VDD VSS) ND2D1BWP12T30P140
ends sar8p_nand2

subckt sar8audit_std_usage VDD VSS FF_CK FF_D FF_RST CONTEXT
    XCU19 (FF_CK VDD VSS U19_CK_DRV) sar8p_clkbuf
    XDU19 (FF_D VDD VSS U19_D) sar8p_buf
    XRU19 (FF_RST VDD VSS U19_RST) sar8p_buf
    RCK (U19_CK_DRV U19_CK) resistor r=20000
    XU19 (U19_CK U19_D U19_Q U19_RST VDD VSS) sar8p_dffr
    XLU19_0 (U19_Q VDD VSS U19_L0_Y) sar8p_inv
    XLU19_1 (U19_Q VDD VSS U19_L1_Y) sar8p_delay_bbm
    XLU19_2 (U19_Q CONTEXT VDD VSS U19_L2_Y) sar8p_and2
ends sar8audit_std_usage
