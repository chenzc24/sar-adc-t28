simulator lang=spectre
global 0 VDD!
include "/home/process/tsmc28n/PDK_mmWave/iPDK_CRN28HPC+ULL_v1.8_2p2a_20190531/tsmcN28/../models/spectre/crn28ull_1d8_elk_v1d8_2p2_shrink0d9_embedded_usage.scs" section=pre_simu
include "/home/process/tsmc28n/PDK_mmWave/iPDK_CRN28HPC+ULL_v1.8_2p2a_20190531/tsmcN28/../models/spectre/crn28ull_1d8_elk_v1d8_2p2_shrink0d9_embedded_usage.scs" section=noise_worst
include "/home/process/tsmc28n/PDK_mmWave/iPDK_CRN28HPC+ULL_v1.8_2p2a_20190531/tsmcN28/../models/spectre/crn28ull_1d8_elk_v1d8_2p2_shrink0d9_embedded_usage.scs" section=ffmacro_mos_moscap
include "/home/process/tsmc28n/PDK_mmWave/iPDK_CRN28HPC+ULL_v1.8_2p2a_20190531/tsmcN28/../models/spectre/crn28ull_1d8_elk_v1d8_2p2_shrink0d9_embedded_usage.scs" section=tt_res_bip_dio_disres
include "/home/process/tsmc28n/PDK_mmWave/iPDK_CRN28HPC+ULL_v1.8_2p2a_20190531/tsmcN28/../models/spectre/crn28ull_1d8_elk_v1d8_2p2_shrink0d9_embedded_usage.scs" section=tt_mom
include "/home/process/tsmc28n/PDK_mmWave/iPDK_CRN28HPC+ULL_v1.8_2p2a_20190531/tsmcN28/../models/spectre/crn28ull_1d8_elk_v1d8_2p2_shrink0d9_embedded_usage.scs" section=tt_ind_jvar
include "/home/process/tsmc28n/PDK_mmWave/iPDK_CRN28HPC+ULL_v1.8_2p2a_20190531/tsmcN28/../models/spectre/crn28ull_1d8_elk_v1d8_2p2_shrink0d9_embedded_usage.scs" section=tt_r_metal
simulator lang=spice
.include "/home/process/tsmc28n/STD_CELL/tcbn28hpcplusbwp12t30p140_190a/tcbn28hpcplusbwp12t30p140_170a_spi/TSMCHOME/digital/Back_End/spice/tcbn28hpcplusbwp12t30p140_170a/tcbn28hpcplusbwp12t30p140_170a.spi"
simulator lang=spectre
include "dut.scs"
VVDD (VDD! 0) vsource dc=0.98999999999999999
VFF_CK (FF_CK 0) vsource type=pwl file="pwl/ff_ck.pwl"
VFF_D (FF_D 0) vsource type=pwl file="pwl/ff_d.pwl"
VFF_RST (FF_RST 0) vsource type=pwl file="pwl/ff_rst.pwl"
VCONTEXT (CONTEXT 0) vsource type=pwl file="pwl/context.pwl"
XDUT (VDD! 0 FF_CK FF_D FF_RST CONTEXT) sar8audit_std_usage
simulatorOptions options psfversion="1.4.0" method=gear2only reltol=1e-6 vabstol=1e-8 iabstol=1e-13 temp=-40 tnom=27 scalem=1 scale=1 gmin=1e-12 rforce=1 checklimitdest=psf
saveOptions options save=selected currents=selected subcktiprobes=no useprobes=no
tran_first tran stop=20n maxstep=10p errpreset=conservative lteratio=10
save CONTEXT
save FF_CK
save FF_D
save FF_RST
save VDD!
save XDUT.U19_CK
save XDUT.U19_D
save XDUT.U19_L0_Y
save XDUT.U19_L1_Y
save XDUT.U19_L2_Y
save XDUT.U19_Q
save XDUT.U19_RST
save XDUT.XCU19.AB
save XDUT.XDU19.N
save XDUT.XLU19_1.AB
save XDUT.XLU19_1.B
save XDUT.XLU19_1.RC0
save XDUT.XLU19_1.RC1
save XDUT.XLU19_2.N
save XDUT.XLU19_2.X000.XLIB.net10
save XDUT.XRU19.N
save XDUT.XU19.RN
save XDUT.XU19.XFF.clkb
save XDUT.XU19.XFF.clkbb
save XDUT.XU19.XFF.mq
save XDUT.XU19.XFF.mq_x
save XDUT.XU19.XFF.net0138
save XDUT.XU19.XFF.net0152
save XDUT.XU19.XFF.net093
save XDUT.XU19.XFF.net103
save XDUT.XU19.XFF.net176
save XDUT.XU19.XFF.net184
save XDUT.XU19.XFF.net208
save XDUT.XU19.XFF.net212
save XDUT.XU19.XFF.qf
save XDUT.XU19.XFF.qf_x
save VCONTEXT:1
save VFF_CK:1
save VFF_D:1
save VFF_RST:1
save VVDD:1
save XDUT.XU19.XFF.MM0:1
save XDUT.XU19.XFF.MM0:2
save XDUT.XU19.XFF.MM0:3
save XDUT.XU19.XFF.MM0:4
save XDUT.XU19.XFF.MM1:1
save XDUT.XU19.XFF.MM1:2
save XDUT.XU19.XFF.MM1:3
save XDUT.XU19.XFF.MM1:4
save XDUT.XU19.XFF.MM3:1
save XDUT.XU19.XFF.MM3:2
save XDUT.XU19.XFF.MM3:3
save XDUT.XU19.XFF.MM3:4
save XDUT.XU19.XFF.MM45:1
save XDUT.XU19.XFF.MM45:2
save XDUT.XU19.XFF.MM45:3
save XDUT.XU19.XFF.MM45:4
save XDUT.XU19.XFF.MM46:1
save XDUT.XU19.XFF.MM46:2
save XDUT.XU19.XFF.MM46:3
save XDUT.XU19.XFF.MM46:4
save XDUT.XU19.XFF.MM4:1
save XDUT.XU19.XFF.MM4:2
save XDUT.XU19.XFF.MM4:3
save XDUT.XU19.XFF.MM4:4
save XDUT.XU19.XFF.MM53:1
save XDUT.XU19.XFF.MM53:2
save XDUT.XU19.XFF.MM53:3
save XDUT.XU19.XFF.MM53:4
save XDUT.XU19.XFF.MM54:1
save XDUT.XU19.XFF.MM54:2
save XDUT.XU19.XFF.MM54:3
save XDUT.XU19.XFF.MM54:4
save XDUT.XU19.XFF.MM55:1
save XDUT.XU19.XFF.MM55:2
save XDUT.XU19.XFF.MM55:3
save XDUT.XU19.XFF.MM55:4
save XDUT.XU19.XFF.MM56:1
save XDUT.XU19.XFF.MM56:2
save XDUT.XU19.XFF.MM56:3
save XDUT.XU19.XFF.MM56:4
save XDUT.XU19.XFF.MM61:1
save XDUT.XU19.XFF.MM61:2
save XDUT.XU19.XFF.MM61:3
save XDUT.XU19.XFF.MM61:4
save XDUT.XU19.XFF.MM64:1
save XDUT.XU19.XFF.MM64:2
save XDUT.XU19.XFF.MM64:3
save XDUT.XU19.XFF.MM64:4
save XDUT.XU19.XFF.MM65:1
save XDUT.XU19.XFF.MM65:2
save XDUT.XU19.XFF.MM65:3
save XDUT.XU19.XFF.MM65:4
save XDUT.XU19.XFF.MM66:1
save XDUT.XU19.XFF.MM66:2
save XDUT.XU19.XFF.MM66:3
save XDUT.XU19.XFF.MM66:4
save XDUT.XU19.XFF.MM79:1
save XDUT.XU19.XFF.MM79:2
save XDUT.XU19.XFF.MM79:3
save XDUT.XU19.XFF.MM79:4
save XDUT.XU19.XFF.MSLTn1:1
save XDUT.XU19.XFF.MSLTn1:2
save XDUT.XU19.XFF.MSLTn1:3
save XDUT.XU19.XFF.MSLTn1:4
save XDUT.XU19.XFF.MSLTp1:1
save XDUT.XU19.XFF.MSLTp1:2
save XDUT.XU19.XFF.MSLTp1:3
save XDUT.XU19.XFF.MSLTp1:4

// MM65 native field exposure; static info, no transient OP save additions.
opmap_primitives info what=primitives where=file file="../raw/opmap_primitives.txt" descriptions=yes extremes=no
opmap_inst info what=inst where=file file="../raw/opmap_inst.txt" descriptions=yes extremes=no
opmap_nodes info what=nodes where=file file="../raw/opmap_nodes.txt" descriptions=yes extremes=no
opmap_oppoint info what=oppoint where=file file="../raw/opmap_oppoint.txt" descriptions=yes extremes=no oppoint=dev save=all
