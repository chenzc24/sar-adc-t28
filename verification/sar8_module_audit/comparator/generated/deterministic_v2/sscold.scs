// Local deterministic comparator/receiver diagnostic. NOT SPECTRE COMPILED.
// Ideal inputs; no CDAC kickback, noise, mismatch or ADC timing qualification.
simulator lang=spectre
global 0 VDD!
parameters SUP=0.81
include "/home/process/tsmc28n/PDK_mmWave/iPDK_CRN28HPC+ULL_v1.8_2p2a_20190531/tsmcN28/../models/spectre/crn28ull_1d8_elk_v1d8_2p2_shrink0d9_embedded_usage.scs" section=pre_simu
include "/home/process/tsmc28n/PDK_mmWave/iPDK_CRN28HPC+ULL_v1.8_2p2a_20190531/tsmcN28/../models/spectre/crn28ull_1d8_elk_v1d8_2p2_shrink0d9_embedded_usage.scs" section=noise_worst
include "/home/process/tsmc28n/PDK_mmWave/iPDK_CRN28HPC+ULL_v1.8_2p2a_20190531/tsmcN28/../models/spectre/crn28ull_1d8_elk_v1d8_2p2_shrink0d9_embedded_usage.scs" section=ssmacro_mos_moscap
include "/home/process/tsmc28n/PDK_mmWave/iPDK_CRN28HPC+ULL_v1.8_2p2a_20190531/tsmcN28/../models/spectre/crn28ull_1d8_elk_v1d8_2p2_shrink0d9_embedded_usage.scs" section=tt_res_bip_dio_disres
include "/home/process/tsmc28n/PDK_mmWave/iPDK_CRN28HPC+ULL_v1.8_2p2a_20190531/tsmcN28/../models/spectre/crn28ull_1d8_elk_v1d8_2p2_shrink0d9_embedded_usage.scs" section=tt_mom
include "/home/process/tsmc28n/PDK_mmWave/iPDK_CRN28HPC+ULL_v1.8_2p2a_20190531/tsmcN28/../models/spectre/crn28ull_1d8_elk_v1d8_2p2_shrink0d9_embedded_usage.scs" section=tt_ind_jvar
include "/home/process/tsmc28n/PDK_mmWave/iPDK_CRN28HPC+ULL_v1.8_2p2a_20190531/tsmcN28/../models/spectre/crn28ull_1d8_elk_v1d8_2p2_shrink0d9_embedded_usage.scs" section=tt_r_metal
include "cells.scs"
XDUT (TOPP TOPN CMP_CLK SAMPLE_GUARD REG_RESET TOKEN0 TOKEN1 TOKEN2 TOKEN3 TOKEN4 TOKEN5 TOKEN6 TOKEN7 VDD! 0 D0 D1 D2 D3 D4 D5 D6 D7) audit_comparator_d
VVDD (VDD! 0) vsource dc=SUP
VCMP_CLK (CMP_CLK 0) vsource type=pwl wave=[0n 0 20n 0 20.1n SUP 32n SUP 32.1n 0 60n 0 60.1n SUP 72n SUP 72.1n 0 100n 0 100.1n SUP 112n SUP 112.1n 0 140n 0 140.1n SUP 152n SUP 152.1n 0 180n 0 180.1n SUP 192n SUP 192.1n 0 220n 0 220.1n SUP 232n SUP 232.1n 0 260n 0]
VTOPP (TOPP 0) vsource type=pwl wave=[0n 0.45087890625 12n 0.45087890625 12.1n 0.45087890625 52n 0.45087890625 52.1n 0.45087890625 92n 0.45087890625 92.1n 0.44912109375 132n 0.44912109375 132.1n 0.45087890625 172n 0.45087890625 172.1n 0.44912109375 212n 0.44912109375 212.1n 0.44912109375 260n 0.44912109375]
VTOPN (TOPN 0) vsource type=pwl wave=[0n 0.44912109375 12n 0.44912109375 12.1n 0.44912109375 52n 0.44912109375 52.1n 0.44912109375 92n 0.44912109375 92.1n 0.45087890625 132n 0.45087890625 132.1n 0.44912109375 172n 0.44912109375 172.1n 0.45087890625 212n 0.45087890625 212.1n 0.45087890625 260n 0.45087890625]
VREG_RESET (REG_RESET 0) vsource type=pwl wave=[0n SUP 10n SUP 10.1n 0 260n 0]
VSAMPLE_GUARD (SAMPLE_GUARD 0) vsource dc=0
VTOKEN0 (TOKEN0 0) vsource dc=SUP
VTOKEN1 (TOKEN1 0) vsource dc=0
VTOKEN2 (TOKEN2 0) vsource dc=0
VTOKEN3 (TOKEN3 0) vsource dc=0
VTOKEN4 (TOKEN4 0) vsource dc=0
VTOKEN5 (TOKEN5 0) vsource dc=0
VTOKEN6 (TOKEN6 0) vsource dc=0
VTOKEN7 (TOKEN7 0) vsource dc=0
simulatorOptions options temp=-40 tnom=27 reltol=1e-6 vabstol=1e-8 iabstol=1e-13 method=gear2only
tran_d tran stop=260n maxstep=5p errpreset=conservative
saveOptions options save=selected currents=selected subcktiprobes=no useprobes=no
save CMP_CLK
save D0
save D1
save D2
save D3
save D4
save D5
save D6
save D7
save REG_RESET
save SAMPLE_GUARD
save TOKEN0
save TOKEN1
save TOKEN2
save TOKEN3
save TOKEN4
save TOKEN5
save TOKEN6
save TOKEN7
save TOPN
save TOPP
save VCMP_CLK:1
save VDD!
save VVDD:1
save XDUT.CODE0
save XDUT.CODE1
save XDUT.CODE2
save XDUT.CODE3
save XDUT.CODE4
save XDUT.CODE5
save XDUT.CODE6
save XDUT.CODE7
save XDUT.COMP_N
save XDUT.COMP_P
save XDUT.PHI_U
save XDUT.XCOMP.MNINN:1
save XDUT.XCOMP.MNINN:2
save XDUT.XCOMP.MNINN:3
save XDUT.XCOMP.MNINN:4
save XDUT.XCOMP.MNINP:1
save XDUT.XCOMP.MNINP:2
save XDUT.XCOMP.MNINP:3
save XDUT.XCOMP.MNINP:4
save XDUT.XCOMP.MNLATN:1
save XDUT.XCOMP.MNLATN:2
save XDUT.XCOMP.MNLATN:3
save XDUT.XCOMP.MNLATN:4
save XDUT.XCOMP.MNLATP:1
save XDUT.XCOMP.MNLATP:2
save XDUT.XCOMP.MNLATP:3
save XDUT.XCOMP.MNLATP:4
save XDUT.XCOMP.MNTAIL:1
save XDUT.XCOMP.MNTAIL:2
save XDUT.XCOMP.MNTAIL:3
save XDUT.XCOMP.MNTAIL:4
save XDUT.XCOMP.MPLATN:1
save XDUT.XCOMP.MPLATN:2
save XDUT.XCOMP.MPLATN:3
save XDUT.XCOMP.MPLATN:4
save XDUT.XCOMP.MPLATP:1
save XDUT.XCOMP.MPLATP:2
save XDUT.XCOMP.MPLATP:3
save XDUT.XCOMP.MPLATP:4
save XDUT.XCOMP.MPRSTN:1
save XDUT.XCOMP.MPRSTN:2
save XDUT.XCOMP.MPRSTN:3
save XDUT.XCOMP.MPRSTN:4
save XDUT.XCOMP.MPRSTP:1
save XDUT.XCOMP.MPRSTP:2
save XDUT.XCOMP.MPRSTP:3
save XDUT.XCOMP.MPRSTP:4
save XDUT.XCOMP.MPRSTX:1
save XDUT.XCOMP.MPRSTX:2
save XDUT.XCOMP.MPRSTX:3
save XDUT.XCOMP.MPRSTX:4
save XDUT.XCOMP.MPRSTY:1
save XDUT.XCOMP.MPRSTY:2
save XDUT.XCOMP.MPRSTY:3
save XDUT.XCOMP.MPRSTY:4
save XDUT.XCOMP.TAIL
save XDUT.XCOMP.X
save XDUT.XCOMP.Y
save XDUT.XCTRL.DATA
save XDUT.XCTRL.PHI_W
save XDUT.XCTRL.XBIT0.NEXT_D
save XDUT.XCTRL.XBIT0.X002.AB
save XDUT.XCTRL.XBIT0.X002.BB
save XDUT.XCTRL.XBIT0.X002.X002.MID
save XDUT.XCTRL.XBIT0.XMUX.N0
save XDUT.XCTRL.XBIT0.XMUX.N1
save XDUT.XCTRL.XBIT0.XMUX.SB
save XDUT.XCTRL.XBIT0.XMUX.X001.MID
save XDUT.XCTRL.XBIT0.XMUX.X002.MID
save XDUT.XCTRL.XBIT0.XMUX.X003.MID
save XDUT.XCTRL.XBIT0.XSTORE.CKB
save XDUT.XCTRL.XBIT0.XSTORE.M
save XDUT.XCTRL.XBIT0.XSTORE.MB
save XDUT.XCTRL.XBIT0.XSTORE.MQ
save XDUT.XCTRL.XBIT0.XSTORE.RN
save XDUT.XCTRL.XBIT0.XSTORE.S
save XDUT.XCTRL.XBIT0.XSTORE.SB
save XDUT.XCTRL.XBIT0.XSTORE.X006.MID
save XDUT.XCTRL.XBIT0.XSTORE.X012.MID
save XDUT.XCTRL.XBIT1.NEXT_D
save XDUT.XCTRL.XBIT1.X002.AB
save XDUT.XCTRL.XBIT1.X002.BB
save XDUT.XCTRL.XBIT1.X002.X002.MID
save XDUT.XCTRL.XBIT1.XMUX.N0
save XDUT.XCTRL.XBIT1.XMUX.N1
save XDUT.XCTRL.XBIT1.XMUX.SB
save XDUT.XCTRL.XBIT1.XMUX.X001.MID
save XDUT.XCTRL.XBIT1.XMUX.X002.MID
save XDUT.XCTRL.XBIT1.XMUX.X003.MID
save XDUT.XCTRL.XBIT1.XSTORE.CKB
save XDUT.XCTRL.XBIT1.XSTORE.M
save XDUT.XCTRL.XBIT1.XSTORE.MB
save XDUT.XCTRL.XBIT1.XSTORE.MQ
save XDUT.XCTRL.XBIT1.XSTORE.RN
save XDUT.XCTRL.XBIT1.XSTORE.S
save XDUT.XCTRL.XBIT1.XSTORE.SB
save XDUT.XCTRL.XBIT1.XSTORE.X006.MID
save XDUT.XCTRL.XBIT1.XSTORE.X012.MID
save XDUT.XCTRL.XBIT2.NEXT_D
save XDUT.XCTRL.XBIT2.X002.AB
save XDUT.XCTRL.XBIT2.X002.BB
save XDUT.XCTRL.XBIT2.X002.X002.MID
save XDUT.XCTRL.XBIT2.XMUX.N0
save XDUT.XCTRL.XBIT2.XMUX.N1
save XDUT.XCTRL.XBIT2.XMUX.SB
save XDUT.XCTRL.XBIT2.XMUX.X001.MID
save XDUT.XCTRL.XBIT2.XMUX.X002.MID
save XDUT.XCTRL.XBIT2.XMUX.X003.MID
save XDUT.XCTRL.XBIT2.XSTORE.CKB
save XDUT.XCTRL.XBIT2.XSTORE.M
save XDUT.XCTRL.XBIT2.XSTORE.MB
save XDUT.XCTRL.XBIT2.XSTORE.MQ
save XDUT.XCTRL.XBIT2.XSTORE.RN
save XDUT.XCTRL.XBIT2.XSTORE.S
save XDUT.XCTRL.XBIT2.XSTORE.SB
save XDUT.XCTRL.XBIT2.XSTORE.X006.MID
save XDUT.XCTRL.XBIT2.XSTORE.X012.MID
save XDUT.XCTRL.XBIT3.NEXT_D
save XDUT.XCTRL.XBIT3.X002.AB
save XDUT.XCTRL.XBIT3.X002.BB
save XDUT.XCTRL.XBIT3.X002.X002.MID
save XDUT.XCTRL.XBIT3.XMUX.N0
save XDUT.XCTRL.XBIT3.XMUX.N1
save XDUT.XCTRL.XBIT3.XMUX.SB
save XDUT.XCTRL.XBIT3.XMUX.X001.MID
save XDUT.XCTRL.XBIT3.XMUX.X002.MID
save XDUT.XCTRL.XBIT3.XMUX.X003.MID
save XDUT.XCTRL.XBIT3.XSTORE.CKB
save XDUT.XCTRL.XBIT3.XSTORE.M
save XDUT.XCTRL.XBIT3.XSTORE.MB
save XDUT.XCTRL.XBIT3.XSTORE.MQ
save XDUT.XCTRL.XBIT3.XSTORE.RN
save XDUT.XCTRL.XBIT3.XSTORE.S
save XDUT.XCTRL.XBIT3.XSTORE.SB
save XDUT.XCTRL.XBIT3.XSTORE.X006.MID
save XDUT.XCTRL.XBIT3.XSTORE.X012.MID
save XDUT.XCTRL.XBIT4.NEXT_D
save XDUT.XCTRL.XBIT4.X002.AB
save XDUT.XCTRL.XBIT4.X002.BB
save XDUT.XCTRL.XBIT4.X002.X002.MID
save XDUT.XCTRL.XBIT4.XMUX.N0
save XDUT.XCTRL.XBIT4.XMUX.N1
save XDUT.XCTRL.XBIT4.XMUX.SB
save XDUT.XCTRL.XBIT4.XMUX.X001.MID
save XDUT.XCTRL.XBIT4.XMUX.X002.MID
save XDUT.XCTRL.XBIT4.XMUX.X003.MID
save XDUT.XCTRL.XBIT4.XSTORE.CKB
save XDUT.XCTRL.XBIT4.XSTORE.M
save XDUT.XCTRL.XBIT4.XSTORE.MB
save XDUT.XCTRL.XBIT4.XSTORE.MQ
save XDUT.XCTRL.XBIT4.XSTORE.RN
save XDUT.XCTRL.XBIT4.XSTORE.S
save XDUT.XCTRL.XBIT4.XSTORE.SB
save XDUT.XCTRL.XBIT4.XSTORE.X006.MID
save XDUT.XCTRL.XBIT4.XSTORE.X012.MID
save XDUT.XCTRL.XBIT5.NEXT_D
save XDUT.XCTRL.XBIT5.X002.AB
save XDUT.XCTRL.XBIT5.X002.BB
save XDUT.XCTRL.XBIT5.X002.X002.MID
save XDUT.XCTRL.XBIT5.XMUX.N0
save XDUT.XCTRL.XBIT5.XMUX.N1
save XDUT.XCTRL.XBIT5.XMUX.SB
save XDUT.XCTRL.XBIT5.XMUX.X001.MID
save XDUT.XCTRL.XBIT5.XMUX.X002.MID
save XDUT.XCTRL.XBIT5.XMUX.X003.MID
save XDUT.XCTRL.XBIT5.XSTORE.CKB
save XDUT.XCTRL.XBIT5.XSTORE.M
save XDUT.XCTRL.XBIT5.XSTORE.MB
save XDUT.XCTRL.XBIT5.XSTORE.MQ
save XDUT.XCTRL.XBIT5.XSTORE.RN
save XDUT.XCTRL.XBIT5.XSTORE.S
save XDUT.XCTRL.XBIT5.XSTORE.SB
save XDUT.XCTRL.XBIT5.XSTORE.X006.MID
save XDUT.XCTRL.XBIT5.XSTORE.X012.MID
save XDUT.XCTRL.XBIT6.NEXT_D
save XDUT.XCTRL.XBIT6.X002.AB
save XDUT.XCTRL.XBIT6.X002.BB
save XDUT.XCTRL.XBIT6.X002.X002.MID
save XDUT.XCTRL.XBIT6.XMUX.N0
save XDUT.XCTRL.XBIT6.XMUX.N1
save XDUT.XCTRL.XBIT6.XMUX.SB
save XDUT.XCTRL.XBIT6.XMUX.X001.MID
save XDUT.XCTRL.XBIT6.XMUX.X002.MID
save XDUT.XCTRL.XBIT6.XMUX.X003.MID
save XDUT.XCTRL.XBIT6.XSTORE.CKB
save XDUT.XCTRL.XBIT6.XSTORE.M
save XDUT.XCTRL.XBIT6.XSTORE.MB
save XDUT.XCTRL.XBIT6.XSTORE.MQ
save XDUT.XCTRL.XBIT6.XSTORE.RN
save XDUT.XCTRL.XBIT6.XSTORE.S
save XDUT.XCTRL.XBIT6.XSTORE.SB
save XDUT.XCTRL.XBIT6.XSTORE.X006.MID
save XDUT.XCTRL.XBIT6.XSTORE.X012.MID
save XDUT.XCTRL.XBIT7.NEXT_D
save XDUT.XCTRL.XBIT7.X002.AB
save XDUT.XCTRL.XBIT7.X002.BB
save XDUT.XCTRL.XBIT7.X002.X002.MID
save XDUT.XCTRL.XBIT7.XMUX.N0
save XDUT.XCTRL.XBIT7.XMUX.N1
save XDUT.XCTRL.XBIT7.XMUX.SB
save XDUT.XCTRL.XBIT7.XMUX.X001.MID
save XDUT.XCTRL.XBIT7.XMUX.X002.MID
save XDUT.XCTRL.XBIT7.XMUX.X003.MID
save XDUT.XCTRL.XBIT7.XSTORE.CKB
save XDUT.XCTRL.XBIT7.XSTORE.M
save XDUT.XCTRL.XBIT7.XSTORE.MB
save XDUT.XCTRL.XBIT7.XSTORE.MQ
save XDUT.XCTRL.XBIT7.XSTORE.RN
save XDUT.XCTRL.XBIT7.XSTORE.S
save XDUT.XCTRL.XBIT7.XSTORE.SB
save XDUT.XCTRL.XBIT7.XSTORE.X006.MID
save XDUT.XCTRL.XBIT7.XSTORE.X012.MID
save XDUT.XCTRL.XTIM.CN
save XDUT.XCTRL.XTIM.DEC
save XDUT.XCTRL.XTIM.NR
save XDUT.XCTRL.XTIM.NRB
save XDUT.XCTRL.XTIM.PR
save XDUT.XCTRL.XTIM.RAW
save XDUT.XCTRL.XTIM.RAW_D
save XDUT.XCTRL.XTIM.SN
save XDUT.XCTRL.XTIM.UD
save XDUT.XCTRL.XTIM.WD
save XDUT.XCTRL.XTIM.WN
save XDUT.XCTRL.XTIM.WRITE_D
save XDUT.XCTRL.XTIM.WRITE_REQ
save XDUT.XCTRL.XTIM.X002.N
save XDUT.XCTRL.XTIM.X002.X000.MN:1
save XDUT.XCTRL.XTIM.X002.X000.MN:2
save XDUT.XCTRL.XTIM.X002.X000.MN:3
save XDUT.XCTRL.XTIM.X002.X000.MN:4
save XDUT.XCTRL.XTIM.X002.X000.MP:1
save XDUT.XCTRL.XTIM.X002.X000.MP:2
save XDUT.XCTRL.XTIM.X002.X000.MP:3
save XDUT.XCTRL.XTIM.X002.X000.MP:4
save XDUT.XCTRL.XTIM.X002.X001.MN:1
save XDUT.XCTRL.XTIM.X002.X001.MN:2
save XDUT.XCTRL.XTIM.X002.X001.MN:3
save XDUT.XCTRL.XTIM.X002.X001.MN:4
save XDUT.XCTRL.XTIM.X002.X001.MP:1
save XDUT.XCTRL.XTIM.X002.X001.MP:2
save XDUT.XCTRL.XTIM.X002.X001.MP:3
save XDUT.XCTRL.XTIM.X002.X001.MP:4
save XDUT.XCTRL.XTIM.X003.N
save XDUT.XCTRL.XTIM.X003.X000.MN:1
save XDUT.XCTRL.XTIM.X003.X000.MN:2
save XDUT.XCTRL.XTIM.X003.X000.MN:3
save XDUT.XCTRL.XTIM.X003.X000.MN:4
save XDUT.XCTRL.XTIM.X003.X000.MP:1
save XDUT.XCTRL.XTIM.X003.X000.MP:2
save XDUT.XCTRL.XTIM.X003.X000.MP:3
save XDUT.XCTRL.XTIM.X003.X000.MP:4
save XDUT.XCTRL.XTIM.X003.X001.MN:1
save XDUT.XCTRL.XTIM.X003.X001.MN:2
save XDUT.XCTRL.XTIM.X003.X001.MN:3
save XDUT.XCTRL.XTIM.X003.X001.MN:4
save XDUT.XCTRL.XTIM.X003.X001.MP:1
save XDUT.XCTRL.XTIM.X003.X001.MP:2
save XDUT.XCTRL.XTIM.X003.X001.MP:3
save XDUT.XCTRL.XTIM.X003.X001.MP:4
save XDUT.XCTRL.XTIM.X005.N
save XDUT.XCTRL.XTIM.X005.X000.MID
save XDUT.XCTRL.XTIM.X006.N
save XDUT.XCTRL.XTIM.X006.NA
save XDUT.XCTRL.XTIM.X006.NB
save XDUT.XCTRL.XTIM.X006.X000.MID
save XDUT.XCTRL.XTIM.X006.X001.MID
save XDUT.XCTRL.XTIM.X006.X002.MID
save XDUT.XCTRL.XTIM.X006.X003.MID
save XDUT.XCTRL.XTIM.X008.N
save XDUT.XCTRL.XTIM.X008.X000.MID
save XDUT.XCTRL.XTIM.X009.N
save XDUT.XCTRL.XTIM.X009.X000.MID
save XDUT.XCTRL.XTIM.X010.N
save XDUT.XCTRL.XTIM.X010.X000.MID
save XDUT.XCTRL.XTIM.X011.AB
save XDUT.XCTRL.XTIM.X013.N
save XDUT.XCTRL.XTIM.X013.X000.MID
save XDUT.XCTRL.XTIM.X014.N
save XDUT.XCTRL.XTIM.X014.X000.MID
save XDUT.XCTRL.XTIM.XD_RAW_D.AB
save XDUT.XCTRL.XTIM.XD_RAW_D.B
save XDUT.XCTRL.XTIM.XD_RAW_D.RC0
save XDUT.XCTRL.XTIM.XD_RAW_D.RC1
save XDUT.XCTRL.XTIM.XD_WRITE_D.AB
save XDUT.XCTRL.XTIM.XD_WRITE_D.B
save XDUT.XCTRL.XTIM.XD_WRITE_D.RC0
save XDUT.XCTRL.XTIM.XD_WRITE_D.RC1
