// TT native completion feedback; conditional reference output cut; NOT SPECTRE COMPILED.
simulator lang=spectre
global 0 VDD!
parameters SUP=0.9
include "/home/process/tsmc28n/PDK_mmWave/iPDK_CRN28HPC+ULL_v1.8_2p2a_20190531/tsmcN28/../models/spectre/crn28ull_1d8_elk_v1d8_2p2_shrink0d9_embedded_usage.scs" section=pre_simu
include "/home/process/tsmc28n/PDK_mmWave/iPDK_CRN28HPC+ULL_v1.8_2p2a_20190531/tsmcN28/../models/spectre/crn28ull_1d8_elk_v1d8_2p2_shrink0d9_embedded_usage.scs" section=noise_worst
include "/home/process/tsmc28n/PDK_mmWave/iPDK_CRN28HPC+ULL_v1.8_2p2a_20190531/tsmcN28/../models/spectre/crn28ull_1d8_elk_v1d8_2p2_shrink0d9_embedded_usage.scs" section=ttmacro_mos_moscap
include "/home/process/tsmc28n/PDK_mmWave/iPDK_CRN28HPC+ULL_v1.8_2p2a_20190531/tsmcN28/../models/spectre/crn28ull_1d8_elk_v1d8_2p2_shrink0d9_embedded_usage.scs" section=tt_res_bip_dio_disres
include "/home/process/tsmc28n/PDK_mmWave/iPDK_CRN28HPC+ULL_v1.8_2p2a_20190531/tsmcN28/../models/spectre/crn28ull_1d8_elk_v1d8_2p2_shrink0d9_embedded_usage.scs" section=tt_mom
include "/home/process/tsmc28n/PDK_mmWave/iPDK_CRN28HPC+ULL_v1.8_2p2a_20190531/tsmcN28/../models/spectre/crn28ull_1d8_elk_v1d8_2p2_shrink0d9_embedded_usage.scs" section=tt_ind_jvar
include "/home/process/tsmc28n/PDK_mmWave/iPDK_CRN28HPC+ULL_v1.8_2p2a_20190531/tsmcN28/../models/spectre/crn28ull_1d8_elk_v1d8_2p2_shrink0d9_embedded_usage.scs" section=tt_r_metal
include "cells.scs"
include "cdac_load.scs"
ahdl_include "initializer.va"
    XDUT (TOPP TOPN SAMPLE_INT VDD! 0 D0 D1 D2 D3 D4 D5 D6 D7) audit_feedback
    XCDAC (TOPN TOPP VCM VREFN VREFP) audit_cdac_hold
VVDD (VDD! 0) vsource dc=SUP
VSAMPLE (SAMPLE_INT 0) vsource type=pwl wave=[0n SUP 20n SUP 20.1n 0 100n 0]
VINIT (CINIT 0) vsource type=pwl wave=[0n SUP 18n SUP 18.1n 0 100n 0]
VPREP (PREP 0) vsource dc=0.45087890625
VPREN (PREN 0) vsource dc=0.44912109375
VVCM (VCM 0) vsource dc=0.45
VREFLOW (VREFN 0) vsource dc=0
VREFHIGH (VREFP 0) vsource dc=0.9
VSENSE_P (TOPP HOLD_P) vsource dc=0
XINIT_P (HOLD_P PREP CINIT 0) cmp_charge_initializer ron=10 control_high=0.9
VSENSE_N (TOPN HOLD_N) vsource dc=0
XINIT_N (HOLD_N PREN CINIT 0) cmp_charge_initializer ron=10 control_high=0.9
COUT0 (D0 0) capacitor c=5f
COUT1 (D1 0) capacitor c=5f
COUT2 (D2 0) capacitor c=5f
COUT3 (D3 0) capacitor c=5f
COUT4 (D4 0) capacitor c=5f
COUT5 (D5 0) capacitor c=5f
COUT6 (D6 0) capacitor c=5f
COUT7 (D7 0) capacitor c=5f
simulatorOptions options temp=27 tnom=27 reltol=1e-6 vabstol=1e-8 iabstol=1e-13 method=gear2only
tran_feedback tran stop=100n maxstep=5p errpreset=conservative
saveOptions options save=selected currents=selected subcktiprobes=no useprobes=no
save CINIT
save D0
save D1
save D2
save D3
save D4
save D5
save D6
save D7
save PREN
save PREP
save SAMPLE_INT
save TOPN
save TOPP
save VCM
save VDD!
save VREFN
save VREFP
save XDUT.ACTIVE
save XDUT.CMP_CLK
save XDUT.CODE0
save XDUT.CODE1
save XDUT.CODE2
save XDUT.CODE3
save XDUT.CODE4
save XDUT.CODE5
save XDUT.CODE6
save XDUT.CODE7
save XDUT.COMP_N
save XDUT.COMP_P
save XDUT.PHI_U
save XDUT.XCOMP.TAIL
save XDUT.XCOMP.X
save XDUT.XCOMP.Y
save XDUT.XCTRL.A0
save XDUT.XCTRL.A01
save XDUT.XCTRL.A1
save XDUT.XCTRL.A2
save XDUT.XCTRL.A23
save XDUT.XCTRL.A3
save XDUT.XCTRL.DATA
save XDUT.XCTRL.PHI_W
save XDUT.XCTRL.T0
save XDUT.XCTRL.T1
save XDUT.XCTRL.T2
save XDUT.XCTRL.T3
save XDUT.XCTRL.T4
save XDUT.XCTRL.T5
save XDUT.XCTRL.T6
save XDUT.XCTRL.T7
save XDUT.XCTRL.X012.AB
save XDUT.XCTRL.X012.BB
save XDUT.XCTRL.X012.X002.MID
save XDUT.XCTRL.X013.AB
save XDUT.XCTRL.X013.BB
save XDUT.XCTRL.X013.X002.MID
save XDUT.XCTRL.X014.AB
save XDUT.XCTRL.X014.BB
save XDUT.XCTRL.X014.X002.MID
save XDUT.XCTRL.X015.AB
save XDUT.XCTRL.X015.BB
save XDUT.XCTRL.X015.X002.MID
save XDUT.XCTRL.X016.AB
save XDUT.XCTRL.X016.BB
save XDUT.XCTRL.X016.X002.MID
save XDUT.XCTRL.X017.AB
save XDUT.XCTRL.X017.BB
save XDUT.XCTRL.X017.X002.MID
save XDUT.XCTRL.X018.AB
save XDUT.XCTRL.X018.BB
save XDUT.XCTRL.X018.X002.MID
save XDUT.XCTRL.XBIT0.NEXT_D
save XDUT.XCTRL.XBIT0.X002.AB
save XDUT.XCTRL.XBIT0.X002.BB
save XDUT.XCTRL.XBIT0.X002.X002.MID
save XDUT.XCTRL.XBIT0.XMUX.N0
save XDUT.XCTRL.XBIT0.XMUX.N1
save XDUT.XCTRL.XBIT0.XMUX.SB
save XDUT.XCTRL.XBIT0.XMUX.X001.MID
save XDUT.XCTRL.XBIT0.XMUX.X002.MID
save XDUT.XCTRL.XBIT0.XMUX.X003.MID
save XDUT.XCTRL.XBIT0.XSTORE.CKB
save XDUT.XCTRL.XBIT0.XSTORE.M
save XDUT.XCTRL.XBIT0.XSTORE.MB
save XDUT.XCTRL.XBIT0.XSTORE.MQ
save XDUT.XCTRL.XBIT0.XSTORE.RN
save XDUT.XCTRL.XBIT0.XSTORE.S
save XDUT.XCTRL.XBIT0.XSTORE.SB
save XDUT.XCTRL.XBIT0.XSTORE.X006.MID
save XDUT.XCTRL.XBIT0.XSTORE.X012.MID
save XDUT.XCTRL.XBIT1.NEXT_D
save XDUT.XCTRL.XBIT1.X002.AB
save XDUT.XCTRL.XBIT1.X002.BB
save XDUT.XCTRL.XBIT1.X002.X002.MID
save XDUT.XCTRL.XBIT1.XMUX.N0
save XDUT.XCTRL.XBIT1.XMUX.N1
save XDUT.XCTRL.XBIT1.XMUX.SB
save XDUT.XCTRL.XBIT1.XMUX.X001.MID
save XDUT.XCTRL.XBIT1.XMUX.X002.MID
save XDUT.XCTRL.XBIT1.XMUX.X003.MID
save XDUT.XCTRL.XBIT1.XSTORE.CKB
save XDUT.XCTRL.XBIT1.XSTORE.M
save XDUT.XCTRL.XBIT1.XSTORE.MB
save XDUT.XCTRL.XBIT1.XSTORE.MQ
save XDUT.XCTRL.XBIT1.XSTORE.RN
save XDUT.XCTRL.XBIT1.XSTORE.S
save XDUT.XCTRL.XBIT1.XSTORE.SB
save XDUT.XCTRL.XBIT1.XSTORE.X006.MID
save XDUT.XCTRL.XBIT1.XSTORE.X012.MID
save XDUT.XCTRL.XBIT2.NEXT_D
save XDUT.XCTRL.XBIT2.X002.AB
save XDUT.XCTRL.XBIT2.X002.BB
save XDUT.XCTRL.XBIT2.X002.X002.MID
save XDUT.XCTRL.XBIT2.XMUX.N0
save XDUT.XCTRL.XBIT2.XMUX.N1
save XDUT.XCTRL.XBIT2.XMUX.SB
save XDUT.XCTRL.XBIT2.XMUX.X001.MID
save XDUT.XCTRL.XBIT2.XMUX.X002.MID
save XDUT.XCTRL.XBIT2.XMUX.X003.MID
save XDUT.XCTRL.XBIT2.XSTORE.CKB
save XDUT.XCTRL.XBIT2.XSTORE.M
save XDUT.XCTRL.XBIT2.XSTORE.MB
save XDUT.XCTRL.XBIT2.XSTORE.MQ
save XDUT.XCTRL.XBIT2.XSTORE.RN
save XDUT.XCTRL.XBIT2.XSTORE.S
save XDUT.XCTRL.XBIT2.XSTORE.SB
save XDUT.XCTRL.XBIT2.XSTORE.X006.MID
save XDUT.XCTRL.XBIT2.XSTORE.X012.MID
save XDUT.XCTRL.XBIT3.NEXT_D
save XDUT.XCTRL.XBIT3.X002.AB
save XDUT.XCTRL.XBIT3.X002.BB
save XDUT.XCTRL.XBIT3.X002.X002.MID
save XDUT.XCTRL.XBIT3.XMUX.N0
save XDUT.XCTRL.XBIT3.XMUX.N1
save XDUT.XCTRL.XBIT3.XMUX.SB
save XDUT.XCTRL.XBIT3.XMUX.X001.MID
save XDUT.XCTRL.XBIT3.XMUX.X002.MID
save XDUT.XCTRL.XBIT3.XMUX.X003.MID
save XDUT.XCTRL.XBIT3.XSTORE.CKB
save XDUT.XCTRL.XBIT3.XSTORE.M
save XDUT.XCTRL.XBIT3.XSTORE.MB
save XDUT.XCTRL.XBIT3.XSTORE.MQ
save XDUT.XCTRL.XBIT3.XSTORE.RN
save XDUT.XCTRL.XBIT3.XSTORE.S
save XDUT.XCTRL.XBIT3.XSTORE.SB
save XDUT.XCTRL.XBIT3.XSTORE.X006.MID
save XDUT.XCTRL.XBIT3.XSTORE.X012.MID
save XDUT.XCTRL.XBIT4.NEXT_D
save XDUT.XCTRL.XBIT4.X002.AB
save XDUT.XCTRL.XBIT4.X002.BB
save XDUT.XCTRL.XBIT4.X002.X002.MID
save XDUT.XCTRL.XBIT4.XMUX.N0
save XDUT.XCTRL.XBIT4.XMUX.N1
save XDUT.XCTRL.XBIT4.XMUX.SB
save XDUT.XCTRL.XBIT4.XMUX.X001.MID
save XDUT.XCTRL.XBIT4.XMUX.X002.MID
save XDUT.XCTRL.XBIT4.XMUX.X003.MID
save XDUT.XCTRL.XBIT4.XSTORE.CKB
save XDUT.XCTRL.XBIT4.XSTORE.M
save XDUT.XCTRL.XBIT4.XSTORE.MB
save XDUT.XCTRL.XBIT4.XSTORE.MQ
save XDUT.XCTRL.XBIT4.XSTORE.RN
save XDUT.XCTRL.XBIT4.XSTORE.S
save XDUT.XCTRL.XBIT4.XSTORE.SB
save XDUT.XCTRL.XBIT4.XSTORE.X006.MID
save XDUT.XCTRL.XBIT4.XSTORE.X012.MID
save XDUT.XCTRL.XBIT5.NEXT_D
save XDUT.XCTRL.XBIT5.X002.AB
save XDUT.XCTRL.XBIT5.X002.BB
save XDUT.XCTRL.XBIT5.X002.X002.MID
save XDUT.XCTRL.XBIT5.XMUX.N0
save XDUT.XCTRL.XBIT5.XMUX.N1
save XDUT.XCTRL.XBIT5.XMUX.SB
save XDUT.XCTRL.XBIT5.XMUX.X001.MID
save XDUT.XCTRL.XBIT5.XMUX.X002.MID
save XDUT.XCTRL.XBIT5.XMUX.X003.MID
save XDUT.XCTRL.XBIT5.XSTORE.CKB
save XDUT.XCTRL.XBIT5.XSTORE.M
save XDUT.XCTRL.XBIT5.XSTORE.MB
save XDUT.XCTRL.XBIT5.XSTORE.MQ
save XDUT.XCTRL.XBIT5.XSTORE.RN
save XDUT.XCTRL.XBIT5.XSTORE.S
save XDUT.XCTRL.XBIT5.XSTORE.SB
save XDUT.XCTRL.XBIT5.XSTORE.X006.MID
save XDUT.XCTRL.XBIT5.XSTORE.X012.MID
save XDUT.XCTRL.XBIT6.NEXT_D
save XDUT.XCTRL.XBIT6.X002.AB
save XDUT.XCTRL.XBIT6.X002.BB
save XDUT.XCTRL.XBIT6.X002.X002.MID
save XDUT.XCTRL.XBIT6.XMUX.N0
save XDUT.XCTRL.XBIT6.XMUX.N1
save XDUT.XCTRL.XBIT6.XMUX.SB
save XDUT.XCTRL.XBIT6.XMUX.X001.MID
save XDUT.XCTRL.XBIT6.XMUX.X002.MID
save XDUT.XCTRL.XBIT6.XMUX.X003.MID
save XDUT.XCTRL.XBIT6.XSTORE.CKB
save XDUT.XCTRL.XBIT6.XSTORE.M
save XDUT.XCTRL.XBIT6.XSTORE.MB
save XDUT.XCTRL.XBIT6.XSTORE.MQ
save XDUT.XCTRL.XBIT6.XSTORE.RN
save XDUT.XCTRL.XBIT6.XSTORE.S
save XDUT.XCTRL.XBIT6.XSTORE.SB
save XDUT.XCTRL.XBIT6.XSTORE.X006.MID
save XDUT.XCTRL.XBIT6.XSTORE.X012.MID
save XDUT.XCTRL.XBIT7.NEXT_D
save XDUT.XCTRL.XBIT7.X002.AB
save XDUT.XCTRL.XBIT7.X002.BB
save XDUT.XCTRL.XBIT7.X002.X002.MID
save XDUT.XCTRL.XBIT7.XMUX.N0
save XDUT.XCTRL.XBIT7.XMUX.N1
save XDUT.XCTRL.XBIT7.XMUX.SB
save XDUT.XCTRL.XBIT7.XMUX.X001.MID
save XDUT.XCTRL.XBIT7.XMUX.X002.MID
save XDUT.XCTRL.XBIT7.XMUX.X003.MID
save XDUT.XCTRL.XBIT7.XSTORE.CKB
save XDUT.XCTRL.XBIT7.XSTORE.M
save XDUT.XCTRL.XBIT7.XSTORE.MB
save XDUT.XCTRL.XBIT7.XSTORE.MQ
save XDUT.XCTRL.XBIT7.XSTORE.RN
save XDUT.XCTRL.XBIT7.XSTORE.S
save XDUT.XCTRL.XBIT7.XSTORE.SB
save XDUT.XCTRL.XBIT7.XSTORE.X006.MID
save XDUT.XCTRL.XBIT7.XSTORE.X012.MID
save XDUT.XCTRL.XSEQ.NT7
save XDUT.XCTRL.XSEQ.XF0.CKB
save XDUT.XCTRL.XSEQ.XF0.M
save XDUT.XCTRL.XSEQ.XF0.MB
save XDUT.XCTRL.XSEQ.XF0.MQ
save XDUT.XCTRL.XSEQ.XF0.RN
save XDUT.XCTRL.XSEQ.XF0.S
save XDUT.XCTRL.XSEQ.XF0.SB
save XDUT.XCTRL.XSEQ.XF0.X006.MID
save XDUT.XCTRL.XSEQ.XF0.X012.MID
save XDUT.XCTRL.XSEQ.XF1.CKB
save XDUT.XCTRL.XSEQ.XF1.M
save XDUT.XCTRL.XSEQ.XF1.MB
save XDUT.XCTRL.XSEQ.XF1.MQ
save XDUT.XCTRL.XSEQ.XF1.RN
save XDUT.XCTRL.XSEQ.XF1.S
save XDUT.XCTRL.XSEQ.XF1.SB
save XDUT.XCTRL.XSEQ.XF1.X006.MID
save XDUT.XCTRL.XSEQ.XF1.X012.MID
save XDUT.XCTRL.XSEQ.XF2.CKB
save XDUT.XCTRL.XSEQ.XF2.M
save XDUT.XCTRL.XSEQ.XF2.MB
save XDUT.XCTRL.XSEQ.XF2.MQ
save XDUT.XCTRL.XSEQ.XF2.RN
save XDUT.XCTRL.XSEQ.XF2.S
save XDUT.XCTRL.XSEQ.XF2.SB
save XDUT.XCTRL.XSEQ.XF2.X006.MID
save XDUT.XCTRL.XSEQ.XF2.X012.MID
save XDUT.XCTRL.XSEQ.XF3.CKB
save XDUT.XCTRL.XSEQ.XF3.M
save XDUT.XCTRL.XSEQ.XF3.MB
save XDUT.XCTRL.XSEQ.XF3.MQ
save XDUT.XCTRL.XSEQ.XF3.RN
save XDUT.XCTRL.XSEQ.XF3.S
save XDUT.XCTRL.XSEQ.XF3.SB
save XDUT.XCTRL.XSEQ.XF3.X006.MID
save XDUT.XCTRL.XSEQ.XF3.X012.MID
save XDUT.XCTRL.XSEQ.XF4.CKB
save XDUT.XCTRL.XSEQ.XF4.M
save XDUT.XCTRL.XSEQ.XF4.MB
save XDUT.XCTRL.XSEQ.XF4.MQ
save XDUT.XCTRL.XSEQ.XF4.RN
save XDUT.XCTRL.XSEQ.XF4.S
save XDUT.XCTRL.XSEQ.XF4.SB
save XDUT.XCTRL.XSEQ.XF4.X006.MID
save XDUT.XCTRL.XSEQ.XF4.X012.MID
save XDUT.XCTRL.XSEQ.XF5.CKB
save XDUT.XCTRL.XSEQ.XF5.M
save XDUT.XCTRL.XSEQ.XF5.MB
save XDUT.XCTRL.XSEQ.XF5.MQ
save XDUT.XCTRL.XSEQ.XF5.RN
save XDUT.XCTRL.XSEQ.XF5.S
save XDUT.XCTRL.XSEQ.XF5.SB
save XDUT.XCTRL.XSEQ.XF5.X006.MID
save XDUT.XCTRL.XSEQ.XF5.X012.MID
save XDUT.XCTRL.XSEQ.XF6.CKB
save XDUT.XCTRL.XSEQ.XF6.M
save XDUT.XCTRL.XSEQ.XF6.MB
save XDUT.XCTRL.XSEQ.XF6.MQ
save XDUT.XCTRL.XSEQ.XF6.RN
save XDUT.XCTRL.XSEQ.XF6.S
save XDUT.XCTRL.XSEQ.XF6.SB
save XDUT.XCTRL.XSEQ.XF6.X006.MID
save XDUT.XCTRL.XSEQ.XF6.X012.MID
save XDUT.XCTRL.XSEQ.XF7.CKB
save XDUT.XCTRL.XSEQ.XF7.M
save XDUT.XCTRL.XSEQ.XF7.MB
save XDUT.XCTRL.XSEQ.XF7.MQ
save XDUT.XCTRL.XSEQ.XF7.RN
save XDUT.XCTRL.XSEQ.XF7.S
save XDUT.XCTRL.XSEQ.XF7.SB
save XDUT.XCTRL.XSEQ.XF7.X006.MID
save XDUT.XCTRL.XSEQ.XF7.X012.MID
save XDUT.XCTRL.XTIM.CLOCK_Q
save XDUT.XCTRL.XTIM.CLOCK_RESET
save XDUT.XCTRL.XTIM.CLOCK_SET
save XDUT.XCTRL.XTIM.CN
save XDUT.XCTRL.XTIM.DEC
save XDUT.XCTRL.XTIM.LIVE
save XDUT.XCTRL.XTIM.NR
save XDUT.XCTRL.XTIM.NRB
save XDUT.XCTRL.XTIM.PR
save XDUT.XCTRL.XTIM.Q0
save XDUT.XCTRL.XTIM.Q1
save XDUT.XCTRL.XTIM.QUIET
save XDUT.XCTRL.XTIM.QUIET_D
save XDUT.XCTRL.XTIM.RAW
save XDUT.XCTRL.XTIM.RAW_D
save XDUT.XCTRL.XTIM.SN
save XDUT.XCTRL.XTIM.UD
save XDUT.XCTRL.XTIM.UN
save XDUT.XCTRL.XTIM.WD
save XDUT.XCTRL.XTIM.WN
save XDUT.XCTRL.XTIM.WRITE_D
save XDUT.XCTRL.XTIM.WRITE_REQ
save XDUT.XCTRL.XTIM.X001.N
save XDUT.XCTRL.XTIM.X001.X000.MID
save XDUT.XCTRL.XTIM.X002.N
save XDUT.XCTRL.XTIM.X003.N
save XDUT.XCTRL.XTIM.X005.N
save XDUT.XCTRL.XTIM.X005.X000.MID
save XDUT.XCTRL.XTIM.X006.N
save XDUT.XCTRL.XTIM.X006.NA
save XDUT.XCTRL.XTIM.X006.NB
save XDUT.XCTRL.XTIM.X006.X000.MID
save XDUT.XCTRL.XTIM.X006.X001.MID
save XDUT.XCTRL.XTIM.X006.X002.MID
save XDUT.XCTRL.XTIM.X006.X003.MID
save XDUT.XCTRL.XTIM.X008.N
save XDUT.XCTRL.XTIM.X008.X000.MID
save XDUT.XCTRL.XTIM.X009.N
save XDUT.XCTRL.XTIM.X009.X000.MID
save XDUT.XCTRL.XTIM.X010.N
save XDUT.XCTRL.XTIM.X010.X000.MID
save XDUT.XCTRL.XTIM.X011.AB
save XDUT.XCTRL.XTIM.X013.N
save XDUT.XCTRL.XTIM.X013.X000.MID
save XDUT.XCTRL.XTIM.X014.N
save XDUT.XCTRL.XTIM.X014.X000.MID
save XDUT.XCTRL.XTIM.X018.N
save XDUT.XCTRL.XTIM.X018.X000.MID
save XDUT.XCTRL.XTIM.X019.N
save XDUT.XCTRL.XTIM.X019.X000.MID
save XDUT.XCTRL.XTIM.X020.N
save XDUT.XCTRL.XTIM.X020.X000.MID
save XDUT.XCTRL.XTIM.X022.N
save XDUT.XCTRL.XTIM.X022.X000.MID
save XDUT.XCTRL.XTIM.X023.AB
save XDUT.XCTRL.XTIM.X023.BB
save XDUT.XCTRL.XTIM.X023.X002.MID
save XDUT.XCTRL.XTIM.X025.N
save XDUT.XCTRL.XTIM.XCLOCK.QB
save XDUT.XCTRL.XTIM.XCLOCK.RB
save XDUT.XCTRL.XTIM.XCLOCK.SN
save XDUT.XCTRL.XTIM.XCLOCK.X001.MID
save XDUT.XCTRL.XTIM.XCLOCK.X002.MID
save XDUT.XCTRL.XTIM.XCLOCK.X003.MID
save XDUT.XCTRL.XTIM.XD_QUIET_D.AB
save XDUT.XCTRL.XTIM.XD_QUIET_D.B
save XDUT.XCTRL.XTIM.XD_QUIET_D.RC0
save XDUT.XCTRL.XTIM.XD_QUIET_D.RC1
save XDUT.XCTRL.XTIM.XD_RAW_D.AB
save XDUT.XCTRL.XTIM.XD_RAW_D.B
save XDUT.XCTRL.XTIM.XD_RAW_D.RC0
save XDUT.XCTRL.XTIM.XD_RAW_D.RC1
save XDUT.XCTRL.XTIM.XD_WRITE_D.AB
save XDUT.XCTRL.XTIM.XD_WRITE_D.B
save XDUT.XCTRL.XTIM.XD_WRITE_D.RC0
save XDUT.XCTRL.XTIM.XD_WRITE_D.RC1
save XDUT.XREF.ACK
save XDUT.XREF.CAP_CLK
save XDUT.XREF.CAP_REQ
save XDUT.XREF.FIRST0
save XDUT.XREF.FIRST1
save XDUT.XREF.FIRST2
save XDUT.XREF.H0
save XDUT.XREF.H1
save XDUT.XREF.H2
save XDUT.XREF.H3
save XDUT.XREF.H4
save XDUT.XREF.H5
save XDUT.XREF.H6
save XDUT.XREF.H7
save XDUT.XREF.L0
save XDUT.XREF.L1
save XDUT.XREF.L2
save XDUT.XREF.L3
save XDUT.XREF.L4
save XDUT.XREF.L5
save XDUT.XREF.L6
save XDUT.XREF.L7
save XDUT.XREF.LATE_CLK
save XDUT.XREF.MSB_DN
save XDUT.XREF.MSB_QN
save XDUT.XREF.Q0
save XDUT.XREF.Q1
save XDUT.XREF.Q2
save XDUT.XREF.Q3
save XDUT.XREF.Q4
save XDUT.XREF.Q5
save XDUT.XREF.Q6
save XDUT.XREF.Q7
save XDUT.XREF.REQ_Q
save XDUT.XREF.REQ_RESET
save XDUT.XREF.TARGET0
save XDUT.XREF.TARGET1
save XDUT.XREF.TARGET2
save XDUT.XREF.TARGET3
save XDUT.XREF.TARGET4
save XDUT.XREF.TARGET5
save XDUT.XREF.TARGET6
save XDUT.XREF.TARGET7
save XDUT.XREF.X000.N
save XDUT.XREF.X001.N
save XDUT.XREF.X002.N
save XDUT.XREF.X003.AB
save XDUT.XREF.X003.BB
save XDUT.XREF.X003.X002.MID
save XDUT.XREF.X007.AB
save XDUT.XREF.X007.BB
save XDUT.XREF.X007.X002.MID
save XDUT.XREF.X008.AB
save XDUT.XREF.XBBM0.CB
save XDUT.XREF.XBBM0.HD
save XDUT.XREF.XBBM0.LD
save XDUT.XREF.XBBM0.X002.N
save XDUT.XREF.XBBM0.X002.X000.MID
save XDUT.XREF.XBBM0.X004.N
save XDUT.XREF.XBBM0.X004.X000.MID
save XDUT.XREF.XBBM0.XD_HD.AB
save XDUT.XREF.XBBM0.XD_HD.B
save XDUT.XREF.XBBM0.XD_HD.RC0
save XDUT.XREF.XBBM0.XD_HD.RC1
save XDUT.XREF.XBBM0.XD_LD.AB
save XDUT.XREF.XBBM0.XD_LD.B
save XDUT.XREF.XBBM0.XD_LD.RC0
save XDUT.XREF.XBBM0.XD_LD.RC1
save XDUT.XREF.XBBM1.CB
save XDUT.XREF.XBBM1.HD
save XDUT.XREF.XBBM1.LD
save XDUT.XREF.XBBM1.X002.N
save XDUT.XREF.XBBM1.X002.X000.MID
save XDUT.XREF.XBBM1.X004.N
save XDUT.XREF.XBBM1.X004.X000.MID
save XDUT.XREF.XBBM1.XD_HD.AB
save XDUT.XREF.XBBM1.XD_HD.B
save XDUT.XREF.XBBM1.XD_HD.RC0
save XDUT.XREF.XBBM1.XD_HD.RC1
save XDUT.XREF.XBBM1.XD_LD.AB
save XDUT.XREF.XBBM1.XD_LD.B
save XDUT.XREF.XBBM1.XD_LD.RC0
save XDUT.XREF.XBBM1.XD_LD.RC1
save XDUT.XREF.XBBM2.CB
save XDUT.XREF.XBBM2.HD
save XDUT.XREF.XBBM2.LD
save XDUT.XREF.XBBM2.X002.N
save XDUT.XREF.XBBM2.X002.X000.MID
save XDUT.XREF.XBBM2.X004.N
save XDUT.XREF.XBBM2.X004.X000.MID
save XDUT.XREF.XBBM2.XD_HD.AB
save XDUT.XREF.XBBM2.XD_HD.B
save XDUT.XREF.XBBM2.XD_HD.RC0
save XDUT.XREF.XBBM2.XD_HD.RC1
save XDUT.XREF.XBBM2.XD_LD.AB
save XDUT.XREF.XBBM2.XD_LD.B
save XDUT.XREF.XBBM2.XD_LD.RC0
save XDUT.XREF.XBBM2.XD_LD.RC1
save XDUT.XREF.XBBM3.CB
save XDUT.XREF.XBBM3.HD
save XDUT.XREF.XBBM3.LD
save XDUT.XREF.XBBM3.X002.N
save XDUT.XREF.XBBM3.X002.X000.MID
save XDUT.XREF.XBBM3.X004.N
save XDUT.XREF.XBBM3.X004.X000.MID
save XDUT.XREF.XBBM3.XD_HD.AB
save XDUT.XREF.XBBM3.XD_HD.B
save XDUT.XREF.XBBM3.XD_HD.RC0
save XDUT.XREF.XBBM3.XD_HD.RC1
save XDUT.XREF.XBBM3.XD_LD.AB
save XDUT.XREF.XBBM3.XD_LD.B
save XDUT.XREF.XBBM3.XD_LD.RC0
save XDUT.XREF.XBBM3.XD_LD.RC1
save XDUT.XREF.XBBM4.CB
save XDUT.XREF.XBBM4.HD
save XDUT.XREF.XBBM4.LD
save XDUT.XREF.XBBM4.X002.N
save XDUT.XREF.XBBM4.X002.X000.MID
save XDUT.XREF.XBBM4.X004.N
save XDUT.XREF.XBBM4.X004.X000.MID
save XDUT.XREF.XBBM4.XD_HD.AB
save XDUT.XREF.XBBM4.XD_HD.B
save XDUT.XREF.XBBM4.XD_HD.RC0
save XDUT.XREF.XBBM4.XD_HD.RC1
save XDUT.XREF.XBBM4.XD_LD.AB
save XDUT.XREF.XBBM4.XD_LD.B
save XDUT.XREF.XBBM4.XD_LD.RC0
save XDUT.XREF.XBBM4.XD_LD.RC1
save XDUT.XREF.XBBM5.CB
save XDUT.XREF.XBBM5.HD
save XDUT.XREF.XBBM5.LD
save XDUT.XREF.XBBM5.X002.N
save XDUT.XREF.XBBM5.X002.X000.MID
save XDUT.XREF.XBBM5.X004.N
save XDUT.XREF.XBBM5.X004.X000.MID
save XDUT.XREF.XBBM5.XD_HD.AB
save XDUT.XREF.XBBM5.XD_HD.B
save XDUT.XREF.XBBM5.XD_HD.RC0
save XDUT.XREF.XBBM5.XD_HD.RC1
save XDUT.XREF.XBBM5.XD_LD.AB
save XDUT.XREF.XBBM5.XD_LD.B
save XDUT.XREF.XBBM5.XD_LD.RC0
save XDUT.XREF.XBBM5.XD_LD.RC1
save XDUT.XREF.XBBM6.CB
save XDUT.XREF.XBBM6.HD
save XDUT.XREF.XBBM6.LD
save XDUT.XREF.XBBM6.X002.N
save XDUT.XREF.XBBM6.X002.X000.MID
save XDUT.XREF.XBBM6.X004.N
save XDUT.XREF.XBBM6.X004.X000.MID
save XDUT.XREF.XBBM6.XD_HD.AB
save XDUT.XREF.XBBM6.XD_HD.B
save XDUT.XREF.XBBM6.XD_HD.RC0
save XDUT.XREF.XBBM6.XD_HD.RC1
save XDUT.XREF.XBBM6.XD_LD.AB
save XDUT.XREF.XBBM6.XD_LD.B
save XDUT.XREF.XBBM6.XD_LD.RC0
save XDUT.XREF.XBBM6.XD_LD.RC1
save XDUT.XREF.XBBM7.CB
save XDUT.XREF.XBBM7.HD
save XDUT.XREF.XBBM7.LD
save XDUT.XREF.XBBM7.X002.N
save XDUT.XREF.XBBM7.X002.X000.MID
save XDUT.XREF.XBBM7.X004.N
save XDUT.XREF.XBBM7.X004.X000.MID
save XDUT.XREF.XBBM7.XD_HD.AB
save XDUT.XREF.XBBM7.XD_HD.B
save XDUT.XREF.XBBM7.XD_HD.RC0
save XDUT.XREF.XBBM7.XD_HD.RC1
save XDUT.XREF.XBBM7.XD_LD.AB
save XDUT.XREF.XBBM7.XD_LD.B
save XDUT.XREF.XBBM7.XD_LD.RC0
save XDUT.XREF.XBBM7.XD_LD.RC1
save XDUT.XREF.XDRV0.GNNPRE
save XDUT.XREF.XDRV0.GNPA
save XDUT.XREF.XDRV0.GPNPRE
save XDUT.XREF.XDRV0.GPPA
save XDUT.XREF.XDRV1.GNNPRE
save XDUT.XREF.XDRV1.GNPA
save XDUT.XREF.XDRV1.GPNPRE
save XDUT.XREF.XDRV1.GPPA
save XDUT.XREF.XDRV2.GNNPRE
save XDUT.XREF.XDRV2.GNPA
save XDUT.XREF.XDRV2.GPNPRE
save XDUT.XREF.XDRV2.GPPA
save XDUT.XREF.XDRV3.GNNPRE
save XDUT.XREF.XDRV3.GNPA
save XDUT.XREF.XDRV3.GPNPRE
save XDUT.XREF.XDRV3.GPPA
save XDUT.XREF.XDRV4.GNNPRE
save XDUT.XREF.XDRV4.GNPA
save XDUT.XREF.XDRV4.GPNPRE
save XDUT.XREF.XDRV4.GPPA
save XDUT.XREF.XDRV5.GNNPRE
save XDUT.XREF.XDRV5.GNPA
save XDUT.XREF.XDRV5.GPNPRE
save XDUT.XREF.XDRV5.GPPA
save XDUT.XREF.XDRV6.GNNPRE
save XDUT.XREF.XDRV6.GNPA
save XDUT.XREF.XDRV6.GPNPRE
save XDUT.XREF.XDRV6.GPPA
save XDUT.XREF.XDRV7.GNNPRE
save XDUT.XREF.XDRV7.GNPA
save XDUT.XREF.XDRV7.GPNPRE
save XDUT.XREF.XDRV7.GPPA
save XDUT.XREF.XD_ACK.AB
save XDUT.XREF.XD_ACK.B
save XDUT.XREF.XD_ACK.RC0
save XDUT.XREF.XD_ACK.RC1
save XDUT.XREF.XD_LATE_CLK.AB
save XDUT.XREF.XD_LATE_CLK.B
save XDUT.XREF.XD_LATE_CLK.RC0
save XDUT.XREF.XD_LATE_CLK.RC1
save XDUT.XREF.XMUX0.N0
save XDUT.XREF.XMUX0.N1
save XDUT.XREF.XMUX0.SB
save XDUT.XREF.XMUX0.X001.MID
save XDUT.XREF.XMUX0.X002.MID
save XDUT.XREF.XMUX0.X003.MID
save XDUT.XREF.XMUX1.N0
save XDUT.XREF.XMUX1.N1
save XDUT.XREF.XMUX1.SB
save XDUT.XREF.XMUX1.X001.MID
save XDUT.XREF.XMUX1.X002.MID
save XDUT.XREF.XMUX1.X003.MID
save XDUT.XREF.XMUX2.N0
save XDUT.XREF.XMUX2.N1
save XDUT.XREF.XMUX2.SB
save XDUT.XREF.XMUX2.X001.MID
save XDUT.XREF.XMUX2.X002.MID
save XDUT.XREF.XMUX2.X003.MID
save XDUT.XREF.XMUX3.N0
save XDUT.XREF.XMUX3.N1
save XDUT.XREF.XMUX3.SB
save XDUT.XREF.XMUX3.X001.MID
save XDUT.XREF.XMUX3.X002.MID
save XDUT.XREF.XMUX3.X003.MID
save XDUT.XREF.XMUX4.N0
save XDUT.XREF.XMUX4.N1
save XDUT.XREF.XMUX4.SB
save XDUT.XREF.XMUX4.X001.MID
save XDUT.XREF.XMUX4.X002.MID
save XDUT.XREF.XMUX4.X003.MID
save XDUT.XREF.XMUX5.N0
save XDUT.XREF.XMUX5.N1
save XDUT.XREF.XMUX5.SB
save XDUT.XREF.XMUX5.X001.MID
save XDUT.XREF.XMUX5.X002.MID
save XDUT.XREF.XMUX5.X003.MID
save XDUT.XREF.XMUX6.N0
save XDUT.XREF.XMUX6.N1
save XDUT.XREF.XMUX6.SB
save XDUT.XREF.XMUX6.X001.MID
save XDUT.XREF.XMUX6.X002.MID
save XDUT.XREF.XMUX6.X003.MID
save XDUT.XREF.XMUX7.N0
save XDUT.XREF.XMUX7.N1
save XDUT.XREF.XMUX7.SB
save XDUT.XREF.XMUX7.X001.MID
save XDUT.XREF.XMUX7.X002.MID
save XDUT.XREF.XMUX7.X003.MID
save XDUT.XREF.XREQUEST.QB
save XDUT.XREF.XREQUEST.RB
save XDUT.XREF.XREQUEST.SN
save XDUT.XREF.XREQUEST.X001.MID
save XDUT.XREF.XREQUEST.X002.MID
save XDUT.XREF.XREQUEST.X003.MID
save XDUT.XREF.XSTORE0.CKB
save XDUT.XREF.XSTORE0.M
save XDUT.XREF.XSTORE0.MB
save XDUT.XREF.XSTORE0.MQ
save XDUT.XREF.XSTORE0.RN
save XDUT.XREF.XSTORE0.S
save XDUT.XREF.XSTORE0.SB
save XDUT.XREF.XSTORE0.X006.MID
save XDUT.XREF.XSTORE0.X012.MID
save XDUT.XREF.XSTORE1.CKB
save XDUT.XREF.XSTORE1.M
save XDUT.XREF.XSTORE1.MB
save XDUT.XREF.XSTORE1.MQ
save XDUT.XREF.XSTORE1.RN
save XDUT.XREF.XSTORE1.S
save XDUT.XREF.XSTORE1.SB
save XDUT.XREF.XSTORE1.X006.MID
save XDUT.XREF.XSTORE1.X012.MID
save XDUT.XREF.XSTORE2.CKB
save XDUT.XREF.XSTORE2.M
save XDUT.XREF.XSTORE2.MB
save XDUT.XREF.XSTORE2.MQ
save XDUT.XREF.XSTORE2.RN
save XDUT.XREF.XSTORE2.S
save XDUT.XREF.XSTORE2.SB
save XDUT.XREF.XSTORE2.X006.MID
save XDUT.XREF.XSTORE2.X012.MID
save XDUT.XREF.XSTORE3.CKB
save XDUT.XREF.XSTORE3.M
save XDUT.XREF.XSTORE3.MB
save XDUT.XREF.XSTORE3.MQ
save XDUT.XREF.XSTORE3.RN
save XDUT.XREF.XSTORE3.S
save XDUT.XREF.XSTORE3.SB
save XDUT.XREF.XSTORE3.X006.MID
save XDUT.XREF.XSTORE3.X012.MID
save XDUT.XREF.XSTORE4.CKB
save XDUT.XREF.XSTORE4.M
save XDUT.XREF.XSTORE4.MB
save XDUT.XREF.XSTORE4.MQ
save XDUT.XREF.XSTORE4.RN
save XDUT.XREF.XSTORE4.S
save XDUT.XREF.XSTORE4.SB
save XDUT.XREF.XSTORE4.X006.MID
save XDUT.XREF.XSTORE4.X012.MID
save XDUT.XREF.XSTORE5.CKB
save XDUT.XREF.XSTORE5.M
save XDUT.XREF.XSTORE5.MB
save XDUT.XREF.XSTORE5.MQ
save XDUT.XREF.XSTORE5.RN
save XDUT.XREF.XSTORE5.S
save XDUT.XREF.XSTORE5.SB
save XDUT.XREF.XSTORE5.X006.MID
save XDUT.XREF.XSTORE5.X012.MID
save XDUT.XREF.XSTORE6.CKB
save XDUT.XREF.XSTORE6.M
save XDUT.XREF.XSTORE6.MB
save XDUT.XREF.XSTORE6.MQ
save XDUT.XREF.XSTORE6.RN
save XDUT.XREF.XSTORE6.S
save XDUT.XREF.XSTORE6.SB
save XDUT.XREF.XSTORE6.X006.MID
save XDUT.XREF.XSTORE6.X012.MID
save XDUT.XREF.XSTORE7.CKB
save XDUT.XREF.XSTORE7.M
save XDUT.XREF.XSTORE7.MB
save XDUT.XREF.XSTORE7.MQ
save XDUT.XREF.XSTORE7.RN
save XDUT.XREF.XSTORE7.S
save XDUT.XREF.XSTORE7.SB
save XDUT.XREF.XSTORE7.X006.MID
save XDUT.XREF.XSTORE7.X012.MID
save VSENSE_N:1
save VSENSE_P:1
save VVDD:1
save XCDAC.CMOMN0:1
save XCDAC.CMOMN1:1
save XCDAC.CMOMN2:1
save XCDAC.CMOMN3:1
save XCDAC.CMOMN4:1
save XCDAC.CMOMN5:1
save XCDAC.CMOMN6:1
save XCDAC.CMOMN7:1
save XCDAC.CMOMN8:1
save XCDAC.CMOMP0:1
save XCDAC.CMOMP1:1
save XCDAC.CMOMP2:1
save XCDAC.CMOMP3:1
save XCDAC.CMOMP4:1
save XCDAC.CMOMP5:1
save XCDAC.CMOMP6:1
save XCDAC.CMOMP7:1
save XCDAC.CMOMP8:1
save XDUT.XCOMP.MNINN:2
save XDUT.XCOMP.MNINP:2
