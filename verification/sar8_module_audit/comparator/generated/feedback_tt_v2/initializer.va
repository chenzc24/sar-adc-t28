// Testbench charge initialization only; not a transistor sampling switch.
`include "disciplines.vams"
module cmp_charge_initializer(p, n, control, reference);
    inout p, n;
    input control, reference;
    electrical p, n, control, reference;
    parameter real ron = 10.0 from (0:inf);
    parameter real control_high = 0.9 from (0:inf);
    real factor;
    analog begin
        factor = V(control, reference) / control_high;
        if (factor < 0.0) factor = 0.0;
        if (factor > 1.0) factor = 1.0;
        I(p, n) <+ factor * V(p, n) / ron;
    end
endmodule
