subckt audit_cdac_hold TOPN TOPP VCM VREFN VREFP
    CMOMN8 (TOPN VREFN) cfmom_2t nr=8 lr=2u w=50n s=50n stm=1 spm=3          multi=1 mismatchflag=1
    CMOMN7 (TOPN VCM) cfmom_2t nr=8 lr=2u w=50n s=50n stm=1 spm=3          multi=128 mismatchflag=1
    CMOMN6 (TOPN VCM) cfmom_2t nr=8 lr=2u w=50n s=50n stm=1 spm=3 multi=64          mismatchflag=1
    CMOMN5 (TOPN VCM) cfmom_2t nr=8 lr=2u w=50n s=50n stm=1 spm=3 multi=32          mismatchflag=1
    CMOMN4 (TOPN VCM) cfmom_2t nr=8 lr=2u w=50n s=50n stm=1 spm=3 multi=16          mismatchflag=1
    CMOMN3 (TOPN VCM) cfmom_2t nr=8 lr=2u w=50n s=50n stm=1 spm=3 multi=8          mismatchflag=1
    CMOMN2 (TOPN VCM) cfmom_2t nr=8 lr=2u w=50n s=50n stm=1 spm=3 multi=4          mismatchflag=1
    CMOMN1 (TOPN VCM) cfmom_2t nr=8 lr=2u w=50n s=50n stm=1 spm=3 multi=2          mismatchflag=1
    CMOMN0 (TOPN VCM) cfmom_2t nr=8 lr=2u w=50n s=50n stm=1 spm=3 multi=1          mismatchflag=1
    CMOMP8 (TOPP VREFP) cfmom_2t nr=8 lr=2u w=50n s=50n stm=1 spm=3          multi=1 mismatchflag=1
    CMOMP7 (TOPP VCM) cfmom_2t nr=8 lr=2u w=50n s=50n stm=1 spm=3          multi=128 mismatchflag=1
    CMOMP6 (TOPP VCM) cfmom_2t nr=8 lr=2u w=50n s=50n stm=1 spm=3 multi=64          mismatchflag=1
    CMOMP5 (TOPP VCM) cfmom_2t nr=8 lr=2u w=50n s=50n stm=1 spm=3 multi=32          mismatchflag=1
    CMOMP4 (TOPP VCM) cfmom_2t nr=8 lr=2u w=50n s=50n stm=1 spm=3 multi=16          mismatchflag=1
    CMOMP3 (TOPP VCM) cfmom_2t nr=8 lr=2u w=50n s=50n stm=1 spm=3 multi=8          mismatchflag=1
    CMOMP2 (TOPP VCM) cfmom_2t nr=8 lr=2u w=50n s=50n stm=1 spm=3 multi=4          mismatchflag=1
    CMOMP1 (TOPP VCM) cfmom_2t nr=8 lr=2u w=50n s=50n stm=1 spm=3 multi=2          mismatchflag=1
    CMOMP0 (TOPP VCM) cfmom_2t nr=8 lr=2u w=50n s=50n stm=1 spm=3 multi=1          mismatchflag=1
ends audit_cdac_hold
