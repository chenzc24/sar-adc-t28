`include "constants.vams"
`include "disciplines.vams"

// TB charge-history actuator. Reads PHI_U/CLK; drives only MOM bottom rails.
module cmp_history_charge(bottom_p, bottom_n, mark, clk, update, supply, vcm, ref);
    output bottom_p, bottom_n, mark;
    input clk, update, supply, vcm;
    inout ref;
    electrical bottom_p, bottom_n, mark, clk, update, supply, vcm, ref;
    parameter real amp_v = 0.02911764705882353;
    parameter real step_sign = 1.0;
    parameter real delay_s = 900e-12 from [0:inf);
    parameter real slew_s = 200e-12 from (0:inf);
    integer armed, fired;
    real step_value;
    analog begin
        @(initial_step) begin
            armed = 0;
            fired = 0;
        end
        @(cross(V(update, ref) - 0.5 * V(supply, ref), +1)) begin
            if (fired == 0) armed = 1;
        end
        @(cross(V(clk, ref) - 0.1 * V(supply, ref), -1)) begin
            if ((armed != 0) && (fired == 0)) begin
                fired = 1;
                armed = 0;
            end
        end
        step_value = transition(fired, delay_s, slew_s, slew_s);
        V(bottom_p, ref) <+ V(vcm, ref) + step_sign * amp_v * step_value;
        V(bottom_n, ref) <+ V(vcm, ref) - step_sign * amp_v * step_value;
        V(mark, ref) <+ V(supply, ref) * transition(fired, 0, 1e-12, 1e-12);
    end
endmodule
