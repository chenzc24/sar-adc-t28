// TB wrapper: unchanged native body, two passive observation ports.
subckt audit_history_feedback TOPP TOPN SAMPLE_INT VDD VSS D0 D1 D2 D3 D4 D5 D6 D7 CMP_CLK PHI_U
    XCTRL (CMP_CLK CODE0 CODE1 CODE2 CODE3 CODE4 CODE5 CODE6 CODE7 COMP_N COMP_P D0 D1 D2 D3 D4 D5 D6 D7 PHI_U SAMPLE_INT VDD VSS ACTIVE) sar8i_ctrl
    XCOMP (CMP_CLK COMP_N COMP_P VDD TOPN TOPP VSS) sar_strongarm_t28
    CL_COMP_N (COMP_N VSS) cfmom_2t nr=8 lr=2.5u w=50n s=50n stm=1 spm=3  multi=2 mismatchflag=1
    CL_COMP_P (COMP_P VSS) cfmom_2t nr=8 lr=2.5u w=50n s=50n stm=1 spm=3  multi=2 mismatchflag=1
    CL_CMP_CLK (CMP_CLK VSS) cfmom_2t nr=8 lr=2.5u w=50n s=50n stm=1 spm=3  multi=2 mismatchflag=1
    XREF (CODE0 CODE1 CODE2 CODE3 CODE4 CODE5 CODE6 CODE7 D0 D1 D2 D3 D4 D5 D6 D7 PHI_U SAMPLE_INT VDD VSS SAMPLE_INT SAMPLE_INT SAMPLE_INT SAMPLE_INT SAMPLE_INT SAMPLE_INT SAMPLE_INT SAMPLE_INT) audit_ref_receive
ends audit_history_feedback
