// External interface sources / impedances / loads only.

// SAR_ADC_T28/tb_sar_adc8_join_r4/schematic
XDUT (D0 D1 D2 D3 D4 D5 D6 D7 SAMPLE VDD! VINN VINP VREFN VREFP 0) sar_adc8_join_r4
VREFLOW (VREFN_SRC 0) vsource dc=0 type=dc
VREFHIGH (VREFP_SRC 0) vsource dc=0.9 type=dc
VVDD (VDD! 0) vsource dc=SUP type=dc
VSAMPLE (SAMPLE 0) vsource type=pulse val0=0 val1=SUP delay=101n rise=100p fall=100p width=39.9n period=100n
RREFN (VREFN_SRC VREFN) resistor r=50
RINN (VINN_SRC VINN) resistor r=50
RREFP (VREFP_SRC VREFP) resistor r=50
RINP (VINP_SRC VINP) resistor r=50
COUT7 (D7 0) capacitor c=5f
COUT6 (D6 0) capacitor c=5f
COUT5 (D5 0) capacitor c=5f
COUT4 (D4 0) capacitor c=5f
COUT3 (D3 0) capacitor c=5f
COUT2 (D2 0) capacitor c=5f
COUT1 (D1 0) capacitor c=5f
COUT0 (D0 0) capacitor c=5f
CREFN (VREFN 0) capacitor c=4p
CREFP (VREFP 0) capacitor c=4p
VVINP (VINP_SRC 0) vsource type=pwl wave=[0n 0.0017578125 200.8n 0.0017578125 200.9n 0.0017578125 300.8n 0.0017578125 300.9n 0.0439453125 400.8n 0.0439453125 400.9n 0.4482421875 500.8n 0.4482421875 500.9n 0.4517578125 600.8n 0.4517578125 600.9n 0.8560546875 700.8n 0.8560546875 700.9n 0.8982421875 800.8n 0.8982421875 800.9n 0.8982421875 900.8n 0.8982421875 900.9n 0.0017578125 1000.8n 0.0017578125 1000.9n 0.4517578125 1100n 0.4517578125]
VVINN (VINN_SRC 0) vsource type=pwl wave=[0n 0.8982421875 200.8n 0.8982421875 200.9n 0.8982421875 300.8n 0.8982421875 300.9n 0.8560546875 400.8n 0.8560546875 400.9n 0.4517578125 500.8n 0.4517578125 500.9n 0.4482421875 600.8n 0.4482421875 600.9n 0.0439453125 700.8n 0.0439453125 700.9n 0.0017578125 800.8n 0.0017578125 800.9n 0.0017578125 900.8n 0.0017578125 900.9n 0.8982421875 1000.8n 0.8982421875 1000.9n 0.4482421875 1100n 0.4482421875]
