`include "disciplines.vams"
module faulty(out);
output out; electrical out;
analog begin V(out) <+ ((V(out)>0.5) ? 0.0 : 1.0); end
endmodule
