simulator lang=spectre
global 0
V1 (out 0) vsource dc=0
V2 (out 0) vsource dc=1
opts options temp=27 reltol=1e-5 vabstol=1e-7 iabstol=1e-12
saveOptions options save=selected
save in out
tran_live tran stop=20n maxstep=100p
