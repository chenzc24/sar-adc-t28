simulator lang=spectre
global 0
VIN (in 0) vsource type=sine ampl=1 freq=1Meg
R1 (in out) resistor r=1k
C1 (out 0) capacitor c=1p
opts options temp=27 reltol=1e-5
saveOptions options save=none
tran_live tran stop=1 maxstep=1p save=nooutput
