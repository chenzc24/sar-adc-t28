simulator lang=spectre
global 0
include "/home/process/simcheck_intentionally_missing_20261103.scs"
VIN (in 0) vsource type=pulse val0=0 val1=1 delay=1n rise=10p fall=10p width=2n period=4n
R1 (in out) resistor r=1k
C1 (out 0) capacitor c=1p
opts options temp=27 reltol=1e-5 vabstol=1e-7 iabstol=1e-12
saveOptions options save=selected
save in out
tran_live tran stop=20n maxstep=100p
