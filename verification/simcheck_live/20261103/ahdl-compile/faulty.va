`include "disciplines.vams"
module faulty(out);
output out; electrical out;
analog begin V(out) <+ SIMCHECK_UNDECLARED_SYMBOL; end
endmodule
