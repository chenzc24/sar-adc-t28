`include "disciplines.vams"
module faulty(out);
output out; electrical out;
analog begin
if ($abstime < 5e-9) V(out) <+ 0.0;
else V(out) <+ ((V(out)>0.5) ? 0.0 : 1.0);
end
endmodule
