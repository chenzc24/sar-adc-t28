simulator lang=spectre
global 0
ahdl_include "faulty.va"
X1 (out) faulty
opts options temp=27 reltol=1e-5 vabstol=1e-7 iabstol=1e-12
saveOptions options save=selected
save in out
conv options homotopy=none dcmaxiters=20 max_minstep_nonconv=1 max_approach_minstep=1 diagnose=yes
tran_live tran stop=20n maxstep=100p minstep=1p
