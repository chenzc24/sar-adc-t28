* Draft: each ? is something the drawing does not say yet
.subckt sar_bootstrap VDD VSS PHI PHIB VIN VCM
XCBOOT BTOP BBOT sky130_fd_pr__cap_mim_m3_1 w=5 l=5 mf=1
XCP1 P1 PHIB sky130_fd_pr__cap_mim_m3_1 w=5 l=5 mf=1
XCP2 P2 PHI sky130_fd_pr__cap_mim_m3_1 w=5 l=5 mf=1
Cu VOUT VCM 1p
XMN1 VDD P2 P1 VSS sky130_fd_pr__nfet_01v8 l=0.03 w=0.25 nf=1 m=2
XMN10 GCLAMP PHIB VSS VSS sky130_fd_pr__nfet_01v8 l=0.03 w=0.25 nf=1 m=4
XMN11 VOUT net1 VIN VIN sky130_fd_pr__nfet_01v8 l=0.06 w=0.25 nf=1 m=8
XMN12 BBOT PHIB VSS VSS sky130_fd_pr__nfet_01v8 l=0.03 w=0.25 nf=1 m=4
XMN13 CTRL net0 BBOT VSS sky130_fd_pr__nfet_01v8 l=0.03 w=0.25 nf=1 m=2
XMN2 VDD P1 P2 VSS sky130_fd_pr__nfet_01v8 l=0.03 w=0.25 nf=1 m=2
XMN3 VDD P1 BTOP VSS sky130_fd_pr__nfet_01v8 l=0.03 w=0.25 nf=1 m=2
XMN5 CTRL PHI BBOT VSS sky130_fd_pr__nfet_01v8 l=0.03 w=0.25 nf=1 m=2
XMN7 net0 VDD GCLAMP VSS sky130_fd_pr__nfet_01v8 l=0.06 w=0.25 nf=1 m=2
XMN9 BBOT net0 VIN VIN sky130_fd_pr__nfet_01v8 l=0.06 w=0.25 nf=1 m=4
XMP4 CTRL PHI VDD VDD sky130_fd_pr__pfet_01v8 l=0.03 w=0.25 nf=1 m=2
XMP8 BTOP CTRL net0 net0 sky130_fd_pr__pfet_01v8 l=0.03 w=0.25 nf=1 m=4
.ends sar_bootstrap
