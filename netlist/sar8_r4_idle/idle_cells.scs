// Native idle-tail MSB-first reference reset candidate; not an OA export.
// Replace frozen top; retain unchanged frozen leaf definitions.
subckt sar8r_delay A VDD VSS Y
R1 (B RC1 ) rupolym l=17.13u w=1u m=1 multi=(1)

R0 (A RC0 ) rupolym l=17.13u w=1u m=1 multi=(1)

    C1 (RC1 VSS) cfmom_2t nr=8 lr=2.5u w=50n s=50n stm=1 spm=3 multi=20  mismatchflag=1
    C0 (RC0 VSS) cfmom_2t nr=8 lr=2.5u w=50n s=50n stm=1 spm=3 multi=20  mismatchflag=1
    X006 (A VDD VSS AB) sar8p_inv
    X005 (RC1 VDD VSS Y) sar8p_inv
    X002 (RC0 VDD VSS B) sar8p_inv
    MN_CLEAR (RC0 AB VSS VSS) nch_mac l=30n w=2u multi=1 nf=1 sd=100n  ad=1.5e-13 as=1.5e-13 pd=4.15u ps=4.15u nrd=0.144730 nrs=0.144730  sa=75.0n sb=75.0n sa1=75.0n sa2=75.0n sa3=75.0n sa4=75.0n  sb1=75.0n sb2=75.0n sb3=75.0n spa=100n spa1=100n spa2=100n  spa3=100n sap=91.9776n sapb=114.444n spba=115.715n spba1=117.043n  dfm_flag=0 spmt=1.11111e+15 spomt=0 spomt1=1.11111e+60  spmb=1.11111e+15 spomb=0 spomb1=1.11111e+60
    MP_CLEAR (RC1 A VDD VDD) pch_mac l=30n w=3u multi=1 nf=1 sd=100n  ad=2.25e-13 as=2.25e-13 pd=6.15u ps=6.15u nrd=0.055246  nrs=0.055246 sa=75.0n sb=75.0n sa1=75.0n sa2=75.0n sa3=75.0n  sa4=75.0n sb1=75.0n sb2=75.0n sb3=75.0n spa=100n spa1=100n  spa2=100n spa3=100n sap=91.9776n sapb=114.444n spba=115.715n  spba1=117.043n dfm_flag=0 spmt=1.11111e+15 spomt=0  spomt1=1.11111e+60 spmb=1.11111e+15 spomb=0 spomb1=1.11111e+60
ends sar8r_delay

subckt sar8r_edge A VDD VSS Y
    XD (A VDD VSS AD) sar8r_delay
    XA (A AD VDD VSS QUAL) sar8p_and2
    XB (QUAL VDD VSS Y) sar8p_clkbuf
ends sar8r_edge

subckt sar_adc8_join_r4 D0 D1 D2 D3 D4 D5 D6 D7 SAMPLE VDD! VINN VINP  VREFN VREFP 0
    XSEQ (SAMPLE_MATCH VDD! 0 SEQ_SAMPLE) sar8r_edge
    XIDLE (ACTIVE SAMPLE_INT VDD! 0 PRESET SAMPLE_MATCH) sar8i_idle
    XSAMPLE (SAMPLE VDD! 0 SAMPLE_INT) sar8p_clkbuf
    XBOOTN (SEQ_SAMPLE TOPN VINN) sar_bootstrap_flat_8b_p
    XBOOTP (SEQ_SAMPLE TOPP VINP) sar_bootstrap_flat_8b_p
    XCDAC (GNN0 GNN1 GNN2 GNN3 GNN4 GNN5 GNN6 GNN7 GNP0 GNP1 GNP2 GNP3  GNP4 GNP5 GNP6 GNP7 GPN0 GPN1 GPN2 GPN3 GPN4 GPN5 GPN6 GPN7 GPP0  GPP1 GPP2 GPP3 GPP4 GPP5 GPP6 GPP7 TOPN TOPP VDD! VREFN VREFP 0)  sar8j_r1_cdac
    XCTRL (CMP_CLK CODE0 CODE1 CODE2 CODE3 CODE4 CODE5 CODE6 CODE7 COMP_N  COMP_P D0 D1 D2 D3 D4 D5 D6 D7 PHI_U SAMPLE_INT VDD! 0 ACTIVE)  sar8i_ctrl
    XREF (CODE0 CODE1 CODE2 CODE3 CODE4 CODE5 CODE6 CODE7 D0 D1 D2 D3 D4  D5 D6 D7 GNN0 GNN1 GNN2 GNN3 GNN4 GNN5 GNN6 GNN7 GNP0 GNP1 GNP2  GNP3 GNP4 GNP5 GNP6 GNP7 GPN0 GPN1 GPN2 GPN3 GPN4 GPN5 GPN6 GPN7  GPP0 GPP1 GPP2 GPP3 GPP4 GPP5 GPP6 GPP7 PHI_U SAMPLE_INT VDD! 0 RST_DONE PRESET)  sar8i_refword
    XCOMP (CMP_CLK COMP_N COMP_P VDD! TOPN TOPP 0) sar_strongarm_t28
    CL_COMP_N (COMP_N 0) cfmom_2t nr=8 lr=2.5u w=50n s=50n stm=1 spm=3  multi=2 mismatchflag=1
    CL_COMP_P (COMP_P 0) cfmom_2t nr=8 lr=2.5u w=50n s=50n stm=1 spm=3  multi=2 mismatchflag=1
    CL_CMP_CLK (CMP_CLK 0) cfmom_2t nr=8 lr=2.5u w=50n s=50n stm=1 spm=3  multi=2 mismatchflag=1
ends sar_adc8_join_r4

subckt sar8s_step A VDD VSS Y
R1 (B RC1 ) rupolym l=17.13u w=1u m=1 multi=(1)

R0 (A RC0 ) rupolym l=17.13u w=1u m=1 multi=(1)

    C1 (RC1 VSS) cfmom_2t nr=8 lr=2.5u w=50n s=50n stm=1 spm=3 multi=6  mismatchflag=1
    C0 (RC0 VSS) cfmom_2t nr=8 lr=2.5u w=50n s=50n stm=1 spm=3 multi=6  mismatchflag=1
    X006 (A VDD VSS AB) sar8p_inv
    X005 (RC1 VDD VSS Y) sar8p_inv
    X002 (RC0 VDD VSS B) sar8p_inv
    MN_CLEAR (RC0 AB VSS VSS) nch_mac l=30n w=2u multi=1 nf=1 sd=100n  ad=1.5e-13 as=1.5e-13 pd=4.15u ps=4.15u nrd=0.144730 nrs=0.144730  sa=75.0n sb=75.0n sa1=75.0n sa2=75.0n sa3=75.0n sa4=75.0n  sb1=75.0n sb2=75.0n sb3=75.0n spa=100n spa1=100n spa2=100n  spa3=100n sap=91.9776n sapb=114.444n spba=115.715n spba1=117.043n  dfm_flag=0 spmt=1.11111e+15 spomt=0 spomt1=1.11111e+60  spmb=1.11111e+15 spomb=0 spomb1=1.11111e+60
    MP_CLEAR (RC1 A VDD VDD) pch_mac l=30n w=3u multi=1 nf=1 sd=100n  ad=2.25e-13 as=2.25e-13 pd=6.15u ps=6.15u nrd=0.055246  nrs=0.055246 sa=75.0n sb=75.0n sa1=75.0n sa2=75.0n sa3=75.0n  sa4=75.0n sb1=75.0n sb2=75.0n sb3=75.0n spa=100n spa1=100n  spa2=100n spa3=100n sap=91.9776n sapb=114.444n spba=115.715n  spba1=117.043n dfm_flag=0 spmt=1.11111e+15 spomt=0  spomt1=1.11111e+60 spmb=1.11111e+15 spomb=0 spomb1=1.11111e+60
ends sar8s_step

subckt sar8s_refword CODE0 CODE1 CODE2 CODE3 CODE4 CODE5 CODE6 CODE7 D0 D1  D2 D3 D4 D5 D6 D7 GNN0 GNN1 GNN2 GNN3 GNN4 GNN5 GNN6 GNN7 GNP0  GNP1 GNP2 GNP3 GNP4 GNP5 GNP6 GNP7 GPN0 GPN1 GPN2 GPN3 GPN4 GPN5  GPN6 GPN7 GPP0 GPP1 GPP2 GPP3 GPP4 GPP5 GPP6 GPP7 PHI_U SAMPLE VDD  VSS RST_DONE
    XRR7 (SAMPLE SAMPLE VDD VSS RST7) sar8p_and2
    XRSTEP1 (SAMPLE VDD VSS TAP1) sar8s_step
    XRR6 (SAMPLE TAP1 VDD VSS RST6) sar8p_and2
    XRSTEP2 (TAP1 VDD VSS TAP2) sar8s_step
    XRR5 (SAMPLE TAP2 VDD VSS RST5) sar8p_and2
    XRSTEP3 (TAP2 VDD VSS TAP3) sar8s_step
    XRR4 (SAMPLE TAP3 VDD VSS RST4) sar8p_and2
    XRSTEP4 (TAP3 VDD VSS TAP4) sar8s_step
    XRR3 (SAMPLE TAP4 VDD VSS RST3) sar8p_and2
    XRSTEP5 (TAP4 VDD VSS TAP5) sar8s_step
    XRR2 (SAMPLE TAP5 VDD VSS RST2) sar8p_and2
    XRSTEP6 (TAP5 VDD VSS TAP6) sar8s_step
    XRR1 (SAMPLE TAP6 VDD VSS RST1) sar8p_and2
    XRSTEP7 (TAP6 VDD VSS TAP7) sar8s_step
    XRR0 (SAMPLE TAP7 VDD VSS RST0) sar8p_and2
    XRDONE (RST0 VDD VSS RST_DONE) sar8p_buf
    X002 (FIRST1 VDD VSS FIRST2) sar8p_buf
    X001 (FIRST0 VDD VSS FIRST1) sar8p_buf
    X000 (PHI_U VDD VSS FIRST0) sar8p_buf
    X007 (FIRST2 LATE_CLK VDD VSS CAP_REQ) sar8p_or2
    X003 (SAMPLE ACK VDD VSS REQ_RESET) sar8p_or2
    XREQUEST (REQ_Q REQ_RESET PHI_U VDD VSS) sar8p_sr
    XD_LATE_CLK (REQ_Q VDD VSS LATE_CLK) sar8p_delay_capture
    XD_ACK (LATE_CLK VDD VSS ACK) sar8p_delay_valid
    X008 (CAP_REQ VDD VSS CAP_CLK) sar8p_clkbuf
    XMUX7 (CODE7 D7 PHI_U VDD VSS TARGET7) sar8p_mux2
    XMUX6 (CODE6 D6 PHI_U VDD VSS TARGET6) sar8p_mux2
    XMUX5 (CODE5 D5 PHI_U VDD VSS TARGET5) sar8p_mux2
    XMUX4 (CODE4 D4 PHI_U VDD VSS TARGET4) sar8p_mux2
    XMUX3 (CODE3 D3 PHI_U VDD VSS TARGET3) sar8p_mux2
    XMUX2 (CODE2 D2 PHI_U VDD VSS TARGET2) sar8p_mux2
    XMUX1 (CODE1 D1 PHI_U VDD VSS TARGET1) sar8p_mux2
    XMUX0 (CODE0 D0 PHI_U VDD VSS TARGET0) sar8p_mux2
    X018 (MSB_QN VDD VSS Q7) sar8p_inv
    X017 (TARGET7 VDD VSS MSB_DN) sar8p_inv
    XSTORE7 (CAP_CLK MSB_DN MSB_QN RST7 VDD VSS) sar8p_dffr
    XSTORE6 (CAP_CLK TARGET6 Q6 RST6 VDD VSS) sar8p_dffr
    XSTORE5 (CAP_CLK TARGET5 Q5 RST5 VDD VSS) sar8p_dffr
    XSTORE4 (CAP_CLK TARGET4 Q4 RST4 VDD VSS) sar8p_dffr
    XSTORE3 (CAP_CLK TARGET3 Q3 RST3 VDD VSS) sar8p_dffr
    XSTORE2 (CAP_CLK TARGET2 Q2 RST2 VDD VSS) sar8p_dffr
    XSTORE1 (CAP_CLK TARGET1 Q1 RST1 VDD VSS) sar8p_dffr
    XSTORE0 (CAP_CLK TARGET0 Q0 RST0 VDD VSS) sar8p_dffr
    XBBM7 (Q7 H7 L7 VDD VSS) sar8p_nonoverlap
    XBBM6 (Q6 H6 L6 VDD VSS) sar8p_nonoverlap
    XBBM5 (Q5 H5 L5 VDD VSS) sar8p_nonoverlap
    XBBM4 (Q4 H4 L4 VDD VSS) sar8p_nonoverlap
    XBBM3 (Q3 H3 L3 VDD VSS) sar8p_nonoverlap
    XBBM2 (Q2 H2 L2 VDD VSS) sar8p_nonoverlap
    XBBM1 (Q1 H1 L1 VDD VSS) sar8p_nonoverlap
    XBBM0 (Q0 H0 L0 VDD VSS) sar8p_nonoverlap
    XDRV0 (GNN0 GNP0 GPN0 GPP0 H0 L0 VDD VSS) sar8p_refdrv_b0
    XDRV1 (GNN1 GNP1 GPN1 GPP1 H1 L1 VDD VSS) sar8p_refdrv_b1
    XDRV2 (GNN2 GNP2 GPN2 GPP2 H2 L2 VDD VSS) sar8p_refdrv_b2
    XDRV3 (GNN3 GNP3 GPN3 GPP3 H3 L3 VDD VSS) sar8p_refdrv_b3
    XDRV4 (GNN4 GNP4 GPN4 GPP4 H4 L4 VDD VSS) sar8p_refdrv_b4
    XDRV5 (GNN5 GNP5 GPN5 GPP5 H5 L5 VDD VSS) sar8p_refdrv_b5
    XDRV6 (GNN6 GNP6 GPN6 GPP6 H6 L6 VDD VSS) sar8p_refdrv_b6
    XDRV7 (GNN7 GNP7 GPN7 GPP7 H7 L7 VDD VSS) sar8p_refdrv_b7
ends sar8s_refword

subckt sar8i_ctrl CMP_CLK CODE0 CODE1 CODE2 CODE3 CODE4 CODE5  CODE6 CODE7 COMP_N COMP_P D0 D1 D2 D3 D4 D5 D6 D7 PHI_U SAMPLE VDD  VSS ACTIVE
    XTIM (ACTIVE CMP_CLK COMP_N COMP_P DATA PHI_U PHI_W SAMPLE VDD VSS)  sar8p_timing
    XSEQ (PHI_U SAMPLE T0 T1 T2 T3 T4 T5 T6 T7 VDD VSS) sar8p_bitseq8
    XBIT7 (CODE7 D7 DATA PHI_W SAMPLE T7 VDD VSS) sar8p_bit
    XBIT6 (CODE6 D6 DATA PHI_W SAMPLE T6 VDD VSS) sar8p_bit
    XBIT5 (CODE5 D5 DATA PHI_W SAMPLE T5 VDD VSS) sar8p_bit
    XBIT4 (CODE4 D4 DATA PHI_W SAMPLE T4 VDD VSS) sar8p_bit
    XBIT3 (CODE3 D3 DATA PHI_W SAMPLE T3 VDD VSS) sar8p_bit
    XBIT2 (CODE2 D2 DATA PHI_W SAMPLE T2 VDD VSS) sar8p_bit
    XBIT1 (CODE1 D1 DATA PHI_W SAMPLE T1 VDD VSS) sar8p_bit
    XBIT0 (CODE0 D0 DATA PHI_W SAMPLE T0 VDD VSS) sar8p_bit
    X018 (A01 A23 VDD VSS ACTIVE) sar8p_or2
    X017 (A2 A3 VDD VSS A23) sar8p_or2
    X016 (A0 A1 VDD VSS A01) sar8p_or2
    X015 (T6 T7 VDD VSS A3) sar8p_or2
    X014 (T4 T5 VDD VSS A2) sar8p_or2
    X013 (T2 T3 VDD VSS A1) sar8p_or2
    X012 (T0 T1 VDD VSS A0) sar8p_or2
ends sar8i_ctrl

subckt sar8i_refword CODE0 CODE1 CODE2 CODE3 CODE4 CODE5 CODE6 CODE7 D0 D1  D2 D3 D4 D5 D6 D7 GNN0 GNN1 GNN2 GNN3 GNN4 GNN5 GNN6 GNN7 GNP0  GNP1 GNP2 GNP3 GNP4 GNP5 GNP6 GNP7 GPN0 GPN1 GPN2 GPN3 GPN4 GPN5  GPN6 GPN7 GPP0 GPP1 GPP2 GPP3 GPP4 GPP5 GPP6 GPP7 PHI_U SAMPLE VDD  VSS RST_DONE PRESET
    XRR7 (PRESET PRESET VDD VSS RST7) sar8p_and2
    XRSTEP1 (PRESET VDD VSS TAP1) sar8s_step
    XRR6 (PRESET TAP1 VDD VSS RST6) sar8p_and2
    XRSTEP2 (TAP1 VDD VSS TAP2) sar8s_step
    XRR5 (PRESET TAP2 VDD VSS RST5) sar8p_and2
    XRSTEP3 (TAP2 VDD VSS TAP3) sar8s_step
    XRR4 (PRESET TAP3 VDD VSS RST4) sar8p_and2
    XRSTEP4 (TAP3 VDD VSS TAP4) sar8s_step
    XRR3 (PRESET TAP4 VDD VSS RST3) sar8p_and2
    XRSTEP5 (TAP4 VDD VSS TAP5) sar8s_step
    XRR2 (PRESET TAP5 VDD VSS RST2) sar8p_and2
    XRSTEP6 (TAP5 VDD VSS TAP6) sar8s_step
    XRR1 (PRESET TAP6 VDD VSS RST1) sar8p_and2
    XRSTEP7 (TAP6 VDD VSS TAP7) sar8s_step
    XRR0 (PRESET TAP7 VDD VSS RST0) sar8p_and2
    XRDONE (RST0 VDD VSS RST_DONE) sar8p_buf
    X002 (FIRST1 VDD VSS FIRST2) sar8p_buf
    X001 (FIRST0 VDD VSS FIRST1) sar8p_buf
    X000 (PHI_U VDD VSS FIRST0) sar8p_buf
    X007 (FIRST2 LATE_CLK VDD VSS CAP_REQ) sar8p_or2
    X003 (SAMPLE ACK VDD VSS REQ_RESET) sar8p_or2
    XREQUEST (REQ_Q REQ_RESET PHI_U VDD VSS) sar8p_sr
    XD_LATE_CLK (REQ_Q VDD VSS LATE_CLK) sar8p_delay_capture
    XD_ACK (LATE_CLK VDD VSS ACK) sar8p_delay_valid
    X008 (CAP_REQ VDD VSS CAP_CLK) sar8p_clkbuf
    XMUX7 (CODE7 D7 PHI_U VDD VSS TARGET7) sar8p_mux2
    XMUX6 (CODE6 D6 PHI_U VDD VSS TARGET6) sar8p_mux2
    XMUX5 (CODE5 D5 PHI_U VDD VSS TARGET5) sar8p_mux2
    XMUX4 (CODE4 D4 PHI_U VDD VSS TARGET4) sar8p_mux2
    XMUX3 (CODE3 D3 PHI_U VDD VSS TARGET3) sar8p_mux2
    XMUX2 (CODE2 D2 PHI_U VDD VSS TARGET2) sar8p_mux2
    XMUX1 (CODE1 D1 PHI_U VDD VSS TARGET1) sar8p_mux2
    XMUX0 (CODE0 D0 PHI_U VDD VSS TARGET0) sar8p_mux2
    X018 (MSB_QN VDD VSS Q7) sar8p_inv
    X017 (TARGET7 VDD VSS MSB_DN) sar8p_inv
    XSTORE7 (CAP_CLK MSB_DN MSB_QN RST7 VDD VSS) sar8p_dffr
    XSTORE6 (CAP_CLK TARGET6 Q6 RST6 VDD VSS) sar8p_dffr
    XSTORE5 (CAP_CLK TARGET5 Q5 RST5 VDD VSS) sar8p_dffr
    XSTORE4 (CAP_CLK TARGET4 Q4 RST4 VDD VSS) sar8p_dffr
    XSTORE3 (CAP_CLK TARGET3 Q3 RST3 VDD VSS) sar8p_dffr
    XSTORE2 (CAP_CLK TARGET2 Q2 RST2 VDD VSS) sar8p_dffr
    XSTORE1 (CAP_CLK TARGET1 Q1 RST1 VDD VSS) sar8p_dffr
    XSTORE0 (CAP_CLK TARGET0 Q0 RST0 VDD VSS) sar8p_dffr
    XBBM7 (Q7 H7 L7 VDD VSS) sar8p_nonoverlap
    XBBM6 (Q6 H6 L6 VDD VSS) sar8p_nonoverlap
    XBBM5 (Q5 H5 L5 VDD VSS) sar8p_nonoverlap
    XBBM4 (Q4 H4 L4 VDD VSS) sar8p_nonoverlap
    XBBM3 (Q3 H3 L3 VDD VSS) sar8p_nonoverlap
    XBBM2 (Q2 H2 L2 VDD VSS) sar8p_nonoverlap
    XBBM1 (Q1 H1 L1 VDD VSS) sar8p_nonoverlap
    XBBM0 (Q0 H0 L0 VDD VSS) sar8p_nonoverlap
    XDRV0 (GNN0 GNP0 GPN0 GPP0 H0 L0 VDD VSS) sar8p_refdrv_b0
    XDRV1 (GNN1 GNP1 GPN1 GPP1 H1 L1 VDD VSS) sar8p_refdrv_b1
    XDRV2 (GNN2 GNP2 GPN2 GPP2 H2 L2 VDD VSS) sar8p_refdrv_b2
    XDRV3 (GNN3 GNP3 GPN3 GPP3 H3 L3 VDD VSS) sar8p_refdrv_b3
    XDRV4 (GNN4 GNP4 GPN4 GPP4 H4 L4 VDD VSS) sar8p_refdrv_b4
    XDRV5 (GNN5 GNP5 GPN5 GPP5 H5 L5 VDD VSS) sar8p_refdrv_b5
    XDRV6 (GNN6 GNP6 GPN6 GPP6 H6 L6 VDD VSS) sar8p_refdrv_b6
    XDRV7 (GNN7 GNP7 GPN7 GPP7 H7 L7 VDD VSS) sar8p_refdrv_b7
ends sar8i_refword

subckt sar8i_guard A VDD VSS Y
R1 (B RC1 ) rupolym l=17.13u w=1u m=1 multi=(1)

R0 (A RC0 ) rupolym l=17.13u w=1u m=1 multi=(1)

    C1 (RC1 VSS) cfmom_2t nr=8 lr=2.5u w=50n s=50n stm=1 spm=3 multi=60  mismatchflag=1
    C0 (RC0 VSS) cfmom_2t nr=8 lr=2.5u w=50n s=50n stm=1 spm=3 multi=60  mismatchflag=1
    X006 (A VDD VSS AB) sar8p_inv
    X005 (RC1 VDD VSS Y) sar8p_inv
    X002 (RC0 VDD VSS B) sar8p_inv
    MN_CLEAR (RC0 AB VSS VSS) nch_mac l=30n w=2u multi=1 nf=1 sd=100n  ad=1.5e-13 as=1.5e-13 pd=4.15u ps=4.15u nrd=0.144730 nrs=0.144730  sa=75.0n sb=75.0n sa1=75.0n sa2=75.0n sa3=75.0n sa4=75.0n  sb1=75.0n sb2=75.0n sb3=75.0n spa=100n spa1=100n spa2=100n  spa3=100n sap=91.9776n sapb=114.444n spba=115.715n spba1=117.043n  dfm_flag=0 spmt=1.11111e+15 spomt=0 spomt1=1.11111e+60  spmb=1.11111e+15 spomb=0 spomb1=1.11111e+60
    MP_CLEAR (RC1 A VDD VDD) pch_mac l=30n w=3u multi=1 nf=1 sd=100n  ad=2.25e-13 as=2.25e-13 pd=6.15u ps=6.15u nrd=0.055246  nrs=0.055246 sa=75.0n sb=75.0n sa1=75.0n sa2=75.0n sa3=75.0n  sa4=75.0n sb1=75.0n sb2=75.0n sb3=75.0n spa=100n spa1=100n  spa2=100n spa3=100n sap=91.9776n sapb=114.444n spba=115.715n  spba1=117.043n dfm_flag=0 spmt=1.11111e+15 spomt=0  spomt1=1.11111e+60 spmb=1.11111e+15 spomb=0 spomb1=1.11111e+60
ends sar8i_guard

subckt sar8i_idle ACTIVE SAMPLE VDD VSS PRESET SAMPLE_MATCH
    XN (ACTIVE VDD VSS IDLE) sar8p_inv
    XD (IDLE VDD VSS IDLE_D) sar8i_guard
    XP (SAMPLE IDLE_D VDD VSS PRESET) sar8p_or2
    XA (SAMPLE SAMPLE VDD VSS SAMPLE_AND) sar8p_and2
    XB (SAMPLE_AND VDD VSS SAMPLE_MATCH) sar8p_buf
ends sar8i_idle
