// Linearized positive-feedback gm/C comparator regeneration model.
simulator lang=spectre
global 0

parameters gm_eff=@GMEFF@ cnode=@CNODE@ vinitial=@VINITIAL@

CREG (VDIFF 0) capacitor c=cnode ic=vinitial
GREG (0 VDIFF VDIFF 0) vccs gm=gm_eff
ic VDIFF=vinitial

simulatorOptions options reltol=1e-7 vabstol=1e-9 iabstol=1e-15 temp=27 tnom=27
tran_regen tran stop=@TSTOP@ maxstep=@MAXSTEP@ skipdc=yes errpreset=conservative
save VDIFF
