// SAR_ADC_T28/tb_sar_adc_allocated_noise_dynamic/netlist
simulator lang=spectre
global 0

Vvdd (vdd 0) vsource dc=900m type=dc
Vvss (vss 0) vsource type=dc
Vrefp (vrefp 0) vsource dc=900m type=dc
Vrefn (vrefn 0) vsource type=dc
Vrst (rst_n 0) vsource type=pwl wave=[ 0 0 5n 0 10n 900m 1.6384m 900m ]
Vsample (clk_sample 0) vsource type=pulse val0=900m val1=0 delay=40n rise=20p fall=20p width=60n period=100n
Vsar (clk_sar 0) vsource type=pulse val0=0 val1=900m delay=42.5n rise=20p fall=20p width=2.5n period=5n
Vvinp (vinp 0) vsource type=sine sinedc=450m ampl=401.062925m freq=4500122.0703125
Vvinn (vinn 0) vsource type=sine sinedc=450m ampl=-401.062925m freq=4500122.0703125

// Stage-1 allocated random-noise subset. Offset, settling, jitter, and the
// unmodeled-distortion guard band are intentionally disabled in this deck.
IADC (vinp vinn vrefp vrefn clk_sample clk_sar rst_n vdd vss dout_9 dout_8 dout_7 dout_6 dout_5 dout_4 dout_3 dout_2 dout_1 dout_0 busy valid) sar_adc_ideal_10b sampling_noise_rms_v=316.40625u comparator_noise_rms_v=316.40625u reference_noise_rms_v=210.9375u sampling_noise_seed=271828 comparator_noise_seed=314159 reference_noise_seed=161803

simulatorOptions options reltol=1e-4 temp=27
tran tran stop=1.6384m errpreset=conservative
save valid dout_9 dout_8 dout_7 dout_6 dout_5 dout_4 dout_3 dout_2 dout_1 dout_0
ahdl_include "../../models/veriloga/sar_adc_ideal_10b.va"
