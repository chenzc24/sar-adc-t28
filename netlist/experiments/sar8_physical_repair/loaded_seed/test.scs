// OA-derived full-parameter nominal test. Foundry models are not distributed.
simulator lang=spectre
global 0 VDD!
parameters SUP=0.99 VDIFF=0.123
include "/home/process/tsmc28n/PDK_mmWave/iPDK_CRN28HPC+ULL_v1.8_2p2a_20190531/tsmcN28/../models/spectre/crn28ull_1d8_elk_v1d8_2p2_shrink0d9_embedded_usage.scs" section=pre_simu
include "/home/process/tsmc28n/PDK_mmWave/iPDK_CRN28HPC+ULL_v1.8_2p2a_20190531/tsmcN28/../models/spectre/crn28ull_1d8_elk_v1d8_2p2_shrink0d9_embedded_usage.scs" section=noise_worst
include "/home/process/tsmc28n/PDK_mmWave/iPDK_CRN28HPC+ULL_v1.8_2p2a_20190531/tsmcN28/../models/spectre/crn28ull_1d8_elk_v1d8_2p2_shrink0d9_embedded_usage.scs" section=ffmacro_mos_moscap
include "/home/process/tsmc28n/PDK_mmWave/iPDK_CRN28HPC+ULL_v1.8_2p2a_20190531/tsmcN28/../models/spectre/crn28ull_1d8_elk_v1d8_2p2_shrink0d9_embedded_usage.scs" section=tt_res_bip_dio_disres
include "/home/process/tsmc28n/PDK_mmWave/iPDK_CRN28HPC+ULL_v1.8_2p2a_20190531/tsmcN28/../models/spectre/crn28ull_1d8_elk_v1d8_2p2_shrink0d9_embedded_usage.scs" section=tt_mom
include "/home/process/tsmc28n/PDK_mmWave/iPDK_CRN28HPC+ULL_v1.8_2p2a_20190531/tsmcN28/../models/spectre/crn28ull_1d8_elk_v1d8_2p2_shrink0d9_embedded_usage.scs" section=tt_ind_jvar
include "/home/process/tsmc28n/PDK_mmWave/iPDK_CRN28HPC+ULL_v1.8_2p2a_20190531/tsmcN28/../models/spectre/crn28ull_1d8_elk_v1d8_2p2_shrink0d9_embedded_usage.scs" section=tt_r_metal

include "dut.scs"

// External interface sources / impedances / loads only.

// SAR_ADC_T28/tb_sar_adc8_join_r4/schematic
XDUT (D0 D1 D2 D3 D4 D5 D6 D7 SAMPLE VDD! VINN VINP VREFN VREFP 0) sar_adc8_join_r4
VVINN (VINN_SRC 0) vsource type=pwl wave=[0n 0.045 100.2n 0.045 100.3n 0.855 200.2n 0.855 200.3n 0.45 300.2n 0.45 300.3n 0.44912109375 400.2n 0.44912109375 400.3n 0.45087890625 500.2n 0.45087890625 500.3n 0.3884765625]
VVINP (VINP_SRC 0) vsource type=pwl wave=[0n 0.855 100.2n 0.855 100.3n 0.045 200.2n 0.045 200.3n 0.45 300.2n 0.45 300.3n 0.45087890625 400.2n 0.45087890625 400.3n 0.44912109375 500.2n 0.44912109375 500.3n 0.5115234375]
VREFLOW (VREFN_SRC 0) vsource dc=0 type=dc
VREFHIGH (VREFP_SRC 0) vsource dc=0.9 type=dc
VVDD (VDD! 0) vsource dc=SUP type=dc
VSAMPLE (SAMPLE 0) vsource type=pulse val0=SUP val1=0 delay=41n rise=100p fall=100p width=59.9n period=100n
RREFN (VREFN_SRC VREFN) resistor r=50
RINN (VINN_SRC VINN) resistor r=50
RREFP (VREFP_SRC VREFP) resistor r=50
RINP (VINP_SRC VINP) resistor r=50
COUT7 (D7 0) capacitor c=5f
COUT6 (D6 0) capacitor c=5f
COUT5 (D5 0) capacitor c=5f
COUT4 (D4 0) capacitor c=5f
COUT3 (D3 0) capacitor c=5f
COUT2 (D2 0) capacitor c=5f
COUT1 (D1 0) capacitor c=5f
COUT0 (D0 0) capacitor c=5f
CREFN (VREFN 0) capacitor c=4p
CREFP (VREFP 0) capacitor c=4p

simulatorOptions options method=gear2only reltol=1e-6 vabstol=1e-8 iabstol=1e-13 temp=-40
saveOptions options save=selected

XMEASURE (XDUT.SAMPLE_INT XDUT.CMP_CLK XDUT.XCTRL.PHI_W XDUT.PHI_U XDUT.XREF.CAP_CLK VDD! VINP_SRC VINN_SRC XDUT.TOPP XDUT.TOPN D0 D1 D2 D3 D4 D5 D6 D7) r4_perf_monitor

tran_perf tran stop=200n maxstep=10p errpreset=conservative lteratio=10 strobeperiod=1n strobeoutput=all outputstart=0n
ahdl_include "r4_perf_monitor.va"
