// SAR_ADC_T28/sar_adc_macro_10b/spectre
// Topology-aware pre-transistor electrical macro. The split CDAC and all
// sampled/reference/comparator dynamics are solved electrically by Spectre;
// only SAR sequencing is event-driven Verilog-A.

simulator lang=spectre

model macro_clamp diode is=1e-6 n=1 rs=5

subckt sar_adc_macro_10b (
+ VINP VINN VREFP_IDEAL VREFN_IDEAL VCM
+ CLK_SAMPLE CLK_TRIAL CLK_LATCH CMP_RESET VDD VSS
+ TOPP TOPN VREFP VREFN COMP_P COMP_N
+ D9 D8 D7 D6 D5 D4 D3 D2 D1 D0 BUSY VALID )

parameters cu=6.86047f ctoppar=0 cbridgepar=0
+ rsample=1k rsource=5k rbottom=1k ropen=1T
+ rref=500 cdecap=2p
+ gm_input=60u gm_reg=100u ccomp=20f rreset=10 rcm=1G ckb=1f
+ cmp_offset=0 vt1=0.35 vt2=0.55

// Local reference memory and acquisition paths.
RREFP (VREFP_IDEAL VREFP) resistor r=rref
RREFN (VREFN_IDEAL VREFN) resistor r=rref
CREFP (VREFP VSS) capacitor c=cdecap
CREFN (VREFN VSS) capacitor c=cdecap

RSOURCEP (VINP VINP_INT) resistor r=rsource
RSOURCEN (VINN VINN_INT) resistor r=rsource
SSAMPLEP (VINP_INT TOPP CLK_SAMPLE VSS) relay rclosed=rsample ropen=ropen vt1=vt1 vt2=vt2
SSAMPLEN (VINN_INT TOPN CLK_SAMPLE VSS) relay rclosed=rsample ropen=ropen vt1=vt1 vt2=vt2

// MSB subarrays: 16+8+4+2+1 = 31 Cu. There is deliberately no MSB dummy;
// the reflected LSB dummy completes the ideal 32-Cu top-plate load.
C9P (TOPP B9P) capacitor c=16*cu
C8P (TOPP B8P) capacitor c=8*cu
C7P (TOPP B7P) capacitor c=4*cu
C6P (TOPP B6P) capacitor c=2*cu
C5P (TOPP B5P) capacitor c=cu
C9N (TOPN B9N) capacitor c=16*cu
C8N (TOPN B8N) capacitor c=8*cu
C7N (TOPN B7N) capacitor c=4*cu
C6N (TOPN B6N) capacitor c=2*cu
C5N (TOPN B5N) capacitor c=cu

// LSB subarrays and 32/31-Cu bridge capacitors.
CBRIDGEP (TOPP LSBP) capacitor c=(32.0/31.0)*cu
CBRIDGEN (TOPN LSBN) capacitor c=(32.0/31.0)*cu
C4P (LSBP B4P) capacitor c=16*cu
C3P (LSBP B3P) capacitor c=8*cu
C2P (LSBP B2P) capacitor c=4*cu
C1P (LSBP B1P) capacitor c=2*cu
C0P (LSBP B0P) capacitor c=cu
CDUMMYP (LSBP BDUMMYP) capacitor c=cu
C4N (LSBN B4N) capacitor c=16*cu
C3N (LSBN B3N) capacitor c=8*cu
C2N (LSBN B2N) capacitor c=4*cu
C1N (LSBN B1N) capacitor c=2*cu
C0N (LSBN B0N) capacitor c=cu
CDUMMYN (LSBN BDUMMYN) capacitor c=cu
CTOPPARP (TOPP VCM) capacitor c=ctoppar
CTOPPARN (TOPN VCM) capacitor c=ctoppar
CBRIDGEPAR_P (LSBP VCM) capacitor c=cbridgepar
CBRIDGEPAR_N (LSBN VCM) capacitor c=cbridgepar
SLSBRESETP (LSBP VCM CLK_SAMPLE VSS) relay rclosed=rbottom ropen=ropen vt1=vt1 vt2=vt2
SLSBRESETN (LSBN VCM CLK_SAMPLE VSS) relay rclosed=rbottom ropen=ropen vt1=vt1 vt2=vt2

// Each active bottom plate has mutually exclusive VCM, code-zero, and
// code-one paths. Code zero is P->VREFP and N->VREFN; code one reverses the
// pair, so the differential top-plate residual equals VIN-VDAC.
S9PS (B9P VCM CLK_SAMPLE VSS) relay rclosed=rbottom ropen=ropen vt1=vt1 vt2=vt2
S9P0 (B9P VREFP SEL0_9 VSS) relay rclosed=rbottom ropen=ropen vt1=vt1 vt2=vt2
S9P1 (B9P VREFN SEL1_9 VSS) relay rclosed=rbottom ropen=ropen vt1=vt1 vt2=vt2
S9NS (B9N VCM CLK_SAMPLE VSS) relay rclosed=rbottom ropen=ropen vt1=vt1 vt2=vt2
S9N0 (B9N VREFN SEL0_9 VSS) relay rclosed=rbottom ropen=ropen vt1=vt1 vt2=vt2
S9N1 (B9N VREFP SEL1_9 VSS) relay rclosed=rbottom ropen=ropen vt1=vt1 vt2=vt2

S8PS (B8P VCM CLK_SAMPLE VSS) relay rclosed=rbottom ropen=ropen vt1=vt1 vt2=vt2
S8P0 (B8P VREFP SEL0_8 VSS) relay rclosed=rbottom ropen=ropen vt1=vt1 vt2=vt2
S8P1 (B8P VREFN SEL1_8 VSS) relay rclosed=rbottom ropen=ropen vt1=vt1 vt2=vt2
S8NS (B8N VCM CLK_SAMPLE VSS) relay rclosed=rbottom ropen=ropen vt1=vt1 vt2=vt2
S8N0 (B8N VREFN SEL0_8 VSS) relay rclosed=rbottom ropen=ropen vt1=vt1 vt2=vt2
S8N1 (B8N VREFP SEL1_8 VSS) relay rclosed=rbottom ropen=ropen vt1=vt1 vt2=vt2

S7PS (B7P VCM CLK_SAMPLE VSS) relay rclosed=rbottom ropen=ropen vt1=vt1 vt2=vt2
S7P0 (B7P VREFP SEL0_7 VSS) relay rclosed=rbottom ropen=ropen vt1=vt1 vt2=vt2
S7P1 (B7P VREFN SEL1_7 VSS) relay rclosed=rbottom ropen=ropen vt1=vt1 vt2=vt2
S7NS (B7N VCM CLK_SAMPLE VSS) relay rclosed=rbottom ropen=ropen vt1=vt1 vt2=vt2
S7N0 (B7N VREFN SEL0_7 VSS) relay rclosed=rbottom ropen=ropen vt1=vt1 vt2=vt2
S7N1 (B7N VREFP SEL1_7 VSS) relay rclosed=rbottom ropen=ropen vt1=vt1 vt2=vt2

S6PS (B6P VCM CLK_SAMPLE VSS) relay rclosed=rbottom ropen=ropen vt1=vt1 vt2=vt2
S6P0 (B6P VREFP SEL0_6 VSS) relay rclosed=rbottom ropen=ropen vt1=vt1 vt2=vt2
S6P1 (B6P VREFN SEL1_6 VSS) relay rclosed=rbottom ropen=ropen vt1=vt1 vt2=vt2
S6NS (B6N VCM CLK_SAMPLE VSS) relay rclosed=rbottom ropen=ropen vt1=vt1 vt2=vt2
S6N0 (B6N VREFN SEL0_6 VSS) relay rclosed=rbottom ropen=ropen vt1=vt1 vt2=vt2
S6N1 (B6N VREFP SEL1_6 VSS) relay rclosed=rbottom ropen=ropen vt1=vt1 vt2=vt2

S5PS (B5P VCM CLK_SAMPLE VSS) relay rclosed=rbottom ropen=ropen vt1=vt1 vt2=vt2
S5P0 (B5P VREFP SEL0_5 VSS) relay rclosed=rbottom ropen=ropen vt1=vt1 vt2=vt2
S5P1 (B5P VREFN SEL1_5 VSS) relay rclosed=rbottom ropen=ropen vt1=vt1 vt2=vt2
S5NS (B5N VCM CLK_SAMPLE VSS) relay rclosed=rbottom ropen=ropen vt1=vt1 vt2=vt2
S5N0 (B5N VREFN SEL0_5 VSS) relay rclosed=rbottom ropen=ropen vt1=vt1 vt2=vt2
S5N1 (B5N VREFP SEL1_5 VSS) relay rclosed=rbottom ropen=ropen vt1=vt1 vt2=vt2

S4PS (B4P VCM CLK_SAMPLE VSS) relay rclosed=rbottom ropen=ropen vt1=vt1 vt2=vt2
S4P0 (B4P VREFP SEL0_4 VSS) relay rclosed=rbottom ropen=ropen vt1=vt1 vt2=vt2
S4P1 (B4P VREFN SEL1_4 VSS) relay rclosed=rbottom ropen=ropen vt1=vt1 vt2=vt2
S4NS (B4N VCM CLK_SAMPLE VSS) relay rclosed=rbottom ropen=ropen vt1=vt1 vt2=vt2
S4N0 (B4N VREFN SEL0_4 VSS) relay rclosed=rbottom ropen=ropen vt1=vt1 vt2=vt2
S4N1 (B4N VREFP SEL1_4 VSS) relay rclosed=rbottom ropen=ropen vt1=vt1 vt2=vt2

S3PS (B3P VCM CLK_SAMPLE VSS) relay rclosed=rbottom ropen=ropen vt1=vt1 vt2=vt2
S3P0 (B3P VREFP SEL0_3 VSS) relay rclosed=rbottom ropen=ropen vt1=vt1 vt2=vt2
S3P1 (B3P VREFN SEL1_3 VSS) relay rclosed=rbottom ropen=ropen vt1=vt1 vt2=vt2
S3NS (B3N VCM CLK_SAMPLE VSS) relay rclosed=rbottom ropen=ropen vt1=vt1 vt2=vt2
S3N0 (B3N VREFN SEL0_3 VSS) relay rclosed=rbottom ropen=ropen vt1=vt1 vt2=vt2
S3N1 (B3N VREFP SEL1_3 VSS) relay rclosed=rbottom ropen=ropen vt1=vt1 vt2=vt2

S2PS (B2P VCM CLK_SAMPLE VSS) relay rclosed=rbottom ropen=ropen vt1=vt1 vt2=vt2
S2P0 (B2P VREFP SEL0_2 VSS) relay rclosed=rbottom ropen=ropen vt1=vt1 vt2=vt2
S2P1 (B2P VREFN SEL1_2 VSS) relay rclosed=rbottom ropen=ropen vt1=vt1 vt2=vt2
S2NS (B2N VCM CLK_SAMPLE VSS) relay rclosed=rbottom ropen=ropen vt1=vt1 vt2=vt2
S2N0 (B2N VREFN SEL0_2 VSS) relay rclosed=rbottom ropen=ropen vt1=vt1 vt2=vt2
S2N1 (B2N VREFP SEL1_2 VSS) relay rclosed=rbottom ropen=ropen vt1=vt1 vt2=vt2

S1PS (B1P VCM CLK_SAMPLE VSS) relay rclosed=rbottom ropen=ropen vt1=vt1 vt2=vt2
S1P0 (B1P VREFP SEL0_1 VSS) relay rclosed=rbottom ropen=ropen vt1=vt1 vt2=vt2
S1P1 (B1P VREFN SEL1_1 VSS) relay rclosed=rbottom ropen=ropen vt1=vt1 vt2=vt2
S1NS (B1N VCM CLK_SAMPLE VSS) relay rclosed=rbottom ropen=ropen vt1=vt1 vt2=vt2
S1N0 (B1N VREFN SEL0_1 VSS) relay rclosed=rbottom ropen=ropen vt1=vt1 vt2=vt2
S1N1 (B1N VREFP SEL1_1 VSS) relay rclosed=rbottom ropen=ropen vt1=vt1 vt2=vt2

S0PS (B0P VCM CLK_SAMPLE VSS) relay rclosed=rbottom ropen=ropen vt1=vt1 vt2=vt2
S0P0 (B0P VREFP SEL0_0 VSS) relay rclosed=rbottom ropen=ropen vt1=vt1 vt2=vt2
S0P1 (B0P VREFN SEL1_0 VSS) relay rclosed=rbottom ropen=ropen vt1=vt1 vt2=vt2
S0NS (B0N VCM CLK_SAMPLE VSS) relay rclosed=rbottom ropen=ropen vt1=vt1 vt2=vt2
S0N0 (B0N VREFN SEL0_0 VSS) relay rclosed=rbottom ropen=ropen vt1=vt1 vt2=vt2
S0N1 (B0N VREFP SEL1_0 VSS) relay rclosed=rbottom ropen=ropen vt1=vt1 vt2=vt2

SDPS (BDUMMYP VCM CLK_SAMPLE VSS) relay rclosed=rbottom ropen=ropen vt1=vt1 vt2=vt2
SDP0 (BDUMMYP VREFP BASE VSS) relay rclosed=rbottom ropen=ropen vt1=vt1 vt2=vt2
SDNS (BDUMMYN VCM CLK_SAMPLE VSS) relay rclosed=rbottom ropen=ropen vt1=vt1 vt2=vt2
SDN0 (BDUMMYN VREFN BASE VSS) relay rclosed=rbottom ropen=ropen vt1=vt1 vt2=vt2

// Resettable gm/C dynamic comparator with explicit offset and kickback. Its
// linear regeneration core is rail-limited by diode clamps.
CCOMP (COMP_P COMP_N) capacitor c=ccomp
GREG (COMP_N COMP_P COMP_P COMP_N) vccs gm=gm_reg
GIN (COMP_N COMP_P TOPP TOPN) vccs gm=gm_input
GOFF (COMP_N COMP_P CMP_OFFSET VSS) vccs gm=-gm_input
VOFF (CMP_OFFSET VSS) vsource dc=cmp_offset type=dc
RCP (COMP_P VCM) resistor r=rcm
RCN (COMP_N VCM) resistor r=rcm
SRESETP (COMP_P VCM CMP_RESET VSS) relay rclosed=rreset ropen=ropen vt1=vt1 vt2=vt2
SRESETN (COMP_N VCM CMP_RESET VSS) relay rclosed=rreset ropen=ropen vt1=vt1 vt2=vt2
CKBP (COMP_P TOPP) capacitor c=ckb
CKBN (COMP_N TOPN) capacitor c=ckb
DHP (COMP_P VDD) macro_clamp
DLP (VSS COMP_P) macro_clamp
DHN (COMP_N VDD) macro_clamp
DLN (VSS COMP_N) macro_clamp

// Explicit controller connection order mirrors its Verilog-A port list.
ICTRL (
+ COMP_P COMP_N CLK_SAMPLE CLK_TRIAL CLK_LATCH VDD VSS
+ SEL0_9 SEL0_8 SEL0_7 SEL0_6 SEL0_5 SEL0_4 SEL0_3 SEL0_2 SEL0_1 SEL0_0
+ SEL1_9 SEL1_8 SEL1_7 SEL1_6 SEL1_5 SEL1_4 SEL1_3 SEL1_2 SEL1_1 SEL1_0
+ BASE D9 D8 D7 D6 D5 D4 D3 D2 D1 D0 BUSY VALID
+ ) sar_macro_controller_10b logic_high_v=0.9 output_transition_s=20p

ends sar_adc_macro_10b
