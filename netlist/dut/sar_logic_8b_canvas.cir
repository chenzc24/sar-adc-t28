* Canvas topology proposal, 2026-10-20. Ideal library gates only.
* Exported by Analog Canvas MCP; no T28 or measured delay claim.

* Ideal and-gate: switches at V(VDD,VSS)/2; vt sets the step width, td the delay
.subckt and_gate VDD VSS A B Y params: vt=10m td=10p
BhA hA 0 V={0.5*(1+tanh((V(A,VSS)-0.5*V(VDD,VSS))/vt))}
BhB hB 0 V={0.5*(1+tanh((V(B,VSS)-0.5*V(VDD,VSS))/vt))}
Bf nfn VSS V={V(VDD,VSS)*(V(hA)*V(hB))}
Rd nfn ndl 1k
Cd ndl VSS {td/1000}
BY Y VSS V={V(ndl,VSS)}
.ends and_gate

* Ideal and-gate-3: switches at V(VDD,VSS)/2; vt sets the step width, td the delay
.subckt and_gate_3 VDD VSS A B C Y params: vt=10m td=10p
BhA hA 0 V={0.5*(1+tanh((V(A,VSS)-0.5*V(VDD,VSS))/vt))}
BhB hB 0 V={0.5*(1+tanh((V(B,VSS)-0.5*V(VDD,VSS))/vt))}
BhC hC 0 V={0.5*(1+tanh((V(C,VSS)-0.5*V(VDD,VSS))/vt))}
Bf nfn VSS V={V(VDD,VSS)*(V(hA)*V(hB)*V(hC))}
Rd nfn ndl 1k
Cd ndl VSS {td/1000}
BY Y VSS V={V(ndl,VSS)}
.ends and_gate_3

* Ideal buffer: switches at V(VDD,VSS)/2; vt sets the step width, td the delay
.subckt buffer VDD VSS A Y params: vt=10m td=10p
BhA hA 0 V={0.5*(1+tanh((V(A,VSS)-0.5*V(VDD,VSS))/vt))}
Bf nfn VSS V={V(VDD,VSS)*(V(hA))}
Rd nfn ndl 1k
Cd ndl VSS {td/1000}
BY Y VSS V={V(ndl,VSS)}
.ends buffer

* Ideal d-flip-flop-reset: switches at V(VDD,VSS)/2; vt sets the step width, td the delay
.subckt d_flip_flop_reset VDD VSS D CK RST Q QBAR params: vt=10m td=10p
BhD hD 0 V={0.5*(1+tanh((V(D,VSS)-0.5*V(VDD,VSS))/vt))}
BhCK hCK 0 V={0.5*(1+tanh((V(CK,VSS)-0.5*V(VDD,VSS))/vt))}
BhRST hRST 0 V={0.5*(1+tanh((V(RST,VSS)-0.5*V(VDD,VSS))/vt))}
Bm 0 nm I={10m*((V(hD)-V(nm))*(1-V(hCK))*(1-V(hRST))-V(nm)*V(hRST))}
Cm nm 0 1p
Rm nm 0 1T
Bs 0 ns I={10m*((V(nm)-V(ns))*V(hCK)*(1-V(hRST))-V(ns)*V(hRST))}
Cs ns 0 1p
Rs ns 0 1T
Bf nfn VSS V={V(VDD,VSS)*(0.5*(1+tanh((V(ns)-0.5)/10m)))}
Rd nfn ndl 1k
Cd ndl VSS {td/1000}
BQ Q VSS V={V(ndl,VSS)}
BQBAR QBAR VSS V={V(VDD,VSS)-V(ndl,VSS)}
.ends d_flip_flop_reset

* Ideal inverter: switches at V(VDD,VSS)/2; vt sets the step width, td the delay
.subckt inverter VDD VSS A Y params: vt=10m td=10p
BhA hA 0 V={0.5*(1+tanh((V(A,VSS)-0.5*V(VDD,VSS))/vt))}
Bf nfn VSS V={V(VDD,VSS)*(1-V(hA))}
Rd nfn ndl 1k
Cd ndl VSS {td/1000}
BY Y VSS V={V(ndl,VSS)}
.ends inverter

* Ideal nand-gate: switches at V(VDD,VSS)/2; vt sets the step width, td the delay
.subckt nand_gate VDD VSS A B Y params: vt=10m td=10p
BhA hA 0 V={0.5*(1+tanh((V(A,VSS)-0.5*V(VDD,VSS))/vt))}
BhB hB 0 V={0.5*(1+tanh((V(B,VSS)-0.5*V(VDD,VSS))/vt))}
Bf nfn VSS V={V(VDD,VSS)*(1-V(hA)*V(hB))}
Rd nfn ndl 1k
Cd ndl VSS {td/1000}
BY Y VSS V={V(ndl,VSS)}
.ends nand_gate

* Ideal or-gate: switches at V(VDD,VSS)/2; vt sets the step width, td the delay
.subckt or_gate VDD VSS A B Y params: vt=10m td=10p
BhA hA 0 V={0.5*(1+tanh((V(A,VSS)-0.5*V(VDD,VSS))/vt))}
BhB hB 0 V={0.5*(1+tanh((V(B,VSS)-0.5*V(VDD,VSS))/vt))}
Bf nfn VSS V={V(VDD,VSS)*(1-(1-V(hA))*(1-V(hB)))}
Rd nfn ndl 1k
Cd ndl VSS {td/1000}
BY Y VSS V={V(ndl,VSS)}
.ends or_gate

* Ideal xor-gate: switches at V(VDD,VSS)/2; vt sets the step width, td the delay
.subckt xor_gate VDD VSS A B Y params: vt=10m td=10p
BhA hA 0 V={0.5*(1+tanh((V(A,VSS)-0.5*V(VDD,VSS))/vt))}
BhB hB 0 V={0.5*(1+tanh((V(B,VSS)-0.5*V(VDD,VSS))/vt))}
Bf nfn VSS V={V(VDD,VSS)*(V(hA)+V(hB)-2*V(hA)*V(hB))}
Rd nfn ndl 1k
Cd ndl VSS {td/1000}
BY Y VSS V={V(ndl,VSS)}
.ends xor_gate

.subckt SAR8_BBM VDD VSS CODE HOLD SEL1 SEL0
XDELAY0 VDD VSS REQ0 DREQ0 buffer td=100p vt=10m
XDELAY1 VDD VSS REQ1 DREQ1 buffer td=100p vt=10m
XNOTCODE VDD VSS CODE NCODE inverter td=10p vt=10m
XON0 VDD VSS REQ0 DREQ0 SEL0 and_gate td=10p vt=10m
XON1 VDD VSS REQ1 DREQ1 SEL1 and_gate td=10p vt=10m
XREQ0 VDD VSS HOLD NCODE REQ0 and_gate td=10p vt=10m
XREQ1 VDD VSS HOLD CODE REQ1 and_gate td=10p vt=10m
.ends SAR8_BBM

.subckt SAR8_BIT VDD VSS COMP TOKEN LATCH_G WORK_RST SYS_RST PUBLISH TRIAL_EN HOLD DOUT SEL0 SEL1
XACTIVE VDD VSS WORK TRY CODE or_gate td=10p vt=10m
XBBM VDD VSS CODE HOLD SEL1 SEL0 SAR8_BBM
XNP VDD VSS PUBLISH NP inverter td=10p vt=10m
XNT VDD VSS TOKEN NT inverter td=10p vt=10m
XOA VDD VSS WNEXT PUBLISH ON_A nand_gate td=10p vt=10m
XOB VDD VSS DOUT NP ON_B nand_gate td=10p vt=10m
XOM VDD VSS ON_A ON_B ONEXT nand_gate td=10p vt=10m
XOUT VDD VSS ONEXT LATCH_G SYS_RST DOUT NC0002 d_flip_flop_reset td=10p vt=10m
XTRIAL VDD VSS TOKEN TRIAL_EN TRY and_gate td=10p vt=10m
XWA VDD VSS COMP TOKEN WN_A nand_gate td=10p vt=10m
XWB VDD VSS WORK NT WN_B nand_gate td=10p vt=10m
XWM VDD VSS WN_A WN_B WNEXT nand_gate td=10p vt=10m
XWORK VDD VSS WNEXT LATCH_G WORK_RST WORK NC0001 d_flip_flop_reset td=10p vt=10m
.ends SAR8_BIT

.subckt SAR8_CLK_GATE VDD VSS CK EN GCK
XGCK VDD VSS CK Q GCK and_gate td=10p vt=10m
XNCK VDD VSS CK CKB inverter td=10p vt=10m
XNEN VDD VSS EN ENB inverter td=10p vt=10m
XQ VDD VSS SN QB Q nand_gate td=10p vt=10m
XQB VDD VSS RN Q QB nand_gate td=10p vt=10m
XRN VDD VSS ENB CKB RN nand_gate td=10p vt=10m
XSN VDD VSS EN CKB SN nand_gate td=10p vt=10m
.ends SAR8_CLK_GATE

.subckt SAR8_FLAGS VDD VSS HOLD_START PREPARE SAMPLE SYS_RST CLK_TRIAL LATCH_G TOKEN0 COMP_P COMP_N
+ WORK_RST HOLD BUSY TRIAL_EN COMP PUBLISH VALID FAULT
XBAD VDD VSS BUSY NREADY BAD and_gate td=10p vt=10m
XBUSY VDD VSS HOLD NDONE BUSY and_gate td=10p vt=10m
XCNBAR VDD VSS COMP_N CNB inverter td=10p vt=10m
XCOMP VDD VSS COMP_P CNB COMP and_gate td=10p vt=10m
XDONE VDD VSS DONE_D LATCH_G WORK_RST DONE NC0002 d_flip_flop_reset td=10p vt=10m
XDONED VDD VSS DONE TOKEN0 DONE_D or_gate td=10p vt=10m
XFAULT VDD VSS FAULT_D LATCH_G WORK_RST FAULT NC0001 d_flip_flop_reset td=10p vt=10m
XFAULTD VDD VSS FAULT BAD FAULT_D or_gate td=10p vt=10m
XHQ VDD VSS HSN HBN HOLD nand_gate td=10p vt=10m
XHQB VDD VSS HRN HOLD HBN nand_gate td=10p vt=10m
XHRESET VDD VSS WORK_RST PREPARE HRESET or_gate td=10p vt=10m
XHRN VDD VSS HRESET HRN inverter td=10p vt=10m
XHSN VDD VSS HOLD_START NHRESET HSN nand_gate td=10p vt=10m
XNDONE VDD VSS DONE NDONE inverter td=10p vt=10m
XNFAULT VDD VSS FAULT NFAULT inverter td=10p vt=10m
XNHRESET VDD VSS HRESET NHRESET inverter td=10p vt=10m
XNOTREADY VDD VSS READY NREADY inverter td=10p vt=10m
XNTRRESET VDD VSS TRRESET NTRRESET inverter td=10p vt=10m
XPUBLISH VDD VSS TOKEN0 READY NFAULT PUBLISH and_gate_3 td=10p vt=10m
XREADY VDD VSS COMP_P COMP_N READY xor_gate td=10p vt=10m
XRESET VDD VSS SAMPLE SYS_RST WORK_RST or_gate td=10p vt=10m
XTQ VDD VSS TSN TQB TRIAL_EN nand_gate td=10p vt=10m
XTQB VDD VSS TRN TRIAL_EN TQB nand_gate td=10p vt=10m
XTRN VDD VSS TRRESET TRN inverter td=10p vt=10m
XTRRESET VDD VSS LATCH_G WORK_RST TRRESET or_gate td=10p vt=10m
XTRSET VDD VSS CLK_TRIAL BUSY TRSET and_gate td=10p vt=10m
XTRSET2 VDD VSS TRSET HOLD_START TRSET2 or_gate td=10p vt=10m
XTSN VDD VSS TRSET2 NTRRESET TSN nand_gate td=10p vt=10m
XVALID VDD VSS VALID_D LATCH_G WORK_RST VALID NC0003 d_flip_flop_reset td=10p vt=10m
XVALIDD VDD VSS VALID PUBLISH VALID_D or_gate td=10p vt=10m
.ends SAR8_FLAGS

.subckt SAR8_TOKEN VDD VSS LATCH_G WORK_RST T7 T6 T5 T4 T3 T2 T1 T0
XT0 VDD VSS T1 LATCH_G WORK_RST T0 NC0006 d_flip_flop_reset td=10p vt=10m
XT1 VDD VSS T2 LATCH_G WORK_RST T1 NC0003 d_flip_flop_reset td=10p vt=10m
XT2 VDD VSS T3 LATCH_G WORK_RST T2 NC0005 d_flip_flop_reset td=10p vt=10m
XT3 VDD VSS T4 LATCH_G WORK_RST T3 NC0002 d_flip_flop_reset td=10p vt=10m
XT4 VDD VSS T5 LATCH_G WORK_RST T4 NC0001 d_flip_flop_reset td=10p vt=10m
XT5 VDD VSS T6 LATCH_G WORK_RST T5 NC0007 d_flip_flop_reset td=10p vt=10m
XT6 VDD VSS T7 LATCH_G WORK_RST T6 NC0008 d_flip_flop_reset td=10p vt=10m
XT7 VDD VSS VDD LATCH_G WORK_RST NT7 NC0004 d_flip_flop_reset td=10p vt=10m
XT7INVERT VDD VSS NT7 T7 inverter td=10p vt=10m
.ends SAR8_TOKEN

.subckt SAR8_TOP VDD VSS RST_N COMP_P COMP_N CLK_SAMPLE PREPARE HOLD_START CLK_TRIAL CLK_LATCH
+ CLK_COMPARE D7 D6 D5 D4 D3 D2 D1 D0 SEL0_7 SEL0_6 SEL0_5 SEL0_4 SEL0_3 SEL0_2 SEL0_1 SEL0_0 SEL1_7
+ SEL1_6 SEL1_5 SEL1_4 SEL1_3 SEL1_2 SEL1_1 SEL1_0 BASE BUSY VALID FAULT CMP_CLK CMP_RESET
XBIT0 VDD VSS COMP T0 LATCH_G WORK_RST SYS_RST PUBLISH TRIAL_EN HOLD D0 SEL0_0 SEL1_0 SAR8_BIT
XBIT1 VDD VSS COMP T1 LATCH_G WORK_RST SYS_RST PUBLISH TRIAL_EN HOLD D1 SEL0_1 SEL1_1 SAR8_BIT
XBIT2 VDD VSS COMP T2 LATCH_G WORK_RST SYS_RST PUBLISH TRIAL_EN HOLD D2 SEL0_2 SEL1_2 SAR8_BIT
XBIT3 VDD VSS COMP T3 LATCH_G WORK_RST SYS_RST PUBLISH TRIAL_EN HOLD D3 SEL0_3 SEL1_3 SAR8_BIT
XBIT4 VDD VSS COMP T4 LATCH_G WORK_RST SYS_RST PUBLISH TRIAL_EN HOLD D4 SEL0_4 SEL1_4 SAR8_BIT
XBIT5 VDD VSS COMP T5 LATCH_G WORK_RST SYS_RST PUBLISH TRIAL_EN HOLD D5 SEL0_5 SEL1_5 SAR8_BIT
XBIT6 VDD VSS COMP T6 LATCH_G WORK_RST SYS_RST PUBLISH TRIAL_EN HOLD D6 SEL0_6 SEL1_6 SAR8_BIT
XBIT7 VDD VSS COMP T7 LATCH_G WORK_RST SYS_RST PUBLISH TRIAL_EN HOLD D7 SEL0_7 SEL1_7 SAR8_BIT
XCMP_RESET VDD VSS CMP_CLK CMP_RESET inverter td=10p vt=10m
XCOMPGATE VDD VSS CLK_COMPARE BUSY CMP_CLK SAR8_CLK_GATE
XDUMMY VDD VSS VSS HOLD NC0001 BASE SAR8_BBM
XFLAGS VDD VSS HOLD_START PREPARE CLK_SAMPLE SYS_RST CLK_TRIAL LATCH_G T0 COMP_P COMP_N WORK_RST
+ HOLD BUSY TRIAL_EN COMP PUBLISH VALID FAULT SAR8_FLAGS
XLATCHGATE VDD VSS CLK_LATCH BUSY LATCH_G SAR8_CLK_GATE
XRESET_INV VDD VSS RST_N SYS_RST inverter td=10p vt=10m
XTOKEN VDD VSS LATCH_G WORK_RST T7 T6 T5 T4 T3 T2 T1 T0 SAR8_TOKEN
.ends SAR8_TOP
