simulator lang=spectre
include "xtor/bootstrap/bootstrap.scs"
include "xtor/cdac/cdac.scs"
include "xtor/comparator/comparator.scs"
include "xtor/sar/single_edge.scs"
include "xtor/reference/single_edge_d2.scs"
include "top/single_edge.scs"
