// RNL workspace entry. DISPLAY ONLY: use design/dut.scs for simulation.
// BEGIN SARADC RNL
// @RNL(type="header") { @VERSION("0.3");
// @USE-PACKAGE(name="sar8",version="0.1",path="sar8.rnl");
// @USE-PACKAGE(name="rnl-std-fill") {}; }
// END SARADC RNL

simulator lang=spectre
include "../top/adc_top.scs"
include "../xtor/bootstrap/bootstrap.scs"
include "../xtor/cdac/cdac.scs"
include "../xtor/comparator/comparator.scs"
include "../xtor/reference/single_edge_d2.scs"
include "../xtor/sar/single_edge.scs"
include "testbenches.scs"
