// Display-only self-contained RNL export. Use design/dut.scs for simulation.

// BEGIN SARADC RNL
// @RNL(type="header") { @VERSION("0.3"); @USE-PACKAGE(name="rnl-std-fill") {};
// @DEVICE(name="*",model="nch*",terminals=["d","g","s","b"]);
// @DEVICE(name="*",model="pch*",terminals=["d","g","s","b"]);
// @USE-PACKAGE(name="sar8",version="0.1") {
//
// $S_sar_adc8_join_r4 = @DEFINE-SYMBOL {
// @LINE {(-11,9.9) (11,9.9) (11,-9.9) (-11,-9.9) (-11,9.9)};
// (-13,6.6) @PIN(terminal=9,direction="left");
// @LINE {(-13,6.6) (-11,6.6)};
// (-10.5,6.6) @TEXT("SAMPLE",size=1.1,halign="start",valign="middle");
// (-13,3.3) @PIN(terminal=11,direction="left");
// @LINE {(-13,3.3) (-11,3.3)};
// (-10.5,3.3) @TEXT("VINN",size=1.1,halign="start",valign="middle");
// (-13,0) @PIN(terminal=12,direction="left");
// @LINE {(-13,0) (-11,0)};
// (-10.5,0) @TEXT("VINP",size=1.1,halign="start",valign="middle");
// (-13,-3.3) @PIN(terminal=13,direction="left");
// @LINE {(-13,-3.3) (-11,-3.3)};
// (-10.5,-3.3) @TEXT("VREFN",size=1.1,halign="start",valign="middle");
// (-13,-6.6) @PIN(terminal=14,direction="left");
// @LINE {(-13,-6.6) (-11,-6.6)};
// (-10.5,-6.6) @TEXT("VREFP",size=1.1,halign="start",valign="middle");
// (13,0) @PIN(terminal=[1, 2, 3, 4, 5, 6, 7, 8],direction="right");
// @LINE {(13,0) (11,0)};
// (10.5,0) @TEXT("D[7:0]",size=1.1,halign="end",valign="middle");
// (0,11.9) @PIN(terminal=10,direction="up");
// @LINE {(0,11.9) (0,9.9)};
// (0,9.1) @TEXT("VDD!",size=1.1,halign="middle",valign="middle");
// (0,-11.9) @PIN(terminal=15,direction="down");
// @LINE {(0,-11.9) (0,-9.9)};
// (0,-9.1) @TEXT("0",size=1.1,halign="middle",valign="middle");
// ? @TEXT("${name}",key="name",size=1.6,halign="middle") => @PLACE(0,13.4);
// ? @TEXT("${model}",key="model",size=0.85,halign="middle") => @PLACE(0,-13.9);
// };
// # @SELECT-INSTANCE(model="sar_adc8_join_r4") => @SET-SYMBOL $S_sar_adc8_join_r4;
// $S_sar_bootstrap_flat_8b_p = @DEFINE-SYMBOL {
// @LINE(fill="fillcolor",fillcolor="#eaf5ef") {(-11,6) (11,6) (11,-6) (-11,-6) (-11,6)};
// (-13,1.65) @PIN(terminal=1,direction="left");
// @LINE {(-13,1.65) (-11,1.65)};
// (-10.5,1.65) @TEXT("CLKS",size=1.1,halign="start",valign="middle");
// (-13,-1.65) @PIN(terminal=3,direction="left");
// @LINE {(-13,-1.65) (-11,-1.65)};
// (-10.5,-1.65) @TEXT("Vin",size=1.1,halign="start",valign="middle");
// (13,0) @PIN(terminal=2,direction="right");
// @LINE {(13,0) (11,0)};
// (10.5,0) @TEXT("VOUT",size=1.1,halign="end",valign="middle");
// ? @TEXT("${name}",key="name",size=1.6,halign="middle") => @PLACE(0,9.5);
// ? @TEXT("${model}",key="model",size=0.85,halign="middle") => @PLACE(0,-10);
// };
// # @SELECT-INSTANCE(model="sar_bootstrap_flat_8b_p") => @SET-SYMBOL $S_sar_bootstrap_flat_8b_p;
// $S_sar8j_r1_sw_b0 = @DEFINE-SYMBOL {
// @LINE {(-9,7) (9,7) (9,-7) (-9,-7) (-9,7)};
// (0,12) @PIN(terminal=1,direction="up");
// @LINE {(0,12) (0,7)};
// (0,6.2) @TEXT("BOT",size=0.65,halign="middle",valign="middle");
// (-5,-12) @PIN(terminal=2,direction="down");
// @LINE {(-5,-12) (-5,-7)};
// (-5,-6.2) @TEXT("GN",size=0.65,halign="middle",valign="middle");
// (5,-12) @PIN(terminal=3,direction="down");
// @LINE {(5,-12) (5,-7)};
// (5,-6.2) @TEXT("GP",size=0.65,halign="middle",valign="middle");
// (-11,-4) @PIN(terminal=5,direction="left");
// @LINE {(-11,-4) (-9,-4)};
// (-8,-4) @TEXT("VREFN",size=0.65,halign="start",valign="middle");
// (-11,4) @PIN(terminal=6,direction="left");
// @LINE {(-11,4) (-9,4)};
// (-8,4) @TEXT("VREFP",size=0.65,halign="start",valign="middle");
// (11,4) @PIN(terminal=4,direction="right");
// @LINE {(11,4) (9,4)};
// (8,4) @TEXT("VDD",size=0.65,halign="end",valign="middle");
// (11,-4) @PIN(terminal=7,direction="right");
// @LINE {(11,-4) (9,-4)};
// (8,-4) @TEXT("VSS",size=0.65,halign="end",valign="middle");
// ? @TEXT("${name}",key="name",size=1.6,halign="middle") => @PLACE(0,10.5);
// ? @TEXT("",key="model",size=0.85,halign="middle") => @PLACE(0,-11);
// };
// # @SELECT-INSTANCE(model="sar8j_r1_sw_b0") => @SET-SYMBOL $S_sar8j_r1_sw_b0;
// $S_sar8j_r1_sw_b1 = @DEFINE-SYMBOL {
// @LINE {(-9,7) (9,7) (9,-7) (-9,-7) (-9,7)};
// (0,12) @PIN(terminal=1,direction="up");
// @LINE {(0,12) (0,7)};
// (0,6.2) @TEXT("BOT",size=0.65,halign="middle",valign="middle");
// (-5,-12) @PIN(terminal=2,direction="down");
// @LINE {(-5,-12) (-5,-7)};
// (-5,-6.2) @TEXT("GN",size=0.65,halign="middle",valign="middle");
// (5,-12) @PIN(terminal=3,direction="down");
// @LINE {(5,-12) (5,-7)};
// (5,-6.2) @TEXT("GP",size=0.65,halign="middle",valign="middle");
// (-11,-4) @PIN(terminal=5,direction="left");
// @LINE {(-11,-4) (-9,-4)};
// (-8,-4) @TEXT("VREFN",size=0.65,halign="start",valign="middle");
// (-11,4) @PIN(terminal=6,direction="left");
// @LINE {(-11,4) (-9,4)};
// (-8,4) @TEXT("VREFP",size=0.65,halign="start",valign="middle");
// (11,4) @PIN(terminal=4,direction="right");
// @LINE {(11,4) (9,4)};
// (8,4) @TEXT("VDD",size=0.65,halign="end",valign="middle");
// (11,-4) @PIN(terminal=7,direction="right");
// @LINE {(11,-4) (9,-4)};
// (8,-4) @TEXT("VSS",size=0.65,halign="end",valign="middle");
// ? @TEXT("${name}",key="name",size=1.6,halign="middle") => @PLACE(0,10.5);
// ? @TEXT("",key="model",size=0.85,halign="middle") => @PLACE(0,-11);
// };
// # @SELECT-INSTANCE(model="sar8j_r1_sw_b1") => @SET-SYMBOL $S_sar8j_r1_sw_b1;
// $S_sar8j_r1_sw_b2 = @DEFINE-SYMBOL {
// @LINE {(-9,7) (9,7) (9,-7) (-9,-7) (-9,7)};
// (0,12) @PIN(terminal=1,direction="up");
// @LINE {(0,12) (0,7)};
// (0,6.2) @TEXT("BOT",size=0.65,halign="middle",valign="middle");
// (-5,-12) @PIN(terminal=2,direction="down");
// @LINE {(-5,-12) (-5,-7)};
// (-5,-6.2) @TEXT("GN",size=0.65,halign="middle",valign="middle");
// (5,-12) @PIN(terminal=3,direction="down");
// @LINE {(5,-12) (5,-7)};
// (5,-6.2) @TEXT("GP",size=0.65,halign="middle",valign="middle");
// (-11,-4) @PIN(terminal=5,direction="left");
// @LINE {(-11,-4) (-9,-4)};
// (-8,-4) @TEXT("VREFN",size=0.65,halign="start",valign="middle");
// (-11,4) @PIN(terminal=6,direction="left");
// @LINE {(-11,4) (-9,4)};
// (-8,4) @TEXT("VREFP",size=0.65,halign="start",valign="middle");
// (11,4) @PIN(terminal=4,direction="right");
// @LINE {(11,4) (9,4)};
// (8,4) @TEXT("VDD",size=0.65,halign="end",valign="middle");
// (11,-4) @PIN(terminal=7,direction="right");
// @LINE {(11,-4) (9,-4)};
// (8,-4) @TEXT("VSS",size=0.65,halign="end",valign="middle");
// ? @TEXT("${name}",key="name",size=1.6,halign="middle") => @PLACE(0,10.5);
// ? @TEXT("",key="model",size=0.85,halign="middle") => @PLACE(0,-11);
// };
// # @SELECT-INSTANCE(model="sar8j_r1_sw_b2") => @SET-SYMBOL $S_sar8j_r1_sw_b2;
// $S_sar8j_r1_sw_b3 = @DEFINE-SYMBOL {
// @LINE {(-9,7) (9,7) (9,-7) (-9,-7) (-9,7)};
// (0,12) @PIN(terminal=1,direction="up");
// @LINE {(0,12) (0,7)};
// (0,6.2) @TEXT("BOT",size=0.65,halign="middle",valign="middle");
// (-5,-12) @PIN(terminal=2,direction="down");
// @LINE {(-5,-12) (-5,-7)};
// (-5,-6.2) @TEXT("GN",size=0.65,halign="middle",valign="middle");
// (5,-12) @PIN(terminal=3,direction="down");
// @LINE {(5,-12) (5,-7)};
// (5,-6.2) @TEXT("GP",size=0.65,halign="middle",valign="middle");
// (-11,-4) @PIN(terminal=5,direction="left");
// @LINE {(-11,-4) (-9,-4)};
// (-8,-4) @TEXT("VREFN",size=0.65,halign="start",valign="middle");
// (-11,4) @PIN(terminal=6,direction="left");
// @LINE {(-11,4) (-9,4)};
// (-8,4) @TEXT("VREFP",size=0.65,halign="start",valign="middle");
// (11,4) @PIN(terminal=4,direction="right");
// @LINE {(11,4) (9,4)};
// (8,4) @TEXT("VDD",size=0.65,halign="end",valign="middle");
// (11,-4) @PIN(terminal=7,direction="right");
// @LINE {(11,-4) (9,-4)};
// (8,-4) @TEXT("VSS",size=0.65,halign="end",valign="middle");
// ? @TEXT("${name}",key="name",size=1.6,halign="middle") => @PLACE(0,10.5);
// ? @TEXT("",key="model",size=0.85,halign="middle") => @PLACE(0,-11);
// };
// # @SELECT-INSTANCE(model="sar8j_r1_sw_b3") => @SET-SYMBOL $S_sar8j_r1_sw_b3;
// $S_sar8j_r1_sw_b4 = @DEFINE-SYMBOL {
// @LINE {(-9,7) (9,7) (9,-7) (-9,-7) (-9,7)};
// (0,12) @PIN(terminal=1,direction="up");
// @LINE {(0,12) (0,7)};
// (0,6.2) @TEXT("BOT",size=0.65,halign="middle",valign="middle");
// (-5,-12) @PIN(terminal=2,direction="down");
// @LINE {(-5,-12) (-5,-7)};
// (-5,-6.2) @TEXT("GN",size=0.65,halign="middle",valign="middle");
// (5,-12) @PIN(terminal=3,direction="down");
// @LINE {(5,-12) (5,-7)};
// (5,-6.2) @TEXT("GP",size=0.65,halign="middle",valign="middle");
// (-11,-4) @PIN(terminal=5,direction="left");
// @LINE {(-11,-4) (-9,-4)};
// (-8,-4) @TEXT("VREFN",size=0.65,halign="start",valign="middle");
// (-11,4) @PIN(terminal=6,direction="left");
// @LINE {(-11,4) (-9,4)};
// (-8,4) @TEXT("VREFP",size=0.65,halign="start",valign="middle");
// (11,4) @PIN(terminal=4,direction="right");
// @LINE {(11,4) (9,4)};
// (8,4) @TEXT("VDD",size=0.65,halign="end",valign="middle");
// (11,-4) @PIN(terminal=7,direction="right");
// @LINE {(11,-4) (9,-4)};
// (8,-4) @TEXT("VSS",size=0.65,halign="end",valign="middle");
// ? @TEXT("${name}",key="name",size=1.6,halign="middle") => @PLACE(0,10.5);
// ? @TEXT("",key="model",size=0.85,halign="middle") => @PLACE(0,-11);
// };
// # @SELECT-INSTANCE(model="sar8j_r1_sw_b4") => @SET-SYMBOL $S_sar8j_r1_sw_b4;
// $S_sar8j_r1_sw_b5 = @DEFINE-SYMBOL {
// @LINE {(-9,7) (9,7) (9,-7) (-9,-7) (-9,7)};
// (0,12) @PIN(terminal=1,direction="up");
// @LINE {(0,12) (0,7)};
// (0,6.2) @TEXT("BOT",size=0.65,halign="middle",valign="middle");
// (-5,-12) @PIN(terminal=2,direction="down");
// @LINE {(-5,-12) (-5,-7)};
// (-5,-6.2) @TEXT("GN",size=0.65,halign="middle",valign="middle");
// (5,-12) @PIN(terminal=3,direction="down");
// @LINE {(5,-12) (5,-7)};
// (5,-6.2) @TEXT("GP",size=0.65,halign="middle",valign="middle");
// (-11,-4) @PIN(terminal=5,direction="left");
// @LINE {(-11,-4) (-9,-4)};
// (-8,-4) @TEXT("VREFN",size=0.65,halign="start",valign="middle");
// (-11,4) @PIN(terminal=6,direction="left");
// @LINE {(-11,4) (-9,4)};
// (-8,4) @TEXT("VREFP",size=0.65,halign="start",valign="middle");
// (11,4) @PIN(terminal=4,direction="right");
// @LINE {(11,4) (9,4)};
// (8,4) @TEXT("VDD",size=0.65,halign="end",valign="middle");
// (11,-4) @PIN(terminal=7,direction="right");
// @LINE {(11,-4) (9,-4)};
// (8,-4) @TEXT("VSS",size=0.65,halign="end",valign="middle");
// ? @TEXT("${name}",key="name",size=1.6,halign="middle") => @PLACE(0,10.5);
// ? @TEXT("",key="model",size=0.85,halign="middle") => @PLACE(0,-11);
// };
// # @SELECT-INSTANCE(model="sar8j_r1_sw_b5") => @SET-SYMBOL $S_sar8j_r1_sw_b5;
// $S_sar8j_r1_sw_b6 = @DEFINE-SYMBOL {
// @LINE {(-9,7) (9,7) (9,-7) (-9,-7) (-9,7)};
// (0,12) @PIN(terminal=1,direction="up");
// @LINE {(0,12) (0,7)};
// (0,6.2) @TEXT("BOT",size=0.65,halign="middle",valign="middle");
// (-5,-12) @PIN(terminal=2,direction="down");
// @LINE {(-5,-12) (-5,-7)};
// (-5,-6.2) @TEXT("GN",size=0.65,halign="middle",valign="middle");
// (5,-12) @PIN(terminal=3,direction="down");
// @LINE {(5,-12) (5,-7)};
// (5,-6.2) @TEXT("GP",size=0.65,halign="middle",valign="middle");
// (-11,-4) @PIN(terminal=5,direction="left");
// @LINE {(-11,-4) (-9,-4)};
// (-8,-4) @TEXT("VREFN",size=0.65,halign="start",valign="middle");
// (-11,4) @PIN(terminal=6,direction="left");
// @LINE {(-11,4) (-9,4)};
// (-8,4) @TEXT("VREFP",size=0.65,halign="start",valign="middle");
// (11,4) @PIN(terminal=4,direction="right");
// @LINE {(11,4) (9,4)};
// (8,4) @TEXT("VDD",size=0.65,halign="end",valign="middle");
// (11,-4) @PIN(terminal=7,direction="right");
// @LINE {(11,-4) (9,-4)};
// (8,-4) @TEXT("VSS",size=0.65,halign="end",valign="middle");
// ? @TEXT("${name}",key="name",size=1.6,halign="middle") => @PLACE(0,10.5);
// ? @TEXT("",key="model",size=0.85,halign="middle") => @PLACE(0,-11);
// };
// # @SELECT-INSTANCE(model="sar8j_r1_sw_b6") => @SET-SYMBOL $S_sar8j_r1_sw_b6;
// $S_sar8j_r1_sw_b7 = @DEFINE-SYMBOL {
// @LINE {(-9,7) (9,7) (9,-7) (-9,-7) (-9,7)};
// (0,12) @PIN(terminal=1,direction="up");
// @LINE {(0,12) (0,7)};
// (0,6.2) @TEXT("BOT",size=0.65,halign="middle",valign="middle");
// (-5,-12) @PIN(terminal=2,direction="down");
// @LINE {(-5,-12) (-5,-7)};
// (-5,-6.2) @TEXT("GN",size=0.65,halign="middle",valign="middle");
// (5,-12) @PIN(terminal=3,direction="down");
// @LINE {(5,-12) (5,-7)};
// (5,-6.2) @TEXT("GP",size=0.65,halign="middle",valign="middle");
// (-11,-4) @PIN(terminal=5,direction="left");
// @LINE {(-11,-4) (-9,-4)};
// (-8,-4) @TEXT("VREFN",size=0.65,halign="start",valign="middle");
// (-11,4) @PIN(terminal=6,direction="left");
// @LINE {(-11,4) (-9,4)};
// (-8,4) @TEXT("VREFP",size=0.65,halign="start",valign="middle");
// (11,4) @PIN(terminal=4,direction="right");
// @LINE {(11,4) (9,4)};
// (8,4) @TEXT("VDD",size=0.65,halign="end",valign="middle");
// (11,-4) @PIN(terminal=7,direction="right");
// @LINE {(11,-4) (9,-4)};
// (8,-4) @TEXT("VSS",size=0.65,halign="end",valign="middle");
// ? @TEXT("${name}",key="name",size=1.6,halign="middle") => @PLACE(0,10.5);
// ? @TEXT("",key="model",size=0.85,halign="middle") => @PLACE(0,-11);
// };
// # @SELECT-INSTANCE(model="sar8j_r1_sw_b7") => @SET-SYMBOL $S_sar8j_r1_sw_b7;
// $S_sar8j_r1_cdac = @DEFINE-SYMBOL {
// @LINE(fill="fillcolor",fillcolor="#eef4e3") {(-18,6) (18,6) (18,-6) (-18,-6) (-18,6)};
// (-20,1.65) @PIN(terminal=36,direction="left");
// @LINE {(-20,1.65) (-18,1.65)};
// (-17.5,1.65) @TEXT("VREFN",size=1.1,halign="start",valign="middle");
// (-20,-1.65) @PIN(terminal=37,direction="left");
// @LINE {(-20,-1.65) (-18,-1.65)};
// (-17.5,-1.65) @TEXT("VREFP",size=1.1,halign="start",valign="middle");
// (-8,8) @PIN(terminal=33,direction="up");
// @LINE {(-8,8) (-8,6)};
// (-8,5.2) @TEXT("TOPN",size=1.1,halign="middle",valign="middle");
// (0,8) @PIN(terminal=34,direction="up");
// @LINE {(0,8) (0,6)};
// (0,5.2) @TEXT("TOPP",size=1.1,halign="middle",valign="middle");
// (8,8) @PIN(terminal=35,direction="up");
// @LINE {(8,8) (8,6)};
// (8,5.2) @TEXT("VDD",size=1.1,halign="middle",valign="middle");
// (-16,-8) @PIN(terminal=[1, 2, 3, 4, 5, 6, 7, 8],direction="down");
// @LINE {(-16,-8) (-16,-6)};
// (-16,-5.2) @TEXT("GNN[7:0]",size=1.1,halign="middle",valign="middle");
// (-8,-8) @PIN(terminal=[9, 10, 11, 12, 13, 14, 15, 16],direction="down");
// @LINE {(-8,-8) (-8,-6)};
// (-8,-5.2) @TEXT("GNP[7:0]",size=1.1,halign="middle",valign="middle");
// (0,-8) @PIN(terminal=[17, 18, 19, 20, 21, 22, 23, 24],direction="down");
// @LINE {(0,-8) (0,-6)};
// (0,-5.2) @TEXT("GPN[7:0]",size=1.1,halign="middle",valign="middle");
// (8,-8) @PIN(terminal=[25, 26, 27, 28, 29, 30, 31, 32],direction="down");
// @LINE {(8,-8) (8,-6)};
// (8,-5.2) @TEXT("GPP[7:0]",size=1.1,halign="middle",valign="middle");
// (16,-8) @PIN(terminal=38,direction="down");
// @LINE {(16,-8) (16,-6)};
// (16,-5.2) @TEXT("VSS",size=1.1,halign="middle",valign="middle");
// ? @TEXT("${name}",key="name",size=1.6,halign="middle") => @PLACE(0,9.5);
// ? @TEXT("${model}",key="model",size=0.85,halign="middle") => @PLACE(0,-10);
// };
// # @SELECT-INSTANCE(model="sar8j_r1_cdac") => @SET-SYMBOL $S_sar8j_r1_cdac;
// $S_sar_strongarm_t28 = @DEFINE-SYMBOL {
// @LINE(fill="fillcolor",fillcolor="#eaf2fa") {(-11,6.6) (11,6.6) (11,-6.6) (-11,-6.6) (-11,6.6)};
// (-13,3.3) @PIN(terminal=1,direction="left");
// @LINE {(-13,3.3) (-11,3.3)};
// (-10.5,3.3) @TEXT("CLK",size=1.1,halign="start",valign="middle");
// (-13,0) @PIN(terminal=5,direction="left");
// @LINE {(-13,0) (-11,0)};
// (-10.5,0) @TEXT("VINN",size=1.1,halign="start",valign="middle");
// (-13,-3.3) @PIN(terminal=6,direction="left");
// @LINE {(-13,-3.3) (-11,-3.3)};
// (-10.5,-3.3) @TEXT("VINP",size=1.1,halign="start",valign="middle");
// (13,1.65) @PIN(terminal=2,direction="right");
// @LINE {(13,1.65) (11,1.65)};
// (10.5,1.65) @TEXT("OUTN",size=1.1,halign="end",valign="middle");
// (13,-1.65) @PIN(terminal=3,direction="right");
// @LINE {(13,-1.65) (11,-1.65)};
// (10.5,-1.65) @TEXT("OUTP",size=1.1,halign="end",valign="middle");
// (0,8.6) @PIN(terminal=4,direction="up");
// @LINE {(0,8.6) (0,6.6)};
// (0,5.8) @TEXT("VDD",size=1.1,halign="middle",valign="middle");
// (0,-8.6) @PIN(terminal=7,direction="down");
// @LINE {(0,-8.6) (0,-6.6)};
// (0,-5.8) @TEXT("VSS",size=1.1,halign="middle",valign="middle");
// ? @TEXT("${name}",key="name",size=1.6,halign="middle") => @PLACE(0,10.1);
// ? @TEXT("${model}",key="model",size=0.85,halign="middle") => @PLACE(0,-10.6);
// };
// # @SELECT-INSTANCE(model="sar_strongarm_t28") => @SET-SYMBOL $S_sar_strongarm_t28;
// $S_sar8i_refword = @DEFINE-SYMBOL {
// @LINE(fill="fillcolor",fillcolor="#f6f0e5") {(-18,8.25) (18,8.25) (18,-8.25) (-18,-8.25) (-18,8.25)};
// (-20,1.65) @PIN(terminal=49,direction="left");
// @LINE {(-20,1.65) (-18,1.65)};
// (-17.5,1.65) @TEXT("PHI_U",size=1.1,halign="start",valign="middle");
// (-20,-1.65) @PIN(terminal=50,direction="left");
// @LINE {(-20,-1.65) (-18,-1.65)};
// (-17.5,-1.65) @TEXT("SAMPLE",size=1.1,halign="start",valign="middle");
// (20,4.95) @PIN(terminal=[1, 2, 3, 4, 5, 6, 7, 8],direction="right");
// @LINE {(20,4.95) (18,4.95)};
// (17.5,4.95) @TEXT("CODE[7:0]",size=1.1,halign="end",valign="middle");
// (20,1.65) @PIN(terminal=[9, 10, 11, 12, 13, 14, 15, 16],direction="right");
// @LINE {(20,1.65) (18,1.65)};
// (17.5,1.65) @TEXT("D[7:0]",size=1.1,halign="end",valign="middle");
// (20,-1.65) @PIN(terminal=53,direction="right");
// @LINE {(20,-1.65) (18,-1.65)};
// (17.5,-1.65) @TEXT("RST_DONE",size=1.1,halign="end",valign="middle");
// (20,-4.95) @PIN(terminal=54,direction="right");
// @LINE {(20,-4.95) (18,-4.95)};
// (17.5,-4.95) @TEXT("PRESET",size=1.1,halign="end",valign="middle");
// (-16,10.25) @PIN(terminal=[17, 18, 19, 20, 21, 22, 23, 24],direction="up");
// @LINE {(-16,10.25) (-16,8.25)};
// (-16,7.45) @TEXT("GNN[7:0]",size=1.1,halign="middle",valign="middle");
// (-8,10.25) @PIN(terminal=[25, 26, 27, 28, 29, 30, 31, 32],direction="up");
// @LINE {(-8,10.25) (-8,8.25)};
// (-8,7.45) @TEXT("GNP[7:0]",size=1.1,halign="middle",valign="middle");
// (0,10.25) @PIN(terminal=[33, 34, 35, 36, 37, 38, 39, 40],direction="up");
// @LINE {(0,10.25) (0,8.25)};
// (0,7.45) @TEXT("GPN[7:0]",size=1.1,halign="middle",valign="middle");
// (8,10.25) @PIN(terminal=[41, 42, 43, 44, 45, 46, 47, 48],direction="up");
// @LINE {(8,10.25) (8,8.25)};
// (8,7.45) @TEXT("GPP[7:0]",size=1.1,halign="middle",valign="middle");
// (16,10.25) @PIN(terminal=51,direction="up");
// @LINE {(16,10.25) (16,8.25)};
// (16,7.45) @TEXT("VDD",size=1.1,halign="middle",valign="middle");
// (0,-10.25) @PIN(terminal=52,direction="down");
// @LINE {(0,-10.25) (0,-8.25)};
// (0,-7.45) @TEXT("VSS",size=1.1,halign="middle",valign="middle");
// ? @TEXT("${name}",key="name",size=1.6,halign="middle") => @PLACE(0,11.75);
// ? @TEXT("${model}",key="model",size=0.85,halign="middle") => @PLACE(0,-12.25);
// };
// # @SELECT-INSTANCE(model="sar8i_refword") => @SET-SYMBOL $S_sar8i_refword;
// $S_sar8_next_word = @DEFINE-SYMBOL {
// @LINE {(-11,9.9) (11,9.9) (11,-9.9) (-11,-9.9) (-11,9.9)};
// (-13,0) @PIN(terminal=10,direction="left");
// @LINE {(-13,0) (-11,0)};
// (-10.5,0) @TEXT("DONE",size=1.1,halign="start",valign="middle");
// (13,6.6) @PIN(terminal=[1, 2, 3, 4, 5, 6, 7, 8],direction="right");
// @LINE {(13,6.6) (11,6.6)};
// (10.5,6.6) @TEXT("CODE[7:0]",size=1.1,halign="end",valign="middle");
// (13,3.3) @PIN(terminal=9,direction="right");
// @LINE {(13,3.3) (11,3.3)};
// (10.5,3.3) @TEXT("DATA",size=1.1,halign="end",valign="middle");
// (13,0) @PIN(terminal=[11, 12, 13, 14, 15, 16, 17, 18],direction="right");
// @LINE {(13,0) (11,0)};
// (10.5,0) @TEXT("D[7:0]",size=1.1,halign="end",valign="middle");
// (13,-3.3) @PIN(terminal=[19, 20, 21, 22, 23, 24, 25, 26],direction="right");
// @LINE {(13,-3.3) (11,-3.3)};
// (10.5,-3.3) @TEXT("NEXT[7:0]",size=1.1,halign="end",valign="middle");
// (13,-6.6) @PIN(terminal=[27, 28, 29, 30, 31],direction="right");
// @LINE {(13,-6.6) (11,-6.6)};
// (10.5,-6.6) @TEXT("TRIAL[6:2]",size=1.1,halign="end",valign="middle");
// (0,11.9) @PIN(terminal=32,direction="up");
// @LINE {(0,11.9) (0,9.9)};
// (0,9.1) @TEXT("VDD",size=1.1,halign="middle",valign="middle");
// (0,-11.9) @PIN(terminal=33,direction="down");
// @LINE {(0,-11.9) (0,-9.9)};
// (0,-9.1) @TEXT("VSS",size=1.1,halign="middle",valign="middle");
// ? @TEXT("${name}",key="name",size=1.6,halign="middle") => @PLACE(0,13.4);
// ? @TEXT("${model}",key="model",size=0.85,halign="middle") => @PLACE(0,-13.9);
// };
// # @SELECT-INSTANCE(model="sar8_next_word") => @SET-SYMBOL $S_sar8_next_word;
// $S_sar8_se_window = @DEFINE-SYMBOL {
// @LINE {(-11,11.55) (11,11.55) (11,-11.55) (-11,-11.55) (-11,11.55)};
// (-13,8.25) @PIN(terminal=1,direction="left");
// @LINE {(-13,8.25) (-11,8.25)};
// (-10.5,8.25) @TEXT("PHASE_REQUEST",size=1.1,halign="start",valign="middle");
// (-13,4.95) @PIN(terminal=2,direction="left");
// @LINE {(-13,4.95) (-11,4.95)};
// (-10.5,4.95) @TEXT("SEL9",size=1.1,halign="start",valign="middle");
// (-13,1.65) @PIN(terminal=3,direction="left");
// @LINE {(-13,1.65) (-11,1.65)};
// (-10.5,1.65) @TEXT("SEL7",size=1.1,halign="start",valign="middle");
// (-13,-1.65) @PIN(terminal=4,direction="left");
// @LINE {(-13,-1.65) (-11,-1.65)};
// (-10.5,-1.65) @TEXT("SEL6",size=1.1,halign="start",valign="middle");
// (-13,-4.95) @PIN(terminal=5,direction="left");
// @LINE {(-13,-4.95) (-11,-4.95)};
// (-10.5,-4.95) @TEXT("SEL5",size=1.1,halign="start",valign="middle");
// (-13,-8.25) @PIN(terminal=6,direction="left");
// @LINE {(-13,-8.25) (-11,-8.25)};
// (-10.5,-8.25) @TEXT("SEL4",size=1.1,halign="start",valign="middle");
// (13,0) @PIN(terminal=9,direction="right");
// @LINE {(13,0) (11,0)};
// (10.5,0) @TEXT("DELIVERED",size=1.1,halign="end",valign="middle");
// (0,13.55) @PIN(terminal=7,direction="up");
// @LINE {(0,13.55) (0,11.55)};
// (0,10.75) @TEXT("VDD",size=1.1,halign="middle",valign="middle");
// (0,-13.55) @PIN(terminal=8,direction="down");
// @LINE {(0,-13.55) (0,-11.55)};
// (0,-10.75) @TEXT("VSS",size=1.1,halign="middle",valign="middle");
// ? @TEXT("${name}",key="name",size=1.6,halign="middle") => @PLACE(0,15.05);
// ? @TEXT("${model}",key="model",size=0.85,halign="middle") => @PLACE(0,-15.55);
// };
// # @SELECT-INSTANCE(model="sar8_se_window") => @SET-SYMBOL $S_sar8_se_window;
// $S_sar8_se_timing = @DEFINE-SYMBOL {
// @LINE {(-11,14.85) (11,14.85) (11,-14.85) (-11,-14.85) (-11,14.85)};
// (-13,11.55) @PIN(terminal=2,direction="left");
// @LINE {(-13,11.55) (-11,11.55)};
// (-10.5,11.55) @TEXT("SAMPLE",size=1.1,halign="start",valign="middle");
// (-13,8.25) @PIN(terminal=3,direction="left");
// @LINE {(-13,8.25) (-11,8.25)};
// (-10.5,8.25) @TEXT("SEL9",size=1.1,halign="start",valign="middle");
// (-13,4.95) @PIN(terminal=4,direction="left");
// @LINE {(-13,4.95) (-11,4.95)};
// (-10.5,4.95) @TEXT("SEL7",size=1.1,halign="start",valign="middle");
// (-13,1.65) @PIN(terminal=5,direction="left");
// @LINE {(-13,1.65) (-11,1.65)};
// (-10.5,1.65) @TEXT("SEL6",size=1.1,halign="start",valign="middle");
// (-13,-1.65) @PIN(terminal=6,direction="left");
// @LINE {(-13,-1.65) (-11,-1.65)};
// (-10.5,-1.65) @TEXT("SEL5",size=1.1,halign="start",valign="middle");
// (-13,-4.95) @PIN(terminal=7,direction="left");
// @LINE {(-13,-4.95) (-11,-4.95)};
// (-10.5,-4.95) @TEXT("SEL4",size=1.1,halign="start",valign="middle");
// (-13,-8.25) @PIN(terminal=8,direction="left");
// @LINE {(-13,-8.25) (-11,-8.25)};
// (-10.5,-8.25) @TEXT("COMP_P",size=1.1,halign="start",valign="middle");
// (-13,-11.55) @PIN(terminal=9,direction="left");
// @LINE {(-13,-11.55) (-11,-11.55)};
// (-10.5,-11.55) @TEXT("COMP_N",size=1.1,halign="start",valign="middle");
// (13,4.95) @PIN(terminal=1,direction="right");
// @LINE {(13,4.95) (11,4.95)};
// (10.5,4.95) @TEXT("ACTIVE",size=1.1,halign="end",valign="middle");
// (13,1.65) @PIN(terminal=10,direction="right");
// @LINE {(13,1.65) (11,1.65)};
// (10.5,1.65) @TEXT("CMP_CLK",size=1.1,halign="end",valign="middle");
// (13,-1.65) @PIN(terminal=11,direction="right");
// @LINE {(13,-1.65) (11,-1.65)};
// (10.5,-1.65) @TEXT("COMMIT",size=1.1,halign="end",valign="middle");
// (13,-4.95) @PIN(terminal=12,direction="right");
// @LINE {(13,-4.95) (11,-4.95)};
// (10.5,-4.95) @TEXT("DATA",size=1.1,halign="end",valign="middle");
// (0,16.85) @PIN(terminal=13,direction="up");
// @LINE {(0,16.85) (0,14.85)};
// (0,14.05) @TEXT("VDD",size=1.1,halign="middle",valign="middle");
// (0,-16.85) @PIN(terminal=14,direction="down");
// @LINE {(0,-16.85) (0,-14.85)};
// (0,-14.05) @TEXT("VSS",size=1.1,halign="middle",valign="middle");
// ? @TEXT("${name}",key="name",size=1.6,halign="middle") => @PLACE(0,18.35);
// ? @TEXT("${model}",key="model",size=0.85,halign="middle") => @PLACE(0,-18.85);
// };
// # @SELECT-INSTANCE(model="sar8_se_timing") => @SET-SYMBOL $S_sar8_se_timing;
// $S_sar8_se_store = @DEFINE-SYMBOL {
// @LINE {(-11,6) (11,6) (11,-6) (-11,-6) (-11,6)};
// (-13,1.65) @PIN(terminal=1,direction="left");
// @LINE {(-13,1.65) (-11,1.65)};
// (-10.5,1.65) @TEXT("CK",size=1.1,halign="start",valign="middle");
// (-13,-1.65) @PIN(terminal=3,direction="left");
// @LINE {(-13,-1.65) (-11,-1.65)};
// (-10.5,-1.65) @TEXT("RESET",size=1.1,halign="start",valign="middle");
// (13,1.65) @PIN(terminal=2,direction="right");
// @LINE {(13,1.65) (11,1.65)};
// (10.5,1.65) @TEXT("DATA",size=1.1,halign="end",valign="middle");
// (13,-1.65) @PIN(terminal=6,direction="right");
// @LINE {(13,-1.65) (11,-1.65)};
// (10.5,-1.65) @TEXT("Q",size=1.1,halign="end",valign="middle");
// (0,8) @PIN(terminal=4,direction="up");
// @LINE {(0,8) (0,6)};
// (0,5.2) @TEXT("VDD",size=1.1,halign="middle",valign="middle");
// (0,-8) @PIN(terminal=5,direction="down");
// @LINE {(0,-8) (0,-6)};
// (0,-5.2) @TEXT("VSS",size=1.1,halign="middle",valign="middle");
// ? @TEXT("${name}",key="name",size=1.6,halign="middle") => @PLACE(0,9.5);
// ? @TEXT("${model}",key="model",size=0.85,halign="middle") => @PLACE(0,-10);
// };
// # @SELECT-INSTANCE(model="sar8_se_store") => @SET-SYMBOL $S_sar8_se_store;
// $S_sar8_se_ctrl = @DEFINE-SYMBOL {
// @LINE(fill="fillcolor",fillcolor="#f1eef8") {(-11,9.9) (11,9.9) (11,-9.9) (-11,-9.9) (-11,9.9)};
// (-13,3.3) @PIN(terminal=10,direction="left");
// @LINE {(-13,3.3) (-11,3.3)};
// (-10.5,3.3) @TEXT("COMP_N",size=1.1,halign="start",valign="middle");
// (-13,0) @PIN(terminal=11,direction="left");
// @LINE {(-13,0) (-11,0)};
// (-10.5,0) @TEXT("COMP_P",size=1.1,halign="start",valign="middle");
// (-13,-3.3) @PIN(terminal=21,direction="left");
// @LINE {(-13,-3.3) (-11,-3.3)};
// (-10.5,-3.3) @TEXT("SAMPLE",size=1.1,halign="start",valign="middle");
// (13,6.6) @PIN(terminal=1,direction="right");
// @LINE {(13,6.6) (11,6.6)};
// (10.5,6.6) @TEXT("CMP_CLK",size=1.1,halign="end",valign="middle");
// (13,3.3) @PIN(terminal=[2, 3, 4, 5, 6, 7, 8, 9],direction="right");
// @LINE {(13,3.3) (11,3.3)};
// (10.5,3.3) @TEXT("CODE[7:0]",size=1.1,halign="end",valign="middle");
// (13,0) @PIN(terminal=[12, 13, 14, 15, 16, 17, 18, 19],direction="right");
// @LINE {(13,0) (11,0)};
// (10.5,0) @TEXT("D[7:0]",size=1.1,halign="end",valign="middle");
// (13,-3.3) @PIN(terminal=20,direction="right");
// @LINE {(13,-3.3) (11,-3.3)};
// (10.5,-3.3) @TEXT("COMMIT",size=1.1,halign="end",valign="middle");
// (13,-6.6) @PIN(terminal=24,direction="right");
// @LINE {(13,-6.6) (11,-6.6)};
// (10.5,-6.6) @TEXT("ACTIVE",size=1.1,halign="end",valign="middle");
// (0,11.9) @PIN(terminal=22,direction="up");
// @LINE {(0,11.9) (0,9.9)};
// (0,9.1) @TEXT("VDD",size=1.1,halign="middle",valign="middle");
// (0,-11.9) @PIN(terminal=23,direction="down");
// @LINE {(0,-11.9) (0,-9.9)};
// (0,-9.1) @TEXT("VSS",size=1.1,halign="middle",valign="middle");
// ? @TEXT("${name}",key="name",size=1.6,halign="middle") => @PLACE(0,13.4);
// ? @TEXT("${model}",key="model",size=0.85,halign="middle") => @PLACE(0,-13.9);
// };
// # @SELECT-INSTANCE(model="sar8_se_ctrl") => @SET-SYMBOL $S_sar8_se_ctrl;
// $S_sar8_se_acquire = @DEFINE-SYMBOL {
// @LINE {(-11,6) (11,6) (11,-6) (-11,-6) (-11,6)};
// (-13,0) @PIN(terminal=1,direction="left");
// @LINE {(-13,0) (-11,0)};
// (-10.5,0) @TEXT("REQUEST",size=1.1,halign="start",valign="middle");
// (13,0) @PIN(terminal=4,direction="right");
// @LINE {(13,0) (11,0)};
// (10.5,0) @TEXT("TRACK",size=1.1,halign="end",valign="middle");
// (0,8) @PIN(terminal=2,direction="up");
// @LINE {(0,8) (0,6)};
// (0,5.2) @TEXT("VDD",size=1.1,halign="middle",valign="middle");
// (0,-8) @PIN(terminal=3,direction="down");
// @LINE {(0,-8) (0,-6)};
// (0,-5.2) @TEXT("VSS",size=1.1,halign="middle",valign="middle");
// ? @TEXT("${name}",key="name",size=1.6,halign="middle") => @PLACE(0,9.5);
// ? @TEXT("${model}",key="model",size=0.85,halign="middle") => @PLACE(0,-10);
// };
// # @SELECT-INSTANCE(model="sar8_se_acquire") => @SET-SYMBOL $S_sar8_se_acquire;
// $S_tb_cdac = @DEFINE-SYMBOL {
// @LINE {(-11,6) (11,6) (11,-6) (-11,-6) (-11,6)};
// ? @TEXT("${name}",key="name",size=1.6,halign="middle") => @PLACE(0,9.5);
// ? @TEXT("${model}",key="model",size=0.85,halign="middle") => @PLACE(0,-10);
// };
// # @SELECT-INSTANCE(model="tb_cdac") => @SET-SYMBOL $S_tb_cdac;
// $S_tb_comparator = @DEFINE-SYMBOL {
// @LINE {(-11,6) (11,6) (11,-6) (-11,-6) (-11,6)};
// ? @TEXT("${name}",key="name",size=1.6,halign="middle") => @PLACE(0,9.5);
// ? @TEXT("${model}",key="model",size=0.85,halign="middle") => @PLACE(0,-10);
// };
// # @SELECT-INSTANCE(model="tb_comparator") => @SET-SYMBOL $S_tb_comparator;
// $S_tb_reference = @DEFINE-SYMBOL {
// @LINE {(-11,6) (11,6) (11,-6) (-11,-6) (-11,6)};
// ? @TEXT("${name}",key="name",size=1.6,halign="middle") => @PLACE(0,9.5);
// ? @TEXT("${model}",key="model",size=0.85,halign="middle") => @PLACE(0,-10);
// };
// # @SELECT-INSTANCE(model="tb_reference") => @SET-SYMBOL $S_tb_reference;
// $S_tb_sampler = @DEFINE-SYMBOL {
// @LINE {(-11,6) (11,6) (11,-6) (-11,-6) (-11,6)};
// ? @TEXT("${name}",key="name",size=1.6,halign="middle") => @PLACE(0,9.5);
// ? @TEXT("${model}",key="model",size=0.85,halign="middle") => @PLACE(0,-10);
// };
// # @SELECT-INSTANCE(model="tb_sampler") => @SET-SYMBOL $S_tb_sampler;
// $S_tb_sar = @DEFINE-SYMBOL {
// @LINE {(-11,6) (11,6) (11,-6) (-11,-6) (-11,6)};
// ? @TEXT("${name}",key="name",size=1.6,halign="middle") => @PLACE(0,9.5);
// ? @TEXT("${model}",key="model",size=0.85,halign="middle") => @PLACE(0,-10);
// };
// # @SELECT-INSTANCE(model="tb_sar") => @SET-SYMBOL $S_tb_sar;
// $S_tb_sar_top = @DEFINE-SYMBOL {
// @LINE {(-11,9.9) (11,9.9) (11,-9.9) (-11,-9.9) (-11,9.9)};
// (-13,6.6) @PIN(terminal=9,direction="left");
// @LINE {(-13,6.6) (-11,6.6)};
// (-10.5,6.6) @TEXT("SAMPLE",size=1.1,halign="start",valign="middle");
// (-13,3.3) @PIN(terminal=11,direction="left");
// @LINE {(-13,3.3) (-11,3.3)};
// (-10.5,3.3) @TEXT("VINN",size=1.1,halign="start",valign="middle");
// (-13,0) @PIN(terminal=12,direction="left");
// @LINE {(-13,0) (-11,0)};
// (-10.5,0) @TEXT("VINP",size=1.1,halign="start",valign="middle");
// (-13,-3.3) @PIN(terminal=13,direction="left");
// @LINE {(-13,-3.3) (-11,-3.3)};
// (-10.5,-3.3) @TEXT("VREFN",size=1.1,halign="start",valign="middle");
// (-13,-6.6) @PIN(terminal=14,direction="left");
// @LINE {(-13,-6.6) (-11,-6.6)};
// (-10.5,-6.6) @TEXT("VREFP",size=1.1,halign="start",valign="middle");
// (13,0) @PIN(terminal=[1, 2, 3, 4, 5, 6, 7, 8],direction="right");
// @LINE {(13,0) (11,0)};
// (10.5,0) @TEXT("D[7:0]",size=1.1,halign="end",valign="middle");
// (0,11.9) @PIN(terminal=10,direction="up");
// @LINE {(0,11.9) (0,9.9)};
// (0,9.1) @TEXT("VDD!",size=1.1,halign="middle",valign="middle");
// (0,-11.9) @PIN(terminal=15,direction="down");
// @LINE {(0,-11.9) (0,-9.9)};
// (0,-9.1) @TEXT("0",size=1.1,halign="middle",valign="middle");
// ? @TEXT("${name}",key="name",size=1.6,halign="middle") => @PLACE(0,13.4);
// ? @TEXT("${model}",key="model",size=0.85,halign="middle") => @PLACE(0,-13.9);
// };
// # @SELECT-INSTANCE(model="tb_sar_top") => @SET-SYMBOL $S_tb_sar_top;
// $S_tb_sar_stalled_top = @DEFINE-SYMBOL {
// @LINE {(-11,9.9) (11,9.9) (11,-9.9) (-11,-9.9) (-11,9.9)};
// (-13,6.6) @PIN(terminal=9,direction="left");
// @LINE {(-13,6.6) (-11,6.6)};
// (-10.5,6.6) @TEXT("SAMPLE",size=1.1,halign="start",valign="middle");
// (-13,3.3) @PIN(terminal=11,direction="left");
// @LINE {(-13,3.3) (-11,3.3)};
// (-10.5,3.3) @TEXT("VINN",size=1.1,halign="start",valign="middle");
// (-13,0) @PIN(terminal=12,direction="left");
// @LINE {(-13,0) (-11,0)};
// (-10.5,0) @TEXT("VINP",size=1.1,halign="start",valign="middle");
// (-13,-3.3) @PIN(terminal=13,direction="left");
// @LINE {(-13,-3.3) (-11,-3.3)};
// (-10.5,-3.3) @TEXT("VREFN",size=1.1,halign="start",valign="middle");
// (-13,-6.6) @PIN(terminal=14,direction="left");
// @LINE {(-13,-6.6) (-11,-6.6)};
// (-10.5,-6.6) @TEXT("VREFP",size=1.1,halign="start",valign="middle");
// (13,0) @PIN(terminal=[1, 2, 3, 4, 5, 6, 7, 8],direction="right");
// @LINE {(13,0) (11,0)};
// (10.5,0) @TEXT("D[7:0]",size=1.1,halign="end",valign="middle");
// (0,11.9) @PIN(terminal=10,direction="up");
// @LINE {(0,11.9) (0,9.9)};
// (0,9.1) @TEXT("VDD!",size=1.1,halign="middle",valign="middle");
// (0,-11.9) @PIN(terminal=15,direction="down");
// @LINE {(0,-11.9) (0,-9.9)};
// (0,-9.1) @TEXT("0",size=1.1,halign="middle",valign="middle");
// ? @TEXT("${name}",key="name",size=1.6,halign="middle") => @PLACE(0,13.4);
// ? @TEXT("${model}",key="model",size=0.85,halign="middle") => @PLACE(0,-13.9);
// };
// # @SELECT-INSTANCE(model="tb_sar_stalled_top") => @SET-SYMBOL $S_tb_sar_stalled_top;
// $S_INVD1BWP12T30P140 = @DEFINE-SYMBOL {
// (-7,0) @PIN(terminal=1,direction="left");
// @LINE {(-7,0) (-5,0)};
// (7,0) @PIN(terminal=2,direction="right");
// @LINE {(5,0) (7,0)};
// (0,7) @PIN(terminal=3,direction="up");
// @LINE {(0,7) (0,5)};
// (0,-7) @PIN(terminal=4,direction="down");
// @LINE {(0,-7) (0,-5)};
// @LINE {(-5,5) (-5,-5) (4,0) (-5,5)};
// (4.5,0) @CIRCLE(radius=0.5);
// ? @TEXT("${name}",key="name",size=1.6,halign="middle") => @PLACE(0,8.5);
// ? @TEXT("",key="model",size=0.85,halign="middle") => @PLACE(0,-9);
// };
// # @SELECT-INSTANCE(model="INVD1BWP12T30P140") => @SET-SYMBOL $S_INVD1BWP12T30P140;
// $S_INVD2BWP12T30P140 = @DEFINE-SYMBOL {
// @LINE {(-11,6) (11,6) (11,-6) (-11,-6) (-11,6)};
// (-13,0) @PIN(terminal=1,direction="left");
// @LINE {(-13,0) (-11,0)};
// (-10.5,0) @TEXT("I",size=1.1,halign="start",valign="middle");
// (13,0) @PIN(terminal=2,direction="right");
// @LINE {(13,0) (11,0)};
// (10.5,0) @TEXT("ZN",size=1.1,halign="end",valign="middle");
// (0,8) @PIN(terminal=3,direction="up");
// @LINE {(0,8) (0,6)};
// (0,5.2) @TEXT("VDD",size=1.1,halign="middle",valign="middle");
// (0,-8) @PIN(terminal=4,direction="down");
// @LINE {(0,-8) (0,-6)};
// (0,-5.2) @TEXT("VSS",size=1.1,halign="middle",valign="middle");
// ? @TEXT("${name}",key="name",size=1.6,halign="middle") => @PLACE(0,9.5);
// ? @TEXT("${model}",key="model",size=0.85,halign="middle") => @PLACE(0,-10);
// };
// # @SELECT-INSTANCE(model="INVD2BWP12T30P140") => @SET-SYMBOL $S_INVD2BWP12T30P140;
// $S_OR2D1BWP12T30P140 = @DEFINE-SYMBOL {
// @LINE {(-11,6) (11,6) (11,-6) (-11,-6) (-11,6)};
// (-13,1.65) @PIN(terminal=1,direction="left");
// @LINE {(-13,1.65) (-11,1.65)};
// (-10.5,1.65) @TEXT("A1",size=1.1,halign="start",valign="middle");
// (-13,-1.65) @PIN(terminal=2,direction="left");
// @LINE {(-13,-1.65) (-11,-1.65)};
// (-10.5,-1.65) @TEXT("A2",size=1.1,halign="start",valign="middle");
// (13,0) @PIN(terminal=3,direction="right");
// @LINE {(13,0) (11,0)};
// (10.5,0) @TEXT("Z",size=1.1,halign="end",valign="middle");
// (0,8) @PIN(terminal=4,direction="up");
// @LINE {(0,8) (0,6)};
// (0,5.2) @TEXT("VDD",size=1.1,halign="middle",valign="middle");
// (0,-8) @PIN(terminal=5,direction="down");
// @LINE {(0,-8) (0,-6)};
// (0,-5.2) @TEXT("VSS",size=1.1,halign="middle",valign="middle");
// ? @TEXT("${name}",key="name",size=1.6,halign="middle") => @PLACE(0,9.5);
// ? @TEXT("${model}",key="model",size=0.85,halign="middle") => @PLACE(0,-10);
// };
// # @SELECT-INSTANCE(model="OR2D1BWP12T30P140") => @SET-SYMBOL $S_OR2D1BWP12T30P140;
// $S_ND2D1BWP12T30P140 = @DEFINE-SYMBOL {
// (-7,1.7) @PIN(terminal=1,direction="left");
// @LINE {(-7,1.7) (-5,1.7)};
// (-7,-1.7) @PIN(terminal=2,direction="left");
// @LINE {(-7,-1.7) (-5,-1.7)};
// (7,0) @PIN(terminal=3,direction="right");
// @LINE {(5,0) (7,0)};
// (0,7) @PIN(terminal=4,direction="up");
// @LINE {(0,7) (0,5)};
// (0,-7) @PIN(terminal=5,direction="down");
// @LINE {(0,-7) (0,-5)};
// @LINE {(-5,5) (0,5) (3,4) (4.4,2) (5,0) (4.4,-2) (3,-4) (0,-5) (-5,-5) (-5,5)};
// (5.5,0) @CIRCLE(radius=0.5);
// ? @TEXT("${name}",key="name",size=1.6,halign="middle") => @PLACE(0,8.5);
// ? @TEXT("",key="model",size=0.85,halign="middle") => @PLACE(0,-9);
// };
// # @SELECT-INSTANCE(model="ND2D1BWP12T30P140") => @SET-SYMBOL $S_ND2D1BWP12T30P140;
// $S_DFCNQD1BWP12T30P140 = @DEFINE-SYMBOL {
// (-7,3.4) @PIN(terminal=1,direction="left");
// @LINE {(-7,3.4) (-5,3.4)};
// (-4.5,3.4) @TEXT("D",size=0.7,halign="start",valign="middle");
// (-7,0) @PIN(terminal=2,direction="left");
// @LINE {(-7,0) (-5,0)};
// (-4.5,0) @TEXT("CK",size=0.7,halign="start",valign="middle");
// @LINE {(-5,0.7) (-3.8,0) (-5,-0.7)};
// (-7,-3.4) @PIN(terminal=3,direction="left");
// @LINE {(-7,-3.4) (-5,-3.4)};
// (-4.5,-3.4) @TEXT("RN",size=0.7,halign="start",valign="middle");
// (-5.4,-3.4) @CIRCLE(radius=0.4);
// (7,0) @PIN(terminal=4,direction="right");
// @LINE {(5,0) (7,0)};
// (0,7) @PIN(terminal=5,direction="up");
// @LINE {(0,7) (0,5)};
// (0,-7) @PIN(terminal=6,direction="down");
// @LINE {(0,-7) (0,-5)};
// @LINE {(-5,5) (5,5) (5,-5) (-5,-5) (-5,5)};
// (1,0) @TEXT("DFF",size=0.85,halign="middle",valign="middle");
// ? @TEXT("${name}",key="name",size=1.6,halign="middle") => @PLACE(0,8.5);
// ? @TEXT("",key="model",size=0.85,halign="middle") => @PLACE(0,-9);
// };
// # @SELECT-INSTANCE(model="DFCNQD1BWP12T30P140") => @SET-SYMBOL $S_DFCNQD1BWP12T30P140;
// $S_AN2D1BWP12T30P140 = @DEFINE-SYMBOL {
// @LINE {(-11,6) (11,6) (11,-6) (-11,-6) (-11,6)};
// (-13,1.65) @PIN(terminal=1,direction="left");
// @LINE {(-13,1.65) (-11,1.65)};
// (-10.5,1.65) @TEXT("A1",size=1.1,halign="start",valign="middle");
// (-13,-1.65) @PIN(terminal=2,direction="left");
// @LINE {(-13,-1.65) (-11,-1.65)};
// (-10.5,-1.65) @TEXT("A2",size=1.1,halign="start",valign="middle");
// (13,0) @PIN(terminal=3,direction="right");
// @LINE {(13,0) (11,0)};
// (10.5,0) @TEXT("Z",size=1.1,halign="end",valign="middle");
// (0,8) @PIN(terminal=4,direction="up");
// @LINE {(0,8) (0,6)};
// (0,5.2) @TEXT("VDD",size=1.1,halign="middle",valign="middle");
// (0,-8) @PIN(terminal=5,direction="down");
// @LINE {(0,-8) (0,-6)};
// (0,-5.2) @TEXT("VSS",size=1.1,halign="middle",valign="middle");
// ? @TEXT("${name}",key="name",size=1.6,halign="middle") => @PLACE(0,9.5);
// ? @TEXT("${model}",key="model",size=0.85,halign="middle") => @PLACE(0,-10);
// };
// # @SELECT-INSTANCE(model="AN2D1BWP12T30P140") => @SET-SYMBOL $S_AN2D1BWP12T30P140;
// $S_XOR2D1BWP12T30P140 = @DEFINE-SYMBOL {
// @LINE {(-11,6) (11,6) (11,-6) (-11,-6) (-11,6)};
// (-13,1.65) @PIN(terminal=1,direction="left");
// @LINE {(-13,1.65) (-11,1.65)};
// (-10.5,1.65) @TEXT("A1",size=1.1,halign="start",valign="middle");
// (-13,-1.65) @PIN(terminal=2,direction="left");
// @LINE {(-13,-1.65) (-11,-1.65)};
// (-10.5,-1.65) @TEXT("A2",size=1.1,halign="start",valign="middle");
// (13,0) @PIN(terminal=3,direction="right");
// @LINE {(13,0) (11,0)};
// (10.5,0) @TEXT("Z",size=1.1,halign="end",valign="middle");
// (0,8) @PIN(terminal=4,direction="up");
// @LINE {(0,8) (0,6)};
// (0,5.2) @TEXT("VDD",size=1.1,halign="middle",valign="middle");
// (0,-8) @PIN(terminal=5,direction="down");
// @LINE {(0,-8) (0,-6)};
// (0,-5.2) @TEXT("VSS",size=1.1,halign="middle",valign="middle");
// ? @TEXT("${name}",key="name",size=1.6,halign="middle") => @PLACE(0,9.5);
// ? @TEXT("${model}",key="model",size=0.85,halign="middle") => @PLACE(0,-10);
// };
// # @SELECT-INSTANCE(model="XOR2D1BWP12T30P140") => @SET-SYMBOL $S_XOR2D1BWP12T30P140;
// $S_MUX2D1BWP12T30P140 = @DEFINE-SYMBOL {
// @LINE {(-11,6.6) (11,6.6) (11,-6.6) (-11,-6.6) (-11,6.6)};
// (-13,3.3) @PIN(terminal=1,direction="left");
// @LINE {(-13,3.3) (-11,3.3)};
// (-10.5,3.3) @TEXT("I0",size=1.1,halign="start",valign="middle");
// (-13,0) @PIN(terminal=2,direction="left");
// @LINE {(-13,0) (-11,0)};
// (-10.5,0) @TEXT("I1",size=1.1,halign="start",valign="middle");
// (-13,-3.3) @PIN(terminal=3,direction="left");
// @LINE {(-13,-3.3) (-11,-3.3)};
// (-10.5,-3.3) @TEXT("S",size=1.1,halign="start",valign="middle");
// (13,0) @PIN(terminal=4,direction="right");
// @LINE {(13,0) (11,0)};
// (10.5,0) @TEXT("Z",size=1.1,halign="end",valign="middle");
// (0,8.6) @PIN(terminal=5,direction="up");
// @LINE {(0,8.6) (0,6.6)};
// (0,5.8) @TEXT("VDD",size=1.1,halign="middle",valign="middle");
// (0,-8.6) @PIN(terminal=6,direction="down");
// @LINE {(0,-8.6) (0,-6.6)};
// (0,-5.8) @TEXT("VSS",size=1.1,halign="middle",valign="middle");
// ? @TEXT("${name}",key="name",size=1.6,halign="middle") => @PLACE(0,10.1);
// ? @TEXT("${model}",key="model",size=0.85,halign="middle") => @PLACE(0,-10.6);
// };
// # @SELECT-INSTANCE(model="MUX2D1BWP12T30P140") => @SET-SYMBOL $S_MUX2D1BWP12T30P140;
// $S_BUFFD1BWP12T30P140 = @DEFINE-SYMBOL {
// @LINE {(-11,6) (11,6) (11,-6) (-11,-6) (-11,6)};
// (-13,0) @PIN(terminal=1,direction="left");
// @LINE {(-13,0) (-11,0)};
// (-10.5,0) @TEXT("I",size=1.1,halign="start",valign="middle");
// (13,0) @PIN(terminal=2,direction="right");
// @LINE {(13,0) (11,0)};
// (10.5,0) @TEXT("Z",size=1.1,halign="end",valign="middle");
// (0,8) @PIN(terminal=3,direction="up");
// @LINE {(0,8) (0,6)};
// (0,5.2) @TEXT("VDD",size=1.1,halign="middle",valign="middle");
// (0,-8) @PIN(terminal=4,direction="down");
// @LINE {(0,-8) (0,-6)};
// (0,-5.2) @TEXT("VSS",size=1.1,halign="middle",valign="middle");
// ? @TEXT("${name}",key="name",size=1.6,halign="middle") => @PLACE(0,9.5);
// ? @TEXT("${model}",key="model",size=0.85,halign="middle") => @PLACE(0,-10);
// };
// # @SELECT-INSTANCE(model="BUFFD1BWP12T30P140") => @SET-SYMBOL $S_BUFFD1BWP12T30P140;
// $S_BUFFD2BWP12T30P140 = @DEFINE-SYMBOL {
// @LINE {(-11,6) (11,6) (11,-6) (-11,-6) (-11,6)};
// (-13,0) @PIN(terminal=1,direction="left");
// @LINE {(-13,0) (-11,0)};
// (-10.5,0) @TEXT("I",size=1.1,halign="start",valign="middle");
// (13,0) @PIN(terminal=2,direction="right");
// @LINE {(13,0) (11,0)};
// (10.5,0) @TEXT("Z",size=1.1,halign="end",valign="middle");
// (0,8) @PIN(terminal=3,direction="up");
// @LINE {(0,8) (0,6)};
// (0,5.2) @TEXT("VDD",size=1.1,halign="middle",valign="middle");
// (0,-8) @PIN(terminal=4,direction="down");
// @LINE {(0,-8) (0,-6)};
// (0,-5.2) @TEXT("VSS",size=1.1,halign="middle",valign="middle");
// ? @TEXT("${name}",key="name",size=1.6,halign="middle") => @PLACE(0,9.5);
// ? @TEXT("${model}",key="model",size=0.85,halign="middle") => @PLACE(0,-10);
// };
// # @SELECT-INSTANCE(model="BUFFD2BWP12T30P140") => @SET-SYMBOL $S_BUFFD2BWP12T30P140;
// $S_CKBD1BWP12T30P140 = @DEFINE-SYMBOL {
// @LINE {(-11,6) (11,6) (11,-6) (-11,-6) (-11,6)};
// (-13,0) @PIN(terminal=1,direction="left");
// @LINE {(-13,0) (-11,0)};
// (-10.5,0) @TEXT("I",size=1.1,halign="start",valign="middle");
// (13,0) @PIN(terminal=2,direction="right");
// @LINE {(13,0) (11,0)};
// (10.5,0) @TEXT("Z",size=1.1,halign="end",valign="middle");
// (0,8) @PIN(terminal=3,direction="up");
// @LINE {(0,8) (0,6)};
// (0,5.2) @TEXT("VDD",size=1.1,halign="middle",valign="middle");
// (0,-8) @PIN(terminal=4,direction="down");
// @LINE {(0,-8) (0,-6)};
// (0,-5.2) @TEXT("VSS",size=1.1,halign="middle",valign="middle");
// ? @TEXT("${name}",key="name",size=1.6,halign="middle") => @PLACE(0,9.5);
// ? @TEXT("${model}",key="model",size=0.85,halign="middle") => @PLACE(0,-10);
// };
// # @SELECT-INSTANCE(model="CKBD1BWP12T30P140") => @SET-SYMBOL $S_CKBD1BWP12T30P140;
// $S_LHCNDQD1BWP12T30P140 = @DEFINE-SYMBOL {
// @LINE {(-11,6.6) (11,6.6) (11,-6.6) (-11,-6.6) (-11,6.6)};
// (-13,3.3) @PIN(terminal=1,direction="left");
// @LINE {(-13,3.3) (-11,3.3)};
// (-10.5,3.3) @TEXT("D",size=1.1,halign="start",valign="middle");
// (-13,0) @PIN(terminal=2,direction="left");
// @LINE {(-13,0) (-11,0)};
// (-10.5,0) @TEXT("E",size=1.1,halign="start",valign="middle");
// (-13,-3.3) @PIN(terminal=3,direction="left");
// @LINE {(-13,-3.3) (-11,-3.3)};
// (-10.5,-3.3) @TEXT("CDN",size=1.1,halign="start",valign="middle");
// (13,0) @PIN(terminal=4,direction="right");
// @LINE {(13,0) (11,0)};
// (10.5,0) @TEXT("Q",size=1.1,halign="end",valign="middle");
// (0,8.6) @PIN(terminal=5,direction="up");
// @LINE {(0,8.6) (0,6.6)};
// (0,5.8) @TEXT("VDD",size=1.1,halign="middle",valign="middle");
// (0,-8.6) @PIN(terminal=6,direction="down");
// @LINE {(0,-8.6) (0,-6.6)};
// (0,-5.8) @TEXT("VSS",size=1.1,halign="middle",valign="middle");
// ? @TEXT("${name}",key="name",size=1.6,halign="middle") => @PLACE(0,10.1);
// ? @TEXT("${model}",key="model",size=0.85,halign="middle") => @PLACE(0,-10.6);
// };
// # @SELECT-INSTANCE(model="LHCNDQD1BWP12T30P140") => @SET-SYMBOL $S_LHCNDQD1BWP12T30P140;
// $S_TIEHBWP12T30P140 = @DEFINE-SYMBOL {
// @LINE {(-11,6) (11,6) (11,-6) (-11,-6) (-11,6)};
// (13,0) @PIN(terminal=1,direction="right");
// @LINE {(13,0) (11,0)};
// (10.5,0) @TEXT("Z",size=1.1,halign="end",valign="middle");
// (0,8) @PIN(terminal=2,direction="up");
// @LINE {(0,8) (0,6)};
// (0,5.2) @TEXT("VDD",size=1.1,halign="middle",valign="middle");
// (0,-8) @PIN(terminal=3,direction="down");
// @LINE {(0,-8) (0,-6)};
// (0,-5.2) @TEXT("VSS",size=1.1,halign="middle",valign="middle");
// ? @TEXT("${name}",key="name",size=1.6,halign="middle") => @PLACE(0,9.5);
// ? @TEXT("${model}",key="model",size=0.85,halign="middle") => @PLACE(0,-10);
// };
// # @SELECT-INSTANCE(model="TIEHBWP12T30P140") => @SET-SYMBOL $S_TIEHBWP12T30P140;
// $S_iprobe = @DEFINE-SYMBOL {
// @LINE {(-11,6) (11,6) (11,-6) (-11,-6) (-11,6)};
// (-13,1.65) @PIN(terminal=1,direction="left");
// @LINE {(-13,1.65) (-11,1.65)};
// (-10.5,1.65) @TEXT("p",size=1.1,halign="start",valign="middle");
// (-13,-1.65) @PIN(terminal=2,direction="left");
// @LINE {(-13,-1.65) (-11,-1.65)};
// (-10.5,-1.65) @TEXT("n",size=1.1,halign="start",valign="middle");
// ? @TEXT("${name}",key="name",size=1.6,halign="middle") => @PLACE(0,9.5);
// ? @TEXT("${model}",key="model",size=0.85,halign="middle") => @PLACE(0,-10);
// };
// # @SELECT-INSTANCE(model="iprobe") => @SET-SYMBOL $S_iprobe;
// $S_DEL025D1BWP12T30P140 = @DEFINE-SYMBOL {
// @LINE {(-11,6) (11,6) (11,-6) (-11,-6) (-11,6)};
// (-13,0) @PIN(terminal=1,direction="left");
// @LINE {(-13,0) (-11,0)};
// (-10.5,0) @TEXT("I",size=1.1,halign="start",valign="middle");
// (13,0) @PIN(terminal=2,direction="right");
// @LINE {(13,0) (11,0)};
// (10.5,0) @TEXT("Z",size=1.1,halign="end",valign="middle");
// (0,8) @PIN(terminal=3,direction="up");
// @LINE {(0,8) (0,6)};
// (0,5.2) @TEXT("VDD",size=1.1,halign="middle",valign="middle");
// (0,-8) @PIN(terminal=4,direction="down");
// @LINE {(0,-8) (0,-6)};
// (0,-5.2) @TEXT("VSS",size=1.1,halign="middle",valign="middle");
// ? @TEXT("${name}",key="name",size=1.6,halign="middle") => @PLACE(0,9.5);
// ? @TEXT("${model}",key="model",size=0.85,halign="middle") => @PLACE(0,-10);
// };
// # @SELECT-INSTANCE(model="DEL025D1BWP12T30P140") => @SET-SYMBOL $S_DEL025D1BWP12T30P140;
// $S_DEL050D1BWP12T30P140 = @DEFINE-SYMBOL {
// @LINE {(-11,6) (11,6) (11,-6) (-11,-6) (-11,6)};
// (-13,0) @PIN(terminal=1,direction="left");
// @LINE {(-13,0) (-11,0)};
// (-10.5,0) @TEXT("I",size=1.1,halign="start",valign="middle");
// (13,0) @PIN(terminal=2,direction="right");
// @LINE {(13,0) (11,0)};
// (10.5,0) @TEXT("Z",size=1.1,halign="end",valign="middle");
// (0,8) @PIN(terminal=3,direction="up");
// @LINE {(0,8) (0,6)};
// (0,5.2) @TEXT("VDD",size=1.1,halign="middle",valign="middle");
// (0,-8) @PIN(terminal=4,direction="down");
// @LINE {(0,-8) (0,-6)};
// (0,-5.2) @TEXT("VSS",size=1.1,halign="middle",valign="middle");
// ? @TEXT("${name}",key="name",size=1.6,halign="middle") => @PLACE(0,9.5);
// ? @TEXT("${model}",key="model",size=0.85,halign="middle") => @PLACE(0,-10);
// };
// # @SELECT-INSTANCE(model="DEL050D1BWP12T30P140") => @SET-SYMBOL $S_DEL050D1BWP12T30P140;
// $S_DEL075D1BWP12T30P140 = @DEFINE-SYMBOL {
// @LINE {(-11,6) (11,6) (11,-6) (-11,-6) (-11,6)};
// (-13,0) @PIN(terminal=1,direction="left");
// @LINE {(-13,0) (-11,0)};
// (-10.5,0) @TEXT("I",size=1.1,halign="start",valign="middle");
// (13,0) @PIN(terminal=2,direction="right");
// @LINE {(13,0) (11,0)};
// (10.5,0) @TEXT("Z",size=1.1,halign="end",valign="middle");
// (0,8) @PIN(terminal=3,direction="up");
// @LINE {(0,8) (0,6)};
// (0,5.2) @TEXT("VDD",size=1.1,halign="middle",valign="middle");
// (0,-8) @PIN(terminal=4,direction="down");
// @LINE {(0,-8) (0,-6)};
// (0,-5.2) @TEXT("VSS",size=1.1,halign="middle",valign="middle");
// ? @TEXT("${name}",key="name",size=1.6,halign="middle") => @PLACE(0,9.5);
// ? @TEXT("${model}",key="model",size=0.85,halign="middle") => @PLACE(0,-10);
// };
// # @SELECT-INSTANCE(model="DEL075D1BWP12T30P140") => @SET-SYMBOL $S_DEL075D1BWP12T30P140;
// $S_DEL100D1BWP12T30P140 = @DEFINE-SYMBOL {
// @LINE {(-11,6) (11,6) (11,-6) (-11,-6) (-11,6)};
// (-13,0) @PIN(terminal=1,direction="left");
// @LINE {(-13,0) (-11,0)};
// (-10.5,0) @TEXT("I",size=1.1,halign="start",valign="middle");
// (13,0) @PIN(terminal=2,direction="right");
// @LINE {(13,0) (11,0)};
// (10.5,0) @TEXT("Z",size=1.1,halign="end",valign="middle");
// (0,8) @PIN(terminal=3,direction="up");
// @LINE {(0,8) (0,6)};
// (0,5.2) @TEXT("VDD",size=1.1,halign="middle",valign="middle");
// (0,-8) @PIN(terminal=4,direction="down");
// @LINE {(0,-8) (0,-6)};
// (0,-5.2) @TEXT("VSS",size=1.1,halign="middle",valign="middle");
// ? @TEXT("${name}",key="name",size=1.6,halign="middle") => @PLACE(0,9.5);
// ? @TEXT("${model}",key="model",size=0.85,halign="middle") => @PLACE(0,-10);
// };
// # @SELECT-INSTANCE(model="DEL100D1BWP12T30P140") => @SET-SYMBOL $S_DEL100D1BWP12T30P140;
// $S_DEL150D1BWP12T30P140 = @DEFINE-SYMBOL {
// @LINE {(-11,6) (11,6) (11,-6) (-11,-6) (-11,6)};
// (-13,0) @PIN(terminal=1,direction="left");
// @LINE {(-13,0) (-11,0)};
// (-10.5,0) @TEXT("I",size=1.1,halign="start",valign="middle");
// (13,0) @PIN(terminal=2,direction="right");
// @LINE {(13,0) (11,0)};
// (10.5,0) @TEXT("Z",size=1.1,halign="end",valign="middle");
// (0,8) @PIN(terminal=3,direction="up");
// @LINE {(0,8) (0,6)};
// (0,5.2) @TEXT("VDD",size=1.1,halign="middle",valign="middle");
// (0,-8) @PIN(terminal=4,direction="down");
// @LINE {(0,-8) (0,-6)};
// (0,-5.2) @TEXT("VSS",size=1.1,halign="middle",valign="middle");
// ? @TEXT("${name}",key="name",size=1.6,halign="middle") => @PLACE(0,9.5);
// ? @TEXT("${model}",key="model",size=0.85,halign="middle") => @PLACE(0,-10);
// };
// # @SELECT-INSTANCE(model="DEL150D1BWP12T30P140") => @SET-SYMBOL $S_DEL150D1BWP12T30P140;
// $S_DEL200D1BWP12T30P140 = @DEFINE-SYMBOL {
// @LINE {(-11,6) (11,6) (11,-6) (-11,-6) (-11,6)};
// (-13,0) @PIN(terminal=1,direction="left");
// @LINE {(-13,0) (-11,0)};
// (-10.5,0) @TEXT("I",size=1.1,halign="start",valign="middle");
// (13,0) @PIN(terminal=2,direction="right");
// @LINE {(13,0) (11,0)};
// (10.5,0) @TEXT("Z",size=1.1,halign="end",valign="middle");
// (0,8) @PIN(terminal=3,direction="up");
// @LINE {(0,8) (0,6)};
// (0,5.2) @TEXT("VDD",size=1.1,halign="middle",valign="middle");
// (0,-8) @PIN(terminal=4,direction="down");
// @LINE {(0,-8) (0,-6)};
// (0,-5.2) @TEXT("VSS",size=1.1,halign="middle",valign="middle");
// ? @TEXT("${name}",key="name",size=1.6,halign="middle") => @PLACE(0,9.5);
// ? @TEXT("${model}",key="model",size=0.85,halign="middle") => @PLACE(0,-10);
// };
// # @SELECT-INSTANCE(model="DEL200D1BWP12T30P140") => @SET-SYMBOL $S_DEL200D1BWP12T30P140;
// $S_DEL250D1BWP12T30P140 = @DEFINE-SYMBOL {
// @LINE {(-11,6) (11,6) (11,-6) (-11,-6) (-11,6)};
// (-13,0) @PIN(terminal=1,direction="left");
// @LINE {(-13,0) (-11,0)};
// (-10.5,0) @TEXT("I",size=1.1,halign="start",valign="middle");
// (13,0) @PIN(terminal=2,direction="right");
// @LINE {(13,0) (11,0)};
// (10.5,0) @TEXT("Z",size=1.1,halign="end",valign="middle");
// (0,8) @PIN(terminal=3,direction="up");
// @LINE {(0,8) (0,6)};
// (0,5.2) @TEXT("VDD",size=1.1,halign="middle",valign="middle");
// (0,-8) @PIN(terminal=4,direction="down");
// @LINE {(0,-8) (0,-6)};
// (0,-5.2) @TEXT("VSS",size=1.1,halign="middle",valign="middle");
// ? @TEXT("${name}",key="name",size=1.6,halign="middle") => @PLACE(0,9.5);
// ? @TEXT("${model}",key="model",size=0.85,halign="middle") => @PLACE(0,-10);
// };
// # @SELECT-INSTANCE(model="DEL250D1BWP12T30P140") => @SET-SYMBOL $S_DEL250D1BWP12T30P140;
// $S_b_cdac = @DEFINE-SYMBOL {
// @LINE {(-11,11.55) (11,11.55) (11,-11.55) (-11,-11.55) (-11,11.55)};
// (-13,8.25) @PIN(terminal=[1, 2, 3, 4, 5, 6, 7, 8],direction="left");
// @LINE {(-13,8.25) (-11,8.25)};
// (-10.5,8.25) @TEXT("GNN[7:0]",size=1.1,halign="start",valign="middle");
// (-13,4.95) @PIN(terminal=[9, 10, 11, 12, 13, 14, 15, 16],direction="left");
// @LINE {(-13,4.95) (-11,4.95)};
// (-10.5,4.95) @TEXT("GNP[7:0]",size=1.1,halign="start",valign="middle");
// (-13,1.65) @PIN(terminal=[17, 18, 19, 20, 21, 22, 23, 24],direction="left");
// @LINE {(-13,1.65) (-11,1.65)};
// (-10.5,1.65) @TEXT("GPN[7:0]",size=1.1,halign="start",valign="middle");
// (-13,-1.65) @PIN(terminal=[25, 26, 27, 28, 29, 30, 31, 32],direction="left");
// @LINE {(-13,-1.65) (-11,-1.65)};
// (-10.5,-1.65) @TEXT("GPP[7:0]",size=1.1,halign="start",valign="middle");
// (-13,-4.95) @PIN(terminal=36,direction="left");
// @LINE {(-13,-4.95) (-11,-4.95)};
// (-10.5,-4.95) @TEXT("VREFN",size=1.1,halign="start",valign="middle");
// (-13,-8.25) @PIN(terminal=37,direction="left");
// @LINE {(-13,-8.25) (-11,-8.25)};
// (-10.5,-8.25) @TEXT("VREFP",size=1.1,halign="start",valign="middle");
// (13,1.65) @PIN(terminal=33,direction="right");
// @LINE {(13,1.65) (11,1.65)};
// (10.5,1.65) @TEXT("TOPN",size=1.1,halign="end",valign="middle");
// (13,-1.65) @PIN(terminal=34,direction="right");
// @LINE {(13,-1.65) (11,-1.65)};
// (10.5,-1.65) @TEXT("TOPP",size=1.1,halign="end",valign="middle");
// (0,13.55) @PIN(terminal=35,direction="up");
// @LINE {(0,13.55) (0,11.55)};
// (0,10.75) @TEXT("VDD",size=1.1,halign="middle",valign="middle");
// (0,-13.55) @PIN(terminal=38,direction="down");
// @LINE {(0,-13.55) (0,-11.55)};
// (0,-10.75) @TEXT("VSS",size=1.1,halign="middle",valign="middle");
// ? @TEXT("${name}",key="name",size=1.6,halign="middle") => @PLACE(0,15.05);
// ? @TEXT("${model}",key="model",size=0.85,halign="middle") => @PLACE(0,-15.55);
// };
// # @SELECT-INSTANCE(model="b_cdac") => @SET-SYMBOL $S_b_cdac;
// $S_b_cdac_bit = @DEFINE-SYMBOL {
// @LINE {(-11,11.55) (11,11.55) (11,-11.55) (-11,-11.55) (-11,11.55)};
// (-13,8.25) @PIN(terminal=1,direction="left");
// @LINE {(-13,8.25) (-11,8.25)};
// (-10.5,8.25) @TEXT("GNN",size=1.1,halign="start",valign="middle");
// (-13,4.95) @PIN(terminal=2,direction="left");
// @LINE {(-13,4.95) (-11,4.95)};
// (-10.5,4.95) @TEXT("GNP",size=1.1,halign="start",valign="middle");
// (-13,1.65) @PIN(terminal=3,direction="left");
// @LINE {(-13,1.65) (-11,1.65)};
// (-10.5,1.65) @TEXT("GPN",size=1.1,halign="start",valign="middle");
// (-13,-1.65) @PIN(terminal=4,direction="left");
// @LINE {(-13,-1.65) (-11,-1.65)};
// (-10.5,-1.65) @TEXT("GPP",size=1.1,halign="start",valign="middle");
// (-13,-4.95) @PIN(terminal=7,direction="left");
// @LINE {(-13,-4.95) (-11,-4.95)};
// (-10.5,-4.95) @TEXT("VREFN",size=1.1,halign="start",valign="middle");
// (-13,-8.25) @PIN(terminal=8,direction="left");
// @LINE {(-13,-8.25) (-11,-8.25)};
// (-10.5,-8.25) @TEXT("VREFP",size=1.1,halign="start",valign="middle");
// (13,1.65) @PIN(terminal=5,direction="right");
// @LINE {(13,1.65) (11,1.65)};
// (10.5,1.65) @TEXT("TOPN",size=1.1,halign="end",valign="middle");
// (13,-1.65) @PIN(terminal=6,direction="right");
// @LINE {(13,-1.65) (11,-1.65)};
// (10.5,-1.65) @TEXT("TOPP",size=1.1,halign="end",valign="middle");
// (0,13.55) @PIN(terminal=9,direction="up");
// @LINE {(0,13.55) (0,11.55)};
// (0,10.75) @TEXT("VDD",size=1.1,halign="middle",valign="middle");
// (0,-13.55) @PIN(terminal=10,direction="down");
// @LINE {(0,-13.55) (0,-11.55)};
// (0,-10.75) @TEXT("VSS",size=1.1,halign="middle",valign="middle");
// ? @TEXT("${name}",key="name",size=1.6,halign="middle") => @PLACE(0,15.05);
// ? @TEXT("${model}",key="model",size=0.85,halign="middle") => @PLACE(0,-15.55);
// };
// # @SELECT-INSTANCE(model="b_cdac_bit") => @SET-SYMBOL $S_b_cdac_bit;
// $S_b_comparator = @DEFINE-SYMBOL {
// @LINE {(-11,6.6) (11,6.6) (11,-6.6) (-11,-6.6) (-11,6.6)};
// (-13,3.3) @PIN(terminal=1,direction="left");
// @LINE {(-13,3.3) (-11,3.3)};
// (-10.5,3.3) @TEXT("CLK",size=1.1,halign="start",valign="middle");
// (-13,0) @PIN(terminal=5,direction="left");
// @LINE {(-13,0) (-11,0)};
// (-10.5,0) @TEXT("VINN",size=1.1,halign="start",valign="middle");
// (-13,-3.3) @PIN(terminal=6,direction="left");
// @LINE {(-13,-3.3) (-11,-3.3)};
// (-10.5,-3.3) @TEXT("VINP",size=1.1,halign="start",valign="middle");
// (13,1.65) @PIN(terminal=2,direction="right");
// @LINE {(13,1.65) (11,1.65)};
// (10.5,1.65) @TEXT("OUTN",size=1.1,halign="end",valign="middle");
// (13,-1.65) @PIN(terminal=3,direction="right");
// @LINE {(13,-1.65) (11,-1.65)};
// (10.5,-1.65) @TEXT("OUTP",size=1.1,halign="end",valign="middle");
// (0,8.6) @PIN(terminal=4,direction="up");
// @LINE {(0,8.6) (0,6.6)};
// (0,5.8) @TEXT("VDD",size=1.1,halign="middle",valign="middle");
// (0,-8.6) @PIN(terminal=7,direction="down");
// @LINE {(0,-8.6) (0,-6.6)};
// (0,-5.8) @TEXT("VSS",size=1.1,halign="middle",valign="middle");
// ? @TEXT("${name}",key="name",size=1.6,halign="middle") => @PLACE(0,10.1);
// ? @TEXT("${model}",key="model",size=0.85,halign="middle") => @PLACE(0,-10.6);
// };
// # @SELECT-INSTANCE(model="b_comparator") => @SET-SYMBOL $S_b_comparator;
// $S_b_reference = @DEFINE-SYMBOL {
// @LINE {(-11,11.55) (11,11.55) (11,-11.55) (-11,-11.55) (-11,11.55)};
// (-13,4.95) @PIN(terminal=[1, 2, 3, 4, 5, 6, 7, 8],direction="left");
// @LINE {(-13,4.95) (-11,4.95)};
// (-10.5,4.95) @TEXT("CODE[7:0]",size=1.1,halign="start",valign="middle");
// (-13,1.65) @PIN(terminal=[9, 10, 11, 12, 13, 14, 15, 16],direction="left");
// @LINE {(-13,1.65) (-11,1.65)};
// (-10.5,1.65) @TEXT("D[7:0]",size=1.1,halign="start",valign="middle");
// (-13,-1.65) @PIN(terminal=49,direction="left");
// @LINE {(-13,-1.65) (-11,-1.65)};
// (-10.5,-1.65) @TEXT("PHI_U",size=1.1,halign="start",valign="middle");
// (-13,-4.95) @PIN(terminal=50,direction="left");
// @LINE {(-13,-4.95) (-11,-4.95)};
// (-10.5,-4.95) @TEXT("SAMPLE",size=1.1,halign="start",valign="middle");
// (13,8.25) @PIN(terminal=[17, 18, 19, 20, 21, 22, 23, 24],direction="right");
// @LINE {(13,8.25) (11,8.25)};
// (10.5,8.25) @TEXT("GNN[7:0]",size=1.1,halign="end",valign="middle");
// (13,4.95) @PIN(terminal=[25, 26, 27, 28, 29, 30, 31, 32],direction="right");
// @LINE {(13,4.95) (11,4.95)};
// (10.5,4.95) @TEXT("GNP[7:0]",size=1.1,halign="end",valign="middle");
// (13,1.65) @PIN(terminal=[33, 34, 35, 36, 37, 38, 39, 40],direction="right");
// @LINE {(13,1.65) (11,1.65)};
// (10.5,1.65) @TEXT("GPN[7:0]",size=1.1,halign="end",valign="middle");
// (13,-1.65) @PIN(terminal=[41, 42, 43, 44, 45, 46, 47, 48],direction="right");
// @LINE {(13,-1.65) (11,-1.65)};
// (10.5,-1.65) @TEXT("GPP[7:0]",size=1.1,halign="end",valign="middle");
// (13,-4.95) @PIN(terminal=53,direction="right");
// @LINE {(13,-4.95) (11,-4.95)};
// (10.5,-4.95) @TEXT("RST_DONE",size=1.1,halign="end",valign="middle");
// (13,-8.25) @PIN(terminal=54,direction="right");
// @LINE {(13,-8.25) (11,-8.25)};
// (10.5,-8.25) @TEXT("PRESET",size=1.1,halign="end",valign="middle");
// (0,13.55) @PIN(terminal=51,direction="up");
// @LINE {(0,13.55) (0,11.55)};
// (0,10.75) @TEXT("VDD",size=1.1,halign="middle",valign="middle");
// (0,-13.55) @PIN(terminal=52,direction="down");
// @LINE {(0,-13.55) (0,-11.55)};
// (0,-10.75) @TEXT("VSS",size=1.1,halign="middle",valign="middle");
// ? @TEXT("${name}",key="name",size=1.6,halign="middle") => @PLACE(0,15.05);
// ? @TEXT("${model}",key="model",size=0.85,halign="middle") => @PLACE(0,-15.55);
// };
// # @SELECT-INSTANCE(model="b_reference") => @SET-SYMBOL $S_b_reference;
// $S_b_edge = @DEFINE-SYMBOL {
// @LINE {(-11,6) (11,6) (11,-6) (-11,-6) (-11,6)};
// (-13,0) @PIN(terminal=1,direction="left");
// @LINE {(-13,0) (-11,0)};
// (-10.5,0) @TEXT("A",size=1.1,halign="start",valign="middle");
// (13,0) @PIN(terminal=4,direction="right");
// @LINE {(13,0) (11,0)};
// (10.5,0) @TEXT("Y",size=1.1,halign="end",valign="middle");
// (0,8) @PIN(terminal=2,direction="up");
// @LINE {(0,8) (0,6)};
// (0,5.2) @TEXT("VDD",size=1.1,halign="middle",valign="middle");
// (0,-8) @PIN(terminal=3,direction="down");
// @LINE {(0,-8) (0,-6)};
// (0,-5.2) @TEXT("VSS",size=1.1,halign="middle",valign="middle");
// ? @TEXT("${name}",key="name",size=1.6,halign="middle") => @PLACE(0,9.5);
// ? @TEXT("${model}",key="model",size=0.85,halign="middle") => @PLACE(0,-10);
// };
// # @SELECT-INSTANCE(model="b_edge") => @SET-SYMBOL $S_b_edge;
// $S_b_idle = @DEFINE-SYMBOL {
// @LINE {(-11,6) (11,6) (11,-6) (-11,-6) (-11,6)};
// (-13,1.65) @PIN(terminal=2,direction="left");
// @LINE {(-13,1.65) (-11,1.65)};
// (-10.5,1.65) @TEXT("SAMPLE",size=1.1,halign="start",valign="middle");
// (-13,-1.65) @PIN(terminal=6,direction="left");
// @LINE {(-13,-1.65) (-11,-1.65)};
// (-10.5,-1.65) @TEXT("SAMPLE_MATCH",size=1.1,halign="start",valign="middle");
// (13,1.65) @PIN(terminal=1,direction="right");
// @LINE {(13,1.65) (11,1.65)};
// (10.5,1.65) @TEXT("ACTIVE",size=1.1,halign="end",valign="middle");
// (13,-1.65) @PIN(terminal=5,direction="right");
// @LINE {(13,-1.65) (11,-1.65)};
// (10.5,-1.65) @TEXT("PRESET",size=1.1,halign="end",valign="middle");
// (0,8) @PIN(terminal=3,direction="up");
// @LINE {(0,8) (0,6)};
// (0,5.2) @TEXT("VDD",size=1.1,halign="middle",valign="middle");
// (0,-8) @PIN(terminal=4,direction="down");
// @LINE {(0,-8) (0,-6)};
// (0,-5.2) @TEXT("VSS",size=1.1,halign="middle",valign="middle");
// ? @TEXT("${name}",key="name",size=1.6,halign="middle") => @PLACE(0,9.5);
// ? @TEXT("${model}",key="model",size=0.85,halign="middle") => @PLACE(0,-10);
// };
// # @SELECT-INSTANCE(model="b_idle") => @SET-SYMBOL $S_b_idle;
// $S_b_sampler = @DEFINE-SYMBOL {
// @LINE {(-11,6) (11,6) (11,-6) (-11,-6) (-11,6)};
// (-13,1.65) @PIN(terminal=1,direction="left");
// @LINE {(-13,1.65) (-11,1.65)};
// (-10.5,1.65) @TEXT("CLKS",size=1.1,halign="start",valign="middle");
// (-13,-1.65) @PIN(terminal=3,direction="left");
// @LINE {(-13,-1.65) (-11,-1.65)};
// (-10.5,-1.65) @TEXT("VIN",size=1.1,halign="start",valign="middle");
// (13,0) @PIN(terminal=2,direction="right");
// @LINE {(13,0) (11,0)};
// (10.5,0) @TEXT("VOUT",size=1.1,halign="end",valign="middle");
// (0,8) @PIN(terminal=4,direction="up");
// @LINE {(0,8) (0,6)};
// (0,5.2) @TEXT("VDD",size=1.1,halign="middle",valign="middle");
// (0,-8) @PIN(terminal=5,direction="down");
// @LINE {(0,-8) (0,-6)};
// (0,-5.2) @TEXT("VSS",size=1.1,halign="middle",valign="middle");
// ? @TEXT("${name}",key="name",size=1.6,halign="middle") => @PLACE(0,9.5);
// ? @TEXT("${model}",key="model",size=0.85,halign="middle") => @PLACE(0,-10);
// };
// # @SELECT-INSTANCE(model="b_sampler") => @SET-SYMBOL $S_b_sampler;
// $S_b_sar = @DEFINE-SYMBOL {
// @LINE {(-11,9.9) (11,9.9) (11,-9.9) (-11,-9.9) (-11,9.9)};
// (-13,3.3) @PIN(terminal=10,direction="left");
// @LINE {(-13,3.3) (-11,3.3)};
// (-10.5,3.3) @TEXT("COMP_N",size=1.1,halign="start",valign="middle");
// (-13,0) @PIN(terminal=11,direction="left");
// @LINE {(-13,0) (-11,0)};
// (-10.5,0) @TEXT("COMP_P",size=1.1,halign="start",valign="middle");
// (-13,-3.3) @PIN(terminal=21,direction="left");
// @LINE {(-13,-3.3) (-11,-3.3)};
// (-10.5,-3.3) @TEXT("SAMPLE",size=1.1,halign="start",valign="middle");
// (13,6.6) @PIN(terminal=1,direction="right");
// @LINE {(13,6.6) (11,6.6)};
// (10.5,6.6) @TEXT("CMP_CLK",size=1.1,halign="end",valign="middle");
// (13,3.3) @PIN(terminal=[2, 3, 4, 5, 6, 7, 8, 9],direction="right");
// @LINE {(13,3.3) (11,3.3)};
// (10.5,3.3) @TEXT("CODE[7:0]",size=1.1,halign="end",valign="middle");
// (13,0) @PIN(terminal=[12, 13, 14, 15, 16, 17, 18, 19],direction="right");
// @LINE {(13,0) (11,0)};
// (10.5,0) @TEXT("D[7:0]",size=1.1,halign="end",valign="middle");
// (13,-3.3) @PIN(terminal=20,direction="right");
// @LINE {(13,-3.3) (11,-3.3)};
// (10.5,-3.3) @TEXT("PHI_U",size=1.1,halign="end",valign="middle");
// (13,-6.6) @PIN(terminal=24,direction="right");
// @LINE {(13,-6.6) (11,-6.6)};
// (10.5,-6.6) @TEXT("ACTIVE",size=1.1,halign="end",valign="middle");
// (0,11.9) @PIN(terminal=22,direction="up");
// @LINE {(0,11.9) (0,9.9)};
// (0,9.1) @TEXT("VDD",size=1.1,halign="middle",valign="middle");
// (0,-11.9) @PIN(terminal=23,direction="down");
// @LINE {(0,-11.9) (0,-9.9)};
// (0,-9.1) @TEXT("VSS",size=1.1,halign="middle",valign="middle");
// ? @TEXT("${name}",key="name",size=1.6,halign="middle") => @PLACE(0,13.4);
// ? @TEXT("${model}",key="model",size=0.85,halign="middle") => @PLACE(0,-13.9);
// };
// # @SELECT-INSTANCE(model="b_sar") => @SET-SYMBOL $S_b_sar;
// $S_sar_adc_b = @DEFINE-SYMBOL {
// @LINE {(-11,9.9) (11,9.9) (11,-9.9) (-11,-9.9) (-11,9.9)};
// (-13,6.6) @PIN(terminal=9,direction="left");
// @LINE {(-13,6.6) (-11,6.6)};
// (-10.5,6.6) @TEXT("SAMPLE",size=1.1,halign="start",valign="middle");
// (-13,3.3) @PIN(terminal=11,direction="left");
// @LINE {(-13,3.3) (-11,3.3)};
// (-10.5,3.3) @TEXT("VINN",size=1.1,halign="start",valign="middle");
// (-13,0) @PIN(terminal=12,direction="left");
// @LINE {(-13,0) (-11,0)};
// (-10.5,0) @TEXT("VINP",size=1.1,halign="start",valign="middle");
// (-13,-3.3) @PIN(terminal=13,direction="left");
// @LINE {(-13,-3.3) (-11,-3.3)};
// (-10.5,-3.3) @TEXT("VREFN",size=1.1,halign="start",valign="middle");
// (-13,-6.6) @PIN(terminal=14,direction="left");
// @LINE {(-13,-6.6) (-11,-6.6)};
// (-10.5,-6.6) @TEXT("VREFP",size=1.1,halign="start",valign="middle");
// (13,0) @PIN(terminal=[1, 2, 3, 4, 5, 6, 7, 8],direction="right");
// @LINE {(13,0) (11,0)};
// (10.5,0) @TEXT("D[7:0]",size=1.1,halign="end",valign="middle");
// (0,11.9) @PIN(terminal=10,direction="up");
// @LINE {(0,11.9) (0,9.9)};
// (0,9.1) @TEXT("VDD",size=1.1,halign="middle",valign="middle");
// (0,-11.9) @PIN(terminal=15,direction="down");
// @LINE {(0,-11.9) (0,-9.9)};
// (0,-9.1) @TEXT("VSS",size=1.1,halign="middle",valign="middle");
// ? @TEXT("${name}",key="name",size=1.6,halign="middle") => @PLACE(0,13.4);
// ? @TEXT("${model}",key="model",size=0.85,halign="middle") => @PLACE(0,-13.9);
// };
// # @SELECT-INSTANCE(model="sar_adc_b") => @SET-SYMBOL $S_sar_adc_b;
// $S_b_delay = @DEFINE-SYMBOL {
// @LINE {(-11,6) (11,6) (11,-6) (-11,-6) (-11,6)};
// (-13,0) @PIN(terminal=1,direction="left");
// @LINE {(-13,0) (-11,0)};
// (-10.5,0) @TEXT("A",size=1.1,halign="start",valign="middle");
// (13,0) @PIN(terminal=4,direction="right");
// @LINE {(13,0) (11,0)};
// (10.5,0) @TEXT("Y",size=1.1,halign="end",valign="middle");
// (0,8) @PIN(terminal=2,direction="up");
// @LINE {(0,8) (0,6)};
// (0,5.2) @TEXT("VDD",size=1.1,halign="middle",valign="middle");
// (0,-8) @PIN(terminal=3,direction="down");
// @LINE {(0,-8) (0,-6)};
// (0,-5.2) @TEXT("VSS",size=1.1,halign="middle",valign="middle");
// ? @TEXT("${name}",key="name",size=1.6,halign="middle") => @PLACE(0,9.5);
// ? @TEXT("${model}",key="model",size=0.85,halign="middle") => @PLACE(0,-10);
// };
// # @SELECT-INSTANCE(model="b_delay") => @SET-SYMBOL $S_b_delay;
// $S_b_behavior_observer = @DEFINE-SYMBOL {
// @LINE {(-11,6) (11,6) (11,-6) (-11,-6) (-11,6)};
// (-13,0) @PIN(terminal=9,direction="left");
// @LINE {(-13,0) (-11,0)};
// (-10.5,0) @TEXT("SAMPLE",size=1.1,halign="start",valign="middle");
// (13,0) @PIN(terminal=[1, 2, 3, 4, 5, 6, 7, 8],direction="right");
// @LINE {(13,0) (11,0)};
// (10.5,0) @TEXT("D[7:0]",size=1.1,halign="end",valign="middle");
// (0,8) @PIN(terminal=10,direction="up");
// @LINE {(0,8) (0,6)};
// (0,5.2) @TEXT("VDD",size=1.1,halign="middle",valign="middle");
// (0,-8) @PIN(terminal=11,direction="down");
// @LINE {(0,-8) (0,-6)};
// (0,-5.2) @TEXT("VSS",size=1.1,halign="middle",valign="middle");
// ? @TEXT("${name}",key="name",size=1.6,halign="middle") => @PLACE(0,9.5);
// ? @TEXT("${model}",key="model",size=0.85,halign="middle") => @PLACE(0,-10);
// };
// # @SELECT-INSTANCE(model="b_behavior_observer") => @SET-SYMBOL $S_b_behavior_observer;
// $S_b_tb_switch = @DEFINE-SYMBOL {
// @LINE {(-11,6.6) (11,6.6) (11,-6.6) (-11,-6.6) (-11,6.6)};
// (-13,3.3) @PIN(terminal=1,direction="left");
// @LINE {(-13,3.3) (-11,3.3)};
// (-10.5,3.3) @TEXT("A",size=1.1,halign="start",valign="middle");
// (-13,0) @PIN(terminal=2,direction="left");
// @LINE {(-13,0) (-11,0)};
// (-10.5,0) @TEXT("B",size=1.1,halign="start",valign="middle");
// (-13,-3.3) @PIN(terminal=3,direction="left");
// @LINE {(-13,-3.3) (-11,-3.3)};
// (-10.5,-3.3) @TEXT("EN",size=1.1,halign="start",valign="middle");
// (0,8.6) @PIN(terminal=4,direction="up");
// @LINE {(0,8.6) (0,6.6)};
// (0,5.8) @TEXT("VDD",size=1.1,halign="middle",valign="middle");
// (0,-8.6) @PIN(terminal=5,direction="down");
// @LINE {(0,-8.6) (0,-6.6)};
// (0,-5.8) @TEXT("VSS",size=1.1,halign="middle",valign="middle");
// ? @TEXT("${name}",key="name",size=1.6,halign="middle") => @PLACE(0,10.1);
// ? @TEXT("${model}",key="model",size=0.85,halign="middle") => @PLACE(0,-10.6);
// };
// # @SELECT-INSTANCE(model="b_tb_switch") => @SET-SYMBOL $S_b_tb_switch;
// $S_b_sampler_bridge = @DEFINE-SYMBOL {
// @LINE {(-11,6) (11,6) (11,-6) (-11,-6) (-11,6)};
// (-13,1.65) @PIN(terminal=1,direction="left");
// @LINE {(-13,1.65) (-11,1.65)};
// (-10.5,1.65) @TEXT("CLKS",size=1.1,halign="start",valign="middle");
// (-13,-1.65) @PIN(terminal=3,direction="left");
// @LINE {(-13,-1.65) (-11,-1.65)};
// (-10.5,-1.65) @TEXT("Vin",size=1.1,halign="start",valign="middle");
// (13,0) @PIN(terminal=2,direction="right");
// @LINE {(13,0) (11,0)};
// (10.5,0) @TEXT("VOUT",size=1.1,halign="end",valign="middle");
// ? @TEXT("${name}",key="name",size=1.6,halign="middle") => @PLACE(0,9.5);
// ? @TEXT("${model}",key="model",size=0.85,halign="middle") => @PLACE(0,-10);
// };
// # @SELECT-INSTANCE(model="b_sampler_bridge") => @SET-SYMBOL $S_b_sampler_bridge;
// } }
// END SARADC RNL

simulator lang=spectre

subckt sar_adc8_join_r4 D0 D1 D2 D3 D4 D5 D6 D7 SAMPLE VDD! VINN VINP  VREFN VREFP 0
    XSEQ (SAMPLE_INT VDD! 0 SEQ_SAMPLE) sar8_se_acquire
    XDONE (ACTIVE DONE VDD! 0) INVD1BWP12T30P140
    XPRESET (DONE SEQ_SAMPLE PRESET VDD! 0) OR2D1BWP12T30P140
    XSAMPLE (SAMPLE SAMPLE_INT VDD! 0) CKBD1BWP12T30P140
    XBOOTN (SEQ_SAMPLE TOPN VINN) sar_bootstrap_flat_8b_p
    XBOOTP (SEQ_SAMPLE TOPP VINP) sar_bootstrap_flat_8b_p
    XCDAC (GNN0 GNN1 GNN2 GNN3 GNN4 GNN5 GNN6 GNN7 GNP0 GNP1 GNP2 GNP3  GNP4 GNP5 GNP6 GNP7 GPN0 GPN1 GPN2 GPN3 GPN4 GPN5 GPN6 GPN7 GPP0  GPP1 GPP2 GPP3 GPP4 GPP5 GPP6 GPP7 TOPN TOPP VDD! VREFN VREFP 0)  sar8j_r1_cdac
    XCTRL (CMP_CLK CODE0 CODE1 CODE2 CODE3 CODE4 CODE5 CODE6 CODE7 COMP_N  COMP_P D0 D1 D2 D3 D4 D5 D6 D7 PHI_U SEQ_SAMPLE VDD! 0 ACTIVE) sar8_se_ctrl
    XREF (CODE0 CODE1 CODE2 CODE3 CODE4 CODE5 CODE6 CODE7 D0 D1 D2 D3 D4  D5 D6 D7 GNN0 GNN1 GNN2 GNN3 GNN4 GNN5 GNN6 GNN7 GNP0 GNP1 GNP2  GNP3 GNP4 GNP5 GNP6 GNP7 GPN0 GPN1 GPN2 GPN3 GPN4 GPN5 GPN6 GPN7  GPP0 GPP1 GPP2 GPP3 GPP4 GPP5 GPP6 GPP7 PHI_U SAMPLE_INT VDD! 0 RST_DONE PRESET)  sar8i_refword
    XCOMP (CMP_CLK COMP_N COMP_P VDD! TOPN TOPP 0) sar_strongarm_t28
    CL_COMP_N (COMP_N 0) cfmom_2t nr=8 lr=2.5u w=50n s=50n stm=1 spm=3  multi=2 mismatchflag=1
    CL_COMP_P (COMP_P 0) cfmom_2t nr=8 lr=2.5u w=50n s=50n stm=1 spm=3  multi=2 mismatchflag=1
    CL_CMP_CLK (CMP_CLK 0) cfmom_2t nr=8 lr=2.5u w=50n s=50n stm=1 spm=3  multi=2 mismatchflag=1
// BEGIN SARADC RNL
// @RNL(author="saradc topology") {
// (-29,84) @TEXT("SAR8   /   Asynchronous differential ADC",size=2.75,halign="start",textcolor="#223d52");
// (-29,76) @TEXT("Sample control",size=1.35,halign="start",textcolor="#223d52");
// (111,76) @TEXT("Reference preset",size=1.35,halign="start",textcolor="#223d52");
// #XSAMPLE @SET-SYMBOL $S_CKBD1BWP12T30P140;
// #XSAMPLE @PLACE(0,62) => @ORIENT("R0");
// #XSEQ @SET-SYMBOL $S_sar8_se_acquire;
// #XSEQ @PLACE(36,62) => @ORIENT("R0");
// #XDONE @SET-SYMBOL $S_INVD1BWP12T30P140;
// #XDONE @PLACE(132,62) => @ORIENT("R0");
// #XPRESET @SET-SYMBOL $S_OR2D1BWP12T30P140;
// #XPRESET @PLACE(161,62) => @ORIENT("R0");
// #XBOOTN @SET-SYMBOL $S_sar_bootstrap_flat_8b_p;
// #XBOOTN @PLACE(0,27) => @ORIENT("R0");
// #XBOOTP @SET-SYMBOL $S_sar_bootstrap_flat_8b_p;
// #XBOOTP @PLACE(0,4) => @ORIENT("R0");
// #XCDAC @SET-SYMBOL $S_sar8j_r1_cdac;
// #XCDAC @PLACE(46,-12) => @ORIENT("R0");
// #XCOMP @SET-SYMBOL $S_sar_strongarm_t28;
// #XCOMP @PLACE(94,18) => @ORIENT("R0");
// #XCTRL @SET-SYMBOL $S_sar8_se_ctrl;
// #XCTRL @PLACE(139,18) => @ORIENT("R0");
// #XREF @SET-SYMBOL $S_sar8i_refword;
// #XREF @PLACE(46,-48) => @ORIENT("R0");
// #CL_COMP_N @SET-SYMBOL $CAPACITOR;
// #CL_COMP_N @PLACE(113,-13) => @ORIENT("R0");
// #CL_COMP_N @TEXT("CL_COMP_N",key="name",size=1.3,halign="start") => @PLACE(116,-10);
// #CL_COMP_N @TEXT("nr=8 lr=2.5u w=50n multi=2",key="value",size=0.9,halign="start") => @PLACE(116,-17);
// #CL_COMP_N @TEXT("",key="model");
// #CL_COMP_P @SET-SYMBOL $CAPACITOR;
// #CL_COMP_P @PLACE(127,-24) => @ORIENT("R0");
// #CL_COMP_P @TEXT("CL_COMP_P",key="name",size=1.3,halign="start") => @PLACE(130,-21);
// #CL_COMP_P @TEXT("nr=8 lr=2.5u w=50n multi=2",key="value",size=0.9,halign="start") => @PLACE(130,-28);
// #CL_COMP_P @TEXT("",key="model");
// #CL_CMP_CLK @SET-SYMBOL $CAPACITOR;
// #CL_CMP_CLK @PLACE(95,51) => @ORIENT("MX");
// #CL_CMP_CLK @TEXT("CL_CMP_CLK",key="name",size=1.3,halign="start") => @PLACE(98,54);
// #CL_CMP_CLK @TEXT("nr=8 lr=2.5u w=50n multi=2",key="value",size=0.9,halign="start") => @PLACE(98,47);
// #CL_CMP_CLK @TEXT("",key="model");
// #XSAMPLE @TEXT("Buffer",key="name",size=1.65,halign="middle",textcolor="#223d52") => @PLACE(0,62);
// #XSAMPLE @TEXT("",key="model");
// #XSEQ @TEXT("Acquisition",key="name",size=1.65,halign="middle",textcolor="#223d52") => @PLACE(36,62);
// #XSEQ @TEXT("",key="model");
// #XDONE @TEXT("Done",key="name",size=1.65,halign="middle",textcolor="#223d52") => @PLACE(132,70);
// #XDONE @TEXT("",key="model");
// #XPRESET @TEXT("Preset",key="name",size=1.65,halign="middle",textcolor="#223d52") => @PLACE(161,62);
// #XPRESET @TEXT("",key="model");
// #XBOOTN @TEXT("Sampler N",key="name",size=1.65,halign="middle",textcolor="#223d52") => @PLACE(0,27);
// #XBOOTN @TEXT("",key="model");
// #XBOOTP @TEXT("Sampler P",key="name",size=1.65,halign="middle",textcolor="#223d52") => @PLACE(0,4);
// #XBOOTP @TEXT("",key="model");
// #XCDAC @TEXT("MOM CDAC",key="name",size=1.65,halign="middle",textcolor="#223d52") => @PLACE(46,-12);
// #XCDAC @TEXT("",key="model");
// #XCOMP @TEXT("StrongARM",key="name",size=1.65,halign="middle",textcolor="#223d52") => @PLACE(94,18);
// #XCOMP @TEXT("",key="model");
// #XCTRL @TEXT("SAR",key="name",size=1.65,halign="middle",textcolor="#223d52") => @PLACE(139,23);
// #XCTRL @TEXT("",key="model");
// #XREF @TEXT("Reference drive",key="name",size=1.65,halign="middle",textcolor="#223d52") => @PLACE(46,-48);
// #XREF @TEXT("",key="model");
// #CL_COMP_N @TEXT("",key="value");
// #CL_COMP_P @TEXT("",key="value");
// #CL_CMP_CLK @TEXT("",key="value");
// %sar_port1 = $IO_PORT @ATTACH &"SAMPLE" => @PLACE(-23,62);
// &"SAMPLE" @WIRE(mode="straight",linecolor="#94601a",linewidth=0.16) {%sar_port1:p #XSAMPLE:1};
// %sar_port2 = $IO_PORT @ATTACH &"VINN" => @PLACE(-23,25.35);
// &"VINN" @WIRE(mode="straight",linecolor="#226e85",linewidth=0.16) {%sar_port2:p #XBOOTN:3};
// %sar_port3 = $IO_PORT @ATTACH &"VINP" => @PLACE(-23,2.35);
// &"VINP" @WIRE(mode="straight",linecolor="#226e85",linewidth=0.16) {%sar_port3:p #XBOOTP:3};
// &"SAMPLE_INT" @WIRE(mode="straight",linecolor="#30485d",linewidth=0.16) {#XSAMPLE:2 (18,62) (18,62) #XSEQ:1};
// &"DONE" @WIRE(mode="straight",linecolor="#30485d",linewidth=0.16) {#XDONE:2 (143.5,62) (143.5,63.65) #XPRESET:1};
// &"TOPN" @WIRE(mode="straight",linecolor="#226e85",linewidth=0.16) {#XBOOTN:2 (38,27) (75,27) (75,18) #XCOMP:5};
// &"TOPN" @WIRE(mode="straight",linecolor="#226e85",linewidth=0.16) {#XCDAC:33 (38,27)};
// $JUNCTION @ATTACH (38,27);
// (46,28.6) @TEXT("TOPN",size=1.13,halign="start",textcolor="#223d52");
// &"TOPP" @WIRE(mode="straight",linecolor="#226e85",linewidth=0.16) {#XBOOTP:2 (19,4) (19,7) (46,7) (75,7) (75,14.7) #XCOMP:6};
// &"TOPP" @WIRE(mode="straight",linecolor="#226e85",linewidth=0.16) {#XCDAC:34 (46,7)};
// $JUNCTION @ATTACH (46,7);
// (54,8.6) @TEXT("TOPP",size=1.13,halign="start",textcolor="#223d52");
// &"COMP_N" @WIRE(mode="straight",linecolor="#226e85",linewidth=0.16) {(113,-11) (113,19.65) (113,21.3)};
// &"COMP_N" @WIRE(mode="straight",linecolor="#226e85",linewidth=0.16) {#XCOMP:2 (113,19.65)};
// $JUNCTION @ATTACH (113,19.65);
// &"COMP_N" @WIRE(mode="straight",linecolor="#226e85",linewidth=0.16) {#XCTRL:10 (113,21.3)};
// $JUNCTION @ATTACH (113,21.3);
// &"COMP_N" @WIRE(mode="straight",linecolor="#226e85",linewidth=0.16) {#CL_COMP_N:1 (113,-11)};
// $JUNCTION @ATTACH (113,-11);
// &"COMP_P" @WIRE(mode="straight",linecolor="#226e85",linewidth=0.16) {(122,-22) (122,16.35) (122,18)};
// &"COMP_P" @WIRE(mode="straight",linecolor="#226e85",linewidth=0.16) {#XCOMP:3 (122,16.35)};
// $JUNCTION @ATTACH (122,16.35);
// &"COMP_P" @WIRE(mode="straight",linecolor="#226e85",linewidth=0.16) {#XCTRL:11 (122,18)};
// $JUNCTION @ATTACH (122,18);
// &"COMP_P" @WIRE(mode="straight",linecolor="#226e85",linewidth=0.16) {#CL_COMP_P:1 (122,-22)};
// $JUNCTION @ATTACH (122,-22);
// &"CMP_CLK" @WIRE(mode="straight",linecolor="#94601a",linewidth=0.16) {(81,42) (95,42) (152,42)};
// &"CMP_CLK" @WIRE(mode="straight",linecolor="#94601a",linewidth=0.16) {#XCTRL:1 (152,42)};
// $JUNCTION @ATTACH (152,42);
// &"CMP_CLK" @WIRE(mode="straight",linecolor="#94601a",linewidth=0.16) {#XCOMP:1 (81,42)};
// $JUNCTION @ATTACH (81,42);
// &"CMP_CLK" @WIRE(mode="straight",linecolor="#94601a",linewidth=0.16) {#CL_CMP_CLK:1 (95,42)};
// $JUNCTION @ATTACH (95,42);
// {&"GNN0" &"GNN1" &"GNN2" &"GNN3" &"GNN4" &"GNN5" &"GNN6" &"GNN7"} @WIRE(mode="straight",linewidth=0.24,linecolor="#536f4b") {#XREF:17  #XCDAC:1};
// {&"GNP0" &"GNP1" &"GNP2" &"GNP3" &"GNP4" &"GNP5" &"GNP6" &"GNP7"} @WIRE(mode="straight",linewidth=0.24,linecolor="#536f4b") {#XREF:25  #XCDAC:9};
// {&"GPN0" &"GPN1" &"GPN2" &"GPN3" &"GPN4" &"GPN5" &"GPN6" &"GPN7"} @WIRE(mode="straight",linewidth=0.24,linecolor="#536f4b") {#XREF:33  #XCDAC:17};
// {&"GPP0" &"GPP1" &"GPP2" &"GPP3" &"GPP4" &"GPP5" &"GPP6" &"GPP7"} @WIRE(mode="straight",linewidth=0.24,linecolor="#536f4b") {#XREF:41  #XCDAC:25};
// {&"CODE0" &"CODE1" &"CODE2" &"CODE3" &"CODE4" &"CODE5" &"CODE6" &"CODE7"} @WIRE(mode="straight",linewidth=0.24,linecolor="#66538a") {#XCTRL:2 (161,21.3) (161,-43.05) #XREF:1};
// {&"D0" &"D1" &"D2" &"D3" &"D4" &"D5" &"D6" &"D7"} @WIRE(mode="straight",linewidth=0.24,linecolor="#66538a") {#XCTRL:12 (170,18) (170,-46.35) #XREF:9};
// (121,-37) @TEXT("Digital feedback",size=1.3,halign="start",textcolor="#223d52");
// &"VDD!" @WIRE(mode="straight",linecolor="#30485d",linewidth=0.16) {#XSEQ:2 (36,73)};
// (36,73.4) @TEXT("VDD!",size=1.1,halign="middle",valign="bottom");
// &"0" @WIRE(mode="straight",linecolor="#30485d",linewidth=0.16) {#XSEQ:3 (36,51)};
// (36,50.6) @TEXT("0",size=1.1,halign="middle",valign="top");
// &"SEQ_SAMPLE" @WIRE(mode="straight",linecolor="#30485d",linewidth=0.16) {#XSEQ:4 (52,62)};
// (52.4,62) @TEXT("SEQ_SAMPLE",size=1.1,halign="start",valign="middle");
// &"ACTIVE" @WIRE(mode="straight",linecolor="#30485d",linewidth=0.16) {#XDONE:1 (122,62)};
// (121.6,62) @TEXT("ACTIVE",size=1.1,halign="end",valign="middle");
// &"VDD!" @WIRE(mode="straight",linecolor="#30485d",linewidth=0.16) {#XDONE:3 (132,72)};
// (132,72.4) @TEXT("VDD!",size=1.1,halign="middle",valign="bottom");
// &"0" @WIRE(mode="straight",linecolor="#30485d",linewidth=0.16) {#XDONE:4 (132,52)};
// (132,51.6) @TEXT("0",size=1.1,halign="middle",valign="top");
// &"SEQ_SAMPLE" @WIRE(mode="straight",linecolor="#30485d",linewidth=0.16) {#XPRESET:2 (145,60.35)};
// (144.6,60.35) @TEXT("SEQ_SAMPLE",size=1.1,halign="end",valign="middle");
// &"PRESET" @WIRE(mode="straight",linecolor="#30485d",linewidth=0.16) {#XPRESET:3 (177,62)};
// (177.4,62) @TEXT("PRESET",size=1.1,halign="start",valign="middle");
// &"VDD!" @WIRE(mode="straight",linecolor="#30485d",linewidth=0.16) {#XPRESET:4 (161,73)};
// (161,73.4) @TEXT("VDD!",size=1.1,halign="middle",valign="bottom");
// &"0" @WIRE(mode="straight",linecolor="#30485d",linewidth=0.16) {#XPRESET:5 (161,51)};
// (161,50.6) @TEXT("0",size=1.1,halign="middle",valign="top");
// &"VDD!" @WIRE(mode="straight",linecolor="#30485d",linewidth=0.16) {#XSAMPLE:3 (0,73)};
// (0,73.4) @TEXT("VDD!",size=1.1,halign="middle",valign="bottom");
// &"0" @WIRE(mode="straight",linecolor="#30485d",linewidth=0.16) {#XSAMPLE:4 (0,51)};
// (0,50.6) @TEXT("0",size=1.1,halign="middle",valign="top");
// &"SEQ_SAMPLE" @WIRE(mode="straight",linecolor="#30485d",linewidth=0.16) {#XBOOTN:1 (-16,28.65)};
// (-16.4,28.65) @TEXT("SEQ_SAMPLE",size=1.1,halign="end",valign="middle");
// &"SEQ_SAMPLE" @WIRE(mode="straight",linecolor="#30485d",linewidth=0.16) {#XBOOTP:1 (-16,5.65)};
// (-16.4,5.65) @TEXT("SEQ_SAMPLE",size=1.1,halign="end",valign="middle");
// &"VDD!" @WIRE(mode="straight",linecolor="#30485d",linewidth=0.16) {#XCDAC:35 (54,-1)};
// (54,-0.6) @TEXT("VDD!",size=1.1,halign="middle",valign="bottom");
// &"VREFN" @WIRE(mode="straight",linecolor="#30485d",linewidth=0.16) {#XCDAC:36 (23,-10.35)};
// (22.6,-10.35) @TEXT("VREFN",size=1.1,halign="end",valign="middle");
// &"VREFP" @WIRE(mode="straight",linecolor="#30485d",linewidth=0.16) {#XCDAC:37 (23,-13.65)};
// (22.6,-13.65) @TEXT("VREFP",size=1.1,halign="end",valign="middle");
// &"0" @WIRE(mode="straight",linecolor="#30485d",linewidth=0.16) {#XCDAC:38 (62,-23)};
// (62,-23.4) @TEXT("0",size=1.1,halign="middle",valign="top");
// &"PHI_U" @WIRE(mode="straight",linecolor="#30485d",linewidth=0.16) {#XCTRL:20 (155,14.7)};
// (155.4,14.7) @TEXT("PHI_U",size=1.1,halign="start",valign="middle");
// &"SEQ_SAMPLE" @WIRE(mode="straight",linecolor="#30485d",linewidth=0.16) {#XCTRL:21 (123,14.7)};
// (122.6,14.7) @TEXT("SEQ_SAMPLE",size=1.1,halign="end",valign="middle");
// &"VDD!" @WIRE(mode="straight",linecolor="#30485d",linewidth=0.16) {#XCTRL:22 (139,32.9)};
// (139,33.3) @TEXT("VDD!",size=1.1,halign="middle",valign="bottom");
// &"0" @WIRE(mode="straight",linecolor="#30485d",linewidth=0.16) {#XCTRL:23 (139,3.1)};
// (139,2.7) @TEXT("0",size=1.1,halign="middle",valign="top");
// &"ACTIVE" @WIRE(mode="straight",linecolor="#30485d",linewidth=0.16) {#XCTRL:24 (155,11.4)};
// (155.4,11.4) @TEXT("ACTIVE",size=1.1,halign="start",valign="middle");
// &"PHI_U" @WIRE(mode="straight",linecolor="#30485d",linewidth=0.16) {#XREF:49 (23,-46.35)};
// (22.6,-46.35) @TEXT("PHI_U",size=1.1,halign="end",valign="middle");
// &"SAMPLE_INT" @WIRE(mode="straight",linecolor="#30485d",linewidth=0.16) {#XREF:50 (23,-49.65)};
// (22.6,-49.65) @TEXT("SAMPLE_INT",size=1.1,halign="end",valign="middle");
// &"VDD!" @WIRE(mode="straight",linecolor="#30485d",linewidth=0.16) {#XREF:51 (62,-34.75)};
// (62,-34.35) @TEXT("VDD!",size=1.1,halign="middle",valign="bottom");
// &"0" @WIRE(mode="straight",linecolor="#30485d",linewidth=0.16) {#XREF:52 (46,-61.25)};
// (46,-61.65) @TEXT("0",size=1.1,halign="middle",valign="top");
// &"RST_DONE" @WIRE(mode="straight",linecolor="#30485d",linewidth=0.16) {#XREF:53 (69,-49.65)};
// (69.4,-49.65) @TEXT("RST_DONE",size=1.1,halign="start",valign="middle");
// &"PRESET" @WIRE(mode="straight",linecolor="#30485d",linewidth=0.16) {#XREF:54 (69,-52.95)};
// (69.4,-52.95) @TEXT("PRESET",size=1.1,halign="start",valign="middle");
// &"VDD!" @WIRE(mode="straight",linecolor="#30485d",linewidth=0.16) {#XCOMP:4 (94,29.6)};
// (94,30) @TEXT("VDD!",size=1.1,halign="middle",valign="bottom");
// &"0" @WIRE(mode="straight",linecolor="#30485d",linewidth=0.16) {#XCOMP:7 (94,6.4)};
// (94,6) @TEXT("0",size=1.1,halign="middle",valign="top");
// &"0" @WIRE(mode="straight",linecolor="#30485d",linewidth=0.16) {#CL_COMP_N:2 (113,-18)};
// (113,-18.4) @TEXT("0",size=1.1,halign="middle",valign="top");
// &"0" @WIRE(mode="straight",linecolor="#30485d",linewidth=0.16) {#CL_COMP_P:2 (127,-29)};
// (127,-29.4) @TEXT("0",size=1.1,halign="middle",valign="top");
// &"0" @WIRE(mode="straight",linecolor="#30485d",linewidth=0.16) {#CL_CMP_CLK:2 (95,56)};
// (95,56.4) @TEXT("0",size=1.1,halign="middle",valign="bottom");
// }
// END SARADC RNL
ends sar_adc8_join_r4

subckt sar_bootstrap_flat_8b_p CLKS VOUT Vin
    Mmain (VOUT G Vin 0) nch_18_mac l=150.0n w=1u multi=1 nf=1 sd=180.0n          ad=1.55e-13 as=1.55e-13 pd=2.31u ps=2.31u nrd=0 nrs=0 sa=155.00n          sb=155.00n sa1=155.00n sa2=155.00n sa3=155.00n sa4=155.00n          sb1=155.00n sb2=155.00n sb3=155.00n spa=180.0n spa1=180.0n          spa2=180.0n spa3=180.0n sap=172.362n sapb=242.67n spba=233.666n          spba1=239.844n spmt=1.11111e+15 spomt=0 spomt1=1.11111e+60          spmb=1.11111e+15 spomb=0 spomb1=1.11111e+60
    Mmain_U1 (VOUT G Vin 0) nch_18_mac l=150.0n w=1u multi=1 nf=1 sd=180.0n          ad=1.55e-13 as=1.55e-13 pd=2.31u ps=2.31u nrd=0 nrs=0 sa=155.00n          sb=155.00n sa1=155.00n sa2=155.00n sa3=155.00n sa4=155.00n          sb1=155.00n sb2=155.00n sb3=155.00n spa=180.0n spa1=180.0n          spa2=180.0n spa3=180.0n sap=172.362n sapb=242.67n spba=233.666n          spba1=239.844n spmt=1.11111e+15 spomt=0 spomt1=1.11111e+60          spmb=1.11111e+15 spomb=0 spomb1=1.11111e+60
    Mmain_U2 (VOUT G Vin 0) nch_18_mac l=150.0n w=1u multi=1 nf=1 sd=180.0n          ad=1.55e-13 as=1.55e-13 pd=2.31u ps=2.31u nrd=0 nrs=0 sa=155.00n          sb=155.00n sa1=155.00n sa2=155.00n sa3=155.00n sa4=155.00n          sb1=155.00n sb2=155.00n sb3=155.00n spa=180.0n spa1=180.0n          spa2=180.0n spa3=180.0n sap=172.362n sapb=242.67n spba=233.666n          spba1=239.844n spmt=1.11111e+15 spomt=0 spomt1=1.11111e+60          spmb=1.11111e+15 spomb=0 spomb1=1.11111e+60
    Mmain_U3 (VOUT G Vin 0) nch_18_mac l=150.0n w=1u multi=1 nf=1 sd=180.0n          ad=1.55e-13 as=1.55e-13 pd=2.31u ps=2.31u nrd=0 nrs=0 sa=155.00n          sb=155.00n sa1=155.00n sa2=155.00n sa3=155.00n sa4=155.00n          sb1=155.00n sb2=155.00n sb3=155.00n spa=180.0n spa1=180.0n          spa2=180.0n spa3=180.0n sap=172.362n sapb=242.67n spba=233.666n          spba1=239.844n spmt=1.11111e+15 spomt=0 spomt1=1.11111e+60          spmb=1.11111e+15 spomb=0 spomb1=1.11111e+60
    M4C (CTRL CLKS BBOT 0) nch_18_mac l=150.0n w=1u multi=1 nf=1 sd=180.0n          ad=1.55e-13 as=1.55e-13 pd=2.31u ps=2.31u nrd=0 nrs=0 sa=155.00n          sb=155.00n sa1=155.00n sa2=155.00n sa3=155.00n sa4=155.00n          sb1=155.00n sb2=155.00n sb3=155.00n spa=180.0n spa1=180.0n          spa2=180.0n spa3=180.0n sap=172.362n sapb=242.67n spba=233.666n          spba1=239.844n spmt=1.11111e+15 spomt=0 spomt1=1.11111e+60          spmb=1.11111e+15 spomb=0 spomb1=1.11111e+60
    Msin (BBOT G Vin 0) nch_18_mac l=150.0n w=1u multi=1 nf=1 sd=180.0n          ad=1.55e-13 as=1.55e-13 pd=2.31u ps=2.31u nrd=0 nrs=0 sa=155.00n          sb=155.00n sa1=155.00n sa2=155.00n sa3=155.00n sa4=155.00n          sb1=155.00n sb2=155.00n sb3=155.00n spa=180.0n spa1=180.0n          spa2=180.0n spa3=180.0n sap=172.362n sapb=242.67n spba=233.666n          spba1=239.844n spmt=1.11111e+15 spomt=0 spomt1=1.11111e+60          spmb=1.11111e+15 spomb=0 spomb1=1.11111e+60
    Maux (G VDD! GRESET 0) nch_18_mac l=150.0n w=1u multi=1 nf=1 sd=180.0n          ad=1.55e-13 as=1.55e-13 pd=2.31u ps=2.31u nrd=0 nrs=0 sa=155.00n          sb=155.00n sa1=155.00n sa2=155.00n sa3=155.00n sa4=155.00n          sb1=155.00n sb2=155.00n sb3=155.00n spa=180.0n spa1=180.0n          spa2=180.0n spa3=180.0n sap=172.362n sapb=242.67n spba=233.666n          spba1=239.844n spmt=1.11111e+15 spomt=0 spomt1=1.11111e+60          spmb=1.11111e+15 spomb=0 spomb1=1.11111e+60
    MRSTG (GRESET CLKSB 0 0) nch_18_mac l=150.0n w=1u multi=1 nf=1          sd=180.0n ad=1.55e-13 as=1.55e-13 pd=2.31u ps=2.31u nrd=0 nrs=0          sa=155.00n sb=155.00n sa1=155.00n sa2=155.00n sa3=155.00n          sa4=155.00n sb1=155.00n sb2=155.00n sb3=155.00n spa=180.0n          spa1=180.0n spa2=180.0n spa3=180.0n sap=172.362n sapb=242.67n          spba=233.666n spba1=239.844n spmt=1.11111e+15 spomt=0          spomt1=1.11111e+60 spmb=1.11111e+15 spomb=0 spomb1=1.11111e+60
    M4A (CTRL G BBOT 0) nch_18_mac l=150.0n w=1u multi=1 nf=1 sd=180.0n          ad=1.55e-13 as=1.55e-13 pd=2.31u ps=2.31u nrd=0 nrs=0 sa=155.00n          sb=155.00n sa1=155.00n sa2=155.00n sa3=155.00n sa4=155.00n          sb1=155.00n sb2=155.00n sb3=155.00n spa=180.0n spa1=180.0n          spa2=180.0n spa3=180.0n sap=172.362n sapb=242.67n spba=233.666n          spba1=239.844n spmt=1.11111e+15 spomt=0 spomt1=1.11111e+60          spmb=1.11111e+15 spomb=0 spomb1=1.11111e+60
    M8 (BBOT CLKSB 0 0) nch_18_mac l=150.0n w=1u multi=1 nf=1 sd=180.0n          ad=1.55e-13 as=1.55e-13 pd=2.31u ps=2.31u nrd=0 nrs=0 sa=155.00n          sb=155.00n sa1=155.00n sa2=155.00n sa3=155.00n sa4=155.00n          sb1=155.00n sb2=155.00n sb3=155.00n spa=180.0n spa1=180.0n          spa2=180.0n spa3=180.0n sap=172.362n sapb=242.67n spba=233.666n          spba1=239.844n spmt=1.11111e+15 spomt=0 spomt1=1.11111e+60          spmb=1.11111e+15 spomb=0 spomb1=1.11111e+60
    MNCLK (CLKSB CLKS 0 0) nch_18_mac l=150.0n w=1u multi=1 nf=1 sd=180.0n          ad=1.55e-13 as=1.55e-13 pd=2.31u ps=2.31u nrd=0 nrs=0 sa=155.00n          sb=155.00n sa1=155.00n sa2=155.00n sa3=155.00n sa4=155.00n          sb1=155.00n sb2=155.00n sb3=155.00n spa=180.0n spa1=180.0n          spa2=180.0n spa3=180.0n sap=172.362n sapb=242.67n spba=233.666n          spba1=239.844n spmt=1.11111e+15 spomt=0 spomt1=1.11111e+60          spmb=1.11111e+15 spomb=0 spomb1=1.11111e+60
    M2 (BTOP G VDD! BTOP) pch_18_mac l=150.0n w=1u multi=1 nf=1 sd=180.0n          ad=1.55e-13 as=1.55e-13 pd=2.31u ps=2.31u nrd=0 nrs=0 sa=155.00n          sb=155.00n sa1=155.00n sa2=155.00n sa3=155.00n sa4=155.00n          sb1=155.00n sb2=155.00n sb3=155.00n spa=180.0n spa1=180.0n          spa2=180.0n spa3=180.0n sap=172.362n sapb=242.67n spba=233.666n          spba1=239.844n spmt=1.11111e+15 spomt=0 spomt1=1.11111e+60          spmb=1.11111e+15 spomb=0 spomb1=1.11111e+60
    M4 (G CTRL BTOP BTOP) pch_18_mac l=150.0n w=1u multi=1 nf=1 sd=180.0n          ad=1.55e-13 as=1.55e-13 pd=2.31u ps=2.31u nrd=0 nrs=0 sa=155.00n          sb=155.00n sa1=155.00n sa2=155.00n sa3=155.00n sa4=155.00n          sb1=155.00n sb2=155.00n sb3=155.00n spa=180.0n spa1=180.0n          spa2=180.0n spa3=180.0n sap=172.362n sapb=242.67n spba=233.666n          spba1=239.844n spmt=1.11111e+15 spomt=0 spomt1=1.11111e+60          spmb=1.11111e+15 spomb=0 spomb1=1.11111e+60
    M4B (CTRL CLKS VDD! VDD!) pch_18_mac l=150.0n w=1u multi=1 nf=1          sd=180.0n ad=1.55e-13 as=1.55e-13 pd=2.31u ps=2.31u nrd=0 nrs=0          sa=155.00n sb=155.00n sa1=155.00n sa2=155.00n sa3=155.00n          sa4=155.00n sb1=155.00n sb2=155.00n sb3=155.00n spa=180.0n          spa1=180.0n spa2=180.0n spa3=180.0n sap=172.362n sapb=242.67n          spba=233.666n spba1=239.844n spmt=1.11111e+15 spomt=0          spomt1=1.11111e+60 spmb=1.11111e+15 spomb=0 spomb1=1.11111e+60
    MPCLK (CLKSB CLKS VDD! VDD!) pch_18_mac l=150.0n w=1u multi=1 nf=1          sd=180.0n ad=1.55e-13 as=1.55e-13 pd=2.31u ps=2.31u nrd=0 nrs=0          sa=155.00n sb=155.00n sa1=155.00n sa2=155.00n sa3=155.00n          sa4=155.00n sb1=155.00n sb2=155.00n sb3=155.00n spa=180.0n          spa1=180.0n spa2=180.0n spa3=180.0n sap=172.362n sapb=242.67n          spba=233.666n spba1=239.844n spmt=1.11111e+15 spomt=0          spomt1=1.11111e+60 spmb=1.11111e+15 spomb=0 spomb1=1.11111e+60
    Cboot (BTOP BBOT) cfmom_2t nr=8 lr=2.5u w=50n s=50n stm=1 spm=3          multi=200 mismatchflag=1
// BEGIN SARADC RNL
// @RNL(author="saradc topology") {
// (-13,67) @TEXT("Bootstrap  /  four parallel sampling switches",size=1.65,halign="start",textcolor="#223d52");
// #MPCLK @SET-SYMBOL $PMOS_4TERM;
// #MPCLK @PLACE(0,35) => @ORIENT("R0");
// #MPCLK @TEXT("MPCLK",key="name",size=1.3,halign="start") => @PLACE(3,38);
// #MPCLK @TEXT("l=150.0n w=1u multi=1",key="value",size=0.9,halign="start") => @PLACE(3,31);
// #MPCLK @TEXT("",key="model");
// #MNCLK @SET-SYMBOL $NMOS_4TERM;
// #MNCLK @PLACE(0,5) => @ORIENT("R0");
// #MNCLK @TEXT("MNCLK",key="name",size=1.3,halign="start") => @PLACE(3,8);
// #MNCLK @TEXT("l=150.0n w=1u multi=1",key="value",size=0.9,halign="start") => @PLACE(3,1);
// #MNCLK @TEXT("",key="model");
// #M4B @SET-SYMBOL $PMOS_4TERM;
// #M4B @PLACE(38,35) => @ORIENT("R0");
// #M4B @TEXT("M4B",key="name",size=1.3,halign="start") => @PLACE(41,38);
// #M4B @TEXT("l=150.0n w=1u multi=1",key="value",size=0.9,halign="start") => @PLACE(41,31);
// #M4B @TEXT("",key="model");
// #M4C @SET-SYMBOL $NMOS_4TERM;
// #M4C @PLACE(38,5) => @ORIENT("R0");
// #M4C @TEXT("M4C",key="name",size=1.3,halign="start") => @PLACE(41,8);
// #M4C @TEXT("l=150.0n w=1u multi=1",key="value",size=0.9,halign="start") => @PLACE(41,1);
// #M4C @TEXT("",key="model");
// #M4A @SET-SYMBOL $NMOS_4TERM;
// #M4A @PLACE(56,5) => @ORIENT("R0");
// #M4A @TEXT("M4A",key="name",size=1.3,halign="start") => @PLACE(59,8);
// #M4A @TEXT("l=150.0n w=1u multi=1",key="value",size=0.9,halign="start") => @PLACE(59,1);
// #M4A @TEXT("",key="model");
// #Cboot @SET-SYMBOL $CAPACITOR;
// #Cboot @PLACE(80,21) => @ORIENT("R0");
// #Cboot @TEXT("Cboot",key="name",size=1.3,halign="start") => @PLACE(83,24);
// #Cboot @TEXT("nr=8 lr=2.5u w=50n multi=200",key="value",size=0.9,halign="start") => @PLACE(83,17);
// #Cboot @TEXT("",key="model");
// #M2 @SET-SYMBOL $PMOS_4TERM;
// #M2 @PLACE(80,48) => @ORIENT("R0");
// #M2 @TEXT("M2",key="name",size=1.3,halign="start") => @PLACE(83,51);
// #M2 @TEXT("l=150.0n w=1u multi=1",key="value",size=0.9,halign="start") => @PLACE(83,44);
// #M2 @TEXT("",key="model");
// #M8 @SET-SYMBOL $NMOS_4TERM;
// #M8 @PLACE(80,-9) => @ORIENT("R0");
// #M8 @TEXT("M8",key="name",size=1.3,halign="start") => @PLACE(83,-6);
// #M8 @TEXT("l=150.0n w=1u multi=1",key="value",size=0.9,halign="start") => @PLACE(83,-13);
// #M8 @TEXT("",key="model");
// #Msin @SET-SYMBOL $NMOS_4TERM;
// #Msin @PLACE(101,-9) => @ORIENT("R0");
// #Msin @TEXT("Msin",key="name",size=1.3,halign="start") => @PLACE(104,-6);
// #Msin @TEXT("l=150.0n w=1u multi=1",key="value",size=0.9,halign="start") => @PLACE(104,-13);
// #Msin @TEXT("",key="model");
// #M4 @SET-SYMBOL $PMOS_4TERM;
// #M4 @PLACE(116,43) => @ORIENT("R0");
// #M4 @TEXT("M4",key="name",size=1.3,halign="start") => @PLACE(119,46);
// #M4 @TEXT("l=150.0n w=1u multi=1",key="value",size=0.9,halign="start") => @PLACE(119,39);
// #M4 @TEXT("",key="model");
// #Maux @SET-SYMBOL $NMOS_4TERM;
// #Maux @PLACE(116,4) => @ORIENT("R0");
// #Maux @TEXT("Maux",key="name",size=1.3,halign="start") => @PLACE(119,7);
// #Maux @TEXT("l=150.0n w=1u multi=1",key="value",size=0.9,halign="start") => @PLACE(119,0);
// #Maux @TEXT("",key="model");
// #MRSTG @SET-SYMBOL $NMOS_4TERM;
// #MRSTG @PLACE(116,-22) => @ORIENT("R0");
// #MRSTG @TEXT("MRSTG",key="name",size=1.3,halign="start") => @PLACE(119,-19);
// #MRSTG @TEXT("l=150.0n w=1u multi=1",key="value",size=0.9,halign="start") => @PLACE(119,-26);
// #MRSTG @TEXT("",key="model");
// #Mmain_U3 @SET-SYMBOL $NMOS_4TERM;
// #Mmain_U3 @PLACE(158,38) => @ORIENT("R270");
// #Mmain_U3 @TEXT("Mmain_U3",key="name",size=1.3,halign="start") => @PLACE(161,41);
// #Mmain_U3 @TEXT("l=150.0n w=1u multi=1",key="value",size=0.9,halign="start") => @PLACE(161,34);
// #Mmain_U3 @TEXT("",key="model");
// #Mmain @SET-SYMBOL $NMOS_4TERM;
// #Mmain @PLACE(158,17) => @ORIENT("R270");
// #Mmain @TEXT("Mmain",key="name",size=1.3,halign="start") => @PLACE(161,20);
// #Mmain @TEXT("l=150.0n w=1u multi=1",key="value",size=0.9,halign="start") => @PLACE(161,13);
// #Mmain @TEXT("",key="model");
// #Mmain_U1 @SET-SYMBOL $NMOS_4TERM;
// #Mmain_U1 @PLACE(158,-4) => @ORIENT("R270");
// #Mmain_U1 @TEXT("Mmain_U1",key="name",size=1.3,halign="start") => @PLACE(161,-1);
// #Mmain_U1 @TEXT("l=150.0n w=1u multi=1",key="value",size=0.9,halign="start") => @PLACE(161,-8);
// #Mmain_U1 @TEXT("",key="model");
// #Mmain_U2 @SET-SYMBOL $NMOS_4TERM;
// #Mmain_U2 @PLACE(158,-25) => @ORIENT("R270");
// #Mmain_U2 @TEXT("Mmain_U2",key="name",size=1.3,halign="start") => @PLACE(161,-22);
// #Mmain_U2 @TEXT("l=150.0n w=1u multi=1",key="value",size=0.9,halign="start") => @PLACE(161,-29);
// #Mmain_U2 @TEXT("",key="model");
// &"CLKSB" @WIRE(mode="straight",linecolor="#30485d",linewidth=0.16) {#MPCLK:1 (0,20)};
// $JUNCTION @ATTACH (0,20);
// &"CLKSB" @WIRE(mode="straight",linecolor="#30485d",linewidth=0.16) {#MNCLK:1 (0,20)};
// $JUNCTION @ATTACH (0,20);
// &"CTRL" @WIRE(mode="straight",linecolor="#30485d",linewidth=0.16) {(56,60) (113,60)};
// &"CTRL" @WIRE(mode="straight",linecolor="#30485d",linewidth=0.16) {#M4A:1 (56,60)};
// $JUNCTION @ATTACH (56,60);
// &"CTRL" @WIRE(mode="straight",linecolor="#30485d",linewidth=0.16) {#M4:2 (113,60)};
// $JUNCTION @ATTACH (113,60);
// &"CTRL" @WIRE(mode="straight",linecolor="#30485d",linewidth=0.16) {(28,60) (31,60) (56,60)};
// &"CTRL" @WIRE(mode="straight",linecolor="#30485d",linewidth=0.16) {#M4B:1 (38,29) (31,29) (31,60)};
// $JUNCTION @ATTACH (31,60);
// &"CTRL" @WIRE(mode="straight",linecolor="#30485d",linewidth=0.16) {#M4C:1 (38,12) (28,12) (28,60)};
// $JUNCTION @ATTACH (28,60);
// &"BTOP" @WIRE(mode="straight",linecolor="#226e85",linewidth=0.16) {#Cboot:1 (80,31)};
// $JUNCTION @ATTACH (80,31);
// &"BTOP" @WIRE(mode="straight",linecolor="#226e85",linewidth=0.16) {#M2:1 (80,31)};
// $JUNCTION @ATTACH (80,31);
// &"BTOP" @WIRE(mode="straight",linecolor="#226e85",linewidth=0.16) {#M4:3 (116,48) (124,48) (124,31) (80,31)};
// &"BBOT" @WIRE(mode="straight",linecolor="#226e85",linewidth=0.16) {(38,-2) (56,-2) (80,-2) (101,-2)};
// &"BBOT" @WIRE(mode="straight",linecolor="#226e85",linewidth=0.16) {#Cboot:2 (80,-2)};
// $JUNCTION @ATTACH (80,-2);
// &"BBOT" @WIRE(mode="straight",linecolor="#226e85",linewidth=0.16) {#M4C:3 (38,-2)};
// $JUNCTION @ATTACH (38,-2);
// &"BBOT" @WIRE(mode="straight",linecolor="#226e85",linewidth=0.16) {#M4A:3 (56,-2)};
// $JUNCTION @ATTACH (56,-2);
// &"BBOT" @WIRE(mode="straight",linecolor="#226e85",linewidth=0.16) {#M8:1 (80,-2)};
// $JUNCTION @ATTACH (80,-2);
// &"BBOT" @WIRE(mode="straight",linecolor="#226e85",linewidth=0.16) {#Msin:1 (101,-2)};
// $JUNCTION @ATTACH (101,-2);
// &"G" @WIRE(mode="straight",linecolor="#226e85",linewidth=0.16) {(138,-22) (138,-1) (138,6) (138,20) (138,41)};
// &"G" @WIRE(mode="straight",linecolor="#226e85",linewidth=0.16) {#M4:1 (138,41)};
// $JUNCTION @ATTACH (138,41);
// &"G" @WIRE(mode="straight",linecolor="#226e85",linewidth=0.16) {#Maux:1 (138,6)};
// $JUNCTION @ATTACH (138,6);
// &"G" @WIRE(mode="straight",linecolor="#226e85",linewidth=0.16) {#Mmain:2 (138,20)};
// $JUNCTION @ATTACH (138,20);
// &"G" @WIRE(mode="straight",linecolor="#226e85",linewidth=0.16) {#Mmain_U1:2 (138,-1)};
// $JUNCTION @ATTACH (138,-1);
// &"G" @WIRE(mode="straight",linecolor="#226e85",linewidth=0.16) {#Mmain_U2:2 (138,-22)};
// $JUNCTION @ATTACH (138,-22);
// &"G" @WIRE(mode="straight",linecolor="#226e85",linewidth=0.16) {#Mmain_U3:2 (138,41)};
// $JUNCTION @ATTACH (138,41);
// &"GRESET" @WIRE(mode="straight",linecolor="#30485d",linewidth=0.16) {#Maux:3 (116,2) (116,-20) #MRSTG:1};
// &"Vin" @WIRE(mode="straight",linecolor="#226e85",linewidth=0.16) {(146,-25) (146,-11) (146,-4) (146,17) (146,38)};
// &"Vin" @WIRE(mode="straight",linecolor="#226e85",linewidth=0.16) {#Msin:3 (146,-11)};
// $JUNCTION @ATTACH (146,-11);
// &"Vin" @WIRE(mode="straight",linecolor="#226e85",linewidth=0.16) {#Mmain:3 (146,17)};
// $JUNCTION @ATTACH (146,17);
// &"Vin" @WIRE(mode="straight",linecolor="#226e85",linewidth=0.16) {#Mmain_U1:3 (146,-4)};
// $JUNCTION @ATTACH (146,-4);
// &"Vin" @WIRE(mode="straight",linecolor="#226e85",linewidth=0.16) {#Mmain_U2:3 (146,-25)};
// $JUNCTION @ATTACH (146,-25);
// &"Vin" @WIRE(mode="straight",linecolor="#226e85",linewidth=0.16) {#Mmain_U3:3 (146,38)};
// $JUNCTION @ATTACH (146,38);
// &"VOUT" @WIRE(mode="straight",linecolor="#226e85",linewidth=0.16) {(177,-25) (177,-4) (177,17) (177,38)};
// &"VOUT" @WIRE(mode="straight",linecolor="#226e85",linewidth=0.16) {#Mmain:1 (177,17)};
// $JUNCTION @ATTACH (177,17);
// &"VOUT" @WIRE(mode="straight",linecolor="#226e85",linewidth=0.16) {#Mmain_U1:1 (177,-4)};
// $JUNCTION @ATTACH (177,-4);
// &"VOUT" @WIRE(mode="straight",linecolor="#226e85",linewidth=0.16) {#Mmain_U2:1 (177,-25)};
// $JUNCTION @ATTACH (177,-25);
// &"VOUT" @WIRE(mode="straight",linecolor="#226e85",linewidth=0.16) {#Mmain_U3:1 (177,38)};
// $JUNCTION @ATTACH (177,38);
// (-13,-37) @TEXT("Clock inverter",size=1.15,halign="start",textcolor="#223d52");
// (33,-37) @TEXT("Precharge and boost",size=1.15,halign="start",textcolor="#223d52");
// (144,-37) @TEXT("Vin -> VOUT",size=1.15,halign="start",textcolor="#223d52");
// &"0" @WIRE(mode="straight",linecolor="#30485d",linewidth=0.16) {#Mmain:4 (158,13)};
// (158,12.6) @TEXT("0",size=1.1,halign="middle",valign="top");
// &"0" @WIRE(mode="straight",linecolor="#30485d",linewidth=0.16) {#Mmain_U1:4 (158,-8)};
// (158,-8.4) @TEXT("0",size=1.1,halign="middle",valign="top");
// &"0" @WIRE(mode="straight",linecolor="#30485d",linewidth=0.16) {#Mmain_U2:4 (158,-29)};
// (158,-29.4) @TEXT("0",size=1.1,halign="middle",valign="top");
// &"0" @WIRE(mode="straight",linecolor="#30485d",linewidth=0.16) {#Mmain_U3:4 (158,34)};
// (158,33.6) @TEXT("0",size=1.1,halign="middle",valign="top");
// &"CLKS" @WIRE(mode="straight",linecolor="#30485d",linewidth=0.16) {#M4C:2 (32,5)};
// (31.6,5) @TEXT("CLKS",size=1.1,halign="end",valign="middle");
// &"0" @WIRE(mode="straight",linecolor="#30485d",linewidth=0.16) {#M4C:4 (42,5)};
// (42.4,5) @TEXT("0",size=1.1,halign="start",valign="middle");
// &"G" @WIRE(mode="straight",linecolor="#30485d",linewidth=0.16) {#Msin:2 (95,-9)};
// (94.6,-9) @TEXT("G",size=1.1,halign="end",valign="middle");
// &"0" @WIRE(mode="straight",linecolor="#30485d",linewidth=0.16) {#Msin:4 (105,-9)};
// (105.4,-9) @TEXT("0",size=1.1,halign="start",valign="middle");
// &"VDD!" @WIRE(mode="straight",linecolor="#30485d",linewidth=0.16) {#Maux:2 (110,4)};
// (109.6,4) @TEXT("VDD!",size=1.1,halign="end",valign="middle");
// &"0" @WIRE(mode="straight",linecolor="#30485d",linewidth=0.16) {#Maux:4 (120,4)};
// (120.4,4) @TEXT("0",size=1.1,halign="start",valign="middle");
// &"CLKSB" @WIRE(mode="straight",linecolor="#30485d",linewidth=0.16) {#MRSTG:2 (110,-22)};
// (109.6,-22) @TEXT("CLKSB",size=1.1,halign="end",valign="middle");
// &"0" @WIRE(mode="straight",linecolor="#30485d",linewidth=0.16) {#MRSTG:3 (116,-27)};
// (116,-27.4) @TEXT("0",size=1.1,halign="middle",valign="top");
// &"0" @WIRE(mode="straight",linecolor="#30485d",linewidth=0.16) {#MRSTG:4 (120,-22)};
// (120.4,-22) @TEXT("0",size=1.1,halign="start",valign="middle");
// &"G" @WIRE(mode="straight",linecolor="#30485d",linewidth=0.16) {#M4A:2 (50,5)};
// (49.6,5) @TEXT("G",size=1.1,halign="end",valign="middle");
// &"0" @WIRE(mode="straight",linecolor="#30485d",linewidth=0.16) {#M4A:4 (60,5)};
// (60.4,5) @TEXT("0",size=1.1,halign="start",valign="middle");
// &"CLKSB" @WIRE(mode="straight",linecolor="#30485d",linewidth=0.16) {#M8:2 (74,-9)};
// (73.6,-9) @TEXT("CLKSB",size=1.1,halign="end",valign="middle");
// &"0" @WIRE(mode="straight",linecolor="#30485d",linewidth=0.16) {#M8:3 (80,-14)};
// (80,-14.4) @TEXT("0",size=1.1,halign="middle",valign="top");
// &"0" @WIRE(mode="straight",linecolor="#30485d",linewidth=0.16) {#M8:4 (84,-9)};
// (84.4,-9) @TEXT("0",size=1.1,halign="start",valign="middle");
// &"CLKS" @WIRE(mode="straight",linecolor="#30485d",linewidth=0.16) {#MNCLK:2 (-6,5)};
// (-6.4,5) @TEXT("CLKS",size=1.1,halign="end",valign="middle");
// &"0" @WIRE(mode="straight",linecolor="#30485d",linewidth=0.16) {#MNCLK:3 (0,0)};
// (0,-0.4) @TEXT("0",size=1.1,halign="middle",valign="top");
// &"0" @WIRE(mode="straight",linecolor="#30485d",linewidth=0.16) {#MNCLK:4 (4,5)};
// (4.4,5) @TEXT("0",size=1.1,halign="start",valign="middle");
// &"G" @WIRE(mode="straight",linecolor="#30485d",linewidth=0.16) {#M2:2 (74,48)};
// (73.6,48) @TEXT("G",size=1.1,halign="end",valign="middle");
// &"VDD!" @WIRE(mode="straight",linecolor="#30485d",linewidth=0.16) {#M2:3 (80,53)};
// (80,53.4) @TEXT("VDD!",size=1.1,halign="middle",valign="bottom");
// &"BTOP" @WIRE(mode="straight",linecolor="#30485d",linewidth=0.16) {#M2:4 (84,48)};
// (84.4,48) @TEXT("BTOP",size=1.1,halign="start",valign="middle");
// &"BTOP" @WIRE(mode="straight",linecolor="#30485d",linewidth=0.16) {#M4:4 (120,43)};
// (120.4,43) @TEXT("BTOP",size=1.1,halign="start",valign="middle");
// &"CLKS" @WIRE(mode="straight",linecolor="#30485d",linewidth=0.16) {#M4B:2 (32,35)};
// (31.6,35) @TEXT("CLKS",size=1.1,halign="end",valign="middle");
// &"VDD!" @WIRE(mode="straight",linecolor="#30485d",linewidth=0.16) {#M4B:3 (38,40)};
// (38,40.4) @TEXT("VDD!",size=1.1,halign="middle",valign="bottom");
// &"VDD!" @WIRE(mode="straight",linecolor="#30485d",linewidth=0.16) {#M4B:4 (42,35)};
// (42.4,35) @TEXT("VDD!",size=1.1,halign="start",valign="middle");
// &"CLKS" @WIRE(mode="straight",linecolor="#30485d",linewidth=0.16) {#MPCLK:2 (-6,35)};
// (-6.4,35) @TEXT("CLKS",size=1.1,halign="end",valign="middle");
// &"VDD!" @WIRE(mode="straight",linecolor="#30485d",linewidth=0.16) {#MPCLK:3 (0,40)};
// (0,40.4) @TEXT("VDD!",size=1.1,halign="middle",valign="bottom");
// &"VDD!" @WIRE(mode="straight",linecolor="#30485d",linewidth=0.16) {#MPCLK:4 (4,35)};
// (4.4,35) @TEXT("VDD!",size=1.1,halign="start",valign="middle");
// }
// END SARADC RNL
ends sar_bootstrap_flat_8b_p

subckt sar8j_r1_sw_b0 BOT GN GP VDD VREFN VREFP VSS
    MP_HIGH (BOT GP VREFP VDD) pch_mac l=90n w=175.00n multi=3 nf=1          sd=100n ad=1.3125e-14 as=1.3125e-14 pd=500n ps=500n nrd=1.633331          nrs=1.633331 sa=75.0n sb=75.0n sa1=75.0n sa2=75.0n sa3=75.0n          sa4=75.0n sb1=75.0n sb2=75.0n sb3=75.0n spa=100n spa1=100n          spa2=100n spa3=100n sap=91.9776n sapb=114.444n spba=115.715n          spba1=117.043n dfm_flag=0 spmt=1.11111e+15 spomt=0          spomt1=1.11111e+60 spmb=1.11111e+15 spomb=0 spomb1=1.11111e+60
    MN_LOW (BOT GN VREFN VSS) nch_mac l=90n w=150.0n multi=3 nf=1 sd=100n          ad=1.125e-14 as=1.125e-14 pd=450.0n ps=450.0n nrd=2.702751          nrs=2.702751 sa=75.0n sb=75.0n sa1=75.0n sa2=75.0n sa3=75.0n          sa4=75.0n sb1=75.0n sb2=75.0n sb3=75.0n spa=100n spa1=100n          spa2=100n spa3=100n sap=91.9776n sapb=114.444n spba=115.715n          spba1=117.043n dfm_flag=0 spmt=1.11111e+15 spomt=0          spomt1=1.11111e+60 spmb=1.11111e+15 spomb=0 spomb1=1.11111e+60
// BEGIN SARADC RNL
// @RNL(author="saradc topology") {
// #MP_HIGH @SET-SYMBOL $PMOS_4TERM;
// #MP_HIGH @PLACE(0,20) => @ORIENT("R0");
// #MP_HIGH @TEXT("MP_HIGH",key="name",size=1.3,halign="start") => @PLACE(3,23);
// #MP_HIGH @TEXT("l=90n w=175.00n multi=3",key="value",size=0.9,halign="start") => @PLACE(3,16);
// #MP_HIGH @TEXT("",key="model");
// #MN_LOW @SET-SYMBOL $NMOS_4TERM;
// #MN_LOW @PLACE(0,-10) => @ORIENT("R0");
// #MN_LOW @TEXT("MN_LOW",key="name",size=1.3,halign="start") => @PLACE(3,-7);
// #MN_LOW @TEXT("l=90n w=150.0n multi=3",key="value",size=0.9,halign="start") => @PLACE(3,-14);
// #MN_LOW @TEXT("",key="model");
// &"BOT" @WIRE(mode="straight",linecolor="#226e85",linewidth=0.16) {#MP_HIGH:1 (0,5)};
// $JUNCTION @ATTACH (0,5);
// &"BOT" @WIRE(mode="straight",linecolor="#226e85",linewidth=0.16) {#MN_LOW:1 (0,5)};
// $JUNCTION @ATTACH (0,5);
// (-20,48) @TEXT("sar8j_r1_sw_b0 / real reference switches",size=1.3,halign="start",textcolor="#223d52");
// &"GP" @WIRE(mode="straight",linecolor="#30485d",linewidth=0.16) {#MP_HIGH:2 (-6,20)};
// (-6.4,20) @TEXT("GP",size=1.1,halign="end",valign="middle");
// &"VREFP" @WIRE(mode="straight",linecolor="#30485d",linewidth=0.16) {#MP_HIGH:3 (0,25)};
// (0,25.4) @TEXT("VREFP",size=1.1,halign="middle",valign="bottom");
// &"VDD" @WIRE(mode="straight",linecolor="#30485d",linewidth=0.16) {#MP_HIGH:4 (4,20)};
// (4.4,20) @TEXT("VDD",size=1.1,halign="start",valign="middle");
// &"GN" @WIRE(mode="straight",linecolor="#30485d",linewidth=0.16) {#MN_LOW:2 (-6,-10)};
// (-6.4,-10) @TEXT("GN",size=1.1,halign="end",valign="middle");
// &"VREFN" @WIRE(mode="straight",linecolor="#30485d",linewidth=0.16) {#MN_LOW:3 (0,-15)};
// (0,-15.4) @TEXT("VREFN",size=1.1,halign="middle",valign="top");
// &"VSS" @WIRE(mode="straight",linecolor="#30485d",linewidth=0.16) {#MN_LOW:4 (4,-10)};
// (4.4,-10) @TEXT("VSS",size=1.1,halign="start",valign="middle");
// }
// END SARADC RNL
ends sar8j_r1_sw_b0

subckt sar8j_r1_sw_b1 BOT GN GP VDD VREFN VREFP VSS
    MP_HIGH (BOT GP VREFP VDD) pch_mac l=90n w=175.00n multi=6 nf=1          sd=100n ad=1.3125e-14 as=1.3125e-14 pd=500n ps=500n nrd=1.633331          nrs=1.633331 sa=75.0n sb=75.0n sa1=75.0n sa2=75.0n sa3=75.0n          sa4=75.0n sb1=75.0n sb2=75.0n sb3=75.0n spa=100n spa1=100n          spa2=100n spa3=100n sap=91.9776n sapb=114.444n spba=115.715n          spba1=117.043n dfm_flag=0 spmt=1.11111e+15 spomt=0          spomt1=1.11111e+60 spmb=1.11111e+15 spomb=0 spomb1=1.11111e+60
    MN_LOW (BOT GN VREFN VSS) nch_mac l=90n w=150.0n multi=6 nf=1 sd=100n          ad=1.125e-14 as=1.125e-14 pd=450.0n ps=450.0n nrd=2.702751          nrs=2.702751 sa=75.0n sb=75.0n sa1=75.0n sa2=75.0n sa3=75.0n          sa4=75.0n sb1=75.0n sb2=75.0n sb3=75.0n spa=100n spa1=100n          spa2=100n spa3=100n sap=91.9776n sapb=114.444n spba=115.715n          spba1=117.043n dfm_flag=0 spmt=1.11111e+15 spomt=0          spomt1=1.11111e+60 spmb=1.11111e+15 spomb=0 spomb1=1.11111e+60
// BEGIN SARADC RNL
// @RNL(author="saradc topology") {
// #MP_HIGH @SET-SYMBOL $PMOS_4TERM;
// #MP_HIGH @PLACE(0,20) => @ORIENT("R0");
// #MP_HIGH @TEXT("MP_HIGH",key="name",size=1.3,halign="start") => @PLACE(3,23);
// #MP_HIGH @TEXT("l=90n w=175.00n multi=6",key="value",size=0.9,halign="start") => @PLACE(3,16);
// #MP_HIGH @TEXT("",key="model");
// #MN_LOW @SET-SYMBOL $NMOS_4TERM;
// #MN_LOW @PLACE(0,-10) => @ORIENT("R0");
// #MN_LOW @TEXT("MN_LOW",key="name",size=1.3,halign="start") => @PLACE(3,-7);
// #MN_LOW @TEXT("l=90n w=150.0n multi=6",key="value",size=0.9,halign="start") => @PLACE(3,-14);
// #MN_LOW @TEXT("",key="model");
// &"BOT" @WIRE(mode="straight",linecolor="#226e85",linewidth=0.16) {#MP_HIGH:1 (0,5)};
// $JUNCTION @ATTACH (0,5);
// &"BOT" @WIRE(mode="straight",linecolor="#226e85",linewidth=0.16) {#MN_LOW:1 (0,5)};
// $JUNCTION @ATTACH (0,5);
// (-20,48) @TEXT("sar8j_r1_sw_b1 / real reference switches",size=1.3,halign="start",textcolor="#223d52");
// &"GP" @WIRE(mode="straight",linecolor="#30485d",linewidth=0.16) {#MP_HIGH:2 (-6,20)};
// (-6.4,20) @TEXT("GP",size=1.1,halign="end",valign="middle");
// &"VREFP" @WIRE(mode="straight",linecolor="#30485d",linewidth=0.16) {#MP_HIGH:3 (0,25)};
// (0,25.4) @TEXT("VREFP",size=1.1,halign="middle",valign="bottom");
// &"VDD" @WIRE(mode="straight",linecolor="#30485d",linewidth=0.16) {#MP_HIGH:4 (4,20)};
// (4.4,20) @TEXT("VDD",size=1.1,halign="start",valign="middle");
// &"GN" @WIRE(mode="straight",linecolor="#30485d",linewidth=0.16) {#MN_LOW:2 (-6,-10)};
// (-6.4,-10) @TEXT("GN",size=1.1,halign="end",valign="middle");
// &"VREFN" @WIRE(mode="straight",linecolor="#30485d",linewidth=0.16) {#MN_LOW:3 (0,-15)};
// (0,-15.4) @TEXT("VREFN",size=1.1,halign="middle",valign="top");
// &"VSS" @WIRE(mode="straight",linecolor="#30485d",linewidth=0.16) {#MN_LOW:4 (4,-10)};
// (4.4,-10) @TEXT("VSS",size=1.1,halign="start",valign="middle");
// }
// END SARADC RNL
ends sar8j_r1_sw_b1

subckt sar8j_r1_sw_b2 BOT GN GP VDD VREFN VREFP VSS
    MP_HIGH (BOT GP VREFP VDD) pch_mac l=90n w=175.00n multi=12 nf=1          sd=100n ad=1.3125e-14 as=1.3125e-14 pd=500n ps=500n nrd=1.633331          nrs=1.633331 sa=75.0n sb=75.0n sa1=75.0n sa2=75.0n sa3=75.0n          sa4=75.0n sb1=75.0n sb2=75.0n sb3=75.0n spa=100n spa1=100n          spa2=100n spa3=100n sap=91.9776n sapb=114.444n spba=115.715n          spba1=117.043n dfm_flag=0 spmt=1.11111e+15 spomt=0          spomt1=1.11111e+60 spmb=1.11111e+15 spomb=0 spomb1=1.11111e+60
    MN_LOW (BOT GN VREFN VSS) nch_mac l=90n w=150.0n multi=12 nf=1 sd=100n          ad=1.125e-14 as=1.125e-14 pd=450.0n ps=450.0n nrd=2.702751          nrs=2.702751 sa=75.0n sb=75.0n sa1=75.0n sa2=75.0n sa3=75.0n          sa4=75.0n sb1=75.0n sb2=75.0n sb3=75.0n spa=100n spa1=100n          spa2=100n spa3=100n sap=91.9776n sapb=114.444n spba=115.715n          spba1=117.043n dfm_flag=0 spmt=1.11111e+15 spomt=0          spomt1=1.11111e+60 spmb=1.11111e+15 spomb=0 spomb1=1.11111e+60
// BEGIN SARADC RNL
// @RNL(author="saradc topology") {
// #MP_HIGH @SET-SYMBOL $PMOS_4TERM;
// #MP_HIGH @PLACE(0,20) => @ORIENT("R0");
// #MP_HIGH @TEXT("MP_HIGH",key="name",size=1.3,halign="start") => @PLACE(3,23);
// #MP_HIGH @TEXT("l=90n w=175.00n multi=12",key="value",size=0.9,halign="start") => @PLACE(3,16);
// #MP_HIGH @TEXT("",key="model");
// #MN_LOW @SET-SYMBOL $NMOS_4TERM;
// #MN_LOW @PLACE(0,-10) => @ORIENT("R0");
// #MN_LOW @TEXT("MN_LOW",key="name",size=1.3,halign="start") => @PLACE(3,-7);
// #MN_LOW @TEXT("l=90n w=150.0n multi=12",key="value",size=0.9,halign="start") => @PLACE(3,-14);
// #MN_LOW @TEXT("",key="model");
// &"BOT" @WIRE(mode="straight",linecolor="#226e85",linewidth=0.16) {#MP_HIGH:1 (0,5)};
// $JUNCTION @ATTACH (0,5);
// &"BOT" @WIRE(mode="straight",linecolor="#226e85",linewidth=0.16) {#MN_LOW:1 (0,5)};
// $JUNCTION @ATTACH (0,5);
// (-20,48) @TEXT("sar8j_r1_sw_b2 / real reference switches",size=1.3,halign="start",textcolor="#223d52");
// &"GP" @WIRE(mode="straight",linecolor="#30485d",linewidth=0.16) {#MP_HIGH:2 (-6,20)};
// (-6.4,20) @TEXT("GP",size=1.1,halign="end",valign="middle");
// &"VREFP" @WIRE(mode="straight",linecolor="#30485d",linewidth=0.16) {#MP_HIGH:3 (0,25)};
// (0,25.4) @TEXT("VREFP",size=1.1,halign="middle",valign="bottom");
// &"VDD" @WIRE(mode="straight",linecolor="#30485d",linewidth=0.16) {#MP_HIGH:4 (4,20)};
// (4.4,20) @TEXT("VDD",size=1.1,halign="start",valign="middle");
// &"GN" @WIRE(mode="straight",linecolor="#30485d",linewidth=0.16) {#MN_LOW:2 (-6,-10)};
// (-6.4,-10) @TEXT("GN",size=1.1,halign="end",valign="middle");
// &"VREFN" @WIRE(mode="straight",linecolor="#30485d",linewidth=0.16) {#MN_LOW:3 (0,-15)};
// (0,-15.4) @TEXT("VREFN",size=1.1,halign="middle",valign="top");
// &"VSS" @WIRE(mode="straight",linecolor="#30485d",linewidth=0.16) {#MN_LOW:4 (4,-10)};
// (4.4,-10) @TEXT("VSS",size=1.1,halign="start",valign="middle");
// }
// END SARADC RNL
ends sar8j_r1_sw_b2

subckt sar8j_r1_sw_b3 BOT GN GP VDD VREFN VREFP VSS
    MP_HIGH (BOT GP VREFP VDD) pch_mac l=90n w=175.00n multi=24 nf=1          sd=100n ad=1.3125e-14 as=1.3125e-14 pd=500n ps=500n nrd=1.633331          nrs=1.633331 sa=75.0n sb=75.0n sa1=75.0n sa2=75.0n sa3=75.0n          sa4=75.0n sb1=75.0n sb2=75.0n sb3=75.0n spa=100n spa1=100n          spa2=100n spa3=100n sap=91.9776n sapb=114.444n spba=115.715n          spba1=117.043n dfm_flag=0 spmt=1.11111e+15 spomt=0          spomt1=1.11111e+60 spmb=1.11111e+15 spomb=0 spomb1=1.11111e+60
    MN_LOW (BOT GN VREFN VSS) nch_mac l=90n w=150.0n multi=24 nf=1 sd=100n          ad=1.125e-14 as=1.125e-14 pd=450.0n ps=450.0n nrd=2.702751          nrs=2.702751 sa=75.0n sb=75.0n sa1=75.0n sa2=75.0n sa3=75.0n          sa4=75.0n sb1=75.0n sb2=75.0n sb3=75.0n spa=100n spa1=100n          spa2=100n spa3=100n sap=91.9776n sapb=114.444n spba=115.715n          spba1=117.043n dfm_flag=0 spmt=1.11111e+15 spomt=0          spomt1=1.11111e+60 spmb=1.11111e+15 spomb=0 spomb1=1.11111e+60
// BEGIN SARADC RNL
// @RNL(author="saradc topology") {
// #MP_HIGH @SET-SYMBOL $PMOS_4TERM;
// #MP_HIGH @PLACE(0,20) => @ORIENT("R0");
// #MP_HIGH @TEXT("MP_HIGH",key="name",size=1.3,halign="start") => @PLACE(3,23);
// #MP_HIGH @TEXT("l=90n w=175.00n multi=24",key="value",size=0.9,halign="start") => @PLACE(3,16);
// #MP_HIGH @TEXT("",key="model");
// #MN_LOW @SET-SYMBOL $NMOS_4TERM;
// #MN_LOW @PLACE(0,-10) => @ORIENT("R0");
// #MN_LOW @TEXT("MN_LOW",key="name",size=1.3,halign="start") => @PLACE(3,-7);
// #MN_LOW @TEXT("l=90n w=150.0n multi=24",key="value",size=0.9,halign="start") => @PLACE(3,-14);
// #MN_LOW @TEXT("",key="model");
// &"BOT" @WIRE(mode="straight",linecolor="#226e85",linewidth=0.16) {#MP_HIGH:1 (0,5)};
// $JUNCTION @ATTACH (0,5);
// &"BOT" @WIRE(mode="straight",linecolor="#226e85",linewidth=0.16) {#MN_LOW:1 (0,5)};
// $JUNCTION @ATTACH (0,5);
// (-20,48) @TEXT("sar8j_r1_sw_b3 / real reference switches",size=1.3,halign="start",textcolor="#223d52");
// &"GP" @WIRE(mode="straight",linecolor="#30485d",linewidth=0.16) {#MP_HIGH:2 (-6,20)};
// (-6.4,20) @TEXT("GP",size=1.1,halign="end",valign="middle");
// &"VREFP" @WIRE(mode="straight",linecolor="#30485d",linewidth=0.16) {#MP_HIGH:3 (0,25)};
// (0,25.4) @TEXT("VREFP",size=1.1,halign="middle",valign="bottom");
// &"VDD" @WIRE(mode="straight",linecolor="#30485d",linewidth=0.16) {#MP_HIGH:4 (4,20)};
// (4.4,20) @TEXT("VDD",size=1.1,halign="start",valign="middle");
// &"GN" @WIRE(mode="straight",linecolor="#30485d",linewidth=0.16) {#MN_LOW:2 (-6,-10)};
// (-6.4,-10) @TEXT("GN",size=1.1,halign="end",valign="middle");
// &"VREFN" @WIRE(mode="straight",linecolor="#30485d",linewidth=0.16) {#MN_LOW:3 (0,-15)};
// (0,-15.4) @TEXT("VREFN",size=1.1,halign="middle",valign="top");
// &"VSS" @WIRE(mode="straight",linecolor="#30485d",linewidth=0.16) {#MN_LOW:4 (4,-10)};
// (4.4,-10) @TEXT("VSS",size=1.1,halign="start",valign="middle");
// }
// END SARADC RNL
ends sar8j_r1_sw_b3

subckt sar8j_r1_sw_b4 BOT GN GP VDD VREFN VREFP VSS
    MP_HIGH (BOT GP VREFP VDD) pch_mac l=90n w=175.00n multi=48 nf=1          sd=100n ad=1.3125e-14 as=1.3125e-14 pd=500n ps=500n nrd=1.633331          nrs=1.633331 sa=75.0n sb=75.0n sa1=75.0n sa2=75.0n sa3=75.0n          sa4=75.0n sb1=75.0n sb2=75.0n sb3=75.0n spa=100n spa1=100n          spa2=100n spa3=100n sap=91.9776n sapb=114.444n spba=115.715n          spba1=117.043n dfm_flag=0 spmt=1.11111e+15 spomt=0          spomt1=1.11111e+60 spmb=1.11111e+15 spomb=0 spomb1=1.11111e+60
    MN_LOW (BOT GN VREFN VSS) nch_mac l=90n w=150.0n multi=48 nf=1 sd=100n          ad=1.125e-14 as=1.125e-14 pd=450.0n ps=450.0n nrd=2.702751          nrs=2.702751 sa=75.0n sb=75.0n sa1=75.0n sa2=75.0n sa3=75.0n          sa4=75.0n sb1=75.0n sb2=75.0n sb3=75.0n spa=100n spa1=100n          spa2=100n spa3=100n sap=91.9776n sapb=114.444n spba=115.715n          spba1=117.043n dfm_flag=0 spmt=1.11111e+15 spomt=0          spomt1=1.11111e+60 spmb=1.11111e+15 spomb=0 spomb1=1.11111e+60
// BEGIN SARADC RNL
// @RNL(author="saradc topology") {
// #MP_HIGH @SET-SYMBOL $PMOS_4TERM;
// #MP_HIGH @PLACE(0,20) => @ORIENT("R0");
// #MP_HIGH @TEXT("MP_HIGH",key="name",size=1.3,halign="start") => @PLACE(3,23);
// #MP_HIGH @TEXT("l=90n w=175.00n multi=48",key="value",size=0.9,halign="start") => @PLACE(3,16);
// #MP_HIGH @TEXT("",key="model");
// #MN_LOW @SET-SYMBOL $NMOS_4TERM;
// #MN_LOW @PLACE(0,-10) => @ORIENT("R0");
// #MN_LOW @TEXT("MN_LOW",key="name",size=1.3,halign="start") => @PLACE(3,-7);
// #MN_LOW @TEXT("l=90n w=150.0n multi=48",key="value",size=0.9,halign="start") => @PLACE(3,-14);
// #MN_LOW @TEXT("",key="model");
// &"BOT" @WIRE(mode="straight",linecolor="#226e85",linewidth=0.16) {#MP_HIGH:1 (0,5)};
// $JUNCTION @ATTACH (0,5);
// &"BOT" @WIRE(mode="straight",linecolor="#226e85",linewidth=0.16) {#MN_LOW:1 (0,5)};
// $JUNCTION @ATTACH (0,5);
// (-20,48) @TEXT("sar8j_r1_sw_b4 / real reference switches",size=1.3,halign="start",textcolor="#223d52");
// &"GP" @WIRE(mode="straight",linecolor="#30485d",linewidth=0.16) {#MP_HIGH:2 (-6,20)};
// (-6.4,20) @TEXT("GP",size=1.1,halign="end",valign="middle");
// &"VREFP" @WIRE(mode="straight",linecolor="#30485d",linewidth=0.16) {#MP_HIGH:3 (0,25)};
// (0,25.4) @TEXT("VREFP",size=1.1,halign="middle",valign="bottom");
// &"VDD" @WIRE(mode="straight",linecolor="#30485d",linewidth=0.16) {#MP_HIGH:4 (4,20)};
// (4.4,20) @TEXT("VDD",size=1.1,halign="start",valign="middle");
// &"GN" @WIRE(mode="straight",linecolor="#30485d",linewidth=0.16) {#MN_LOW:2 (-6,-10)};
// (-6.4,-10) @TEXT("GN",size=1.1,halign="end",valign="middle");
// &"VREFN" @WIRE(mode="straight",linecolor="#30485d",linewidth=0.16) {#MN_LOW:3 (0,-15)};
// (0,-15.4) @TEXT("VREFN",size=1.1,halign="middle",valign="top");
// &"VSS" @WIRE(mode="straight",linecolor="#30485d",linewidth=0.16) {#MN_LOW:4 (4,-10)};
// (4.4,-10) @TEXT("VSS",size=1.1,halign="start",valign="middle");
// }
// END SARADC RNL
ends sar8j_r1_sw_b4

subckt sar8j_r1_sw_b5 BOT GN GP VDD VREFN VREFP VSS
    MP_HIGH (BOT GP VREFP VDD) pch_mac l=90n w=175.00n multi=96 nf=1          sd=100n ad=1.3125e-14 as=1.3125e-14 pd=500n ps=500n nrd=1.633331          nrs=1.633331 sa=75.0n sb=75.0n sa1=75.0n sa2=75.0n sa3=75.0n          sa4=75.0n sb1=75.0n sb2=75.0n sb3=75.0n spa=100n spa1=100n          spa2=100n spa3=100n sap=91.9776n sapb=114.444n spba=115.715n          spba1=117.043n dfm_flag=0 spmt=1.11111e+15 spomt=0          spomt1=1.11111e+60 spmb=1.11111e+15 spomb=0 spomb1=1.11111e+60
    MN_LOW (BOT GN VREFN VSS) nch_mac l=90n w=150.0n multi=96 nf=1 sd=100n          ad=1.125e-14 as=1.125e-14 pd=450.0n ps=450.0n nrd=2.702751          nrs=2.702751 sa=75.0n sb=75.0n sa1=75.0n sa2=75.0n sa3=75.0n          sa4=75.0n sb1=75.0n sb2=75.0n sb3=75.0n spa=100n spa1=100n          spa2=100n spa3=100n sap=91.9776n sapb=114.444n spba=115.715n          spba1=117.043n dfm_flag=0 spmt=1.11111e+15 spomt=0          spomt1=1.11111e+60 spmb=1.11111e+15 spomb=0 spomb1=1.11111e+60
// BEGIN SARADC RNL
// @RNL(author="saradc topology") {
// #MP_HIGH @SET-SYMBOL $PMOS_4TERM;
// #MP_HIGH @PLACE(0,20) => @ORIENT("R0");
// #MP_HIGH @TEXT("MP_HIGH",key="name",size=1.3,halign="start") => @PLACE(3,23);
// #MP_HIGH @TEXT("l=90n w=175.00n multi=96",key="value",size=0.9,halign="start") => @PLACE(3,16);
// #MP_HIGH @TEXT("",key="model");
// #MN_LOW @SET-SYMBOL $NMOS_4TERM;
// #MN_LOW @PLACE(0,-10) => @ORIENT("R0");
// #MN_LOW @TEXT("MN_LOW",key="name",size=1.3,halign="start") => @PLACE(3,-7);
// #MN_LOW @TEXT("l=90n w=150.0n multi=96",key="value",size=0.9,halign="start") => @PLACE(3,-14);
// #MN_LOW @TEXT("",key="model");
// &"BOT" @WIRE(mode="straight",linecolor="#226e85",linewidth=0.16) {#MP_HIGH:1 (0,5)};
// $JUNCTION @ATTACH (0,5);
// &"BOT" @WIRE(mode="straight",linecolor="#226e85",linewidth=0.16) {#MN_LOW:1 (0,5)};
// $JUNCTION @ATTACH (0,5);
// (-20,48) @TEXT("sar8j_r1_sw_b5 / real reference switches",size=1.3,halign="start",textcolor="#223d52");
// &"GP" @WIRE(mode="straight",linecolor="#30485d",linewidth=0.16) {#MP_HIGH:2 (-6,20)};
// (-6.4,20) @TEXT("GP",size=1.1,halign="end",valign="middle");
// &"VREFP" @WIRE(mode="straight",linecolor="#30485d",linewidth=0.16) {#MP_HIGH:3 (0,25)};
// (0,25.4) @TEXT("VREFP",size=1.1,halign="middle",valign="bottom");
// &"VDD" @WIRE(mode="straight",linecolor="#30485d",linewidth=0.16) {#MP_HIGH:4 (4,20)};
// (4.4,20) @TEXT("VDD",size=1.1,halign="start",valign="middle");
// &"GN" @WIRE(mode="straight",linecolor="#30485d",linewidth=0.16) {#MN_LOW:2 (-6,-10)};
// (-6.4,-10) @TEXT("GN",size=1.1,halign="end",valign="middle");
// &"VREFN" @WIRE(mode="straight",linecolor="#30485d",linewidth=0.16) {#MN_LOW:3 (0,-15)};
// (0,-15.4) @TEXT("VREFN",size=1.1,halign="middle",valign="top");
// &"VSS" @WIRE(mode="straight",linecolor="#30485d",linewidth=0.16) {#MN_LOW:4 (4,-10)};
// (4.4,-10) @TEXT("VSS",size=1.1,halign="start",valign="middle");
// }
// END SARADC RNL
ends sar8j_r1_sw_b5

subckt sar8j_r1_sw_b6 BOT GN GP VDD VREFN VREFP VSS
    MP_HIGH (BOT GP VREFP VDD) pch_mac l=90n w=175.00n multi=192 nf=1          sd=100n ad=1.3125e-14 as=1.3125e-14 pd=500n ps=500n nrd=1.633331          nrs=1.633331 sa=75.0n sb=75.0n sa1=75.0n sa2=75.0n sa3=75.0n          sa4=75.0n sb1=75.0n sb2=75.0n sb3=75.0n spa=100n spa1=100n          spa2=100n spa3=100n sap=91.9776n sapb=114.444n spba=115.715n          spba1=117.043n dfm_flag=0 spmt=1.11111e+15 spomt=0          spomt1=1.11111e+60 spmb=1.11111e+15 spomb=0 spomb1=1.11111e+60
    MN_LOW (BOT GN VREFN VSS) nch_mac l=90n w=150.0n multi=192 nf=1          sd=100n ad=1.125e-14 as=1.125e-14 pd=450.0n ps=450.0n nrd=2.702751          nrs=2.702751 sa=75.0n sb=75.0n sa1=75.0n sa2=75.0n sa3=75.0n          sa4=75.0n sb1=75.0n sb2=75.0n sb3=75.0n spa=100n spa1=100n          spa2=100n spa3=100n sap=91.9776n sapb=114.444n spba=115.715n          spba1=117.043n dfm_flag=0 spmt=1.11111e+15 spomt=0          spomt1=1.11111e+60 spmb=1.11111e+15 spomb=0 spomb1=1.11111e+60
// BEGIN SARADC RNL
// @RNL(author="saradc topology") {
// #MP_HIGH @SET-SYMBOL $PMOS_4TERM;
// #MP_HIGH @PLACE(0,20) => @ORIENT("R0");
// #MP_HIGH @TEXT("MP_HIGH",key="name",size=1.3,halign="start") => @PLACE(3,23);
// #MP_HIGH @TEXT("l=90n w=175.00n multi=192",key="value",size=0.9,halign="start") => @PLACE(3,16);
// #MP_HIGH @TEXT("",key="model");
// #MN_LOW @SET-SYMBOL $NMOS_4TERM;
// #MN_LOW @PLACE(0,-10) => @ORIENT("R0");
// #MN_LOW @TEXT("MN_LOW",key="name",size=1.3,halign="start") => @PLACE(3,-7);
// #MN_LOW @TEXT("l=90n w=150.0n multi=192",key="value",size=0.9,halign="start") => @PLACE(3,-14);
// #MN_LOW @TEXT("",key="model");
// &"BOT" @WIRE(mode="straight",linecolor="#226e85",linewidth=0.16) {#MP_HIGH:1 (0,5)};
// $JUNCTION @ATTACH (0,5);
// &"BOT" @WIRE(mode="straight",linecolor="#226e85",linewidth=0.16) {#MN_LOW:1 (0,5)};
// $JUNCTION @ATTACH (0,5);
// (-20,48) @TEXT("sar8j_r1_sw_b6 / real reference switches",size=1.3,halign="start",textcolor="#223d52");
// &"GP" @WIRE(mode="straight",linecolor="#30485d",linewidth=0.16) {#MP_HIGH:2 (-6,20)};
// (-6.4,20) @TEXT("GP",size=1.1,halign="end",valign="middle");
// &"VREFP" @WIRE(mode="straight",linecolor="#30485d",linewidth=0.16) {#MP_HIGH:3 (0,25)};
// (0,25.4) @TEXT("VREFP",size=1.1,halign="middle",valign="bottom");
// &"VDD" @WIRE(mode="straight",linecolor="#30485d",linewidth=0.16) {#MP_HIGH:4 (4,20)};
// (4.4,20) @TEXT("VDD",size=1.1,halign="start",valign="middle");
// &"GN" @WIRE(mode="straight",linecolor="#30485d",linewidth=0.16) {#MN_LOW:2 (-6,-10)};
// (-6.4,-10) @TEXT("GN",size=1.1,halign="end",valign="middle");
// &"VREFN" @WIRE(mode="straight",linecolor="#30485d",linewidth=0.16) {#MN_LOW:3 (0,-15)};
// (0,-15.4) @TEXT("VREFN",size=1.1,halign="middle",valign="top");
// &"VSS" @WIRE(mode="straight",linecolor="#30485d",linewidth=0.16) {#MN_LOW:4 (4,-10)};
// (4.4,-10) @TEXT("VSS",size=1.1,halign="start",valign="middle");
// }
// END SARADC RNL
ends sar8j_r1_sw_b6

subckt sar8j_r1_sw_b7 BOT GN GP VDD VREFN VREFP VSS
    MP_HIGH (BOT GP VREFP VDD) pch_mac l=90n w=175.00n multi=384 nf=1          sd=100n ad=1.3125e-14 as=1.3125e-14 pd=500n ps=500n nrd=1.633331          nrs=1.633331 sa=75.0n sb=75.0n sa1=75.0n sa2=75.0n sa3=75.0n          sa4=75.0n sb1=75.0n sb2=75.0n sb3=75.0n spa=100n spa1=100n          spa2=100n spa3=100n sap=91.9776n sapb=114.444n spba=115.715n          spba1=117.043n dfm_flag=0 spmt=1.11111e+15 spomt=0          spomt1=1.11111e+60 spmb=1.11111e+15 spomb=0 spomb1=1.11111e+60
    MN_LOW (BOT GN VREFN VSS) nch_mac l=90n w=150.0n multi=384 nf=1          sd=100n ad=1.125e-14 as=1.125e-14 pd=450.0n ps=450.0n nrd=2.702751          nrs=2.702751 sa=75.0n sb=75.0n sa1=75.0n sa2=75.0n sa3=75.0n          sa4=75.0n sb1=75.0n sb2=75.0n sb3=75.0n spa=100n spa1=100n          spa2=100n spa3=100n sap=91.9776n sapb=114.444n spba=115.715n          spba1=117.043n dfm_flag=0 spmt=1.11111e+15 spomt=0          spomt1=1.11111e+60 spmb=1.11111e+15 spomb=0 spomb1=1.11111e+60
// BEGIN SARADC RNL
// @RNL(author="saradc topology") {
// #MP_HIGH @SET-SYMBOL $PMOS_4TERM;
// #MP_HIGH @PLACE(0,20) => @ORIENT("R0");
// #MP_HIGH @TEXT("MP_HIGH",key="name",size=1.3,halign="start") => @PLACE(3,23);
// #MP_HIGH @TEXT("l=90n w=175.00n multi=384",key="value",size=0.9,halign="start") => @PLACE(3,16);
// #MP_HIGH @TEXT("",key="model");
// #MN_LOW @SET-SYMBOL $NMOS_4TERM;
// #MN_LOW @PLACE(0,-10) => @ORIENT("R0");
// #MN_LOW @TEXT("MN_LOW",key="name",size=1.3,halign="start") => @PLACE(3,-7);
// #MN_LOW @TEXT("l=90n w=150.0n multi=384",key="value",size=0.9,halign="start") => @PLACE(3,-14);
// #MN_LOW @TEXT("",key="model");
// &"BOT" @WIRE(mode="straight",linecolor="#226e85",linewidth=0.16) {#MP_HIGH:1 (0,5)};
// $JUNCTION @ATTACH (0,5);
// &"BOT" @WIRE(mode="straight",linecolor="#226e85",linewidth=0.16) {#MN_LOW:1 (0,5)};
// $JUNCTION @ATTACH (0,5);
// (-20,48) @TEXT("sar8j_r1_sw_b7 / real reference switches",size=1.3,halign="start",textcolor="#223d52");
// &"GP" @WIRE(mode="straight",linecolor="#30485d",linewidth=0.16) {#MP_HIGH:2 (-6,20)};
// (-6.4,20) @TEXT("GP",size=1.1,halign="end",valign="middle");
// &"VREFP" @WIRE(mode="straight",linecolor="#30485d",linewidth=0.16) {#MP_HIGH:3 (0,25)};
// (0,25.4) @TEXT("VREFP",size=1.1,halign="middle",valign="bottom");
// &"VDD" @WIRE(mode="straight",linecolor="#30485d",linewidth=0.16) {#MP_HIGH:4 (4,20)};
// (4.4,20) @TEXT("VDD",size=1.1,halign="start",valign="middle");
// &"GN" @WIRE(mode="straight",linecolor="#30485d",linewidth=0.16) {#MN_LOW:2 (-6,-10)};
// (-6.4,-10) @TEXT("GN",size=1.1,halign="end",valign="middle");
// &"VREFN" @WIRE(mode="straight",linecolor="#30485d",linewidth=0.16) {#MN_LOW:3 (0,-15)};
// (0,-15.4) @TEXT("VREFN",size=1.1,halign="middle",valign="top");
// &"VSS" @WIRE(mode="straight",linecolor="#30485d",linewidth=0.16) {#MN_LOW:4 (4,-10)};
// (4.4,-10) @TEXT("VSS",size=1.1,halign="start",valign="middle");
// }
// END SARADC RNL
ends sar8j_r1_sw_b7

subckt sar8j_r1_cdac GNN0 GNN1 GNN2 GNN3 GNN4 GNN5 GNN6 GNN7 GNP0 GNP1          GNP2 GNP3 GNP4 GNP5 GNP6 GNP7 GPN0 GPN1 GPN2 GPN3 GPN4 GPN5 GPN6          GPN7 GPP0 GPP1 GPP2 GPP3 GPP4 GPP5 GPP6 GPP7 TOPN TOPP VDD VREFN          VREFP VSS
    CMOMN8 (TOPN VREFN) cfmom_2t nr=8 lr=2u w=50n s=50n stm=1 spm=3          multi=1 mismatchflag=1
    CMOMN7 (TOPN BN7) cfmom_2t nr=8 lr=2u w=50n s=50n stm=1 spm=3          multi=128 mismatchflag=1
    CMOMN6 (TOPN BN6) cfmom_2t nr=8 lr=2u w=50n s=50n stm=1 spm=3 multi=64          mismatchflag=1
    CMOMN5 (TOPN BN5) cfmom_2t nr=8 lr=2u w=50n s=50n stm=1 spm=3 multi=32          mismatchflag=1
    CMOMN4 (TOPN BN4) cfmom_2t nr=8 lr=2u w=50n s=50n stm=1 spm=3 multi=16          mismatchflag=1
    CMOMN3 (TOPN BN3) cfmom_2t nr=8 lr=2u w=50n s=50n stm=1 spm=3 multi=8          mismatchflag=1
    CMOMN2 (TOPN BN2) cfmom_2t nr=8 lr=2u w=50n s=50n stm=1 spm=3 multi=4          mismatchflag=1
    CMOMN1 (TOPN BN1) cfmom_2t nr=8 lr=2u w=50n s=50n stm=1 spm=3 multi=2          mismatchflag=1
    CMOMN0 (TOPN BN0) cfmom_2t nr=8 lr=2u w=50n s=50n stm=1 spm=3 multi=1          mismatchflag=1
    CMOMP8 (TOPP VREFP) cfmom_2t nr=8 lr=2u w=50n s=50n stm=1 spm=3          multi=1 mismatchflag=1
    CMOMP7 (TOPP BP7) cfmom_2t nr=8 lr=2u w=50n s=50n stm=1 spm=3          multi=128 mismatchflag=1
    CMOMP6 (TOPP BP6) cfmom_2t nr=8 lr=2u w=50n s=50n stm=1 spm=3 multi=64          mismatchflag=1
    CMOMP5 (TOPP BP5) cfmom_2t nr=8 lr=2u w=50n s=50n stm=1 spm=3 multi=32          mismatchflag=1
    CMOMP4 (TOPP BP4) cfmom_2t nr=8 lr=2u w=50n s=50n stm=1 spm=3 multi=16          mismatchflag=1
    CMOMP3 (TOPP BP3) cfmom_2t nr=8 lr=2u w=50n s=50n stm=1 spm=3 multi=8          mismatchflag=1
    CMOMP2 (TOPP BP2) cfmom_2t nr=8 lr=2u w=50n s=50n stm=1 spm=3 multi=4          mismatchflag=1
    CMOMP1 (TOPP BP1) cfmom_2t nr=8 lr=2u w=50n s=50n stm=1 spm=3 multi=2          mismatchflag=1
    CMOMP0 (TOPP BP0) cfmom_2t nr=8 lr=2u w=50n s=50n stm=1 spm=3 multi=1          mismatchflag=1
    XSN0 (BN0 GNN0 GNP0 VDD VREFN VREFP VSS) sar8j_r1_sw_b0
    XSP0 (BP0 GPN0 GPP0 VDD VREFN VREFP VSS) sar8j_r1_sw_b0
    XSN1 (BN1 GNN1 GNP1 VDD VREFN VREFP VSS) sar8j_r1_sw_b1
    XSP1 (BP1 GPN1 GPP1 VDD VREFN VREFP VSS) sar8j_r1_sw_b1
    XSN2 (BN2 GNN2 GNP2 VDD VREFN VREFP VSS) sar8j_r1_sw_b2
    XSP2 (BP2 GPN2 GPP2 VDD VREFN VREFP VSS) sar8j_r1_sw_b2
    XSN3 (BN3 GNN3 GNP3 VDD VREFN VREFP VSS) sar8j_r1_sw_b3
    XSP3 (BP3 GPN3 GPP3 VDD VREFN VREFP VSS) sar8j_r1_sw_b3
    XSN4 (BN4 GNN4 GNP4 VDD VREFN VREFP VSS) sar8j_r1_sw_b4
    XSP4 (BP4 GPN4 GPP4 VDD VREFN VREFP VSS) sar8j_r1_sw_b4
    XSN5 (BN5 GNN5 GNP5 VDD VREFN VREFP VSS) sar8j_r1_sw_b5
    XSP5 (BP5 GPN5 GPP5 VDD VREFN VREFP VSS) sar8j_r1_sw_b5
    XSN6 (BN6 GNN6 GNP6 VDD VREFN VREFP VSS) sar8j_r1_sw_b6
    XSP6 (BP6 GPN6 GPP6 VDD VREFN VREFP VSS) sar8j_r1_sw_b6
    XSN7 (BN7 GNN7 GNP7 VDD VREFN VREFP VSS) sar8j_r1_sw_b7
    XSP7 (BP7 GPN7 GPP7 VDD VREFN VREFP VSS) sar8j_r1_sw_b7
// BEGIN SARADC RNL
// @RNL(author="saradc topology") {
// (-15,68) @TEXT("Differential MOM CDAC  /  binary weights and unit dummy",size=1.65,halign="start",textcolor="#223d52");
// #CMOMN0 @SET-SYMBOL $CAPACITOR;
// #CMOMN0 @PLACE(0,34) => @ORIENT("R0");
// #CMOMN0 @TEXT("CMOMN0",key="name",size=1.3,halign="start") => @PLACE(3,37);
// #CMOMN0 @TEXT("nr=8 lr=2u w=50n multi=1",key="value",size=0.9,halign="start") => @PLACE(3,30);
// #CMOMN0 @TEXT("",key="model");
// #XSN0 @SET-SYMBOL $S_sar8j_r1_sw_b0;
// #XSN0 @PLACE(0,12) => @ORIENT("R0");
// &"BN0" @WIRE(mode="straight",linecolor="#30485d",linewidth=0.16) {#CMOMN0:2 (0,32) (0,24) #XSN0:1};
// #CMOMN1 @SET-SYMBOL $CAPACITOR;
// #CMOMN1 @PLACE(38,34) => @ORIENT("R0");
// #CMOMN1 @TEXT("CMOMN1",key="name",size=1.3,halign="start") => @PLACE(41,37);
// #CMOMN1 @TEXT("nr=8 lr=2u w=50n multi=2",key="value",size=0.9,halign="start") => @PLACE(41,30);
// #CMOMN1 @TEXT("",key="model");
// #XSN1 @SET-SYMBOL $S_sar8j_r1_sw_b1;
// #XSN1 @PLACE(38,12) => @ORIENT("R0");
// &"BN1" @WIRE(mode="straight",linecolor="#30485d",linewidth=0.16) {#CMOMN1:2 (38,32) (38,24) #XSN1:1};
// #CMOMN2 @SET-SYMBOL $CAPACITOR;
// #CMOMN2 @PLACE(76,34) => @ORIENT("R0");
// #CMOMN2 @TEXT("CMOMN2",key="name",size=1.3,halign="start") => @PLACE(79,37);
// #CMOMN2 @TEXT("nr=8 lr=2u w=50n multi=4",key="value",size=0.9,halign="start") => @PLACE(79,30);
// #CMOMN2 @TEXT("",key="model");
// #XSN2 @SET-SYMBOL $S_sar8j_r1_sw_b2;
// #XSN2 @PLACE(76,12) => @ORIENT("R0");
// &"BN2" @WIRE(mode="straight",linecolor="#30485d",linewidth=0.16) {#CMOMN2:2 (76,32) (76,24) #XSN2:1};
// #CMOMN3 @SET-SYMBOL $CAPACITOR;
// #CMOMN3 @PLACE(114,34) => @ORIENT("R0");
// #CMOMN3 @TEXT("CMOMN3",key="name",size=1.3,halign="start") => @PLACE(117,37);
// #CMOMN3 @TEXT("nr=8 lr=2u w=50n multi=8",key="value",size=0.9,halign="start") => @PLACE(117,30);
// #CMOMN3 @TEXT("",key="model");
// #XSN3 @SET-SYMBOL $S_sar8j_r1_sw_b3;
// #XSN3 @PLACE(114,12) => @ORIENT("R0");
// &"BN3" @WIRE(mode="straight",linecolor="#30485d",linewidth=0.16) {#CMOMN3:2 (114,32) (114,24) #XSN3:1};
// #CMOMN4 @SET-SYMBOL $CAPACITOR;
// #CMOMN4 @PLACE(152,34) => @ORIENT("R0");
// #CMOMN4 @TEXT("CMOMN4",key="name",size=1.3,halign="start") => @PLACE(155,37);
// #CMOMN4 @TEXT("nr=8 lr=2u w=50n multi=16",key="value",size=0.9,halign="start") => @PLACE(155,30);
// #CMOMN4 @TEXT("",key="model");
// #XSN4 @SET-SYMBOL $S_sar8j_r1_sw_b4;
// #XSN4 @PLACE(152,12) => @ORIENT("R0");
// &"BN4" @WIRE(mode="straight",linecolor="#30485d",linewidth=0.16) {#CMOMN4:2 (152,32) (152,24) #XSN4:1};
// #CMOMN5 @SET-SYMBOL $CAPACITOR;
// #CMOMN5 @PLACE(190,34) => @ORIENT("R0");
// #CMOMN5 @TEXT("CMOMN5",key="name",size=1.3,halign="start") => @PLACE(193,37);
// #CMOMN5 @TEXT("nr=8 lr=2u w=50n multi=32",key="value",size=0.9,halign="start") => @PLACE(193,30);
// #CMOMN5 @TEXT("",key="model");
// #XSN5 @SET-SYMBOL $S_sar8j_r1_sw_b5;
// #XSN5 @PLACE(190,12) => @ORIENT("R0");
// &"BN5" @WIRE(mode="straight",linecolor="#30485d",linewidth=0.16) {#CMOMN5:2 (190,32) (190,24) #XSN5:1};
// #CMOMN6 @SET-SYMBOL $CAPACITOR;
// #CMOMN6 @PLACE(228,34) => @ORIENT("R0");
// #CMOMN6 @TEXT("CMOMN6",key="name",size=1.3,halign="start") => @PLACE(231,37);
// #CMOMN6 @TEXT("nr=8 lr=2u w=50n multi=64",key="value",size=0.9,halign="start") => @PLACE(231,30);
// #CMOMN6 @TEXT("",key="model");
// #XSN6 @SET-SYMBOL $S_sar8j_r1_sw_b6;
// #XSN6 @PLACE(228,12) => @ORIENT("R0");
// &"BN6" @WIRE(mode="straight",linecolor="#30485d",linewidth=0.16) {#CMOMN6:2 (228,32) (228,24) #XSN6:1};
// #CMOMN7 @SET-SYMBOL $CAPACITOR;
// #CMOMN7 @PLACE(266,34) => @ORIENT("R0");
// #CMOMN7 @TEXT("CMOMN7",key="name",size=1.3,halign="start") => @PLACE(269,37);
// #CMOMN7 @TEXT("nr=8 lr=2u w=50n multi=128",key="value",size=0.9,halign="start") => @PLACE(269,30);
// #CMOMN7 @TEXT("",key="model");
// #XSN7 @SET-SYMBOL $S_sar8j_r1_sw_b7;
// #XSN7 @PLACE(266,12) => @ORIENT("R0");
// &"BN7" @WIRE(mode="straight",linecolor="#30485d",linewidth=0.16) {#CMOMN7:2 (266,32) (266,24) #XSN7:1};
// #CMOMN8 @SET-SYMBOL $CAPACITOR;
// #CMOMN8 @PLACE(304,34) => @ORIENT("R0");
// #CMOMN8 @TEXT("CMOMN8",key="name",size=1.3,halign="start") => @PLACE(307,37);
// #CMOMN8 @TEXT("nr=8 lr=2u w=50n multi=1",key="value",size=0.9,halign="start") => @PLACE(307,30);
// #CMOMN8 @TEXT("",key="model");
// &"TOPN" @WIRE(mode="straight",linecolor="#226e85",linewidth=0.16) {(0,46) (38,46) (76,46) (114,46) (152,46) (190,46) (228,46) (266,46) (304,46)};
// &"TOPN" @WIRE(mode="straight",linecolor="#226e85",linewidth=0.16) {#CMOMN0:1 (0,46)};
// $JUNCTION @ATTACH (0,46);
// &"TOPN" @WIRE(mode="straight",linecolor="#226e85",linewidth=0.16) {#CMOMN1:1 (38,46)};
// $JUNCTION @ATTACH (38,46);
// &"TOPN" @WIRE(mode="straight",linecolor="#226e85",linewidth=0.16) {#CMOMN2:1 (76,46)};
// $JUNCTION @ATTACH (76,46);
// &"TOPN" @WIRE(mode="straight",linecolor="#226e85",linewidth=0.16) {#CMOMN3:1 (114,46)};
// $JUNCTION @ATTACH (114,46);
// &"TOPN" @WIRE(mode="straight",linecolor="#226e85",linewidth=0.16) {#CMOMN4:1 (152,46)};
// $JUNCTION @ATTACH (152,46);
// &"TOPN" @WIRE(mode="straight",linecolor="#226e85",linewidth=0.16) {#CMOMN5:1 (190,46)};
// $JUNCTION @ATTACH (190,46);
// &"TOPN" @WIRE(mode="straight",linecolor="#226e85",linewidth=0.16) {#CMOMN6:1 (228,46)};
// $JUNCTION @ATTACH (228,46);
// &"TOPN" @WIRE(mode="straight",linecolor="#226e85",linewidth=0.16) {#CMOMN7:1 (266,46)};
// $JUNCTION @ATTACH (266,46);
// &"TOPN" @WIRE(mode="straight",linecolor="#226e85",linewidth=0.16) {#CMOMN8:1 (304,46)};
// $JUNCTION @ATTACH (304,46);
// (-15,54) @TEXT("TOPN / negative bank",size=1.2,halign="start",textcolor="#223d52");
// (289,16) @TEXT("Dummy -> VREFN",size=1,halign="start",textcolor="#223d52");
// #CMOMP0 @SET-SYMBOL $CAPACITOR;
// #CMOMP0 @PLACE(0,-32) => @ORIENT("R0");
// #CMOMP0 @TEXT("CMOMP0",key="name",size=1.3,halign="start") => @PLACE(3,-29);
// #CMOMP0 @TEXT("nr=8 lr=2u w=50n multi=1",key="value",size=0.9,halign="start") => @PLACE(3,-36);
// #CMOMP0 @TEXT("",key="model");
// #XSP0 @SET-SYMBOL $S_sar8j_r1_sw_b0;
// #XSP0 @PLACE(0,-54) => @ORIENT("R0");
// &"BP0" @WIRE(mode="straight",linecolor="#30485d",linewidth=0.16) {#CMOMP0:2 (0,-34) (0,-42) #XSP0:1};
// #CMOMP1 @SET-SYMBOL $CAPACITOR;
// #CMOMP1 @PLACE(38,-32) => @ORIENT("R0");
// #CMOMP1 @TEXT("CMOMP1",key="name",size=1.3,halign="start") => @PLACE(41,-29);
// #CMOMP1 @TEXT("nr=8 lr=2u w=50n multi=2",key="value",size=0.9,halign="start") => @PLACE(41,-36);
// #CMOMP1 @TEXT("",key="model");
// #XSP1 @SET-SYMBOL $S_sar8j_r1_sw_b1;
// #XSP1 @PLACE(38,-54) => @ORIENT("R0");
// &"BP1" @WIRE(mode="straight",linecolor="#30485d",linewidth=0.16) {#CMOMP1:2 (38,-34) (38,-42) #XSP1:1};
// #CMOMP2 @SET-SYMBOL $CAPACITOR;
// #CMOMP2 @PLACE(76,-32) => @ORIENT("R0");
// #CMOMP2 @TEXT("CMOMP2",key="name",size=1.3,halign="start") => @PLACE(79,-29);
// #CMOMP2 @TEXT("nr=8 lr=2u w=50n multi=4",key="value",size=0.9,halign="start") => @PLACE(79,-36);
// #CMOMP2 @TEXT("",key="model");
// #XSP2 @SET-SYMBOL $S_sar8j_r1_sw_b2;
// #XSP2 @PLACE(76,-54) => @ORIENT("R0");
// &"BP2" @WIRE(mode="straight",linecolor="#30485d",linewidth=0.16) {#CMOMP2:2 (76,-34) (76,-42) #XSP2:1};
// #CMOMP3 @SET-SYMBOL $CAPACITOR;
// #CMOMP3 @PLACE(114,-32) => @ORIENT("R0");
// #CMOMP3 @TEXT("CMOMP3",key="name",size=1.3,halign="start") => @PLACE(117,-29);
// #CMOMP3 @TEXT("nr=8 lr=2u w=50n multi=8",key="value",size=0.9,halign="start") => @PLACE(117,-36);
// #CMOMP3 @TEXT("",key="model");
// #XSP3 @SET-SYMBOL $S_sar8j_r1_sw_b3;
// #XSP3 @PLACE(114,-54) => @ORIENT("R0");
// &"BP3" @WIRE(mode="straight",linecolor="#30485d",linewidth=0.16) {#CMOMP3:2 (114,-34) (114,-42) #XSP3:1};
// #CMOMP4 @SET-SYMBOL $CAPACITOR;
// #CMOMP4 @PLACE(152,-32) => @ORIENT("R0");
// #CMOMP4 @TEXT("CMOMP4",key="name",size=1.3,halign="start") => @PLACE(155,-29);
// #CMOMP4 @TEXT("nr=8 lr=2u w=50n multi=16",key="value",size=0.9,halign="start") => @PLACE(155,-36);
// #CMOMP4 @TEXT("",key="model");
// #XSP4 @SET-SYMBOL $S_sar8j_r1_sw_b4;
// #XSP4 @PLACE(152,-54) => @ORIENT("R0");
// &"BP4" @WIRE(mode="straight",linecolor="#30485d",linewidth=0.16) {#CMOMP4:2 (152,-34) (152,-42) #XSP4:1};
// #CMOMP5 @SET-SYMBOL $CAPACITOR;
// #CMOMP5 @PLACE(190,-32) => @ORIENT("R0");
// #CMOMP5 @TEXT("CMOMP5",key="name",size=1.3,halign="start") => @PLACE(193,-29);
// #CMOMP5 @TEXT("nr=8 lr=2u w=50n multi=32",key="value",size=0.9,halign="start") => @PLACE(193,-36);
// #CMOMP5 @TEXT("",key="model");
// #XSP5 @SET-SYMBOL $S_sar8j_r1_sw_b5;
// #XSP5 @PLACE(190,-54) => @ORIENT("R0");
// &"BP5" @WIRE(mode="straight",linecolor="#30485d",linewidth=0.16) {#CMOMP5:2 (190,-34) (190,-42) #XSP5:1};
// #CMOMP6 @SET-SYMBOL $CAPACITOR;
// #CMOMP6 @PLACE(228,-32) => @ORIENT("R0");
// #CMOMP6 @TEXT("CMOMP6",key="name",size=1.3,halign="start") => @PLACE(231,-29);
// #CMOMP6 @TEXT("nr=8 lr=2u w=50n multi=64",key="value",size=0.9,halign="start") => @PLACE(231,-36);
// #CMOMP6 @TEXT("",key="model");
// #XSP6 @SET-SYMBOL $S_sar8j_r1_sw_b6;
// #XSP6 @PLACE(228,-54) => @ORIENT("R0");
// &"BP6" @WIRE(mode="straight",linecolor="#30485d",linewidth=0.16) {#CMOMP6:2 (228,-34) (228,-42) #XSP6:1};
// #CMOMP7 @SET-SYMBOL $CAPACITOR;
// #CMOMP7 @PLACE(266,-32) => @ORIENT("R0");
// #CMOMP7 @TEXT("CMOMP7",key="name",size=1.3,halign="start") => @PLACE(269,-29);
// #CMOMP7 @TEXT("nr=8 lr=2u w=50n multi=128",key="value",size=0.9,halign="start") => @PLACE(269,-36);
// #CMOMP7 @TEXT("",key="model");
// #XSP7 @SET-SYMBOL $S_sar8j_r1_sw_b7;
// #XSP7 @PLACE(266,-54) => @ORIENT("R0");
// &"BP7" @WIRE(mode="straight",linecolor="#30485d",linewidth=0.16) {#CMOMP7:2 (266,-34) (266,-42) #XSP7:1};
// #CMOMP8 @SET-SYMBOL $CAPACITOR;
// #CMOMP8 @PLACE(304,-32) => @ORIENT("R0");
// #CMOMP8 @TEXT("CMOMP8",key="name",size=1.3,halign="start") => @PLACE(307,-29);
// #CMOMP8 @TEXT("nr=8 lr=2u w=50n multi=1",key="value",size=0.9,halign="start") => @PLACE(307,-36);
// #CMOMP8 @TEXT("",key="model");
// &"TOPP" @WIRE(mode="straight",linecolor="#226e85",linewidth=0.16) {(0,-20) (38,-20) (76,-20) (114,-20) (152,-20) (190,-20) (228,-20) (266,-20) (304,-20)};
// &"TOPP" @WIRE(mode="straight",linecolor="#226e85",linewidth=0.16) {#CMOMP0:1 (0,-20)};
// $JUNCTION @ATTACH (0,-20);
// &"TOPP" @WIRE(mode="straight",linecolor="#226e85",linewidth=0.16) {#CMOMP1:1 (38,-20)};
// $JUNCTION @ATTACH (38,-20);
// &"TOPP" @WIRE(mode="straight",linecolor="#226e85",linewidth=0.16) {#CMOMP2:1 (76,-20)};
// $JUNCTION @ATTACH (76,-20);
// &"TOPP" @WIRE(mode="straight",linecolor="#226e85",linewidth=0.16) {#CMOMP3:1 (114,-20)};
// $JUNCTION @ATTACH (114,-20);
// &"TOPP" @WIRE(mode="straight",linecolor="#226e85",linewidth=0.16) {#CMOMP4:1 (152,-20)};
// $JUNCTION @ATTACH (152,-20);
// &"TOPP" @WIRE(mode="straight",linecolor="#226e85",linewidth=0.16) {#CMOMP5:1 (190,-20)};
// $JUNCTION @ATTACH (190,-20);
// &"TOPP" @WIRE(mode="straight",linecolor="#226e85",linewidth=0.16) {#CMOMP6:1 (228,-20)};
// $JUNCTION @ATTACH (228,-20);
// &"TOPP" @WIRE(mode="straight",linecolor="#226e85",linewidth=0.16) {#CMOMP7:1 (266,-20)};
// $JUNCTION @ATTACH (266,-20);
// &"TOPP" @WIRE(mode="straight",linecolor="#226e85",linewidth=0.16) {#CMOMP8:1 (304,-20)};
// $JUNCTION @ATTACH (304,-20);
// (-15,-12) @TEXT("TOPP / positive bank",size=1.2,halign="start",textcolor="#223d52");
// (289,-50) @TEXT("Dummy -> VREFP",size=1,halign="start",textcolor="#223d52");
// &"VREFN" @WIRE(mode="straight",linecolor="#30485d",linewidth=0.16) {#CMOMN8:2 (304,29)};
// (304,28.6) @TEXT("VREFN",size=1.1,halign="middle",valign="top");
// &"VREFP" @WIRE(mode="straight",linecolor="#30485d",linewidth=0.16) {#CMOMP8:2 (304,-37)};
// (304,-37.4) @TEXT("VREFP",size=1.1,halign="middle",valign="top");
// &"GNN0" @WIRE(mode="straight",linecolor="#30485d",linewidth=0.16) {#XSN0:2 (-5,-3)};
// (-5,-3.4) @TEXT("GNN0",size=1.1,halign="middle",valign="top");
// &"GNP0" @WIRE(mode="straight",linecolor="#30485d",linewidth=0.16) {#XSN0:3 (5,-3)};
// (5,-3.4) @TEXT("GNP0",size=1.1,halign="middle",valign="top");
// &"VDD" @WIRE(mode="straight",linecolor="#30485d",linewidth=0.16) {#XSN0:4 (14,16)};
// (14.4,16) @TEXT("VDD",size=1.1,halign="start",valign="middle");
// &"VREFN" @WIRE(mode="straight",linecolor="#30485d",linewidth=0.16) {#XSN0:5 (-14,8)};
// (-14.4,8) @TEXT("VREFN",size=1.1,halign="end",valign="middle");
// &"VREFP" @WIRE(mode="straight",linecolor="#30485d",linewidth=0.16) {#XSN0:6 (-14,16)};
// (-14.4,16) @TEXT("VREFP",size=1.1,halign="end",valign="middle");
// &"VSS" @WIRE(mode="straight",linecolor="#30485d",linewidth=0.16) {#XSN0:7 (14,8)};
// (14.4,8) @TEXT("VSS",size=1.1,halign="start",valign="middle");
// &"GPN0" @WIRE(mode="straight",linecolor="#30485d",linewidth=0.16) {#XSP0:2 (-5,-69)};
// (-5,-69.4) @TEXT("GPN0",size=1.1,halign="middle",valign="top");
// &"GPP0" @WIRE(mode="straight",linecolor="#30485d",linewidth=0.16) {#XSP0:3 (5,-69)};
// (5,-69.4) @TEXT("GPP0",size=1.1,halign="middle",valign="top");
// &"VDD" @WIRE(mode="straight",linecolor="#30485d",linewidth=0.16) {#XSP0:4 (14,-50)};
// (14.4,-50) @TEXT("VDD",size=1.1,halign="start",valign="middle");
// &"VREFN" @WIRE(mode="straight",linecolor="#30485d",linewidth=0.16) {#XSP0:5 (-14,-58)};
// (-14.4,-58) @TEXT("VREFN",size=1.1,halign="end",valign="middle");
// &"VREFP" @WIRE(mode="straight",linecolor="#30485d",linewidth=0.16) {#XSP0:6 (-14,-50)};
// (-14.4,-50) @TEXT("VREFP",size=1.1,halign="end",valign="middle");
// &"VSS" @WIRE(mode="straight",linecolor="#30485d",linewidth=0.16) {#XSP0:7 (14,-58)};
// (14.4,-58) @TEXT("VSS",size=1.1,halign="start",valign="middle");
// &"GNN1" @WIRE(mode="straight",linecolor="#30485d",linewidth=0.16) {#XSN1:2 (33,-3)};
// (33,-3.4) @TEXT("GNN1",size=1.1,halign="middle",valign="top");
// &"GNP1" @WIRE(mode="straight",linecolor="#30485d",linewidth=0.16) {#XSN1:3 (43,-3)};
// (43,-3.4) @TEXT("GNP1",size=1.1,halign="middle",valign="top");
// &"VDD" @WIRE(mode="straight",linecolor="#30485d",linewidth=0.16) {#XSN1:4 (52,16)};
// (52.4,16) @TEXT("VDD",size=1.1,halign="start",valign="middle");
// &"VREFN" @WIRE(mode="straight",linecolor="#30485d",linewidth=0.16) {#XSN1:5 (24,8)};
// (23.6,8) @TEXT("VREFN",size=1.1,halign="end",valign="middle");
// &"VREFP" @WIRE(mode="straight",linecolor="#30485d",linewidth=0.16) {#XSN1:6 (24,16)};
// (23.6,16) @TEXT("VREFP",size=1.1,halign="end",valign="middle");
// &"VSS" @WIRE(mode="straight",linecolor="#30485d",linewidth=0.16) {#XSN1:7 (52,8)};
// (52.4,8) @TEXT("VSS",size=1.1,halign="start",valign="middle");
// &"GPN1" @WIRE(mode="straight",linecolor="#30485d",linewidth=0.16) {#XSP1:2 (33,-69)};
// (33,-69.4) @TEXT("GPN1",size=1.1,halign="middle",valign="top");
// &"GPP1" @WIRE(mode="straight",linecolor="#30485d",linewidth=0.16) {#XSP1:3 (43,-69)};
// (43,-69.4) @TEXT("GPP1",size=1.1,halign="middle",valign="top");
// &"VDD" @WIRE(mode="straight",linecolor="#30485d",linewidth=0.16) {#XSP1:4 (52,-50)};
// (52.4,-50) @TEXT("VDD",size=1.1,halign="start",valign="middle");
// &"VREFN" @WIRE(mode="straight",linecolor="#30485d",linewidth=0.16) {#XSP1:5 (24,-58)};
// (23.6,-58) @TEXT("VREFN",size=1.1,halign="end",valign="middle");
// &"VREFP" @WIRE(mode="straight",linecolor="#30485d",linewidth=0.16) {#XSP1:6 (24,-50)};
// (23.6,-50) @TEXT("VREFP",size=1.1,halign="end",valign="middle");
// &"VSS" @WIRE(mode="straight",linecolor="#30485d",linewidth=0.16) {#XSP1:7 (52,-58)};
// (52.4,-58) @TEXT("VSS",size=1.1,halign="start",valign="middle");
// &"GNN2" @WIRE(mode="straight",linecolor="#30485d",linewidth=0.16) {#XSN2:2 (71,-3)};
// (71,-3.4) @TEXT("GNN2",size=1.1,halign="middle",valign="top");
// &"GNP2" @WIRE(mode="straight",linecolor="#30485d",linewidth=0.16) {#XSN2:3 (81,-3)};
// (81,-3.4) @TEXT("GNP2",size=1.1,halign="middle",valign="top");
// &"VDD" @WIRE(mode="straight",linecolor="#30485d",linewidth=0.16) {#XSN2:4 (90,16)};
// (90.4,16) @TEXT("VDD",size=1.1,halign="start",valign="middle");
// &"VREFN" @WIRE(mode="straight",linecolor="#30485d",linewidth=0.16) {#XSN2:5 (62,8)};
// (61.6,8) @TEXT("VREFN",size=1.1,halign="end",valign="middle");
// &"VREFP" @WIRE(mode="straight",linecolor="#30485d",linewidth=0.16) {#XSN2:6 (62,16)};
// (61.6,16) @TEXT("VREFP",size=1.1,halign="end",valign="middle");
// &"VSS" @WIRE(mode="straight",linecolor="#30485d",linewidth=0.16) {#XSN2:7 (90,8)};
// (90.4,8) @TEXT("VSS",size=1.1,halign="start",valign="middle");
// &"GPN2" @WIRE(mode="straight",linecolor="#30485d",linewidth=0.16) {#XSP2:2 (71,-69)};
// (71,-69.4) @TEXT("GPN2",size=1.1,halign="middle",valign="top");
// &"GPP2" @WIRE(mode="straight",linecolor="#30485d",linewidth=0.16) {#XSP2:3 (81,-69)};
// (81,-69.4) @TEXT("GPP2",size=1.1,halign="middle",valign="top");
// &"VDD" @WIRE(mode="straight",linecolor="#30485d",linewidth=0.16) {#XSP2:4 (90,-50)};
// (90.4,-50) @TEXT("VDD",size=1.1,halign="start",valign="middle");
// &"VREFN" @WIRE(mode="straight",linecolor="#30485d",linewidth=0.16) {#XSP2:5 (62,-58)};
// (61.6,-58) @TEXT("VREFN",size=1.1,halign="end",valign="middle");
// &"VREFP" @WIRE(mode="straight",linecolor="#30485d",linewidth=0.16) {#XSP2:6 (62,-50)};
// (61.6,-50) @TEXT("VREFP",size=1.1,halign="end",valign="middle");
// &"VSS" @WIRE(mode="straight",linecolor="#30485d",linewidth=0.16) {#XSP2:7 (90,-58)};
// (90.4,-58) @TEXT("VSS",size=1.1,halign="start",valign="middle");
// &"GNN3" @WIRE(mode="straight",linecolor="#30485d",linewidth=0.16) {#XSN3:2 (109,-3)};
// (109,-3.4) @TEXT("GNN3",size=1.1,halign="middle",valign="top");
// &"GNP3" @WIRE(mode="straight",linecolor="#30485d",linewidth=0.16) {#XSN3:3 (119,-3)};
// (119,-3.4) @TEXT("GNP3",size=1.1,halign="middle",valign="top");
// &"VDD" @WIRE(mode="straight",linecolor="#30485d",linewidth=0.16) {#XSN3:4 (128,16)};
// (128.4,16) @TEXT("VDD",size=1.1,halign="start",valign="middle");
// &"VREFN" @WIRE(mode="straight",linecolor="#30485d",linewidth=0.16) {#XSN3:5 (100,8)};
// (99.6,8) @TEXT("VREFN",size=1.1,halign="end",valign="middle");
// &"VREFP" @WIRE(mode="straight",linecolor="#30485d",linewidth=0.16) {#XSN3:6 (100,16)};
// (99.6,16) @TEXT("VREFP",size=1.1,halign="end",valign="middle");
// &"VSS" @WIRE(mode="straight",linecolor="#30485d",linewidth=0.16) {#XSN3:7 (128,8)};
// (128.4,8) @TEXT("VSS",size=1.1,halign="start",valign="middle");
// &"GPN3" @WIRE(mode="straight",linecolor="#30485d",linewidth=0.16) {#XSP3:2 (109,-69)};
// (109,-69.4) @TEXT("GPN3",size=1.1,halign="middle",valign="top");
// &"GPP3" @WIRE(mode="straight",linecolor="#30485d",linewidth=0.16) {#XSP3:3 (119,-69)};
// (119,-69.4) @TEXT("GPP3",size=1.1,halign="middle",valign="top");
// &"VDD" @WIRE(mode="straight",linecolor="#30485d",linewidth=0.16) {#XSP3:4 (128,-50)};
// (128.4,-50) @TEXT("VDD",size=1.1,halign="start",valign="middle");
// &"VREFN" @WIRE(mode="straight",linecolor="#30485d",linewidth=0.16) {#XSP3:5 (100,-58)};
// (99.6,-58) @TEXT("VREFN",size=1.1,halign="end",valign="middle");
// &"VREFP" @WIRE(mode="straight",linecolor="#30485d",linewidth=0.16) {#XSP3:6 (100,-50)};
// (99.6,-50) @TEXT("VREFP",size=1.1,halign="end",valign="middle");
// &"VSS" @WIRE(mode="straight",linecolor="#30485d",linewidth=0.16) {#XSP3:7 (128,-58)};
// (128.4,-58) @TEXT("VSS",size=1.1,halign="start",valign="middle");
// &"GNN4" @WIRE(mode="straight",linecolor="#30485d",linewidth=0.16) {#XSN4:2 (147,-3)};
// (147,-3.4) @TEXT("GNN4",size=1.1,halign="middle",valign="top");
// &"GNP4" @WIRE(mode="straight",linecolor="#30485d",linewidth=0.16) {#XSN4:3 (157,-3)};
// (157,-3.4) @TEXT("GNP4",size=1.1,halign="middle",valign="top");
// &"VDD" @WIRE(mode="straight",linecolor="#30485d",linewidth=0.16) {#XSN4:4 (166,16)};
// (166.4,16) @TEXT("VDD",size=1.1,halign="start",valign="middle");
// &"VREFN" @WIRE(mode="straight",linecolor="#30485d",linewidth=0.16) {#XSN4:5 (138,8)};
// (137.6,8) @TEXT("VREFN",size=1.1,halign="end",valign="middle");
// &"VREFP" @WIRE(mode="straight",linecolor="#30485d",linewidth=0.16) {#XSN4:6 (138,16)};
// (137.6,16) @TEXT("VREFP",size=1.1,halign="end",valign="middle");
// &"VSS" @WIRE(mode="straight",linecolor="#30485d",linewidth=0.16) {#XSN4:7 (166,8)};
// (166.4,8) @TEXT("VSS",size=1.1,halign="start",valign="middle");
// &"GPN4" @WIRE(mode="straight",linecolor="#30485d",linewidth=0.16) {#XSP4:2 (147,-69)};
// (147,-69.4) @TEXT("GPN4",size=1.1,halign="middle",valign="top");
// &"GPP4" @WIRE(mode="straight",linecolor="#30485d",linewidth=0.16) {#XSP4:3 (157,-69)};
// (157,-69.4) @TEXT("GPP4",size=1.1,halign="middle",valign="top");
// &"VDD" @WIRE(mode="straight",linecolor="#30485d",linewidth=0.16) {#XSP4:4 (166,-50)};
// (166.4,-50) @TEXT("VDD",size=1.1,halign="start",valign="middle");
// &"VREFN" @WIRE(mode="straight",linecolor="#30485d",linewidth=0.16) {#XSP4:5 (138,-58)};
// (137.6,-58) @TEXT("VREFN",size=1.1,halign="end",valign="middle");
// &"VREFP" @WIRE(mode="straight",linecolor="#30485d",linewidth=0.16) {#XSP4:6 (138,-50)};
// (137.6,-50) @TEXT("VREFP",size=1.1,halign="end",valign="middle");
// &"VSS" @WIRE(mode="straight",linecolor="#30485d",linewidth=0.16) {#XSP4:7 (166,-58)};
// (166.4,-58) @TEXT("VSS",size=1.1,halign="start",valign="middle");
// &"GNN5" @WIRE(mode="straight",linecolor="#30485d",linewidth=0.16) {#XSN5:2 (185,-3)};
// (185,-3.4) @TEXT("GNN5",size=1.1,halign="middle",valign="top");
// &"GNP5" @WIRE(mode="straight",linecolor="#30485d",linewidth=0.16) {#XSN5:3 (195,-3)};
// (195,-3.4) @TEXT("GNP5",size=1.1,halign="middle",valign="top");
// &"VDD" @WIRE(mode="straight",linecolor="#30485d",linewidth=0.16) {#XSN5:4 (204,16)};
// (204.4,16) @TEXT("VDD",size=1.1,halign="start",valign="middle");
// &"VREFN" @WIRE(mode="straight",linecolor="#30485d",linewidth=0.16) {#XSN5:5 (176,8)};
// (175.6,8) @TEXT("VREFN",size=1.1,halign="end",valign="middle");
// &"VREFP" @WIRE(mode="straight",linecolor="#30485d",linewidth=0.16) {#XSN5:6 (176,16)};
// (175.6,16) @TEXT("VREFP",size=1.1,halign="end",valign="middle");
// &"VSS" @WIRE(mode="straight",linecolor="#30485d",linewidth=0.16) {#XSN5:7 (204,8)};
// (204.4,8) @TEXT("VSS",size=1.1,halign="start",valign="middle");
// &"GPN5" @WIRE(mode="straight",linecolor="#30485d",linewidth=0.16) {#XSP5:2 (185,-69)};
// (185,-69.4) @TEXT("GPN5",size=1.1,halign="middle",valign="top");
// &"GPP5" @WIRE(mode="straight",linecolor="#30485d",linewidth=0.16) {#XSP5:3 (195,-69)};
// (195,-69.4) @TEXT("GPP5",size=1.1,halign="middle",valign="top");
// &"VDD" @WIRE(mode="straight",linecolor="#30485d",linewidth=0.16) {#XSP5:4 (204,-50)};
// (204.4,-50) @TEXT("VDD",size=1.1,halign="start",valign="middle");
// &"VREFN" @WIRE(mode="straight",linecolor="#30485d",linewidth=0.16) {#XSP5:5 (176,-58)};
// (175.6,-58) @TEXT("VREFN",size=1.1,halign="end",valign="middle");
// &"VREFP" @WIRE(mode="straight",linecolor="#30485d",linewidth=0.16) {#XSP5:6 (176,-50)};
// (175.6,-50) @TEXT("VREFP",size=1.1,halign="end",valign="middle");
// &"VSS" @WIRE(mode="straight",linecolor="#30485d",linewidth=0.16) {#XSP5:7 (204,-58)};
// (204.4,-58) @TEXT("VSS",size=1.1,halign="start",valign="middle");
// &"GNN6" @WIRE(mode="straight",linecolor="#30485d",linewidth=0.16) {#XSN6:2 (223,-3)};
// (223,-3.4) @TEXT("GNN6",size=1.1,halign="middle",valign="top");
// &"GNP6" @WIRE(mode="straight",linecolor="#30485d",linewidth=0.16) {#XSN6:3 (233,-3)};
// (233,-3.4) @TEXT("GNP6",size=1.1,halign="middle",valign="top");
// &"VDD" @WIRE(mode="straight",linecolor="#30485d",linewidth=0.16) {#XSN6:4 (242,16)};
// (242.4,16) @TEXT("VDD",size=1.1,halign="start",valign="middle");
// &"VREFN" @WIRE(mode="straight",linecolor="#30485d",linewidth=0.16) {#XSN6:5 (214,8)};
// (213.6,8) @TEXT("VREFN",size=1.1,halign="end",valign="middle");
// &"VREFP" @WIRE(mode="straight",linecolor="#30485d",linewidth=0.16) {#XSN6:6 (214,16)};
// (213.6,16) @TEXT("VREFP",size=1.1,halign="end",valign="middle");
// &"VSS" @WIRE(mode="straight",linecolor="#30485d",linewidth=0.16) {#XSN6:7 (242,8)};
// (242.4,8) @TEXT("VSS",size=1.1,halign="start",valign="middle");
// &"GPN6" @WIRE(mode="straight",linecolor="#30485d",linewidth=0.16) {#XSP6:2 (223,-69)};
// (223,-69.4) @TEXT("GPN6",size=1.1,halign="middle",valign="top");
// &"GPP6" @WIRE(mode="straight",linecolor="#30485d",linewidth=0.16) {#XSP6:3 (233,-69)};
// (233,-69.4) @TEXT("GPP6",size=1.1,halign="middle",valign="top");
// &"VDD" @WIRE(mode="straight",linecolor="#30485d",linewidth=0.16) {#XSP6:4 (242,-50)};
// (242.4,-50) @TEXT("VDD",size=1.1,halign="start",valign="middle");
// &"VREFN" @WIRE(mode="straight",linecolor="#30485d",linewidth=0.16) {#XSP6:5 (214,-58)};
// (213.6,-58) @TEXT("VREFN",size=1.1,halign="end",valign="middle");
// &"VREFP" @WIRE(mode="straight",linecolor="#30485d",linewidth=0.16) {#XSP6:6 (214,-50)};
// (213.6,-50) @TEXT("VREFP",size=1.1,halign="end",valign="middle");
// &"VSS" @WIRE(mode="straight",linecolor="#30485d",linewidth=0.16) {#XSP6:7 (242,-58)};
// (242.4,-58) @TEXT("VSS",size=1.1,halign="start",valign="middle");
// &"GNN7" @WIRE(mode="straight",linecolor="#30485d",linewidth=0.16) {#XSN7:2 (261,-3)};
// (261,-3.4) @TEXT("GNN7",size=1.1,halign="middle",valign="top");
// &"GNP7" @WIRE(mode="straight",linecolor="#30485d",linewidth=0.16) {#XSN7:3 (271,-3)};
// (271,-3.4) @TEXT("GNP7",size=1.1,halign="middle",valign="top");
// &"VDD" @WIRE(mode="straight",linecolor="#30485d",linewidth=0.16) {#XSN7:4 (280,16)};
// (280.4,16) @TEXT("VDD",size=1.1,halign="start",valign="middle");
// &"VREFN" @WIRE(mode="straight",linecolor="#30485d",linewidth=0.16) {#XSN7:5 (252,8)};
// (251.6,8) @TEXT("VREFN",size=1.1,halign="end",valign="middle");
// &"VREFP" @WIRE(mode="straight",linecolor="#30485d",linewidth=0.16) {#XSN7:6 (252,16)};
// (251.6,16) @TEXT("VREFP",size=1.1,halign="end",valign="middle");
// &"VSS" @WIRE(mode="straight",linecolor="#30485d",linewidth=0.16) {#XSN7:7 (280,8)};
// (280.4,8) @TEXT("VSS",size=1.1,halign="start",valign="middle");
// &"GPN7" @WIRE(mode="straight",linecolor="#30485d",linewidth=0.16) {#XSP7:2 (261,-69)};
// (261,-69.4) @TEXT("GPN7",size=1.1,halign="middle",valign="top");
// &"GPP7" @WIRE(mode="straight",linecolor="#30485d",linewidth=0.16) {#XSP7:3 (271,-69)};
// (271,-69.4) @TEXT("GPP7",size=1.1,halign="middle",valign="top");
// &"VDD" @WIRE(mode="straight",linecolor="#30485d",linewidth=0.16) {#XSP7:4 (280,-50)};
// (280.4,-50) @TEXT("VDD",size=1.1,halign="start",valign="middle");
// &"VREFN" @WIRE(mode="straight",linecolor="#30485d",linewidth=0.16) {#XSP7:5 (252,-58)};
// (251.6,-58) @TEXT("VREFN",size=1.1,halign="end",valign="middle");
// &"VREFP" @WIRE(mode="straight",linecolor="#30485d",linewidth=0.16) {#XSP7:6 (252,-50)};
// (251.6,-50) @TEXT("VREFP",size=1.1,halign="end",valign="middle");
// &"VSS" @WIRE(mode="straight",linecolor="#30485d",linewidth=0.16) {#XSP7:7 (280,-58)};
// (280.4,-58) @TEXT("VSS",size=1.1,halign="start",valign="middle");
// }
// END SARADC RNL
ends sar8j_r1_cdac

subckt sar_strongarm_t28 CLK OUTN OUTP VDD VINN VINP VSS
    MNLATN (OUTN OUTP Y VSS) nch_mac l=30n w=500n multi=1 nf=1 sd=100n          ad=3.75e-14 as=3.75e-14 pd=1.15u ps=1.15u nrd=0.662935          nrs=0.662935 sa=75.0n sb=75.0n sa1=75.0n sa2=75.0n sa3=75.0n          sa4=75.0n sb1=75.0n sb2=75.0n sb3=75.0n spa=100n spa1=100n          spa2=100n spa3=100n sap=91.9776n sapb=114.444n spba=115.715n          spba1=117.043n dfm_flag=0 spmt=1.11111e+15 spomt=0          spomt1=1.11111e+60 spmb=1.11111e+15 spomb=0 spomb1=1.11111e+60
    MNLATP (OUTP OUTN X VSS) nch_mac l=30n w=500n multi=1 nf=1 sd=100n          ad=3.75e-14 as=3.75e-14 pd=1.15u ps=1.15u nrd=0.662935          nrs=0.662935 sa=75.0n sb=75.0n sa1=75.0n sa2=75.0n sa3=75.0n          sa4=75.0n sb1=75.0n sb2=75.0n sb3=75.0n spa=100n spa1=100n          spa2=100n spa3=100n sap=91.9776n sapb=114.444n spba=115.715n          spba1=117.043n dfm_flag=0 spmt=1.11111e+15 spomt=0          spomt1=1.11111e+60 spmb=1.11111e+15 spomb=0 spomb1=1.11111e+60
    MNINN (X VINN TAIL VSS) nch_mac l=30n w=1u multi=1 nf=1 sd=100n          ad=7.5e-14 as=7.5e-14 pd=2.15u ps=2.15u nrd=0.289519 nrs=0.289519          sa=75.0n sb=75.0n sa1=75.0n sa2=75.0n sa3=75.0n sa4=75.0n          sb1=75.0n sb2=75.0n sb3=75.0n spa=100n spa1=100n spa2=100n          spa3=100n sap=91.9776n sapb=114.444n spba=115.715n spba1=117.043n          dfm_flag=0 spmt=1.11111e+15 spomt=0 spomt1=1.11111e+60          spmb=1.11111e+15 spomb=0 spomb1=1.11111e+60
    MNINP (Y VINP TAIL VSS) nch_mac l=30n w=1u multi=1 nf=1 sd=100n          ad=7.5e-14 as=7.5e-14 pd=2.15u ps=2.15u nrd=0.289519 nrs=0.289519          sa=75.0n sb=75.0n sa1=75.0n sa2=75.0n sa3=75.0n sa4=75.0n          sb1=75.0n sb2=75.0n sb3=75.0n spa=100n spa1=100n spa2=100n          spa3=100n sap=91.9776n sapb=114.444n spba=115.715n spba1=117.043n          dfm_flag=0 spmt=1.11111e+15 spomt=0 spomt1=1.11111e+60          spmb=1.11111e+15 spomb=0 spomb1=1.11111e+60
    MNTAIL (TAIL CLK VSS VSS) nch_mac l=30n w=1u multi=1 nf=1 sd=100n          ad=7.5e-14 as=7.5e-14 pd=2.15u ps=2.15u nrd=0.289519 nrs=0.289519          sa=75.0n sb=75.0n sa1=75.0n sa2=75.0n sa3=75.0n sa4=75.0n          sb1=75.0n sb2=75.0n sb3=75.0n spa=100n spa1=100n spa2=100n          spa3=100n sap=91.9776n sapb=114.444n spba=115.715n spba1=117.043n          dfm_flag=0 spmt=1.11111e+15 spomt=0 spomt1=1.11111e+60          spmb=1.11111e+15 spomb=0 spomb1=1.11111e+60
    MPRSTN (OUTN CLK VDD VDD) pch_mac l=30n w=500n multi=1 nf=1 sd=100n          ad=3.75e-14 as=3.75e-14 pd=1.15u ps=1.15u nrd=0.383209          nrs=0.383209 sa=75.0n sb=75.0n sa1=75.0n sa2=75.0n sa3=75.0n          sa4=75.0n sb1=75.0n sb2=75.0n sb3=75.0n spa=100n spa1=100n          spa2=100n spa3=100n sap=91.9776n sapb=114.444n spba=115.715n          spba1=117.043n dfm_flag=0 spmt=1.11111e+15 spomt=0          spomt1=1.11111e+60 spmb=1.11111e+15 spomb=0 spomb1=1.11111e+60
    MPRSTP (OUTP CLK VDD VDD) pch_mac l=30n w=500n multi=1 nf=1 sd=100n          ad=3.75e-14 as=3.75e-14 pd=1.15u ps=1.15u nrd=0.383209          nrs=0.383209 sa=75.0n sb=75.0n sa1=75.0n sa2=75.0n sa3=75.0n          sa4=75.0n sb1=75.0n sb2=75.0n sb3=75.0n spa=100n spa1=100n          spa2=100n spa3=100n sap=91.9776n sapb=114.444n spba=115.715n          spba1=117.043n dfm_flag=0 spmt=1.11111e+15 spomt=0          spomt1=1.11111e+60 spmb=1.11111e+15 spomb=0 spomb1=1.11111e+60
    MPRSTY (Y CLK VDD VDD) pch_mac l=30n w=500n multi=1 nf=1 sd=100n          ad=3.75e-14 as=3.75e-14 pd=1.15u ps=1.15u nrd=0.383209          nrs=0.383209 sa=75.0n sb=75.0n sa1=75.0n sa2=75.0n sa3=75.0n          sa4=75.0n sb1=75.0n sb2=75.0n sb3=75.0n spa=100n spa1=100n          spa2=100n spa3=100n sap=91.9776n sapb=114.444n spba=115.715n          spba1=117.043n dfm_flag=0 spmt=1.11111e+15 spomt=0          spomt1=1.11111e+60 spmb=1.11111e+15 spomb=0 spomb1=1.11111e+60
    MPRSTX (X CLK VDD VDD) pch_mac l=30n w=500n multi=1 nf=1 sd=100n          ad=3.75e-14 as=3.75e-14 pd=1.15u ps=1.15u nrd=0.383209          nrs=0.383209 sa=75.0n sb=75.0n sa1=75.0n sa2=75.0n sa3=75.0n          sa4=75.0n sb1=75.0n sb2=75.0n sb3=75.0n spa=100n spa1=100n          spa2=100n spa3=100n sap=91.9776n sapb=114.444n spba=115.715n          spba1=117.043n dfm_flag=0 spmt=1.11111e+15 spomt=0          spomt1=1.11111e+60 spmb=1.11111e+15 spomb=0 spomb1=1.11111e+60
    MPLATN (OUTN OUTP VDD VDD) pch_mac l=30n w=500n multi=1 nf=1 sd=100n          ad=3.75e-14 as=3.75e-14 pd=1.15u ps=1.15u nrd=0.383209          nrs=0.383209 sa=75.0n sb=75.0n sa1=75.0n sa2=75.0n sa3=75.0n          sa4=75.0n sb1=75.0n sb2=75.0n sb3=75.0n spa=100n spa1=100n          spa2=100n spa3=100n sap=91.9776n sapb=114.444n spba=115.715n          spba1=117.043n dfm_flag=0 spmt=1.11111e+15 spomt=0          spomt1=1.11111e+60 spmb=1.11111e+15 spomb=0 spomb1=1.11111e+60
    MPLATP (OUTP OUTN VDD VDD) pch_mac l=30n w=500n multi=1 nf=1 sd=100n          ad=3.75e-14 as=3.75e-14 pd=1.15u ps=1.15u nrd=0.383209          nrs=0.383209 sa=75.0n sb=75.0n sa1=75.0n sa2=75.0n sa3=75.0n          sa4=75.0n sb1=75.0n sb2=75.0n sb3=75.0n spa=100n spa1=100n          spa2=100n spa3=100n sap=91.9776n sapb=114.444n spba=115.715n          spba1=117.043n dfm_flag=0 spmt=1.11111e+15 spomt=0          spomt1=1.11111e+60 spmb=1.11111e+15 spomb=0 spomb1=1.11111e+60
// BEGIN SARADC RNL
// @RNL(author="saradc topology") {
// (-48,68) @TEXT("StrongARM  /  differential latch",size=1.7,halign="start",textcolor="#223d52");
// #MPLATN @SET-SYMBOL $PMOS_4TERM;
// #MPLATN @PLACE(-20,42) => @ORIENT("MY");
// #MPLATN @TEXT("MPLATN",key="name",size=1.3,halign="start") => @PLACE(-17,45);
// #MPLATN @TEXT("l=30n w=500n multi=1",key="value",size=0.9,halign="start") => @PLACE(-17,38);
// #MPLATN @TEXT("",key="model");
// #MPLATP @SET-SYMBOL $PMOS_4TERM;
// #MPLATP @PLACE(20,42) => @ORIENT("R0");
// #MPLATP @TEXT("MPLATP",key="name",size=1.3,halign="start") => @PLACE(23,45);
// #MPLATP @TEXT("l=30n w=500n multi=1",key="value",size=0.9,halign="start") => @PLACE(23,38);
// #MPLATP @TEXT("",key="model");
// #MNLATN @SET-SYMBOL $NMOS_4TERM;
// #MNLATN @PLACE(-20,20) => @ORIENT("MY");
// #MNLATN @TEXT("MNLATN",key="name",size=1.3,halign="start") => @PLACE(-17,23);
// #MNLATN @TEXT("l=30n w=500n multi=1",key="value",size=0.9,halign="start") => @PLACE(-17,16);
// #MNLATN @TEXT("",key="model");
// #MNLATP @SET-SYMBOL $NMOS_4TERM;
// #MNLATP @PLACE(20,20) => @ORIENT("R0");
// #MNLATP @TEXT("MNLATP",key="name",size=1.3,halign="start") => @PLACE(23,23);
// #MNLATP @TEXT("l=30n w=500n multi=1",key="value",size=0.9,halign="start") => @PLACE(23,16);
// #MNLATP @TEXT("",key="model");
// #MNINP @SET-SYMBOL $NMOS_4TERM;
// #MNINP @PLACE(-20,-5) => @ORIENT("R0");
// #MNINP @TEXT("MNINP",key="name",size=1.3,halign="start") => @PLACE(-17,-2);
// #MNINP @TEXT("l=30n w=1u multi=1",key="value",size=0.9,halign="start") => @PLACE(-17,-9);
// #MNINP @TEXT("",key="model");
// #MNINN @SET-SYMBOL $NMOS_4TERM;
// #MNINN @PLACE(20,-5) => @ORIENT("MY");
// #MNINN @TEXT("MNINN",key="name",size=1.3,halign="start") => @PLACE(23,-2);
// #MNINN @TEXT("l=30n w=1u multi=1",key="value",size=0.9,halign="start") => @PLACE(23,-9);
// #MNINN @TEXT("",key="model");
// #MNTAIL @SET-SYMBOL $NMOS_4TERM;
// #MNTAIL @PLACE(0,-30) => @ORIENT("R0");
// #MNTAIL @TEXT("MNTAIL",key="name",size=1.3,halign="start") => @PLACE(3,-27);
// #MNTAIL @TEXT("l=30n w=1u multi=1",key="value",size=0.9,halign="start") => @PLACE(3,-34);
// #MNTAIL @TEXT("",key="model");
// #MPRSTN @SET-SYMBOL $PMOS_4TERM;
// #MPRSTN @PLACE(-42,42) => @ORIENT("R0");
// #MPRSTN @TEXT("MPRSTN",key="name",size=1.3,halign="start") => @PLACE(-39,45);
// #MPRSTN @TEXT("l=30n w=500n multi=1",key="value",size=0.9,halign="start") => @PLACE(-39,38);
// #MPRSTN @TEXT("",key="model");
// #MPRSTP @SET-SYMBOL $PMOS_4TERM;
// #MPRSTP @PLACE(42,42) => @ORIENT("MY");
// #MPRSTP @TEXT("MPRSTP",key="name",size=1.3,halign="start") => @PLACE(45,45);
// #MPRSTP @TEXT("l=30n w=500n multi=1",key="value",size=0.9,halign="start") => @PLACE(45,38);
// #MPRSTP @TEXT("",key="model");
// #MPRSTY @SET-SYMBOL $PMOS_4TERM;
// #MPRSTY @PLACE(-42,10) => @ORIENT("R0");
// #MPRSTY @TEXT("MPRSTY",key="name",size=1.3,halign="start") => @PLACE(-39,13);
// #MPRSTY @TEXT("l=30n w=500n multi=1",key="value",size=0.9,halign="start") => @PLACE(-39,6);
// #MPRSTY @TEXT("",key="model");
// #MPRSTX @SET-SYMBOL $PMOS_4TERM;
// #MPRSTX @PLACE(42,10) => @ORIENT("MY");
// #MPRSTX @TEXT("MPRSTX",key="name",size=1.3,halign="start") => @PLACE(45,13);
// #MPRSTX @TEXT("l=30n w=500n multi=1",key="value",size=0.9,halign="start") => @PLACE(45,6);
// #MPRSTX @TEXT("",key="model");
// &"VDD" @WIRE(mode="straight",linecolor="#647584",linewidth=0.16) {(-42,61) (-20,61) (20,61) (42,61)};
// &"VDD" @WIRE(mode="straight",linecolor="#647584",linewidth=0.16) {#MPLATN:3 (-20,61)};
// $JUNCTION @ATTACH (-20,61);
// &"VDD" @WIRE(mode="straight",linecolor="#647584",linewidth=0.16) {#MPLATP:3 (20,61)};
// $JUNCTION @ATTACH (20,61);
// &"VDD" @WIRE(mode="straight",linecolor="#647584",linewidth=0.16) {#MPRSTN:3 (-42,61)};
// $JUNCTION @ATTACH (-42,61);
// &"VDD" @WIRE(mode="straight",linecolor="#647584",linewidth=0.16) {#MPRSTP:3 (42,61)};
// $JUNCTION @ATTACH (42,61);
// &"VDD" @WIRE(mode="straight",linecolor="#647584",linewidth=0.16) {#MPRSTY:3 (-42,15) (-55,15) (-55,61) (-42,61)};
// &"VDD" @WIRE(mode="straight",linecolor="#647584",linewidth=0.16) {#MPRSTX:3 (42,15) (55,15) (55,61) (42,61)};
// &"OUTN" @WIRE(mode="straight",linecolor="#226e85",linewidth=0.16) {(-42,31) (-20,31)};
// &"OUTN" @WIRE(mode="straight",linecolor="#226e85",linewidth=0.16) {#MPLATN:1 (-20,31)};
// $JUNCTION @ATTACH (-20,31);
// &"OUTN" @WIRE(mode="straight",linecolor="#226e85",linewidth=0.16) {#MNLATN:1 (-20,31)};
// $JUNCTION @ATTACH (-20,31);
// &"OUTN" @WIRE(mode="straight",linecolor="#226e85",linewidth=0.16) {#MPRSTN:1 (-42,31)};
// $JUNCTION @ATTACH (-42,31);
// &"OUTP" @WIRE(mode="straight",linecolor="#226e85",linewidth=0.16) {(20,33) (42,33)};
// &"OUTP" @WIRE(mode="straight",linecolor="#226e85",linewidth=0.16) {#MPLATP:1 (20,33)};
// $JUNCTION @ATTACH (20,33);
// &"OUTP" @WIRE(mode="straight",linecolor="#226e85",linewidth=0.16) {#MNLATP:1 (20,33)};
// $JUNCTION @ATTACH (20,33);
// &"OUTP" @WIRE(mode="straight",linecolor="#226e85",linewidth=0.16) {#MPRSTP:1 (42,33)};
// $JUNCTION @ATTACH (42,33);
// &"OUTN" @WIRE(mode="straight",linecolor="#226e85",linewidth=0.16) {#MPLATN:1 (-20,36) (8,36) (8,42) #MPLATP:2};
// &"OUTN" @WIRE(mode="straight",linecolor="#226e85",linewidth=0.16) {(8,36) (8,20) #MNLATP:2};
// $JUNCTION @ATTACH (8,36);
// &"OUTP" @WIRE(mode="straight",linecolor="#226e85",linewidth=0.16) {#MPLATP:1 (20,28) (-8,28) (-8,42) #MPLATN:2};
// &"OUTP" @WIRE(mode="straight",linecolor="#226e85",linewidth=0.16) {(-8,28) (-8,20) #MNLATN:2};
// $JUNCTION @ATTACH (-8,28);
// &"Y" @WIRE(mode="straight",linecolor="#226e85",linewidth=0.16) {(-42,4) (-20,4)};
// &"Y" @WIRE(mode="straight",linecolor="#226e85",linewidth=0.16) {#MNLATN:3 (-20,4)};
// $JUNCTION @ATTACH (-20,4);
// &"Y" @WIRE(mode="straight",linecolor="#226e85",linewidth=0.16) {#MNINP:1 (-20,4)};
// $JUNCTION @ATTACH (-20,4);
// &"Y" @WIRE(mode="straight",linecolor="#226e85",linewidth=0.16) {#MPRSTY:1 (-42,4)};
// $JUNCTION @ATTACH (-42,4);
// &"X" @WIRE(mode="straight",linecolor="#226e85",linewidth=0.16) {(20,4) (42,4)};
// &"X" @WIRE(mode="straight",linecolor="#226e85",linewidth=0.16) {#MNLATP:3 (20,4)};
// $JUNCTION @ATTACH (20,4);
// &"X" @WIRE(mode="straight",linecolor="#226e85",linewidth=0.16) {#MNINN:1 (20,4)};
// $JUNCTION @ATTACH (20,4);
// &"X" @WIRE(mode="straight",linecolor="#226e85",linewidth=0.16) {#MPRSTX:1 (42,4)};
// $JUNCTION @ATTACH (42,4);
// &"TAIL" @WIRE(mode="straight",linecolor="#226e85",linewidth=0.16) {(-20,-18) (0,-18) (20,-18)};
// &"TAIL" @WIRE(mode="straight",linecolor="#226e85",linewidth=0.16) {#MNINP:3 (-20,-18)};
// $JUNCTION @ATTACH (-20,-18);
// &"TAIL" @WIRE(mode="straight",linecolor="#226e85",linewidth=0.16) {#MNINN:3 (20,-18)};
// $JUNCTION @ATTACH (20,-18);
// &"TAIL" @WIRE(mode="straight",linecolor="#226e85",linewidth=0.16) {#MNTAIL:1 (0,-18)};
// $JUNCTION @ATTACH (0,-18);
// &"VSS" @WIRE(mode="straight",linecolor="#30485d",linewidth=0.16) {#MNLATN:4 (-24,20)};
// (-24.4,20) @TEXT("VSS",size=1.1,halign="end",valign="middle");
// &"VSS" @WIRE(mode="straight",linecolor="#30485d",linewidth=0.16) {#MNLATP:4 (24,20)};
// (24.4,20) @TEXT("VSS",size=1.1,halign="start",valign="middle");
// &"VINN" @WIRE(mode="straight",linecolor="#30485d",linewidth=0.16) {#MNINN:2 (26,-5)};
// (26.4,-5) @TEXT("VINN",size=1.1,halign="start",valign="middle");
// &"VSS" @WIRE(mode="straight",linecolor="#30485d",linewidth=0.16) {#MNINN:4 (16,-5)};
// (15.6,-5) @TEXT("VSS",size=1.1,halign="end",valign="middle");
// &"VINP" @WIRE(mode="straight",linecolor="#30485d",linewidth=0.16) {#MNINP:2 (-26,-5)};
// (-26.4,-5) @TEXT("VINP",size=1.1,halign="end",valign="middle");
// &"VSS" @WIRE(mode="straight",linecolor="#30485d",linewidth=0.16) {#MNINP:4 (-16,-5)};
// (-15.6,-5) @TEXT("VSS",size=1.1,halign="start",valign="middle");
// &"CLK" @WIRE(mode="straight",linecolor="#30485d",linewidth=0.16) {#MNTAIL:2 (-6,-30)};
// (-6.4,-30) @TEXT("CLK",size=1.1,halign="end",valign="middle");
// &"VSS" @WIRE(mode="straight",linecolor="#30485d",linewidth=0.16) {#MNTAIL:3 (0,-35)};
// (0,-35.4) @TEXT("VSS",size=1.1,halign="middle",valign="top");
// &"VSS" @WIRE(mode="straight",linecolor="#30485d",linewidth=0.16) {#MNTAIL:4 (4,-30)};
// (4.4,-30) @TEXT("VSS",size=1.1,halign="start",valign="middle");
// &"CLK" @WIRE(mode="straight",linecolor="#30485d",linewidth=0.16) {#MPRSTN:2 (-48,42)};
// (-48.4,42) @TEXT("CLK",size=1.1,halign="end",valign="middle");
// &"VDD" @WIRE(mode="straight",linecolor="#30485d",linewidth=0.16) {#MPRSTN:4 (-38,42)};
// (-37.6,42) @TEXT("VDD",size=1.1,halign="start",valign="middle");
// &"CLK" @WIRE(mode="straight",linecolor="#30485d",linewidth=0.16) {#MPRSTP:2 (48,42)};
// (48.4,42) @TEXT("CLK",size=1.1,halign="start",valign="middle");
// &"VDD" @WIRE(mode="straight",linecolor="#30485d",linewidth=0.16) {#MPRSTP:4 (38,42)};
// (37.6,42) @TEXT("VDD",size=1.1,halign="end",valign="middle");
// &"CLK" @WIRE(mode="straight",linecolor="#30485d",linewidth=0.16) {#MPRSTY:2 (-48,10)};
// (-48.4,10) @TEXT("CLK",size=1.1,halign="end",valign="middle");
// &"VDD" @WIRE(mode="straight",linecolor="#30485d",linewidth=0.16) {#MPRSTY:4 (-38,10)};
// (-37.6,10) @TEXT("VDD",size=1.1,halign="start",valign="middle");
// &"CLK" @WIRE(mode="straight",linecolor="#30485d",linewidth=0.16) {#MPRSTX:2 (48,10)};
// (48.4,10) @TEXT("CLK",size=1.1,halign="start",valign="middle");
// &"VDD" @WIRE(mode="straight",linecolor="#30485d",linewidth=0.16) {#MPRSTX:4 (38,10)};
// (37.6,10) @TEXT("VDD",size=1.1,halign="end",valign="middle");
// &"VDD" @WIRE(mode="straight",linecolor="#30485d",linewidth=0.16) {#MPLATN:4 (-24,42)};
// (-24.4,42) @TEXT("VDD",size=1.1,halign="end",valign="middle");
// &"VDD" @WIRE(mode="straight",linecolor="#30485d",linewidth=0.16) {#MPLATP:4 (24,42)};
// (24.4,42) @TEXT("VDD",size=1.1,halign="start",valign="middle");
// }
// END SARADC RNL
ends sar_strongarm_t28

subckt sar8i_refword CODE0 CODE1 CODE2 CODE3 CODE4 CODE5 CODE6 CODE7 D0 D1  D2 D3 D4 D5 D6 D7 GNN0 GNN1 GNN2 GNN3 GNN4 GNN5 GNN6 GNN7 GNP0  GNP1 GNP2 GNP3 GNP4 GNP5 GNP6 GNP7 GPN0 GPN1 GPN2 GPN3 GPN4 GPN5  GPN6 GPN7 GPP0 GPP1 GPP2 GPP3 GPP4 GPP5 GPP6 GPP7 PHI_U SAMPLE VDD  VSS RST_DONE PRESET
XPRESET_N (PRESET RUN VDD VSS) INVD1BWP12T30P140
XINITIAL0 (CODE0 RUN QN0 VDD VSS) ND2D1BWP12T30P140
XPN0 (QN0 GPN0 VDD VSS) INVD1BWP12T30P140
XNN0 (QN0 GNN0 VDD VSS) BUFFD1BWP12T30P140
WNP0 (GNN0 GNP0) iprobe
WPP0 (GPN0 GPP0) iprobe
XINITIAL1 (CODE1 RUN QN1 VDD VSS) ND2D1BWP12T30P140
XPN1 (QN1 GPN1 VDD VSS) INVD1BWP12T30P140
XNN1 (QN1 GNN1 VDD VSS) BUFFD1BWP12T30P140
WNP1 (GNN1 GNP1) iprobe
WPP1 (GPN1 GPP1) iprobe
XINITIAL2 (CODE2 RUN QN2 VDD VSS) ND2D1BWP12T30P140
XPN2 (QN2 GPN2 VDD VSS) INVD1BWP12T30P140
XNN2 (QN2 GNN2 VDD VSS) BUFFD1BWP12T30P140
WNP2 (GNN2 GNP2) iprobe
WPP2 (GPN2 GPP2) iprobe
XINITIAL3 (CODE3 RUN QN3 VDD VSS) ND2D1BWP12T30P140
XPN3 (QN3 GPN3 VDD VSS) INVD1BWP12T30P140
XNN3 (QN3 GNN3 VDD VSS) BUFFD1BWP12T30P140
WNP3 (GNN3 GNP3) iprobe
WPP3 (GPN3 GPP3) iprobe
XINITIAL4 (CODE4 RUN QN4 VDD VSS) ND2D1BWP12T30P140
XPN4 (QN4 GPN4 VDD VSS) INVD1BWP12T30P140
XNN4 (QN4 GNN4 VDD VSS) BUFFD1BWP12T30P140
WNP4 (GNN4 GNP4) iprobe
WPP4 (GPN4 GPP4) iprobe
XINITIAL5 (CODE5 RUN QN5 VDD VSS) ND2D1BWP12T30P140
XPN5 (QN5 GPN5 VDD VSS) INVD1BWP12T30P140
XNN5 (QN5 GNN5 VDD VSS) BUFFD1BWP12T30P140
WNP5 (GNN5 GNP5) iprobe
WPP5 (GPN5 GPP5) iprobe
XINITIAL6 (CODE6 RUN QN6 VDD VSS) ND2D1BWP12T30P140
XPN6 (QN6 GPN6 VDD VSS) INVD1BWP12T30P140
XNN6 (QN6 GNN6 VDD VSS) BUFFD1BWP12T30P140
WNP6 (GNN6 GNP6) iprobe
WPP6 (GPN6 GPP6) iprobe
// PRESET rises with CODE7 high at the end of every MSB-1 conversion. The INV+INV+ND2 form keeps
// the stacked node within the terminal-voltage rule (native OR2D1 reached 1.124 V).
XINITIAL7_A (CODE7 CODE7_B VDD VSS) INVD1BWP12T30P140
XINITIAL7_B (PRESET PRESET_B VDD VSS) INVD1BWP12T30P140
XINITIAL7 (CODE7_B PRESET_B Q7 VDD VSS) ND2D1BWP12T30P140
XINV7 (Q7 QN7 VDD VSS) INVD1BWP12T30P140
XPN7 (QN7 GPN7 VDD VSS) INVD2BWP12T30P140
XNN7 (QN7 GNN7 VDD VSS) BUFFD2BWP12T30P140
WNP7 (GNN7 GNP7) iprobe
WPP7 (GPN7 GPP7) iprobe
WUNUSED (RST_DONE VSS) iprobe
// BEGIN SARADC RNL
// @RNL(author="saradc topology") {
// (-17,70) @TEXT("Single-edge reference decode and switch drive",size=2,halign="start",textcolor="#223d52");
// #XPRESET_N @SET-SYMBOL $S_INVD1BWP12T30P140;
// #XPRESET_N @PLACE(0,38) => @ORIENT("R0");
// #WUNUSED @SET-SYMBOL $S_iprobe;
// #WUNUSED @PLACE(31,38) => @ORIENT("R0");
// (-18,17) @TEXT("Bit 0",size=1.2,halign="start",textcolor="#223d52");
// #XINITIAL0 @SET-SYMBOL $S_ND2D1BWP12T30P140;
// #XINITIAL0 @PLACE(0,9) => @ORIENT("R0");
// #XPN0 @SET-SYMBOL $S_INVD1BWP12T30P140;
// #XPN0 @PLACE(34,9) => @ORIENT("R0");
// #XNN0 @SET-SYMBOL $S_BUFFD1BWP12T30P140;
// #XNN0 @PLACE(68,9) => @ORIENT("R0");
// #WNP0 @SET-SYMBOL $S_iprobe;
// #WNP0 @PLACE(102,9) => @ORIENT("R0");
// #WPP0 @SET-SYMBOL $S_iprobe;
// #WPP0 @PLACE(136,9) => @ORIENT("R0");
// (-18,-8) @TEXT("Bit 1",size=1.2,halign="start",textcolor="#223d52");
// #XINITIAL1 @SET-SYMBOL $S_ND2D1BWP12T30P140;
// #XINITIAL1 @PLACE(0,-16) => @ORIENT("R0");
// #XPN1 @SET-SYMBOL $S_INVD1BWP12T30P140;
// #XPN1 @PLACE(34,-16) => @ORIENT("R0");
// #XNN1 @SET-SYMBOL $S_BUFFD1BWP12T30P140;
// #XNN1 @PLACE(68,-16) => @ORIENT("R0");
// #WNP1 @SET-SYMBOL $S_iprobe;
// #WNP1 @PLACE(102,-16) => @ORIENT("R0");
// #WPP1 @SET-SYMBOL $S_iprobe;
// #WPP1 @PLACE(136,-16) => @ORIENT("R0");
// (-18,-33) @TEXT("Bit 2",size=1.2,halign="start",textcolor="#223d52");
// #XINITIAL2 @SET-SYMBOL $S_ND2D1BWP12T30P140;
// #XINITIAL2 @PLACE(0,-41) => @ORIENT("R0");
// #XPN2 @SET-SYMBOL $S_INVD1BWP12T30P140;
// #XPN2 @PLACE(34,-41) => @ORIENT("R0");
// #XNN2 @SET-SYMBOL $S_BUFFD1BWP12T30P140;
// #XNN2 @PLACE(68,-41) => @ORIENT("R0");
// #WNP2 @SET-SYMBOL $S_iprobe;
// #WNP2 @PLACE(102,-41) => @ORIENT("R0");
// #WPP2 @SET-SYMBOL $S_iprobe;
// #WPP2 @PLACE(136,-41) => @ORIENT("R0");
// (-18,-58) @TEXT("Bit 3",size=1.2,halign="start",textcolor="#223d52");
// #XINITIAL3 @SET-SYMBOL $S_ND2D1BWP12T30P140;
// #XINITIAL3 @PLACE(0,-66) => @ORIENT("R0");
// #XPN3 @SET-SYMBOL $S_INVD1BWP12T30P140;
// #XPN3 @PLACE(34,-66) => @ORIENT("R0");
// #XNN3 @SET-SYMBOL $S_BUFFD1BWP12T30P140;
// #XNN3 @PLACE(68,-66) => @ORIENT("R0");
// #WNP3 @SET-SYMBOL $S_iprobe;
// #WNP3 @PLACE(102,-66) => @ORIENT("R0");
// #WPP3 @SET-SYMBOL $S_iprobe;
// #WPP3 @PLACE(136,-66) => @ORIENT("R0");
// (-18,-83) @TEXT("Bit 4",size=1.2,halign="start",textcolor="#223d52");
// #XINITIAL4 @SET-SYMBOL $S_ND2D1BWP12T30P140;
// #XINITIAL4 @PLACE(0,-91) => @ORIENT("R0");
// #XPN4 @SET-SYMBOL $S_INVD1BWP12T30P140;
// #XPN4 @PLACE(34,-91) => @ORIENT("R0");
// #XNN4 @SET-SYMBOL $S_BUFFD1BWP12T30P140;
// #XNN4 @PLACE(68,-91) => @ORIENT("R0");
// #WNP4 @SET-SYMBOL $S_iprobe;
// #WNP4 @PLACE(102,-91) => @ORIENT("R0");
// #WPP4 @SET-SYMBOL $S_iprobe;
// #WPP4 @PLACE(136,-91) => @ORIENT("R0");
// (-18,-108) @TEXT("Bit 5",size=1.2,halign="start",textcolor="#223d52");
// #XINITIAL5 @SET-SYMBOL $S_ND2D1BWP12T30P140;
// #XINITIAL5 @PLACE(0,-116) => @ORIENT("R0");
// #XPN5 @SET-SYMBOL $S_INVD1BWP12T30P140;
// #XPN5 @PLACE(34,-116) => @ORIENT("R0");
// #XNN5 @SET-SYMBOL $S_BUFFD1BWP12T30P140;
// #XNN5 @PLACE(68,-116) => @ORIENT("R0");
// #WNP5 @SET-SYMBOL $S_iprobe;
// #WNP5 @PLACE(102,-116) => @ORIENT("R0");
// #WPP5 @SET-SYMBOL $S_iprobe;
// #WPP5 @PLACE(136,-116) => @ORIENT("R0");
// (-18,-133) @TEXT("Bit 6",size=1.2,halign="start",textcolor="#223d52");
// #XINITIAL6 @SET-SYMBOL $S_ND2D1BWP12T30P140;
// #XINITIAL6 @PLACE(0,-141) => @ORIENT("R0");
// #XPN6 @SET-SYMBOL $S_INVD1BWP12T30P140;
// #XPN6 @PLACE(34,-141) => @ORIENT("R0");
// #XNN6 @SET-SYMBOL $S_BUFFD1BWP12T30P140;
// #XNN6 @PLACE(68,-141) => @ORIENT("R0");
// #WNP6 @SET-SYMBOL $S_iprobe;
// #WNP6 @PLACE(102,-141) => @ORIENT("R0");
// #WPP6 @SET-SYMBOL $S_iprobe;
// #WPP6 @PLACE(136,-141) => @ORIENT("R0");
// (-18,-158) @TEXT("Bit 7",size=1.2,halign="start",textcolor="#223d52");
// #XINITIAL7_A @SET-SYMBOL $S_INVD1BWP12T30P140;
// #XINITIAL7_A @PLACE(0,-166) => @ORIENT("R0");
// #XINITIAL7_B @SET-SYMBOL $S_INVD1BWP12T30P140;
// #XINITIAL7_B @PLACE(34,-166) => @ORIENT("R0");
// #XINITIAL7 @SET-SYMBOL $S_ND2D1BWP12T30P140;
// #XINITIAL7 @PLACE(68,-166) => @ORIENT("R0");
// #XINV7 @SET-SYMBOL $S_INVD1BWP12T30P140;
// #XINV7 @PLACE(102,-166) => @ORIENT("R0");
// #XPN7 @SET-SYMBOL $S_INVD2BWP12T30P140;
// #XPN7 @PLACE(136,-166) => @ORIENT("R0");
// #XNN7 @SET-SYMBOL $S_BUFFD2BWP12T30P140;
// #XNN7 @PLACE(170,-166) => @ORIENT("R0");
// #WNP7 @SET-SYMBOL $S_iprobe;
// #WNP7 @PLACE(204,-166) => @ORIENT("R0");
// #WPP7 @SET-SYMBOL $S_iprobe;
// #WPP7 @PLACE(238,-166) => @ORIENT("R0");
// &"GNN0" @WIRE(mode="straight",linecolor="#30485d",linewidth=0.16) {#XNN0:2 (85,9) (85,10.65) #WNP0:1};
// &"GNN1" @WIRE(mode="straight",linecolor="#30485d",linewidth=0.16) {#XNN1:2 (85,-16) (85,-14.35) #WNP1:1};
// &"GNN2" @WIRE(mode="straight",linecolor="#30485d",linewidth=0.16) {#XNN2:2 (85,-41) (85,-39.35) #WNP2:1};
// &"GNN3" @WIRE(mode="straight",linecolor="#30485d",linewidth=0.16) {#XNN3:2 (85,-66) (85,-64.35) #WNP3:1};
// &"GNN4" @WIRE(mode="straight",linecolor="#30485d",linewidth=0.16) {#XNN4:2 (85,-91) (85,-89.35) #WNP4:1};
// &"GNN5" @WIRE(mode="straight",linecolor="#30485d",linewidth=0.16) {#XNN5:2 (85,-116) (85,-114.35) #WNP5:1};
// &"GNN6" @WIRE(mode="straight",linecolor="#30485d",linewidth=0.16) {#XNN6:2 (85,-141) (85,-139.35) #WNP6:1};
// &"PRESET_B" @WIRE(mode="straight",linecolor="#30485d",linewidth=0.16) {#XINITIAL7_B:2 (51,-166) (51,-167.7) #XINITIAL7:2};
// &"Q7" @WIRE(mode="straight",linecolor="#30485d",linewidth=0.16) {#XINITIAL7:3 (85,-166) (85,-166) #XINV7:1};
// &"GNN7" @WIRE(mode="straight",linecolor="#30485d",linewidth=0.16) {#XNN7:2 (187,-166) (187,-164.35) #WNP7:1};
// &"PRESET" @WIRE(mode="straight",linecolor="#30485d",linewidth=0.16) {#XPRESET_N:1 (-10,38)};
// (-10.4,38) @TEXT("PRESET",size=1.1,halign="end",valign="middle");
// &"RUN" @WIRE(mode="straight",linecolor="#30485d",linewidth=0.16) {#XPRESET_N:2 (10,38)};
// (10.4,38) @TEXT("RUN",size=1.1,halign="start",valign="middle");
// &"VDD" @WIRE(mode="straight",linecolor="#30485d",linewidth=0.16) {#XPRESET_N:3 (0,48)};
// (0,48.4) @TEXT("VDD",size=1.1,halign="middle",valign="bottom");
// &"VSS" @WIRE(mode="straight",linecolor="#30485d",linewidth=0.16) {#XPRESET_N:4 (0,28)};
// (0,27.6) @TEXT("VSS",size=1.1,halign="middle",valign="top");
// &"CODE0" @WIRE(mode="straight",linecolor="#30485d",linewidth=0.16) {#XINITIAL0:1 (-10,10.7)};
// (-10.4,10.7) @TEXT("CODE0",size=1.1,halign="end",valign="middle");
// &"RUN" @WIRE(mode="straight",linecolor="#30485d",linewidth=0.16) {#XINITIAL0:2 (-10,7.3)};
// (-10.4,7.3) @TEXT("RUN",size=1.1,halign="end",valign="middle");
// &"QN0" @WIRE(mode="straight",linecolor="#30485d",linewidth=0.16) {#XINITIAL0:3 (10,9)};
// (10.4,9) @TEXT("QN0",size=1.1,halign="start",valign="middle");
// &"VDD" @WIRE(mode="straight",linecolor="#30485d",linewidth=0.16) {#XINITIAL0:4 (0,19)};
// (0,19.4) @TEXT("VDD",size=1.1,halign="middle",valign="bottom");
// &"VSS" @WIRE(mode="straight",linecolor="#30485d",linewidth=0.16) {#XINITIAL0:5 (0,-1)};
// (0,-1.4) @TEXT("VSS",size=1.1,halign="middle",valign="top");
// &"QN0" @WIRE(mode="straight",linecolor="#30485d",linewidth=0.16) {#XPN0:1 (24,9)};
// (23.6,9) @TEXT("QN0",size=1.1,halign="end",valign="middle");
// &"GPN0" @WIRE(mode="straight",linecolor="#30485d",linewidth=0.16) {#XPN0:2 (44,9)};
// (44.4,9) @TEXT("GPN0",size=1.1,halign="start",valign="middle");
// &"VDD" @WIRE(mode="straight",linecolor="#30485d",linewidth=0.16) {#XPN0:3 (34,19)};
// (34,19.4) @TEXT("VDD",size=1.1,halign="middle",valign="bottom");
// &"VSS" @WIRE(mode="straight",linecolor="#30485d",linewidth=0.16) {#XPN0:4 (34,-1)};
// (34,-1.4) @TEXT("VSS",size=1.1,halign="middle",valign="top");
// &"QN0" @WIRE(mode="straight",linecolor="#30485d",linewidth=0.16) {#XNN0:1 (52,9)};
// (51.6,9) @TEXT("QN0",size=1.1,halign="end",valign="middle");
// &"VDD" @WIRE(mode="straight",linecolor="#30485d",linewidth=0.16) {#XNN0:3 (68,20)};
// (68,20.4) @TEXT("VDD",size=1.1,halign="middle",valign="bottom");
// &"VSS" @WIRE(mode="straight",linecolor="#30485d",linewidth=0.16) {#XNN0:4 (68,-2)};
// (68,-2.4) @TEXT("VSS",size=1.1,halign="middle",valign="top");
// &"GNP0" @WIRE(mode="straight",linecolor="#30485d",linewidth=0.16) {#WNP0:2 (86,7.35)};
// (85.6,7.35) @TEXT("GNP0",size=1.1,halign="end",valign="middle");
// &"GPN0" @WIRE(mode="straight",linecolor="#30485d",linewidth=0.16) {#WPP0:1 (120,10.65)};
// (119.6,10.65) @TEXT("GPN0",size=1.1,halign="end",valign="middle");
// &"GPP0" @WIRE(mode="straight",linecolor="#30485d",linewidth=0.16) {#WPP0:2 (120,7.35)};
// (119.6,7.35) @TEXT("GPP0",size=1.1,halign="end",valign="middle");
// &"CODE1" @WIRE(mode="straight",linecolor="#30485d",linewidth=0.16) {#XINITIAL1:1 (-10,-14.3)};
// (-10.4,-14.3) @TEXT("CODE1",size=1.1,halign="end",valign="middle");
// &"RUN" @WIRE(mode="straight",linecolor="#30485d",linewidth=0.16) {#XINITIAL1:2 (-10,-17.7)};
// (-10.4,-17.7) @TEXT("RUN",size=1.1,halign="end",valign="middle");
// &"QN1" @WIRE(mode="straight",linecolor="#30485d",linewidth=0.16) {#XINITIAL1:3 (10,-16)};
// (10.4,-16) @TEXT("QN1",size=1.1,halign="start",valign="middle");
// &"VDD" @WIRE(mode="straight",linecolor="#30485d",linewidth=0.16) {#XINITIAL1:4 (0,-6)};
// (0,-5.6) @TEXT("VDD",size=1.1,halign="middle",valign="bottom");
// &"VSS" @WIRE(mode="straight",linecolor="#30485d",linewidth=0.16) {#XINITIAL1:5 (0,-26)};
// (0,-26.4) @TEXT("VSS",size=1.1,halign="middle",valign="top");
// &"QN1" @WIRE(mode="straight",linecolor="#30485d",linewidth=0.16) {#XPN1:1 (24,-16)};
// (23.6,-16) @TEXT("QN1",size=1.1,halign="end",valign="middle");
// &"GPN1" @WIRE(mode="straight",linecolor="#30485d",linewidth=0.16) {#XPN1:2 (44,-16)};
// (44.4,-16) @TEXT("GPN1",size=1.1,halign="start",valign="middle");
// &"VDD" @WIRE(mode="straight",linecolor="#30485d",linewidth=0.16) {#XPN1:3 (34,-6)};
// (34,-5.6) @TEXT("VDD",size=1.1,halign="middle",valign="bottom");
// &"VSS" @WIRE(mode="straight",linecolor="#30485d",linewidth=0.16) {#XPN1:4 (34,-26)};
// (34,-26.4) @TEXT("VSS",size=1.1,halign="middle",valign="top");
// &"QN1" @WIRE(mode="straight",linecolor="#30485d",linewidth=0.16) {#XNN1:1 (52,-16)};
// (51.6,-16) @TEXT("QN1",size=1.1,halign="end",valign="middle");
// &"VDD" @WIRE(mode="straight",linecolor="#30485d",linewidth=0.16) {#XNN1:3 (68,-5)};
// (68,-4.6) @TEXT("VDD",size=1.1,halign="middle",valign="bottom");
// &"VSS" @WIRE(mode="straight",linecolor="#30485d",linewidth=0.16) {#XNN1:4 (68,-27)};
// (68,-27.4) @TEXT("VSS",size=1.1,halign="middle",valign="top");
// &"GNP1" @WIRE(mode="straight",linecolor="#30485d",linewidth=0.16) {#WNP1:2 (86,-17.65)};
// (85.6,-17.65) @TEXT("GNP1",size=1.1,halign="end",valign="middle");
// &"GPN1" @WIRE(mode="straight",linecolor="#30485d",linewidth=0.16) {#WPP1:1 (120,-14.35)};
// (119.6,-14.35) @TEXT("GPN1",size=1.1,halign="end",valign="middle");
// &"GPP1" @WIRE(mode="straight",linecolor="#30485d",linewidth=0.16) {#WPP1:2 (120,-17.65)};
// (119.6,-17.65) @TEXT("GPP1",size=1.1,halign="end",valign="middle");
// &"CODE2" @WIRE(mode="straight",linecolor="#30485d",linewidth=0.16) {#XINITIAL2:1 (-10,-39.3)};
// (-10.4,-39.3) @TEXT("CODE2",size=1.1,halign="end",valign="middle");
// &"RUN" @WIRE(mode="straight",linecolor="#30485d",linewidth=0.16) {#XINITIAL2:2 (-10,-42.7)};
// (-10.4,-42.7) @TEXT("RUN",size=1.1,halign="end",valign="middle");
// &"QN2" @WIRE(mode="straight",linecolor="#30485d",linewidth=0.16) {#XINITIAL2:3 (10,-41)};
// (10.4,-41) @TEXT("QN2",size=1.1,halign="start",valign="middle");
// &"VDD" @WIRE(mode="straight",linecolor="#30485d",linewidth=0.16) {#XINITIAL2:4 (0,-31)};
// (0,-30.6) @TEXT("VDD",size=1.1,halign="middle",valign="bottom");
// &"VSS" @WIRE(mode="straight",linecolor="#30485d",linewidth=0.16) {#XINITIAL2:5 (0,-51)};
// (0,-51.4) @TEXT("VSS",size=1.1,halign="middle",valign="top");
// &"QN2" @WIRE(mode="straight",linecolor="#30485d",linewidth=0.16) {#XPN2:1 (24,-41)};
// (23.6,-41) @TEXT("QN2",size=1.1,halign="end",valign="middle");
// &"GPN2" @WIRE(mode="straight",linecolor="#30485d",linewidth=0.16) {#XPN2:2 (44,-41)};
// (44.4,-41) @TEXT("GPN2",size=1.1,halign="start",valign="middle");
// &"VDD" @WIRE(mode="straight",linecolor="#30485d",linewidth=0.16) {#XPN2:3 (34,-31)};
// (34,-30.6) @TEXT("VDD",size=1.1,halign="middle",valign="bottom");
// &"VSS" @WIRE(mode="straight",linecolor="#30485d",linewidth=0.16) {#XPN2:4 (34,-51)};
// (34,-51.4) @TEXT("VSS",size=1.1,halign="middle",valign="top");
// &"QN2" @WIRE(mode="straight",linecolor="#30485d",linewidth=0.16) {#XNN2:1 (52,-41)};
// (51.6,-41) @TEXT("QN2",size=1.1,halign="end",valign="middle");
// &"VDD" @WIRE(mode="straight",linecolor="#30485d",linewidth=0.16) {#XNN2:3 (68,-30)};
// (68,-29.6) @TEXT("VDD",size=1.1,halign="middle",valign="bottom");
// &"VSS" @WIRE(mode="straight",linecolor="#30485d",linewidth=0.16) {#XNN2:4 (68,-52)};
// (68,-52.4) @TEXT("VSS",size=1.1,halign="middle",valign="top");
// &"GNP2" @WIRE(mode="straight",linecolor="#30485d",linewidth=0.16) {#WNP2:2 (86,-42.65)};
// (85.6,-42.65) @TEXT("GNP2",size=1.1,halign="end",valign="middle");
// &"GPN2" @WIRE(mode="straight",linecolor="#30485d",linewidth=0.16) {#WPP2:1 (120,-39.35)};
// (119.6,-39.35) @TEXT("GPN2",size=1.1,halign="end",valign="middle");
// &"GPP2" @WIRE(mode="straight",linecolor="#30485d",linewidth=0.16) {#WPP2:2 (120,-42.65)};
// (119.6,-42.65) @TEXT("GPP2",size=1.1,halign="end",valign="middle");
// &"CODE3" @WIRE(mode="straight",linecolor="#30485d",linewidth=0.16) {#XINITIAL3:1 (-10,-64.3)};
// (-10.4,-64.3) @TEXT("CODE3",size=1.1,halign="end",valign="middle");
// &"RUN" @WIRE(mode="straight",linecolor="#30485d",linewidth=0.16) {#XINITIAL3:2 (-10,-67.7)};
// (-10.4,-67.7) @TEXT("RUN",size=1.1,halign="end",valign="middle");
// &"QN3" @WIRE(mode="straight",linecolor="#30485d",linewidth=0.16) {#XINITIAL3:3 (10,-66)};
// (10.4,-66) @TEXT("QN3",size=1.1,halign="start",valign="middle");
// &"VDD" @WIRE(mode="straight",linecolor="#30485d",linewidth=0.16) {#XINITIAL3:4 (0,-56)};
// (0,-55.6) @TEXT("VDD",size=1.1,halign="middle",valign="bottom");
// &"VSS" @WIRE(mode="straight",linecolor="#30485d",linewidth=0.16) {#XINITIAL3:5 (0,-76)};
// (0,-76.4) @TEXT("VSS",size=1.1,halign="middle",valign="top");
// &"QN3" @WIRE(mode="straight",linecolor="#30485d",linewidth=0.16) {#XPN3:1 (24,-66)};
// (23.6,-66) @TEXT("QN3",size=1.1,halign="end",valign="middle");
// &"GPN3" @WIRE(mode="straight",linecolor="#30485d",linewidth=0.16) {#XPN3:2 (44,-66)};
// (44.4,-66) @TEXT("GPN3",size=1.1,halign="start",valign="middle");
// &"VDD" @WIRE(mode="straight",linecolor="#30485d",linewidth=0.16) {#XPN3:3 (34,-56)};
// (34,-55.6) @TEXT("VDD",size=1.1,halign="middle",valign="bottom");
// &"VSS" @WIRE(mode="straight",linecolor="#30485d",linewidth=0.16) {#XPN3:4 (34,-76)};
// (34,-76.4) @TEXT("VSS",size=1.1,halign="middle",valign="top");
// &"QN3" @WIRE(mode="straight",linecolor="#30485d",linewidth=0.16) {#XNN3:1 (52,-66)};
// (51.6,-66) @TEXT("QN3",size=1.1,halign="end",valign="middle");
// &"VDD" @WIRE(mode="straight",linecolor="#30485d",linewidth=0.16) {#XNN3:3 (68,-55)};
// (68,-54.6) @TEXT("VDD",size=1.1,halign="middle",valign="bottom");
// &"VSS" @WIRE(mode="straight",linecolor="#30485d",linewidth=0.16) {#XNN3:4 (68,-77)};
// (68,-77.4) @TEXT("VSS",size=1.1,halign="middle",valign="top");
// &"GNP3" @WIRE(mode="straight",linecolor="#30485d",linewidth=0.16) {#WNP3:2 (86,-67.65)};
// (85.6,-67.65) @TEXT("GNP3",size=1.1,halign="end",valign="middle");
// &"GPN3" @WIRE(mode="straight",linecolor="#30485d",linewidth=0.16) {#WPP3:1 (120,-64.35)};
// (119.6,-64.35) @TEXT("GPN3",size=1.1,halign="end",valign="middle");
// &"GPP3" @WIRE(mode="straight",linecolor="#30485d",linewidth=0.16) {#WPP3:2 (120,-67.65)};
// (119.6,-67.65) @TEXT("GPP3",size=1.1,halign="end",valign="middle");
// &"CODE4" @WIRE(mode="straight",linecolor="#30485d",linewidth=0.16) {#XINITIAL4:1 (-10,-89.3)};
// (-10.4,-89.3) @TEXT("CODE4",size=1.1,halign="end",valign="middle");
// &"RUN" @WIRE(mode="straight",linecolor="#30485d",linewidth=0.16) {#XINITIAL4:2 (-10,-92.7)};
// (-10.4,-92.7) @TEXT("RUN",size=1.1,halign="end",valign="middle");
// &"QN4" @WIRE(mode="straight",linecolor="#30485d",linewidth=0.16) {#XINITIAL4:3 (10,-91)};
// (10.4,-91) @TEXT("QN4",size=1.1,halign="start",valign="middle");
// &"VDD" @WIRE(mode="straight",linecolor="#30485d",linewidth=0.16) {#XINITIAL4:4 (0,-81)};
// (0,-80.6) @TEXT("VDD",size=1.1,halign="middle",valign="bottom");
// &"VSS" @WIRE(mode="straight",linecolor="#30485d",linewidth=0.16) {#XINITIAL4:5 (0,-101)};
// (0,-101.4) @TEXT("VSS",size=1.1,halign="middle",valign="top");
// &"QN4" @WIRE(mode="straight",linecolor="#30485d",linewidth=0.16) {#XPN4:1 (24,-91)};
// (23.6,-91) @TEXT("QN4",size=1.1,halign="end",valign="middle");
// &"GPN4" @WIRE(mode="straight",linecolor="#30485d",linewidth=0.16) {#XPN4:2 (44,-91)};
// (44.4,-91) @TEXT("GPN4",size=1.1,halign="start",valign="middle");
// &"VDD" @WIRE(mode="straight",linecolor="#30485d",linewidth=0.16) {#XPN4:3 (34,-81)};
// (34,-80.6) @TEXT("VDD",size=1.1,halign="middle",valign="bottom");
// &"VSS" @WIRE(mode="straight",linecolor="#30485d",linewidth=0.16) {#XPN4:4 (34,-101)};
// (34,-101.4) @TEXT("VSS",size=1.1,halign="middle",valign="top");
// &"QN4" @WIRE(mode="straight",linecolor="#30485d",linewidth=0.16) {#XNN4:1 (52,-91)};
// (51.6,-91) @TEXT("QN4",size=1.1,halign="end",valign="middle");
// &"VDD" @WIRE(mode="straight",linecolor="#30485d",linewidth=0.16) {#XNN4:3 (68,-80)};
// (68,-79.6) @TEXT("VDD",size=1.1,halign="middle",valign="bottom");
// &"VSS" @WIRE(mode="straight",linecolor="#30485d",linewidth=0.16) {#XNN4:4 (68,-102)};
// (68,-102.4) @TEXT("VSS",size=1.1,halign="middle",valign="top");
// &"GNP4" @WIRE(mode="straight",linecolor="#30485d",linewidth=0.16) {#WNP4:2 (86,-92.65)};
// (85.6,-92.65) @TEXT("GNP4",size=1.1,halign="end",valign="middle");
// &"GPN4" @WIRE(mode="straight",linecolor="#30485d",linewidth=0.16) {#WPP4:1 (120,-89.35)};
// (119.6,-89.35) @TEXT("GPN4",size=1.1,halign="end",valign="middle");
// &"GPP4" @WIRE(mode="straight",linecolor="#30485d",linewidth=0.16) {#WPP4:2 (120,-92.65)};
// (119.6,-92.65) @TEXT("GPP4",size=1.1,halign="end",valign="middle");
// &"CODE5" @WIRE(mode="straight",linecolor="#30485d",linewidth=0.16) {#XINITIAL5:1 (-10,-114.3)};
// (-10.4,-114.3) @TEXT("CODE5",size=1.1,halign="end",valign="middle");
// &"RUN" @WIRE(mode="straight",linecolor="#30485d",linewidth=0.16) {#XINITIAL5:2 (-10,-117.7)};
// (-10.4,-117.7) @TEXT("RUN",size=1.1,halign="end",valign="middle");
// &"QN5" @WIRE(mode="straight",linecolor="#30485d",linewidth=0.16) {#XINITIAL5:3 (10,-116)};
// (10.4,-116) @TEXT("QN5",size=1.1,halign="start",valign="middle");
// &"VDD" @WIRE(mode="straight",linecolor="#30485d",linewidth=0.16) {#XINITIAL5:4 (0,-106)};
// (0,-105.6) @TEXT("VDD",size=1.1,halign="middle",valign="bottom");
// &"VSS" @WIRE(mode="straight",linecolor="#30485d",linewidth=0.16) {#XINITIAL5:5 (0,-126)};
// (0,-126.4) @TEXT("VSS",size=1.1,halign="middle",valign="top");
// &"QN5" @WIRE(mode="straight",linecolor="#30485d",linewidth=0.16) {#XPN5:1 (24,-116)};
// (23.6,-116) @TEXT("QN5",size=1.1,halign="end",valign="middle");
// &"GPN5" @WIRE(mode="straight",linecolor="#30485d",linewidth=0.16) {#XPN5:2 (44,-116)};
// (44.4,-116) @TEXT("GPN5",size=1.1,halign="start",valign="middle");
// &"VDD" @WIRE(mode="straight",linecolor="#30485d",linewidth=0.16) {#XPN5:3 (34,-106)};
// (34,-105.6) @TEXT("VDD",size=1.1,halign="middle",valign="bottom");
// &"VSS" @WIRE(mode="straight",linecolor="#30485d",linewidth=0.16) {#XPN5:4 (34,-126)};
// (34,-126.4) @TEXT("VSS",size=1.1,halign="middle",valign="top");
// &"QN5" @WIRE(mode="straight",linecolor="#30485d",linewidth=0.16) {#XNN5:1 (52,-116)};
// (51.6,-116) @TEXT("QN5",size=1.1,halign="end",valign="middle");
// &"VDD" @WIRE(mode="straight",linecolor="#30485d",linewidth=0.16) {#XNN5:3 (68,-105)};
// (68,-104.6) @TEXT("VDD",size=1.1,halign="middle",valign="bottom");
// &"VSS" @WIRE(mode="straight",linecolor="#30485d",linewidth=0.16) {#XNN5:4 (68,-127)};
// (68,-127.4) @TEXT("VSS",size=1.1,halign="middle",valign="top");
// &"GNP5" @WIRE(mode="straight",linecolor="#30485d",linewidth=0.16) {#WNP5:2 (86,-117.65)};
// (85.6,-117.65) @TEXT("GNP5",size=1.1,halign="end",valign="middle");
// &"GPN5" @WIRE(mode="straight",linecolor="#30485d",linewidth=0.16) {#WPP5:1 (120,-114.35)};
// (119.6,-114.35) @TEXT("GPN5",size=1.1,halign="end",valign="middle");
// &"GPP5" @WIRE(mode="straight",linecolor="#30485d",linewidth=0.16) {#WPP5:2 (120,-117.65)};
// (119.6,-117.65) @TEXT("GPP5",size=1.1,halign="end",valign="middle");
// &"CODE6" @WIRE(mode="straight",linecolor="#30485d",linewidth=0.16) {#XINITIAL6:1 (-10,-139.3)};
// (-10.4,-139.3) @TEXT("CODE6",size=1.1,halign="end",valign="middle");
// &"RUN" @WIRE(mode="straight",linecolor="#30485d",linewidth=0.16) {#XINITIAL6:2 (-10,-142.7)};
// (-10.4,-142.7) @TEXT("RUN",size=1.1,halign="end",valign="middle");
// &"QN6" @WIRE(mode="straight",linecolor="#30485d",linewidth=0.16) {#XINITIAL6:3 (10,-141)};
// (10.4,-141) @TEXT("QN6",size=1.1,halign="start",valign="middle");
// &"VDD" @WIRE(mode="straight",linecolor="#30485d",linewidth=0.16) {#XINITIAL6:4 (0,-131)};
// (0,-130.6) @TEXT("VDD",size=1.1,halign="middle",valign="bottom");
// &"VSS" @WIRE(mode="straight",linecolor="#30485d",linewidth=0.16) {#XINITIAL6:5 (0,-151)};
// (0,-151.4) @TEXT("VSS",size=1.1,halign="middle",valign="top");
// &"QN6" @WIRE(mode="straight",linecolor="#30485d",linewidth=0.16) {#XPN6:1 (24,-141)};
// (23.6,-141) @TEXT("QN6",size=1.1,halign="end",valign="middle");
// &"GPN6" @WIRE(mode="straight",linecolor="#30485d",linewidth=0.16) {#XPN6:2 (44,-141)};
// (44.4,-141) @TEXT("GPN6",size=1.1,halign="start",valign="middle");
// &"VDD" @WIRE(mode="straight",linecolor="#30485d",linewidth=0.16) {#XPN6:3 (34,-131)};
// (34,-130.6) @TEXT("VDD",size=1.1,halign="middle",valign="bottom");
// &"VSS" @WIRE(mode="straight",linecolor="#30485d",linewidth=0.16) {#XPN6:4 (34,-151)};
// (34,-151.4) @TEXT("VSS",size=1.1,halign="middle",valign="top");
// &"QN6" @WIRE(mode="straight",linecolor="#30485d",linewidth=0.16) {#XNN6:1 (52,-141)};
// (51.6,-141) @TEXT("QN6",size=1.1,halign="end",valign="middle");
// &"VDD" @WIRE(mode="straight",linecolor="#30485d",linewidth=0.16) {#XNN6:3 (68,-130)};
// (68,-129.6) @TEXT("VDD",size=1.1,halign="middle",valign="bottom");
// &"VSS" @WIRE(mode="straight",linecolor="#30485d",linewidth=0.16) {#XNN6:4 (68,-152)};
// (68,-152.4) @TEXT("VSS",size=1.1,halign="middle",valign="top");
// &"GNP6" @WIRE(mode="straight",linecolor="#30485d",linewidth=0.16) {#WNP6:2 (86,-142.65)};
// (85.6,-142.65) @TEXT("GNP6",size=1.1,halign="end",valign="middle");
// &"GPN6" @WIRE(mode="straight",linecolor="#30485d",linewidth=0.16) {#WPP6:1 (120,-139.35)};
// (119.6,-139.35) @TEXT("GPN6",size=1.1,halign="end",valign="middle");
// &"GPP6" @WIRE(mode="straight",linecolor="#30485d",linewidth=0.16) {#WPP6:2 (120,-142.65)};
// (119.6,-142.65) @TEXT("GPP6",size=1.1,halign="end",valign="middle");
// &"CODE7" @WIRE(mode="straight",linecolor="#30485d",linewidth=0.16) {#XINITIAL7_A:1 (-10,-166)};
// (-10.4,-166) @TEXT("CODE7",size=1.1,halign="end",valign="middle");
// &"CODE7_B" @WIRE(mode="straight",linecolor="#30485d",linewidth=0.16) {#XINITIAL7_A:2 (10,-166)};
// (10.4,-166) @TEXT("CODE7_B",size=1.1,halign="start",valign="middle");
// &"VDD" @WIRE(mode="straight",linecolor="#30485d",linewidth=0.16) {#XINITIAL7_A:3 (0,-156)};
// (0,-155.6) @TEXT("VDD",size=1.1,halign="middle",valign="bottom");
// &"VSS" @WIRE(mode="straight",linecolor="#30485d",linewidth=0.16) {#XINITIAL7_A:4 (0,-176)};
// (0,-176.4) @TEXT("VSS",size=1.1,halign="middle",valign="top");
// &"PRESET" @WIRE(mode="straight",linecolor="#30485d",linewidth=0.16) {#XINITIAL7_B:1 (24,-166)};
// (23.6,-166) @TEXT("PRESET",size=1.1,halign="end",valign="middle");
// &"VDD" @WIRE(mode="straight",linecolor="#30485d",linewidth=0.16) {#XINITIAL7_B:3 (34,-156)};
// (34,-155.6) @TEXT("VDD",size=1.1,halign="middle",valign="bottom");
// &"VSS" @WIRE(mode="straight",linecolor="#30485d",linewidth=0.16) {#XINITIAL7_B:4 (34,-176)};
// (34,-176.4) @TEXT("VSS",size=1.1,halign="middle",valign="top");
// &"CODE7_B" @WIRE(mode="straight",linecolor="#30485d",linewidth=0.16) {#XINITIAL7:1 (58,-164.3)};
// (57.6,-164.3) @TEXT("CODE7_B",size=1.1,halign="end",valign="middle");
// &"VDD" @WIRE(mode="straight",linecolor="#30485d",linewidth=0.16) {#XINITIAL7:4 (68,-156)};
// (68,-155.6) @TEXT("VDD",size=1.1,halign="middle",valign="bottom");
// &"VSS" @WIRE(mode="straight",linecolor="#30485d",linewidth=0.16) {#XINITIAL7:5 (68,-176)};
// (68,-176.4) @TEXT("VSS",size=1.1,halign="middle",valign="top");
// &"QN7" @WIRE(mode="straight",linecolor="#30485d",linewidth=0.16) {#XINV7:2 (112,-166)};
// (112.4,-166) @TEXT("QN7",size=1.1,halign="start",valign="middle");
// &"VDD" @WIRE(mode="straight",linecolor="#30485d",linewidth=0.16) {#XINV7:3 (102,-156)};
// (102,-155.6) @TEXT("VDD",size=1.1,halign="middle",valign="bottom");
// &"VSS" @WIRE(mode="straight",linecolor="#30485d",linewidth=0.16) {#XINV7:4 (102,-176)};
// (102,-176.4) @TEXT("VSS",size=1.1,halign="middle",valign="top");
// &"QN7" @WIRE(mode="straight",linecolor="#30485d",linewidth=0.16) {#XPN7:1 (120,-166)};
// (119.6,-166) @TEXT("QN7",size=1.1,halign="end",valign="middle");
// &"GPN7" @WIRE(mode="straight",linecolor="#30485d",linewidth=0.16) {#XPN7:2 (152,-166)};
// (152.4,-166) @TEXT("GPN7",size=1.1,halign="start",valign="middle");
// &"VDD" @WIRE(mode="straight",linecolor="#30485d",linewidth=0.16) {#XPN7:3 (136,-155)};
// (136,-154.6) @TEXT("VDD",size=1.1,halign="middle",valign="bottom");
// &"VSS" @WIRE(mode="straight",linecolor="#30485d",linewidth=0.16) {#XPN7:4 (136,-177)};
// (136,-177.4) @TEXT("VSS",size=1.1,halign="middle",valign="top");
// &"QN7" @WIRE(mode="straight",linecolor="#30485d",linewidth=0.16) {#XNN7:1 (154,-166)};
// (153.6,-166) @TEXT("QN7",size=1.1,halign="end",valign="middle");
// &"VDD" @WIRE(mode="straight",linecolor="#30485d",linewidth=0.16) {#XNN7:3 (170,-155)};
// (170,-154.6) @TEXT("VDD",size=1.1,halign="middle",valign="bottom");
// &"VSS" @WIRE(mode="straight",linecolor="#30485d",linewidth=0.16) {#XNN7:4 (170,-177)};
// (170,-177.4) @TEXT("VSS",size=1.1,halign="middle",valign="top");
// &"GNP7" @WIRE(mode="straight",linecolor="#30485d",linewidth=0.16) {#WNP7:2 (188,-167.65)};
// (187.6,-167.65) @TEXT("GNP7",size=1.1,halign="end",valign="middle");
// &"GPN7" @WIRE(mode="straight",linecolor="#30485d",linewidth=0.16) {#WPP7:1 (222,-164.35)};
// (221.6,-164.35) @TEXT("GPN7",size=1.1,halign="end",valign="middle");
// &"GPP7" @WIRE(mode="straight",linecolor="#30485d",linewidth=0.16) {#WPP7:2 (222,-167.65)};
// (221.6,-167.65) @TEXT("GPP7",size=1.1,halign="end",valign="middle");
// &"RST_DONE" @WIRE(mode="straight",linecolor="#30485d",linewidth=0.16) {#WUNUSED:1 (15,39.65)};
// (14.6,39.65) @TEXT("RST_DONE",size=1.1,halign="end",valign="middle");
// &"VSS" @WIRE(mode="straight",linecolor="#30485d",linewidth=0.16) {#WUNUSED:2 (15,36.35)};
// (14.6,36.35) @TEXT("VSS",size=1.1,halign="end",valign="middle");
// }
// END SARADC RNL
ends sar8i_refword

subckt sar8_next_word CODE0 CODE1 CODE2 CODE3 CODE4 CODE5 CODE6 CODE7 DATA DONE D0 D1 D2 D3 D4 D5 D6 D7 NEXT0 NEXT1 NEXT2 NEXT3 NEXT4 NEXT5 NEXT6 NEXT7 TRIAL6 TRIAL5 TRIAL4 TRIAL3 TRIAL2 VDD VSS
// Prefix ORs identify the current trial and are evaluated before DATA arrives.
X01 (CODE0 CODE1 ANY01 VDD VSS) OR2D1BWP12T30P140
X23 (CODE2 CODE3 ANY23 VDD VSS) OR2D1BWP12T30P140
X45 (CODE4 CODE5 ANY45 VDD VSS) OR2D1BWP12T30P140
X02 (ANY01 CODE2 ANY02 VDD VSS) OR2D1BWP12T30P140
X03 (ANY01 ANY23 ANY03 VDD VSS) OR2D1BWP12T30P140
X04 (ANY03 CODE4 LOW_BITS VDD VSS) OR2D1BWP12T30P140
X05 (ANY03 ANY45 ANY05 VDD VSS) OR2D1BWP12T30P140
X06 (ANY05 CODE6 ANY06 VDD VSS) OR2D1BWP12T30P140
XREAD0 (CODE0 DONE D0 VDD VSS) AN2D1BWP12T30P140
XEMPTY1 (CODE0 EMPTY1 VDD VSS) INVD1BWP12T30P140
XTRIAL1 (EMPTY1 CODE1 TRIAL1 VDD VSS) AN2D1BWP12T30P140
XVISIBLE1 (CODE0 DONE VISIBLE1 VDD VSS) OR2D1BWP12T30P140
XREAD1 (CODE1 VISIBLE1 D1 VDD VSS) AN2D1BWP12T30P140
XEMPTY2 (ANY01 EMPTY2 VDD VSS) INVD1BWP12T30P140
XTRIAL2 (EMPTY2 CODE2 TRIAL2 VDD VSS) AN2D1BWP12T30P140
XVISIBLE2 (ANY01 DONE VISIBLE2 VDD VSS) OR2D1BWP12T30P140
XREAD2 (CODE2 VISIBLE2 D2 VDD VSS) AN2D1BWP12T30P140
XEMPTY3 (ANY02 EMPTY3 VDD VSS) INVD1BWP12T30P140
XTRIAL3 (EMPTY3 CODE3 TRIAL3 VDD VSS) AN2D1BWP12T30P140
XVISIBLE3 (ANY02 DONE VISIBLE3 VDD VSS) OR2D1BWP12T30P140
XREAD3 (CODE3 VISIBLE3 D3 VDD VSS) AN2D1BWP12T30P140
XEMPTY4 (ANY03 EMPTY4 VDD VSS) INVD1BWP12T30P140
XTRIAL4 (EMPTY4 CODE4 TRIAL4 VDD VSS) AN2D1BWP12T30P140
XVISIBLE4 (ANY03 DONE VISIBLE4 VDD VSS) OR2D1BWP12T30P140
XREAD4 (CODE4 VISIBLE4 D4 VDD VSS) AN2D1BWP12T30P140
XEMPTY5 (LOW_BITS EMPTY5 VDD VSS) INVD1BWP12T30P140
XTRIAL5 (EMPTY5 CODE5 TRIAL5 VDD VSS) AN2D1BWP12T30P140
XVISIBLE5 (LOW_BITS DONE VISIBLE5 VDD VSS) OR2D1BWP12T30P140
XREAD5 (CODE5 VISIBLE5 D5 VDD VSS) AN2D1BWP12T30P140
XEMPTY6 (ANY05 EMPTY6 VDD VSS) INVD1BWP12T30P140
XTRIAL6 (EMPTY6 CODE6 TRIAL6 VDD VSS) AN2D1BWP12T30P140
XVISIBLE6 (ANY05 DONE VISIBLE6 VDD VSS) OR2D1BWP12T30P140
XREAD6 (CODE6 VISIBLE6 D6 VDD VSS) AN2D1BWP12T30P140
XEMPTY7 (ANY06 EMPTY7 VDD VSS) INVD1BWP12T30P140
XTRIAL7 (EMPTY7 CODE7 TRIAL7 VDD VSS) AN2D1BWP12T30P140
XVISIBLE7 (ANY06 DONE VISIBLE7 VDD VSS) OR2D1BWP12T30P140
XREAD7 (CODE7 VISIBLE7 D7 VDD VSS) AN2D1BWP12T30P140
XBASE0 (D0 TRIAL1 BASE0 VDD VSS) OR2D1BWP12T30P140
XKEEP0 (CODE0 DATA KEEP0 VDD VSS) AN2D1BWP12T30P140
XNEXT0 (BASE0 KEEP0 NEXT0 VDD VSS) OR2D1BWP12T30P140
XBASE1 (D1 TRIAL2 BASE1 VDD VSS) OR2D1BWP12T30P140
XKEEP1 (TRIAL1 DATA KEEP1 VDD VSS) AN2D1BWP12T30P140
XNEXT1 (BASE1 KEEP1 NEXT1 VDD VSS) OR2D1BWP12T30P140
XBASE2 (D2 TRIAL3 BASE2 VDD VSS) OR2D1BWP12T30P140
XKEEP2 (TRIAL2 DATA KEEP2 VDD VSS) AN2D1BWP12T30P140
XNEXT2 (BASE2 KEEP2 NEXT2 VDD VSS) OR2D1BWP12T30P140
XBASE3 (D3 TRIAL4 BASE3 VDD VSS) OR2D1BWP12T30P140
XKEEP3 (TRIAL3 DATA KEEP3 VDD VSS) AN2D1BWP12T30P140
XNEXT3 (BASE3 KEEP3 NEXT3 VDD VSS) OR2D1BWP12T30P140
XBASE4 (D4 TRIAL5 BASE4 VDD VSS) OR2D1BWP12T30P140
XKEEP4 (TRIAL4 DATA KEEP4 VDD VSS) AN2D1BWP12T30P140
XNEXT4 (BASE4 KEEP4 NEXT4 VDD VSS) OR2D1BWP12T30P140
XBASE5 (D5 TRIAL6 BASE5 VDD VSS) OR2D1BWP12T30P140
XKEEP5 (TRIAL5 DATA KEEP5 VDD VSS) AN2D1BWP12T30P140
XNEXT5 (BASE5 KEEP5 NEXT5 VDD VSS) OR2D1BWP12T30P140
XBASE6 (D6 TRIAL7 BASE6 VDD VSS) OR2D1BWP12T30P140
XKEEP6 (TRIAL6 DATA KEEP6 VDD VSS) AN2D1BWP12T30P140
XNEXT6 (BASE6 KEEP6 NEXT6 VDD VSS) OR2D1BWP12T30P140
XKEEP7 (TRIAL7 DATA KEEP7 VDD VSS) AN2D1BWP12T30P140
XNEXT7 (D7 KEEP7 NEXT7 VDD VSS) OR2D1BWP12T30P140
// BEGIN SARADC RNL
// @RNL(author="saradc topology") {
// (-18,45) @TEXT("Next trial word",size=2,halign="start",textcolor="#223d52");
// #X01 @SET-SYMBOL $S_OR2D1BWP12T30P140;
// #X01 @PLACE(0,22) => @ORIENT("R0");
// #X23 @SET-SYMBOL $S_OR2D1BWP12T30P140;
// #X23 @PLACE(34,22) => @ORIENT("R0");
// #X45 @SET-SYMBOL $S_OR2D1BWP12T30P140;
// #X45 @PLACE(68,22) => @ORIENT("R0");
// #X02 @SET-SYMBOL $S_OR2D1BWP12T30P140;
// #X02 @PLACE(102,22) => @ORIENT("R0");
// #X03 @SET-SYMBOL $S_OR2D1BWP12T30P140;
// #X03 @PLACE(136,22) => @ORIENT("R0");
// #X04 @SET-SYMBOL $S_OR2D1BWP12T30P140;
// #X04 @PLACE(170,22) => @ORIENT("R0");
// #X05 @SET-SYMBOL $S_OR2D1BWP12T30P140;
// #X05 @PLACE(204,22) => @ORIENT("R0");
// #X06 @SET-SYMBOL $S_OR2D1BWP12T30P140;
// #X06 @PLACE(238,22) => @ORIENT("R0");
// (-24,-5) @TEXT("Bit 0",size=1.2,halign="start",textcolor="#223d52");
// #XREAD0 @SET-SYMBOL $S_AN2D1BWP12T30P140;
// #XREAD0 @PLACE(105,-12) => @ORIENT("R0");
// #XBASE0 @SET-SYMBOL $S_OR2D1BWP12T30P140;
// #XBASE0 @PLACE(140,-12) => @ORIENT("R0");
// #XKEEP0 @SET-SYMBOL $S_AN2D1BWP12T30P140;
// #XKEEP0 @PLACE(175,-12) => @ORIENT("R0");
// #XNEXT0 @SET-SYMBOL $S_OR2D1BWP12T30P140;
// #XNEXT0 @PLACE(210,-12) => @ORIENT("R0");
// (-24,-37) @TEXT("Bit 1",size=1.2,halign="start",textcolor="#223d52");
// #XEMPTY1 @SET-SYMBOL $S_INVD1BWP12T30P140;
// #XEMPTY1 @PLACE(0,-44) => @ORIENT("R0");
// #XTRIAL1 @SET-SYMBOL $S_AN2D1BWP12T30P140;
// #XTRIAL1 @PLACE(35,-44) => @ORIENT("R0");
// #XVISIBLE1 @SET-SYMBOL $S_OR2D1BWP12T30P140;
// #XVISIBLE1 @PLACE(70,-44) => @ORIENT("R0");
// #XREAD1 @SET-SYMBOL $S_AN2D1BWP12T30P140;
// #XREAD1 @PLACE(105,-44) => @ORIENT("R0");
// #XBASE1 @SET-SYMBOL $S_OR2D1BWP12T30P140;
// #XBASE1 @PLACE(140,-44) => @ORIENT("R0");
// #XKEEP1 @SET-SYMBOL $S_AN2D1BWP12T30P140;
// #XKEEP1 @PLACE(175,-44) => @ORIENT("R0");
// #XNEXT1 @SET-SYMBOL $S_OR2D1BWP12T30P140;
// #XNEXT1 @PLACE(210,-44) => @ORIENT("R0");
// (-24,-69) @TEXT("Bit 2",size=1.2,halign="start",textcolor="#223d52");
// #XEMPTY2 @SET-SYMBOL $S_INVD1BWP12T30P140;
// #XEMPTY2 @PLACE(0,-76) => @ORIENT("R0");
// #XTRIAL2 @SET-SYMBOL $S_AN2D1BWP12T30P140;
// #XTRIAL2 @PLACE(35,-76) => @ORIENT("R0");
// #XVISIBLE2 @SET-SYMBOL $S_OR2D1BWP12T30P140;
// #XVISIBLE2 @PLACE(70,-76) => @ORIENT("R0");
// #XREAD2 @SET-SYMBOL $S_AN2D1BWP12T30P140;
// #XREAD2 @PLACE(105,-76) => @ORIENT("R0");
// #XBASE2 @SET-SYMBOL $S_OR2D1BWP12T30P140;
// #XBASE2 @PLACE(140,-76) => @ORIENT("R0");
// #XKEEP2 @SET-SYMBOL $S_AN2D1BWP12T30P140;
// #XKEEP2 @PLACE(175,-76) => @ORIENT("R0");
// #XNEXT2 @SET-SYMBOL $S_OR2D1BWP12T30P140;
// #XNEXT2 @PLACE(210,-76) => @ORIENT("R0");
// (-24,-101) @TEXT("Bit 3",size=1.2,halign="start",textcolor="#223d52");
// #XEMPTY3 @SET-SYMBOL $S_INVD1BWP12T30P140;
// #XEMPTY3 @PLACE(0,-108) => @ORIENT("R0");
// #XTRIAL3 @SET-SYMBOL $S_AN2D1BWP12T30P140;
// #XTRIAL3 @PLACE(35,-108) => @ORIENT("R0");
// #XVISIBLE3 @SET-SYMBOL $S_OR2D1BWP12T30P140;
// #XVISIBLE3 @PLACE(70,-108) => @ORIENT("R0");
// #XREAD3 @SET-SYMBOL $S_AN2D1BWP12T30P140;
// #XREAD3 @PLACE(105,-108) => @ORIENT("R0");
// #XBASE3 @SET-SYMBOL $S_OR2D1BWP12T30P140;
// #XBASE3 @PLACE(140,-108) => @ORIENT("R0");
// #XKEEP3 @SET-SYMBOL $S_AN2D1BWP12T30P140;
// #XKEEP3 @PLACE(175,-108) => @ORIENT("R0");
// #XNEXT3 @SET-SYMBOL $S_OR2D1BWP12T30P140;
// #XNEXT3 @PLACE(210,-108) => @ORIENT("R0");
// (-24,-133) @TEXT("Bit 4",size=1.2,halign="start",textcolor="#223d52");
// #XEMPTY4 @SET-SYMBOL $S_INVD1BWP12T30P140;
// #XEMPTY4 @PLACE(0,-140) => @ORIENT("R0");
// #XTRIAL4 @SET-SYMBOL $S_AN2D1BWP12T30P140;
// #XTRIAL4 @PLACE(35,-140) => @ORIENT("R0");
// #XVISIBLE4 @SET-SYMBOL $S_OR2D1BWP12T30P140;
// #XVISIBLE4 @PLACE(70,-140) => @ORIENT("R0");
// #XREAD4 @SET-SYMBOL $S_AN2D1BWP12T30P140;
// #XREAD4 @PLACE(105,-140) => @ORIENT("R0");
// #XBASE4 @SET-SYMBOL $S_OR2D1BWP12T30P140;
// #XBASE4 @PLACE(140,-140) => @ORIENT("R0");
// #XKEEP4 @SET-SYMBOL $S_AN2D1BWP12T30P140;
// #XKEEP4 @PLACE(175,-140) => @ORIENT("R0");
// #XNEXT4 @SET-SYMBOL $S_OR2D1BWP12T30P140;
// #XNEXT4 @PLACE(210,-140) => @ORIENT("R0");
// (-24,-165) @TEXT("Bit 5",size=1.2,halign="start",textcolor="#223d52");
// #XEMPTY5 @SET-SYMBOL $S_INVD1BWP12T30P140;
// #XEMPTY5 @PLACE(0,-172) => @ORIENT("R0");
// #XTRIAL5 @SET-SYMBOL $S_AN2D1BWP12T30P140;
// #XTRIAL5 @PLACE(35,-172) => @ORIENT("R0");
// #XVISIBLE5 @SET-SYMBOL $S_OR2D1BWP12T30P140;
// #XVISIBLE5 @PLACE(70,-172) => @ORIENT("R0");
// #XREAD5 @SET-SYMBOL $S_AN2D1BWP12T30P140;
// #XREAD5 @PLACE(105,-172) => @ORIENT("R0");
// #XBASE5 @SET-SYMBOL $S_OR2D1BWP12T30P140;
// #XBASE5 @PLACE(140,-172) => @ORIENT("R0");
// #XKEEP5 @SET-SYMBOL $S_AN2D1BWP12T30P140;
// #XKEEP5 @PLACE(175,-172) => @ORIENT("R0");
// #XNEXT5 @SET-SYMBOL $S_OR2D1BWP12T30P140;
// #XNEXT5 @PLACE(210,-172) => @ORIENT("R0");
// (-24,-197) @TEXT("Bit 6",size=1.2,halign="start",textcolor="#223d52");
// #XEMPTY6 @SET-SYMBOL $S_INVD1BWP12T30P140;
// #XEMPTY6 @PLACE(0,-204) => @ORIENT("R0");
// #XTRIAL6 @SET-SYMBOL $S_AN2D1BWP12T30P140;
// #XTRIAL6 @PLACE(35,-204) => @ORIENT("R0");
// #XVISIBLE6 @SET-SYMBOL $S_OR2D1BWP12T30P140;
// #XVISIBLE6 @PLACE(70,-204) => @ORIENT("R0");
// #XREAD6 @SET-SYMBOL $S_AN2D1BWP12T30P140;
// #XREAD6 @PLACE(105,-204) => @ORIENT("R0");
// #XBASE6 @SET-SYMBOL $S_OR2D1BWP12T30P140;
// #XBASE6 @PLACE(140,-204) => @ORIENT("R0");
// #XKEEP6 @SET-SYMBOL $S_AN2D1BWP12T30P140;
// #XKEEP6 @PLACE(175,-204) => @ORIENT("R0");
// #XNEXT6 @SET-SYMBOL $S_OR2D1BWP12T30P140;
// #XNEXT6 @PLACE(210,-204) => @ORIENT("R0");
// (-24,-229) @TEXT("Bit 7",size=1.2,halign="start",textcolor="#223d52");
// #XEMPTY7 @SET-SYMBOL $S_INVD1BWP12T30P140;
// #XEMPTY7 @PLACE(0,-236) => @ORIENT("R0");
// #XTRIAL7 @SET-SYMBOL $S_AN2D1BWP12T30P140;
// #XTRIAL7 @PLACE(35,-236) => @ORIENT("R0");
// #XVISIBLE7 @SET-SYMBOL $S_OR2D1BWP12T30P140;
// #XVISIBLE7 @PLACE(70,-236) => @ORIENT("R0");
// #XREAD7 @SET-SYMBOL $S_AN2D1BWP12T30P140;
// #XREAD7 @PLACE(105,-236) => @ORIENT("R0");
// #XKEEP7 @SET-SYMBOL $S_AN2D1BWP12T30P140;
// #XKEEP7 @PLACE(175,-236) => @ORIENT("R0");
// #XNEXT7 @SET-SYMBOL $S_OR2D1BWP12T30P140;
// #XNEXT7 @PLACE(210,-236) => @ORIENT("R0");
// &"D0" @WIRE(mode="straight",linecolor="#30485d",linewidth=0.16) {#XREAD0:3 (122.5,-12) (122.5,-10.35) #XBASE0:1};
// &"EMPTY1" @WIRE(mode="straight",linecolor="#30485d",linewidth=0.16) {#XEMPTY1:2 (14.5,-44) (14.5,-42.35) #XTRIAL1:1};
// &"VISIBLE1" @WIRE(mode="straight",linecolor="#30485d",linewidth=0.16) {#XVISIBLE1:3 (87.5,-44) (87.5,-45.65) #XREAD1:2};
// &"D1" @WIRE(mode="straight",linecolor="#30485d",linewidth=0.16) {#XREAD1:3 (122.5,-44) (122.5,-42.35) #XBASE1:1};
// &"EMPTY2" @WIRE(mode="straight",linecolor="#30485d",linewidth=0.16) {#XEMPTY2:2 (14.5,-76) (14.5,-74.35) #XTRIAL2:1};
// &"VISIBLE2" @WIRE(mode="straight",linecolor="#30485d",linewidth=0.16) {#XVISIBLE2:3 (87.5,-76) (87.5,-77.65) #XREAD2:2};
// &"D2" @WIRE(mode="straight",linecolor="#30485d",linewidth=0.16) {#XREAD2:3 (122.5,-76) (122.5,-74.35) #XBASE2:1};
// &"EMPTY3" @WIRE(mode="straight",linecolor="#30485d",linewidth=0.16) {#XEMPTY3:2 (14.5,-108) (14.5,-106.35) #XTRIAL3:1};
// &"VISIBLE3" @WIRE(mode="straight",linecolor="#30485d",linewidth=0.16) {#XVISIBLE3:3 (87.5,-108) (87.5,-109.65) #XREAD3:2};
// &"D3" @WIRE(mode="straight",linecolor="#30485d",linewidth=0.16) {#XREAD3:3 (122.5,-108) (122.5,-106.35) #XBASE3:1};
// &"EMPTY4" @WIRE(mode="straight",linecolor="#30485d",linewidth=0.16) {#XEMPTY4:2 (14.5,-140) (14.5,-138.35) #XTRIAL4:1};
// &"VISIBLE4" @WIRE(mode="straight",linecolor="#30485d",linewidth=0.16) {#XVISIBLE4:3 (87.5,-140) (87.5,-141.65) #XREAD4:2};
// &"D4" @WIRE(mode="straight",linecolor="#30485d",linewidth=0.16) {#XREAD4:3 (122.5,-140) (122.5,-138.35) #XBASE4:1};
// &"EMPTY5" @WIRE(mode="straight",linecolor="#30485d",linewidth=0.16) {#XEMPTY5:2 (14.5,-172) (14.5,-170.35) #XTRIAL5:1};
// &"VISIBLE5" @WIRE(mode="straight",linecolor="#30485d",linewidth=0.16) {#XVISIBLE5:3 (87.5,-172) (87.5,-173.65) #XREAD5:2};
// &"D5" @WIRE(mode="straight",linecolor="#30485d",linewidth=0.16) {#XREAD5:3 (122.5,-172) (122.5,-170.35) #XBASE5:1};
// &"EMPTY6" @WIRE(mode="straight",linecolor="#30485d",linewidth=0.16) {#XEMPTY6:2 (14.5,-204) (14.5,-202.35) #XTRIAL6:1};
// &"VISIBLE6" @WIRE(mode="straight",linecolor="#30485d",linewidth=0.16) {#XVISIBLE6:3 (87.5,-204) (87.5,-205.65) #XREAD6:2};
// &"D6" @WIRE(mode="straight",linecolor="#30485d",linewidth=0.16) {#XREAD6:3 (122.5,-204) (122.5,-202.35) #XBASE6:1};
// &"EMPTY7" @WIRE(mode="straight",linecolor="#30485d",linewidth=0.16) {#XEMPTY7:2 (14.5,-236) (14.5,-234.35) #XTRIAL7:1};
// &"VISIBLE7" @WIRE(mode="straight",linecolor="#30485d",linewidth=0.16) {#XVISIBLE7:3 (87.5,-236) (87.5,-237.65) #XREAD7:2};
// &"KEEP0" @WIRE(mode="straight",linecolor="#30485d",linewidth=0.16) {#XKEEP0:3 (192.5,-12) (192.5,-13.65) #XNEXT0:2};
// &"KEEP1" @WIRE(mode="straight",linecolor="#30485d",linewidth=0.16) {#XKEEP1:3 (192.5,-44) (192.5,-45.65) #XNEXT1:2};
// &"KEEP2" @WIRE(mode="straight",linecolor="#30485d",linewidth=0.16) {#XKEEP2:3 (192.5,-76) (192.5,-77.65) #XNEXT2:2};
// &"KEEP3" @WIRE(mode="straight",linecolor="#30485d",linewidth=0.16) {#XKEEP3:3 (192.5,-108) (192.5,-109.65) #XNEXT3:2};
// &"KEEP4" @WIRE(mode="straight",linecolor="#30485d",linewidth=0.16) {#XKEEP4:3 (192.5,-140) (192.5,-141.65) #XNEXT4:2};
// &"KEEP5" @WIRE(mode="straight",linecolor="#30485d",linewidth=0.16) {#XKEEP5:3 (192.5,-172) (192.5,-173.65) #XNEXT5:2};
// &"KEEP6" @WIRE(mode="straight",linecolor="#30485d",linewidth=0.16) {#XKEEP6:3 (192.5,-204) (192.5,-205.65) #XNEXT6:2};
// &"KEEP7" @WIRE(mode="straight",linecolor="#30485d",linewidth=0.16) {#XKEEP7:3 (192.5,-236) (192.5,-237.65) #XNEXT7:2};
// &"CODE0" @WIRE(mode="straight",linecolor="#30485d",linewidth=0.16) {#X01:1 (-16,23.65)};
// (-16.4,23.65) @TEXT("CODE0",size=1.1,halign="end",valign="middle");
// &"CODE1" @WIRE(mode="straight",linecolor="#30485d",linewidth=0.16) {#X01:2 (-16,20.35)};
// (-16.4,20.35) @TEXT("CODE1",size=1.1,halign="end",valign="middle");
// &"ANY01" @WIRE(mode="straight",linecolor="#30485d",linewidth=0.16) {#X01:3 (16,22)};
// (16.4,22) @TEXT("ANY01",size=1.1,halign="start",valign="middle");
// &"VDD" @WIRE(mode="straight",linecolor="#30485d",linewidth=0.16) {#X01:4 (0,33)};
// (0,33.4) @TEXT("VDD",size=1.1,halign="middle",valign="bottom");
// &"VSS" @WIRE(mode="straight",linecolor="#30485d",linewidth=0.16) {#X01:5 (0,11)};
// (0,10.6) @TEXT("VSS",size=1.1,halign="middle",valign="top");
// &"CODE2" @WIRE(mode="straight",linecolor="#30485d",linewidth=0.16) {#X23:1 (18,23.65)};
// (17.6,23.65) @TEXT("CODE2",size=1.1,halign="end",valign="middle");
// &"CODE3" @WIRE(mode="straight",linecolor="#30485d",linewidth=0.16) {#X23:2 (18,20.35)};
// (17.6,20.35) @TEXT("CODE3",size=1.1,halign="end",valign="middle");
// &"ANY23" @WIRE(mode="straight",linecolor="#30485d",linewidth=0.16) {#X23:3 (50,22)};
// (50.4,22) @TEXT("ANY23",size=1.1,halign="start",valign="middle");
// &"VDD" @WIRE(mode="straight",linecolor="#30485d",linewidth=0.16) {#X23:4 (34,33)};
// (34,33.4) @TEXT("VDD",size=1.1,halign="middle",valign="bottom");
// &"VSS" @WIRE(mode="straight",linecolor="#30485d",linewidth=0.16) {#X23:5 (34,11)};
// (34,10.6) @TEXT("VSS",size=1.1,halign="middle",valign="top");
// &"CODE4" @WIRE(mode="straight",linecolor="#30485d",linewidth=0.16) {#X45:1 (52,23.65)};
// (51.6,23.65) @TEXT("CODE4",size=1.1,halign="end",valign="middle");
// &"CODE5" @WIRE(mode="straight",linecolor="#30485d",linewidth=0.16) {#X45:2 (52,20.35)};
// (51.6,20.35) @TEXT("CODE5",size=1.1,halign="end",valign="middle");
// &"ANY45" @WIRE(mode="straight",linecolor="#30485d",linewidth=0.16) {#X45:3 (84,22)};
// (84.4,22) @TEXT("ANY45",size=1.1,halign="start",valign="middle");
// &"VDD" @WIRE(mode="straight",linecolor="#30485d",linewidth=0.16) {#X45:4 (68,33)};
// (68,33.4) @TEXT("VDD",size=1.1,halign="middle",valign="bottom");
// &"VSS" @WIRE(mode="straight",linecolor="#30485d",linewidth=0.16) {#X45:5 (68,11)};
// (68,10.6) @TEXT("VSS",size=1.1,halign="middle",valign="top");
// &"ANY01" @WIRE(mode="straight",linecolor="#30485d",linewidth=0.16) {#X02:1 (86,23.65)};
// (85.6,23.65) @TEXT("ANY01",size=1.1,halign="end",valign="middle");
// &"CODE2" @WIRE(mode="straight",linecolor="#30485d",linewidth=0.16) {#X02:2 (86,20.35)};
// (85.6,20.35) @TEXT("CODE2",size=1.1,halign="end",valign="middle");
// &"ANY02" @WIRE(mode="straight",linecolor="#30485d",linewidth=0.16) {#X02:3 (118,22)};
// (118.4,22) @TEXT("ANY02",size=1.1,halign="start",valign="middle");
// &"VDD" @WIRE(mode="straight",linecolor="#30485d",linewidth=0.16) {#X02:4 (102,33)};
// (102,33.4) @TEXT("VDD",size=1.1,halign="middle",valign="bottom");
// &"VSS" @WIRE(mode="straight",linecolor="#30485d",linewidth=0.16) {#X02:5 (102,11)};
// (102,10.6) @TEXT("VSS",size=1.1,halign="middle",valign="top");
// &"ANY01" @WIRE(mode="straight",linecolor="#30485d",linewidth=0.16) {#X03:1 (120,23.65)};
// (119.6,23.65) @TEXT("ANY01",size=1.1,halign="end",valign="middle");
// &"ANY23" @WIRE(mode="straight",linecolor="#30485d",linewidth=0.16) {#X03:2 (120,20.35)};
// (119.6,20.35) @TEXT("ANY23",size=1.1,halign="end",valign="middle");
// &"ANY03" @WIRE(mode="straight",linecolor="#30485d",linewidth=0.16) {#X03:3 (152,22)};
// (152.4,22) @TEXT("ANY03",size=1.1,halign="start",valign="middle");
// &"VDD" @WIRE(mode="straight",linecolor="#30485d",linewidth=0.16) {#X03:4 (136,33)};
// (136,33.4) @TEXT("VDD",size=1.1,halign="middle",valign="bottom");
// &"VSS" @WIRE(mode="straight",linecolor="#30485d",linewidth=0.16) {#X03:5 (136,11)};
// (136,10.6) @TEXT("VSS",size=1.1,halign="middle",valign="top");
// &"ANY03" @WIRE(mode="straight",linecolor="#30485d",linewidth=0.16) {#X04:1 (154,23.65)};
// (153.6,23.65) @TEXT("ANY03",size=1.1,halign="end",valign="middle");
// &"CODE4" @WIRE(mode="straight",linecolor="#30485d",linewidth=0.16) {#X04:2 (154,20.35)};
// (153.6,20.35) @TEXT("CODE4",size=1.1,halign="end",valign="middle");
// &"LOW_BITS" @WIRE(mode="straight",linecolor="#30485d",linewidth=0.16) {#X04:3 (186,22)};
// (186.4,22) @TEXT("LOW_BITS",size=1.1,halign="start",valign="middle");
// &"VDD" @WIRE(mode="straight",linecolor="#30485d",linewidth=0.16) {#X04:4 (170,33)};
// (170,33.4) @TEXT("VDD",size=1.1,halign="middle",valign="bottom");
// &"VSS" @WIRE(mode="straight",linecolor="#30485d",linewidth=0.16) {#X04:5 (170,11)};
// (170,10.6) @TEXT("VSS",size=1.1,halign="middle",valign="top");
// &"ANY03" @WIRE(mode="straight",linecolor="#30485d",linewidth=0.16) {#X05:1 (188,23.65)};
// (187.6,23.65) @TEXT("ANY03",size=1.1,halign="end",valign="middle");
// &"ANY45" @WIRE(mode="straight",linecolor="#30485d",linewidth=0.16) {#X05:2 (188,20.35)};
// (187.6,20.35) @TEXT("ANY45",size=1.1,halign="end",valign="middle");
// &"ANY05" @WIRE(mode="straight",linecolor="#30485d",linewidth=0.16) {#X05:3 (220,22)};
// (220.4,22) @TEXT("ANY05",size=1.1,halign="start",valign="middle");
// &"VDD" @WIRE(mode="straight",linecolor="#30485d",linewidth=0.16) {#X05:4 (204,33)};
// (204,33.4) @TEXT("VDD",size=1.1,halign="middle",valign="bottom");
// &"VSS" @WIRE(mode="straight",linecolor="#30485d",linewidth=0.16) {#X05:5 (204,11)};
// (204,10.6) @TEXT("VSS",size=1.1,halign="middle",valign="top");
// &"ANY05" @WIRE(mode="straight",linecolor="#30485d",linewidth=0.16) {#X06:1 (222,23.65)};
// (221.6,23.65) @TEXT("ANY05",size=1.1,halign="end",valign="middle");
// &"CODE6" @WIRE(mode="straight",linecolor="#30485d",linewidth=0.16) {#X06:2 (222,20.35)};
// (221.6,20.35) @TEXT("CODE6",size=1.1,halign="end",valign="middle");
// &"ANY06" @WIRE(mode="straight",linecolor="#30485d",linewidth=0.16) {#X06:3 (254,22)};
// (254.4,22) @TEXT("ANY06",size=1.1,halign="start",valign="middle");
// &"VDD" @WIRE(mode="straight",linecolor="#30485d",linewidth=0.16) {#X06:4 (238,33)};
// (238,33.4) @TEXT("VDD",size=1.1,halign="middle",valign="bottom");
// &"VSS" @WIRE(mode="straight",linecolor="#30485d",linewidth=0.16) {#X06:5 (238,11)};
// (238,10.6) @TEXT("VSS",size=1.1,halign="middle",valign="top");
// &"CODE0" @WIRE(mode="straight",linecolor="#30485d",linewidth=0.16) {#XREAD0:1 (89,-10.35)};
// (88.6,-10.35) @TEXT("CODE0",size=1.1,halign="end",valign="middle");
// &"DONE" @WIRE(mode="straight",linecolor="#30485d",linewidth=0.16) {#XREAD0:2 (89,-13.65)};
// (88.6,-13.65) @TEXT("DONE",size=1.1,halign="end",valign="middle");
// &"VDD" @WIRE(mode="straight",linecolor="#30485d",linewidth=0.16) {#XREAD0:4 (105,-1)};
// (105,-0.6) @TEXT("VDD",size=1.1,halign="middle",valign="bottom");
// &"VSS" @WIRE(mode="straight",linecolor="#30485d",linewidth=0.16) {#XREAD0:5 (105,-23)};
// (105,-23.4) @TEXT("VSS",size=1.1,halign="middle",valign="top");
// &"CODE0" @WIRE(mode="straight",linecolor="#30485d",linewidth=0.16) {#XEMPTY1:1 (-10,-44)};
// (-10.4,-44) @TEXT("CODE0",size=1.1,halign="end",valign="middle");
// &"VDD" @WIRE(mode="straight",linecolor="#30485d",linewidth=0.16) {#XEMPTY1:3 (0,-34)};
// (0,-33.6) @TEXT("VDD",size=1.1,halign="middle",valign="bottom");
// &"VSS" @WIRE(mode="straight",linecolor="#30485d",linewidth=0.16) {#XEMPTY1:4 (0,-54)};
// (0,-54.4) @TEXT("VSS",size=1.1,halign="middle",valign="top");
// &"CODE1" @WIRE(mode="straight",linecolor="#30485d",linewidth=0.16) {#XTRIAL1:2 (19,-45.65)};
// (18.6,-45.65) @TEXT("CODE1",size=1.1,halign="end",valign="middle");
// &"TRIAL1" @WIRE(mode="straight",linecolor="#30485d",linewidth=0.16) {#XTRIAL1:3 (51,-44)};
// (51.4,-44) @TEXT("TRIAL1",size=1.1,halign="start",valign="middle");
// &"VDD" @WIRE(mode="straight",linecolor="#30485d",linewidth=0.16) {#XTRIAL1:4 (35,-33)};
// (35,-32.6) @TEXT("VDD",size=1.1,halign="middle",valign="bottom");
// &"VSS" @WIRE(mode="straight",linecolor="#30485d",linewidth=0.16) {#XTRIAL1:5 (35,-55)};
// (35,-55.4) @TEXT("VSS",size=1.1,halign="middle",valign="top");
// &"CODE0" @WIRE(mode="straight",linecolor="#30485d",linewidth=0.16) {#XVISIBLE1:1 (54,-42.35)};
// (53.6,-42.35) @TEXT("CODE0",size=1.1,halign="end",valign="middle");
// &"DONE" @WIRE(mode="straight",linecolor="#30485d",linewidth=0.16) {#XVISIBLE1:2 (54,-45.65)};
// (53.6,-45.65) @TEXT("DONE",size=1.1,halign="end",valign="middle");
// &"VDD" @WIRE(mode="straight",linecolor="#30485d",linewidth=0.16) {#XVISIBLE1:4 (70,-33)};
// (70,-32.6) @TEXT("VDD",size=1.1,halign="middle",valign="bottom");
// &"VSS" @WIRE(mode="straight",linecolor="#30485d",linewidth=0.16) {#XVISIBLE1:5 (70,-55)};
// (70,-55.4) @TEXT("VSS",size=1.1,halign="middle",valign="top");
// &"CODE1" @WIRE(mode="straight",linecolor="#30485d",linewidth=0.16) {#XREAD1:1 (89,-42.35)};
// (88.6,-42.35) @TEXT("CODE1",size=1.1,halign="end",valign="middle");
// &"VDD" @WIRE(mode="straight",linecolor="#30485d",linewidth=0.16) {#XREAD1:4 (105,-33)};
// (105,-32.6) @TEXT("VDD",size=1.1,halign="middle",valign="bottom");
// &"VSS" @WIRE(mode="straight",linecolor="#30485d",linewidth=0.16) {#XREAD1:5 (105,-55)};
// (105,-55.4) @TEXT("VSS",size=1.1,halign="middle",valign="top");
// &"ANY01" @WIRE(mode="straight",linecolor="#30485d",linewidth=0.16) {#XEMPTY2:1 (-10,-76)};
// (-10.4,-76) @TEXT("ANY01",size=1.1,halign="end",valign="middle");
// &"VDD" @WIRE(mode="straight",linecolor="#30485d",linewidth=0.16) {#XEMPTY2:3 (0,-66)};
// (0,-65.6) @TEXT("VDD",size=1.1,halign="middle",valign="bottom");
// &"VSS" @WIRE(mode="straight",linecolor="#30485d",linewidth=0.16) {#XEMPTY2:4 (0,-86)};
// (0,-86.4) @TEXT("VSS",size=1.1,halign="middle",valign="top");
// &"CODE2" @WIRE(mode="straight",linecolor="#30485d",linewidth=0.16) {#XTRIAL2:2 (19,-77.65)};
// (18.6,-77.65) @TEXT("CODE2",size=1.1,halign="end",valign="middle");
// &"TRIAL2" @WIRE(mode="straight",linecolor="#30485d",linewidth=0.16) {#XTRIAL2:3 (51,-76)};
// (51.4,-76) @TEXT("TRIAL2",size=1.1,halign="start",valign="middle");
// &"VDD" @WIRE(mode="straight",linecolor="#30485d",linewidth=0.16) {#XTRIAL2:4 (35,-65)};
// (35,-64.6) @TEXT("VDD",size=1.1,halign="middle",valign="bottom");
// &"VSS" @WIRE(mode="straight",linecolor="#30485d",linewidth=0.16) {#XTRIAL2:5 (35,-87)};
// (35,-87.4) @TEXT("VSS",size=1.1,halign="middle",valign="top");
// &"ANY01" @WIRE(mode="straight",linecolor="#30485d",linewidth=0.16) {#XVISIBLE2:1 (54,-74.35)};
// (53.6,-74.35) @TEXT("ANY01",size=1.1,halign="end",valign="middle");
// &"DONE" @WIRE(mode="straight",linecolor="#30485d",linewidth=0.16) {#XVISIBLE2:2 (54,-77.65)};
// (53.6,-77.65) @TEXT("DONE",size=1.1,halign="end",valign="middle");
// &"VDD" @WIRE(mode="straight",linecolor="#30485d",linewidth=0.16) {#XVISIBLE2:4 (70,-65)};
// (70,-64.6) @TEXT("VDD",size=1.1,halign="middle",valign="bottom");
// &"VSS" @WIRE(mode="straight",linecolor="#30485d",linewidth=0.16) {#XVISIBLE2:5 (70,-87)};
// (70,-87.4) @TEXT("VSS",size=1.1,halign="middle",valign="top");
// &"CODE2" @WIRE(mode="straight",linecolor="#30485d",linewidth=0.16) {#XREAD2:1 (89,-74.35)};
// (88.6,-74.35) @TEXT("CODE2",size=1.1,halign="end",valign="middle");
// &"VDD" @WIRE(mode="straight",linecolor="#30485d",linewidth=0.16) {#XREAD2:4 (105,-65)};
// (105,-64.6) @TEXT("VDD",size=1.1,halign="middle",valign="bottom");
// &"VSS" @WIRE(mode="straight",linecolor="#30485d",linewidth=0.16) {#XREAD2:5 (105,-87)};
// (105,-87.4) @TEXT("VSS",size=1.1,halign="middle",valign="top");
// &"ANY02" @WIRE(mode="straight",linecolor="#30485d",linewidth=0.16) {#XEMPTY3:1 (-10,-108)};
// (-10.4,-108) @TEXT("ANY02",size=1.1,halign="end",valign="middle");
// &"VDD" @WIRE(mode="straight",linecolor="#30485d",linewidth=0.16) {#XEMPTY3:3 (0,-98)};
// (0,-97.6) @TEXT("VDD",size=1.1,halign="middle",valign="bottom");
// &"VSS" @WIRE(mode="straight",linecolor="#30485d",linewidth=0.16) {#XEMPTY3:4 (0,-118)};
// (0,-118.4) @TEXT("VSS",size=1.1,halign="middle",valign="top");
// &"CODE3" @WIRE(mode="straight",linecolor="#30485d",linewidth=0.16) {#XTRIAL3:2 (19,-109.65)};
// (18.6,-109.65) @TEXT("CODE3",size=1.1,halign="end",valign="middle");
// &"TRIAL3" @WIRE(mode="straight",linecolor="#30485d",linewidth=0.16) {#XTRIAL3:3 (51,-108)};
// (51.4,-108) @TEXT("TRIAL3",size=1.1,halign="start",valign="middle");
// &"VDD" @WIRE(mode="straight",linecolor="#30485d",linewidth=0.16) {#XTRIAL3:4 (35,-97)};
// (35,-96.6) @TEXT("VDD",size=1.1,halign="middle",valign="bottom");
// &"VSS" @WIRE(mode="straight",linecolor="#30485d",linewidth=0.16) {#XTRIAL3:5 (35,-119)};
// (35,-119.4) @TEXT("VSS",size=1.1,halign="middle",valign="top");
// &"ANY02" @WIRE(mode="straight",linecolor="#30485d",linewidth=0.16) {#XVISIBLE3:1 (54,-106.35)};
// (53.6,-106.35) @TEXT("ANY02",size=1.1,halign="end",valign="middle");
// &"DONE" @WIRE(mode="straight",linecolor="#30485d",linewidth=0.16) {#XVISIBLE3:2 (54,-109.65)};
// (53.6,-109.65) @TEXT("DONE",size=1.1,halign="end",valign="middle");
// &"VDD" @WIRE(mode="straight",linecolor="#30485d",linewidth=0.16) {#XVISIBLE3:4 (70,-97)};
// (70,-96.6) @TEXT("VDD",size=1.1,halign="middle",valign="bottom");
// &"VSS" @WIRE(mode="straight",linecolor="#30485d",linewidth=0.16) {#XVISIBLE3:5 (70,-119)};
// (70,-119.4) @TEXT("VSS",size=1.1,halign="middle",valign="top");
// &"CODE3" @WIRE(mode="straight",linecolor="#30485d",linewidth=0.16) {#XREAD3:1 (89,-106.35)};
// (88.6,-106.35) @TEXT("CODE3",size=1.1,halign="end",valign="middle");
// &"VDD" @WIRE(mode="straight",linecolor="#30485d",linewidth=0.16) {#XREAD3:4 (105,-97)};
// (105,-96.6) @TEXT("VDD",size=1.1,halign="middle",valign="bottom");
// &"VSS" @WIRE(mode="straight",linecolor="#30485d",linewidth=0.16) {#XREAD3:5 (105,-119)};
// (105,-119.4) @TEXT("VSS",size=1.1,halign="middle",valign="top");
// &"ANY03" @WIRE(mode="straight",linecolor="#30485d",linewidth=0.16) {#XEMPTY4:1 (-10,-140)};
// (-10.4,-140) @TEXT("ANY03",size=1.1,halign="end",valign="middle");
// &"VDD" @WIRE(mode="straight",linecolor="#30485d",linewidth=0.16) {#XEMPTY4:3 (0,-130)};
// (0,-129.6) @TEXT("VDD",size=1.1,halign="middle",valign="bottom");
// &"VSS" @WIRE(mode="straight",linecolor="#30485d",linewidth=0.16) {#XEMPTY4:4 (0,-150)};
// (0,-150.4) @TEXT("VSS",size=1.1,halign="middle",valign="top");
// &"CODE4" @WIRE(mode="straight",linecolor="#30485d",linewidth=0.16) {#XTRIAL4:2 (19,-141.65)};
// (18.6,-141.65) @TEXT("CODE4",size=1.1,halign="end",valign="middle");
// &"TRIAL4" @WIRE(mode="straight",linecolor="#30485d",linewidth=0.16) {#XTRIAL4:3 (51,-140)};
// (51.4,-140) @TEXT("TRIAL4",size=1.1,halign="start",valign="middle");
// &"VDD" @WIRE(mode="straight",linecolor="#30485d",linewidth=0.16) {#XTRIAL4:4 (35,-129)};
// (35,-128.6) @TEXT("VDD",size=1.1,halign="middle",valign="bottom");
// &"VSS" @WIRE(mode="straight",linecolor="#30485d",linewidth=0.16) {#XTRIAL4:5 (35,-151)};
// (35,-151.4) @TEXT("VSS",size=1.1,halign="middle",valign="top");
// &"ANY03" @WIRE(mode="straight",linecolor="#30485d",linewidth=0.16) {#XVISIBLE4:1 (54,-138.35)};
// (53.6,-138.35) @TEXT("ANY03",size=1.1,halign="end",valign="middle");
// &"DONE" @WIRE(mode="straight",linecolor="#30485d",linewidth=0.16) {#XVISIBLE4:2 (54,-141.65)};
// (53.6,-141.65) @TEXT("DONE",size=1.1,halign="end",valign="middle");
// &"VDD" @WIRE(mode="straight",linecolor="#30485d",linewidth=0.16) {#XVISIBLE4:4 (70,-129)};
// (70,-128.6) @TEXT("VDD",size=1.1,halign="middle",valign="bottom");
// &"VSS" @WIRE(mode="straight",linecolor="#30485d",linewidth=0.16) {#XVISIBLE4:5 (70,-151)};
// (70,-151.4) @TEXT("VSS",size=1.1,halign="middle",valign="top");
// &"CODE4" @WIRE(mode="straight",linecolor="#30485d",linewidth=0.16) {#XREAD4:1 (89,-138.35)};
// (88.6,-138.35) @TEXT("CODE4",size=1.1,halign="end",valign="middle");
// &"VDD" @WIRE(mode="straight",linecolor="#30485d",linewidth=0.16) {#XREAD4:4 (105,-129)};
// (105,-128.6) @TEXT("VDD",size=1.1,halign="middle",valign="bottom");
// &"VSS" @WIRE(mode="straight",linecolor="#30485d",linewidth=0.16) {#XREAD4:5 (105,-151)};
// (105,-151.4) @TEXT("VSS",size=1.1,halign="middle",valign="top");
// &"LOW_BITS" @WIRE(mode="straight",linecolor="#30485d",linewidth=0.16) {#XEMPTY5:1 (-10,-172)};
// (-10.4,-172) @TEXT("LOW_BITS",size=1.1,halign="end",valign="middle");
// &"VDD" @WIRE(mode="straight",linecolor="#30485d",linewidth=0.16) {#XEMPTY5:3 (0,-162)};
// (0,-161.6) @TEXT("VDD",size=1.1,halign="middle",valign="bottom");
// &"VSS" @WIRE(mode="straight",linecolor="#30485d",linewidth=0.16) {#XEMPTY5:4 (0,-182)};
// (0,-182.4) @TEXT("VSS",size=1.1,halign="middle",valign="top");
// &"CODE5" @WIRE(mode="straight",linecolor="#30485d",linewidth=0.16) {#XTRIAL5:2 (19,-173.65)};
// (18.6,-173.65) @TEXT("CODE5",size=1.1,halign="end",valign="middle");
// &"TRIAL5" @WIRE(mode="straight",linecolor="#30485d",linewidth=0.16) {#XTRIAL5:3 (51,-172)};
// (51.4,-172) @TEXT("TRIAL5",size=1.1,halign="start",valign="middle");
// &"VDD" @WIRE(mode="straight",linecolor="#30485d",linewidth=0.16) {#XTRIAL5:4 (35,-161)};
// (35,-160.6) @TEXT("VDD",size=1.1,halign="middle",valign="bottom");
// &"VSS" @WIRE(mode="straight",linecolor="#30485d",linewidth=0.16) {#XTRIAL5:5 (35,-183)};
// (35,-183.4) @TEXT("VSS",size=1.1,halign="middle",valign="top");
// &"LOW_BITS" @WIRE(mode="straight",linecolor="#30485d",linewidth=0.16) {#XVISIBLE5:1 (54,-170.35)};
// (53.6,-170.35) @TEXT("LOW_BITS",size=1.1,halign="end",valign="middle");
// &"DONE" @WIRE(mode="straight",linecolor="#30485d",linewidth=0.16) {#XVISIBLE5:2 (54,-173.65)};
// (53.6,-173.65) @TEXT("DONE",size=1.1,halign="end",valign="middle");
// &"VDD" @WIRE(mode="straight",linecolor="#30485d",linewidth=0.16) {#XVISIBLE5:4 (70,-161)};
// (70,-160.6) @TEXT("VDD",size=1.1,halign="middle",valign="bottom");
// &"VSS" @WIRE(mode="straight",linecolor="#30485d",linewidth=0.16) {#XVISIBLE5:5 (70,-183)};
// (70,-183.4) @TEXT("VSS",size=1.1,halign="middle",valign="top");
// &"CODE5" @WIRE(mode="straight",linecolor="#30485d",linewidth=0.16) {#XREAD5:1 (89,-170.35)};
// (88.6,-170.35) @TEXT("CODE5",size=1.1,halign="end",valign="middle");
// &"VDD" @WIRE(mode="straight",linecolor="#30485d",linewidth=0.16) {#XREAD5:4 (105,-161)};
// (105,-160.6) @TEXT("VDD",size=1.1,halign="middle",valign="bottom");
// &"VSS" @WIRE(mode="straight",linecolor="#30485d",linewidth=0.16) {#XREAD5:5 (105,-183)};
// (105,-183.4) @TEXT("VSS",size=1.1,halign="middle",valign="top");
// &"ANY05" @WIRE(mode="straight",linecolor="#30485d",linewidth=0.16) {#XEMPTY6:1 (-10,-204)};
// (-10.4,-204) @TEXT("ANY05",size=1.1,halign="end",valign="middle");
// &"VDD" @WIRE(mode="straight",linecolor="#30485d",linewidth=0.16) {#XEMPTY6:3 (0,-194)};
// (0,-193.6) @TEXT("VDD",size=1.1,halign="middle",valign="bottom");
// &"VSS" @WIRE(mode="straight",linecolor="#30485d",linewidth=0.16) {#XEMPTY6:4 (0,-214)};
// (0,-214.4) @TEXT("VSS",size=1.1,halign="middle",valign="top");
// &"CODE6" @WIRE(mode="straight",linecolor="#30485d",linewidth=0.16) {#XTRIAL6:2 (19,-205.65)};
// (18.6,-205.65) @TEXT("CODE6",size=1.1,halign="end",valign="middle");
// &"TRIAL6" @WIRE(mode="straight",linecolor="#30485d",linewidth=0.16) {#XTRIAL6:3 (51,-204)};
// (51.4,-204) @TEXT("TRIAL6",size=1.1,halign="start",valign="middle");
// &"VDD" @WIRE(mode="straight",linecolor="#30485d",linewidth=0.16) {#XTRIAL6:4 (35,-193)};
// (35,-192.6) @TEXT("VDD",size=1.1,halign="middle",valign="bottom");
// &"VSS" @WIRE(mode="straight",linecolor="#30485d",linewidth=0.16) {#XTRIAL6:5 (35,-215)};
// (35,-215.4) @TEXT("VSS",size=1.1,halign="middle",valign="top");
// &"ANY05" @WIRE(mode="straight",linecolor="#30485d",linewidth=0.16) {#XVISIBLE6:1 (54,-202.35)};
// (53.6,-202.35) @TEXT("ANY05",size=1.1,halign="end",valign="middle");
// &"DONE" @WIRE(mode="straight",linecolor="#30485d",linewidth=0.16) {#XVISIBLE6:2 (54,-205.65)};
// (53.6,-205.65) @TEXT("DONE",size=1.1,halign="end",valign="middle");
// &"VDD" @WIRE(mode="straight",linecolor="#30485d",linewidth=0.16) {#XVISIBLE6:4 (70,-193)};
// (70,-192.6) @TEXT("VDD",size=1.1,halign="middle",valign="bottom");
// &"VSS" @WIRE(mode="straight",linecolor="#30485d",linewidth=0.16) {#XVISIBLE6:5 (70,-215)};
// (70,-215.4) @TEXT("VSS",size=1.1,halign="middle",valign="top");
// &"CODE6" @WIRE(mode="straight",linecolor="#30485d",linewidth=0.16) {#XREAD6:1 (89,-202.35)};
// (88.6,-202.35) @TEXT("CODE6",size=1.1,halign="end",valign="middle");
// &"VDD" @WIRE(mode="straight",linecolor="#30485d",linewidth=0.16) {#XREAD6:4 (105,-193)};
// (105,-192.6) @TEXT("VDD",size=1.1,halign="middle",valign="bottom");
// &"VSS" @WIRE(mode="straight",linecolor="#30485d",linewidth=0.16) {#XREAD6:5 (105,-215)};
// (105,-215.4) @TEXT("VSS",size=1.1,halign="middle",valign="top");
// &"ANY06" @WIRE(mode="straight",linecolor="#30485d",linewidth=0.16) {#XEMPTY7:1 (-10,-236)};
// (-10.4,-236) @TEXT("ANY06",size=1.1,halign="end",valign="middle");
// &"VDD" @WIRE(mode="straight",linecolor="#30485d",linewidth=0.16) {#XEMPTY7:3 (0,-226)};
// (0,-225.6) @TEXT("VDD",size=1.1,halign="middle",valign="bottom");
// &"VSS" @WIRE(mode="straight",linecolor="#30485d",linewidth=0.16) {#XEMPTY7:4 (0,-246)};
// (0,-246.4) @TEXT("VSS",size=1.1,halign="middle",valign="top");
// &"CODE7" @WIRE(mode="straight",linecolor="#30485d",linewidth=0.16) {#XTRIAL7:2 (19,-237.65)};
// (18.6,-237.65) @TEXT("CODE7",size=1.1,halign="end",valign="middle");
// &"TRIAL7" @WIRE(mode="straight",linecolor="#30485d",linewidth=0.16) {#XTRIAL7:3 (51,-236)};
// (51.4,-236) @TEXT("TRIAL7",size=1.1,halign="start",valign="middle");
// &"VDD" @WIRE(mode="straight",linecolor="#30485d",linewidth=0.16) {#XTRIAL7:4 (35,-225)};
// (35,-224.6) @TEXT("VDD",size=1.1,halign="middle",valign="bottom");
// &"VSS" @WIRE(mode="straight",linecolor="#30485d",linewidth=0.16) {#XTRIAL7:5 (35,-247)};
// (35,-247.4) @TEXT("VSS",size=1.1,halign="middle",valign="top");
// &"ANY06" @WIRE(mode="straight",linecolor="#30485d",linewidth=0.16) {#XVISIBLE7:1 (54,-234.35)};
// (53.6,-234.35) @TEXT("ANY06",size=1.1,halign="end",valign="middle");
// &"DONE" @WIRE(mode="straight",linecolor="#30485d",linewidth=0.16) {#XVISIBLE7:2 (54,-237.65)};
// (53.6,-237.65) @TEXT("DONE",size=1.1,halign="end",valign="middle");
// &"VDD" @WIRE(mode="straight",linecolor="#30485d",linewidth=0.16) {#XVISIBLE7:4 (70,-225)};
// (70,-224.6) @TEXT("VDD",size=1.1,halign="middle",valign="bottom");
// &"VSS" @WIRE(mode="straight",linecolor="#30485d",linewidth=0.16) {#XVISIBLE7:5 (70,-247)};
// (70,-247.4) @TEXT("VSS",size=1.1,halign="middle",valign="top");
// &"CODE7" @WIRE(mode="straight",linecolor="#30485d",linewidth=0.16) {#XREAD7:1 (89,-234.35)};
// (88.6,-234.35) @TEXT("CODE7",size=1.1,halign="end",valign="middle");
// &"D7" @WIRE(mode="straight",linecolor="#30485d",linewidth=0.16) {#XREAD7:3 (121,-236)};
// (121.4,-236) @TEXT("D7",size=1.1,halign="start",valign="middle");
// &"VDD" @WIRE(mode="straight",linecolor="#30485d",linewidth=0.16) {#XREAD7:4 (105,-225)};
// (105,-224.6) @TEXT("VDD",size=1.1,halign="middle",valign="bottom");
// &"VSS" @WIRE(mode="straight",linecolor="#30485d",linewidth=0.16) {#XREAD7:5 (105,-247)};
// (105,-247.4) @TEXT("VSS",size=1.1,halign="middle",valign="top");
// &"TRIAL1" @WIRE(mode="straight",linecolor="#30485d",linewidth=0.16) {#XBASE0:2 (124,-13.65)};
// (123.6,-13.65) @TEXT("TRIAL1",size=1.1,halign="end",valign="middle");
// &"BASE0" @WIRE(mode="straight",linecolor="#30485d",linewidth=0.16) {#XBASE0:3 (156,-12)};
// (156.4,-12) @TEXT("BASE0",size=1.1,halign="start",valign="middle");
// &"VDD" @WIRE(mode="straight",linecolor="#30485d",linewidth=0.16) {#XBASE0:4 (140,-1)};
// (140,-0.6) @TEXT("VDD",size=1.1,halign="middle",valign="bottom");
// &"VSS" @WIRE(mode="straight",linecolor="#30485d",linewidth=0.16) {#XBASE0:5 (140,-23)};
// (140,-23.4) @TEXT("VSS",size=1.1,halign="middle",valign="top");
// &"CODE0" @WIRE(mode="straight",linecolor="#30485d",linewidth=0.16) {#XKEEP0:1 (159,-10.35)};
// (158.6,-10.35) @TEXT("CODE0",size=1.1,halign="end",valign="middle");
// &"DATA" @WIRE(mode="straight",linecolor="#30485d",linewidth=0.16) {#XKEEP0:2 (159,-13.65)};
// (158.6,-13.65) @TEXT("DATA",size=1.1,halign="end",valign="middle");
// &"VDD" @WIRE(mode="straight",linecolor="#30485d",linewidth=0.16) {#XKEEP0:4 (175,-1)};
// (175,-0.6) @TEXT("VDD",size=1.1,halign="middle",valign="bottom");
// &"VSS" @WIRE(mode="straight",linecolor="#30485d",linewidth=0.16) {#XKEEP0:5 (175,-23)};
// (175,-23.4) @TEXT("VSS",size=1.1,halign="middle",valign="top");
// &"BASE0" @WIRE(mode="straight",linecolor="#30485d",linewidth=0.16) {#XNEXT0:1 (194,-10.35)};
// (193.6,-10.35) @TEXT("BASE0",size=1.1,halign="end",valign="middle");
// &"NEXT0" @WIRE(mode="straight",linecolor="#30485d",linewidth=0.16) {#XNEXT0:3 (226,-12)};
// (226.4,-12) @TEXT("NEXT0",size=1.1,halign="start",valign="middle");
// &"VDD" @WIRE(mode="straight",linecolor="#30485d",linewidth=0.16) {#XNEXT0:4 (210,-1)};
// (210,-0.6) @TEXT("VDD",size=1.1,halign="middle",valign="bottom");
// &"VSS" @WIRE(mode="straight",linecolor="#30485d",linewidth=0.16) {#XNEXT0:5 (210,-23)};
// (210,-23.4) @TEXT("VSS",size=1.1,halign="middle",valign="top");
// &"TRIAL2" @WIRE(mode="straight",linecolor="#30485d",linewidth=0.16) {#XBASE1:2 (124,-45.65)};
// (123.6,-45.65) @TEXT("TRIAL2",size=1.1,halign="end",valign="middle");
// &"BASE1" @WIRE(mode="straight",linecolor="#30485d",linewidth=0.16) {#XBASE1:3 (156,-44)};
// (156.4,-44) @TEXT("BASE1",size=1.1,halign="start",valign="middle");
// &"VDD" @WIRE(mode="straight",linecolor="#30485d",linewidth=0.16) {#XBASE1:4 (140,-33)};
// (140,-32.6) @TEXT("VDD",size=1.1,halign="middle",valign="bottom");
// &"VSS" @WIRE(mode="straight",linecolor="#30485d",linewidth=0.16) {#XBASE1:5 (140,-55)};
// (140,-55.4) @TEXT("VSS",size=1.1,halign="middle",valign="top");
// &"TRIAL1" @WIRE(mode="straight",linecolor="#30485d",linewidth=0.16) {#XKEEP1:1 (159,-42.35)};
// (158.6,-42.35) @TEXT("TRIAL1",size=1.1,halign="end",valign="middle");
// &"DATA" @WIRE(mode="straight",linecolor="#30485d",linewidth=0.16) {#XKEEP1:2 (159,-45.65)};
// (158.6,-45.65) @TEXT("DATA",size=1.1,halign="end",valign="middle");
// &"VDD" @WIRE(mode="straight",linecolor="#30485d",linewidth=0.16) {#XKEEP1:4 (175,-33)};
// (175,-32.6) @TEXT("VDD",size=1.1,halign="middle",valign="bottom");
// &"VSS" @WIRE(mode="straight",linecolor="#30485d",linewidth=0.16) {#XKEEP1:5 (175,-55)};
// (175,-55.4) @TEXT("VSS",size=1.1,halign="middle",valign="top");
// &"BASE1" @WIRE(mode="straight",linecolor="#30485d",linewidth=0.16) {#XNEXT1:1 (194,-42.35)};
// (193.6,-42.35) @TEXT("BASE1",size=1.1,halign="end",valign="middle");
// &"NEXT1" @WIRE(mode="straight",linecolor="#30485d",linewidth=0.16) {#XNEXT1:3 (226,-44)};
// (226.4,-44) @TEXT("NEXT1",size=1.1,halign="start",valign="middle");
// &"VDD" @WIRE(mode="straight",linecolor="#30485d",linewidth=0.16) {#XNEXT1:4 (210,-33)};
// (210,-32.6) @TEXT("VDD",size=1.1,halign="middle",valign="bottom");
// &"VSS" @WIRE(mode="straight",linecolor="#30485d",linewidth=0.16) {#XNEXT1:5 (210,-55)};
// (210,-55.4) @TEXT("VSS",size=1.1,halign="middle",valign="top");
// &"TRIAL3" @WIRE(mode="straight",linecolor="#30485d",linewidth=0.16) {#XBASE2:2 (124,-77.65)};
// (123.6,-77.65) @TEXT("TRIAL3",size=1.1,halign="end",valign="middle");
// &"BASE2" @WIRE(mode="straight",linecolor="#30485d",linewidth=0.16) {#XBASE2:3 (156,-76)};
// (156.4,-76) @TEXT("BASE2",size=1.1,halign="start",valign="middle");
// &"VDD" @WIRE(mode="straight",linecolor="#30485d",linewidth=0.16) {#XBASE2:4 (140,-65)};
// (140,-64.6) @TEXT("VDD",size=1.1,halign="middle",valign="bottom");
// &"VSS" @WIRE(mode="straight",linecolor="#30485d",linewidth=0.16) {#XBASE2:5 (140,-87)};
// (140,-87.4) @TEXT("VSS",size=1.1,halign="middle",valign="top");
// &"TRIAL2" @WIRE(mode="straight",linecolor="#30485d",linewidth=0.16) {#XKEEP2:1 (159,-74.35)};
// (158.6,-74.35) @TEXT("TRIAL2",size=1.1,halign="end",valign="middle");
// &"DATA" @WIRE(mode="straight",linecolor="#30485d",linewidth=0.16) {#XKEEP2:2 (159,-77.65)};
// (158.6,-77.65) @TEXT("DATA",size=1.1,halign="end",valign="middle");
// &"VDD" @WIRE(mode="straight",linecolor="#30485d",linewidth=0.16) {#XKEEP2:4 (175,-65)};
// (175,-64.6) @TEXT("VDD",size=1.1,halign="middle",valign="bottom");
// &"VSS" @WIRE(mode="straight",linecolor="#30485d",linewidth=0.16) {#XKEEP2:5 (175,-87)};
// (175,-87.4) @TEXT("VSS",size=1.1,halign="middle",valign="top");
// &"BASE2" @WIRE(mode="straight",linecolor="#30485d",linewidth=0.16) {#XNEXT2:1 (194,-74.35)};
// (193.6,-74.35) @TEXT("BASE2",size=1.1,halign="end",valign="middle");
// &"NEXT2" @WIRE(mode="straight",linecolor="#30485d",linewidth=0.16) {#XNEXT2:3 (226,-76)};
// (226.4,-76) @TEXT("NEXT2",size=1.1,halign="start",valign="middle");
// &"VDD" @WIRE(mode="straight",linecolor="#30485d",linewidth=0.16) {#XNEXT2:4 (210,-65)};
// (210,-64.6) @TEXT("VDD",size=1.1,halign="middle",valign="bottom");
// &"VSS" @WIRE(mode="straight",linecolor="#30485d",linewidth=0.16) {#XNEXT2:5 (210,-87)};
// (210,-87.4) @TEXT("VSS",size=1.1,halign="middle",valign="top");
// &"TRIAL4" @WIRE(mode="straight",linecolor="#30485d",linewidth=0.16) {#XBASE3:2 (124,-109.65)};
// (123.6,-109.65) @TEXT("TRIAL4",size=1.1,halign="end",valign="middle");
// &"BASE3" @WIRE(mode="straight",linecolor="#30485d",linewidth=0.16) {#XBASE3:3 (156,-108)};
// (156.4,-108) @TEXT("BASE3",size=1.1,halign="start",valign="middle");
// &"VDD" @WIRE(mode="straight",linecolor="#30485d",linewidth=0.16) {#XBASE3:4 (140,-97)};
// (140,-96.6) @TEXT("VDD",size=1.1,halign="middle",valign="bottom");
// &"VSS" @WIRE(mode="straight",linecolor="#30485d",linewidth=0.16) {#XBASE3:5 (140,-119)};
// (140,-119.4) @TEXT("VSS",size=1.1,halign="middle",valign="top");
// &"TRIAL3" @WIRE(mode="straight",linecolor="#30485d",linewidth=0.16) {#XKEEP3:1 (159,-106.35)};
// (158.6,-106.35) @TEXT("TRIAL3",size=1.1,halign="end",valign="middle");
// &"DATA" @WIRE(mode="straight",linecolor="#30485d",linewidth=0.16) {#XKEEP3:2 (159,-109.65)};
// (158.6,-109.65) @TEXT("DATA",size=1.1,halign="end",valign="middle");
// &"VDD" @WIRE(mode="straight",linecolor="#30485d",linewidth=0.16) {#XKEEP3:4 (175,-97)};
// (175,-96.6) @TEXT("VDD",size=1.1,halign="middle",valign="bottom");
// &"VSS" @WIRE(mode="straight",linecolor="#30485d",linewidth=0.16) {#XKEEP3:5 (175,-119)};
// (175,-119.4) @TEXT("VSS",size=1.1,halign="middle",valign="top");
// &"BASE3" @WIRE(mode="straight",linecolor="#30485d",linewidth=0.16) {#XNEXT3:1 (194,-106.35)};
// (193.6,-106.35) @TEXT("BASE3",size=1.1,halign="end",valign="middle");
// &"NEXT3" @WIRE(mode="straight",linecolor="#30485d",linewidth=0.16) {#XNEXT3:3 (226,-108)};
// (226.4,-108) @TEXT("NEXT3",size=1.1,halign="start",valign="middle");
// &"VDD" @WIRE(mode="straight",linecolor="#30485d",linewidth=0.16) {#XNEXT3:4 (210,-97)};
// (210,-96.6) @TEXT("VDD",size=1.1,halign="middle",valign="bottom");
// &"VSS" @WIRE(mode="straight",linecolor="#30485d",linewidth=0.16) {#XNEXT3:5 (210,-119)};
// (210,-119.4) @TEXT("VSS",size=1.1,halign="middle",valign="top");
// &"TRIAL5" @WIRE(mode="straight",linecolor="#30485d",linewidth=0.16) {#XBASE4:2 (124,-141.65)};
// (123.6,-141.65) @TEXT("TRIAL5",size=1.1,halign="end",valign="middle");
// &"BASE4" @WIRE(mode="straight",linecolor="#30485d",linewidth=0.16) {#XBASE4:3 (156,-140)};
// (156.4,-140) @TEXT("BASE4",size=1.1,halign="start",valign="middle");
// &"VDD" @WIRE(mode="straight",linecolor="#30485d",linewidth=0.16) {#XBASE4:4 (140,-129)};
// (140,-128.6) @TEXT("VDD",size=1.1,halign="middle",valign="bottom");
// &"VSS" @WIRE(mode="straight",linecolor="#30485d",linewidth=0.16) {#XBASE4:5 (140,-151)};
// (140,-151.4) @TEXT("VSS",size=1.1,halign="middle",valign="top");
// &"TRIAL4" @WIRE(mode="straight",linecolor="#30485d",linewidth=0.16) {#XKEEP4:1 (159,-138.35)};
// (158.6,-138.35) @TEXT("TRIAL4",size=1.1,halign="end",valign="middle");
// &"DATA" @WIRE(mode="straight",linecolor="#30485d",linewidth=0.16) {#XKEEP4:2 (159,-141.65)};
// (158.6,-141.65) @TEXT("DATA",size=1.1,halign="end",valign="middle");
// &"VDD" @WIRE(mode="straight",linecolor="#30485d",linewidth=0.16) {#XKEEP4:4 (175,-129)};
// (175,-128.6) @TEXT("VDD",size=1.1,halign="middle",valign="bottom");
// &"VSS" @WIRE(mode="straight",linecolor="#30485d",linewidth=0.16) {#XKEEP4:5 (175,-151)};
// (175,-151.4) @TEXT("VSS",size=1.1,halign="middle",valign="top");
// &"BASE4" @WIRE(mode="straight",linecolor="#30485d",linewidth=0.16) {#XNEXT4:1 (194,-138.35)};
// (193.6,-138.35) @TEXT("BASE4",size=1.1,halign="end",valign="middle");
// &"NEXT4" @WIRE(mode="straight",linecolor="#30485d",linewidth=0.16) {#XNEXT4:3 (226,-140)};
// (226.4,-140) @TEXT("NEXT4",size=1.1,halign="start",valign="middle");
// &"VDD" @WIRE(mode="straight",linecolor="#30485d",linewidth=0.16) {#XNEXT4:4 (210,-129)};
// (210,-128.6) @TEXT("VDD",size=1.1,halign="middle",valign="bottom");
// &"VSS" @WIRE(mode="straight",linecolor="#30485d",linewidth=0.16) {#XNEXT4:5 (210,-151)};
// (210,-151.4) @TEXT("VSS",size=1.1,halign="middle",valign="top");
// &"TRIAL6" @WIRE(mode="straight",linecolor="#30485d",linewidth=0.16) {#XBASE5:2 (124,-173.65)};
// (123.6,-173.65) @TEXT("TRIAL6",size=1.1,halign="end",valign="middle");
// &"BASE5" @WIRE(mode="straight",linecolor="#30485d",linewidth=0.16) {#XBASE5:3 (156,-172)};
// (156.4,-172) @TEXT("BASE5",size=1.1,halign="start",valign="middle");
// &"VDD" @WIRE(mode="straight",linecolor="#30485d",linewidth=0.16) {#XBASE5:4 (140,-161)};
// (140,-160.6) @TEXT("VDD",size=1.1,halign="middle",valign="bottom");
// &"VSS" @WIRE(mode="straight",linecolor="#30485d",linewidth=0.16) {#XBASE5:5 (140,-183)};
// (140,-183.4) @TEXT("VSS",size=1.1,halign="middle",valign="top");
// &"TRIAL5" @WIRE(mode="straight",linecolor="#30485d",linewidth=0.16) {#XKEEP5:1 (159,-170.35)};
// (158.6,-170.35) @TEXT("TRIAL5",size=1.1,halign="end",valign="middle");
// &"DATA" @WIRE(mode="straight",linecolor="#30485d",linewidth=0.16) {#XKEEP5:2 (159,-173.65)};
// (158.6,-173.65) @TEXT("DATA",size=1.1,halign="end",valign="middle");
// &"VDD" @WIRE(mode="straight",linecolor="#30485d",linewidth=0.16) {#XKEEP5:4 (175,-161)};
// (175,-160.6) @TEXT("VDD",size=1.1,halign="middle",valign="bottom");
// &"VSS" @WIRE(mode="straight",linecolor="#30485d",linewidth=0.16) {#XKEEP5:5 (175,-183)};
// (175,-183.4) @TEXT("VSS",size=1.1,halign="middle",valign="top");
// &"BASE5" @WIRE(mode="straight",linecolor="#30485d",linewidth=0.16) {#XNEXT5:1 (194,-170.35)};
// (193.6,-170.35) @TEXT("BASE5",size=1.1,halign="end",valign="middle");
// &"NEXT5" @WIRE(mode="straight",linecolor="#30485d",linewidth=0.16) {#XNEXT5:3 (226,-172)};
// (226.4,-172) @TEXT("NEXT5",size=1.1,halign="start",valign="middle");
// &"VDD" @WIRE(mode="straight",linecolor="#30485d",linewidth=0.16) {#XNEXT5:4 (210,-161)};
// (210,-160.6) @TEXT("VDD",size=1.1,halign="middle",valign="bottom");
// &"VSS" @WIRE(mode="straight",linecolor="#30485d",linewidth=0.16) {#XNEXT5:5 (210,-183)};
// (210,-183.4) @TEXT("VSS",size=1.1,halign="middle",valign="top");
// &"TRIAL7" @WIRE(mode="straight",linecolor="#30485d",linewidth=0.16) {#XBASE6:2 (124,-205.65)};
// (123.6,-205.65) @TEXT("TRIAL7",size=1.1,halign="end",valign="middle");
// &"BASE6" @WIRE(mode="straight",linecolor="#30485d",linewidth=0.16) {#XBASE6:3 (156,-204)};
// (156.4,-204) @TEXT("BASE6",size=1.1,halign="start",valign="middle");
// &"VDD" @WIRE(mode="straight",linecolor="#30485d",linewidth=0.16) {#XBASE6:4 (140,-193)};
// (140,-192.6) @TEXT("VDD",size=1.1,halign="middle",valign="bottom");
// &"VSS" @WIRE(mode="straight",linecolor="#30485d",linewidth=0.16) {#XBASE6:5 (140,-215)};
// (140,-215.4) @TEXT("VSS",size=1.1,halign="middle",valign="top");
// &"TRIAL6" @WIRE(mode="straight",linecolor="#30485d",linewidth=0.16) {#XKEEP6:1 (159,-202.35)};
// (158.6,-202.35) @TEXT("TRIAL6",size=1.1,halign="end",valign="middle");
// &"DATA" @WIRE(mode="straight",linecolor="#30485d",linewidth=0.16) {#XKEEP6:2 (159,-205.65)};
// (158.6,-205.65) @TEXT("DATA",size=1.1,halign="end",valign="middle");
// &"VDD" @WIRE(mode="straight",linecolor="#30485d",linewidth=0.16) {#XKEEP6:4 (175,-193)};
// (175,-192.6) @TEXT("VDD",size=1.1,halign="middle",valign="bottom");
// &"VSS" @WIRE(mode="straight",linecolor="#30485d",linewidth=0.16) {#XKEEP6:5 (175,-215)};
// (175,-215.4) @TEXT("VSS",size=1.1,halign="middle",valign="top");
// &"BASE6" @WIRE(mode="straight",linecolor="#30485d",linewidth=0.16) {#XNEXT6:1 (194,-202.35)};
// (193.6,-202.35) @TEXT("BASE6",size=1.1,halign="end",valign="middle");
// &"NEXT6" @WIRE(mode="straight",linecolor="#30485d",linewidth=0.16) {#XNEXT6:3 (226,-204)};
// (226.4,-204) @TEXT("NEXT6",size=1.1,halign="start",valign="middle");
// &"VDD" @WIRE(mode="straight",linecolor="#30485d",linewidth=0.16) {#XNEXT6:4 (210,-193)};
// (210,-192.6) @TEXT("VDD",size=1.1,halign="middle",valign="bottom");
// &"VSS" @WIRE(mode="straight",linecolor="#30485d",linewidth=0.16) {#XNEXT6:5 (210,-215)};
// (210,-215.4) @TEXT("VSS",size=1.1,halign="middle",valign="top");
// &"TRIAL7" @WIRE(mode="straight",linecolor="#30485d",linewidth=0.16) {#XKEEP7:1 (159,-234.35)};
// (158.6,-234.35) @TEXT("TRIAL7",size=1.1,halign="end",valign="middle");
// &"DATA" @WIRE(mode="straight",linecolor="#30485d",linewidth=0.16) {#XKEEP7:2 (159,-237.65)};
// (158.6,-237.65) @TEXT("DATA",size=1.1,halign="end",valign="middle");
// &"VDD" @WIRE(mode="straight",linecolor="#30485d",linewidth=0.16) {#XKEEP7:4 (175,-225)};
// (175,-224.6) @TEXT("VDD",size=1.1,halign="middle",valign="bottom");
// &"VSS" @WIRE(mode="straight",linecolor="#30485d",linewidth=0.16) {#XKEEP7:5 (175,-247)};
// (175,-247.4) @TEXT("VSS",size=1.1,halign="middle",valign="top");
// &"D7" @WIRE(mode="straight",linecolor="#30485d",linewidth=0.16) {#XNEXT7:1 (194,-234.35)};
// (193.6,-234.35) @TEXT("D7",size=1.1,halign="end",valign="middle");
// &"NEXT7" @WIRE(mode="straight",linecolor="#30485d",linewidth=0.16) {#XNEXT7:3 (226,-236)};
// (226.4,-236) @TEXT("NEXT7",size=1.1,halign="start",valign="middle");
// &"VDD" @WIRE(mode="straight",linecolor="#30485d",linewidth=0.16) {#XNEXT7:4 (210,-225)};
// (210,-224.6) @TEXT("VDD",size=1.1,halign="middle",valign="bottom");
// &"VSS" @WIRE(mode="straight",linecolor="#30485d",linewidth=0.16) {#XNEXT7:5 (210,-247)};
// (210,-247.4) @TEXT("VSS",size=1.1,halign="middle",valign="top");
// }
// END SARADC RNL
ends sar8_next_word

subckt sar8_se_window PHASE_REQUEST SEL9 SEL7 SEL6 SEL5 SEL4 VDD VSS DELIVERED
// A transition propagates once per decision. Both polarities traverse real DEL cells.
// Taps by compared bit: 6:T11 5:T9 4:T7 3:T6 2:T5 1,0:T4. Each SELn rises once per
// conversion, on the commit before its first use, and only shortens the window.
XDEL1 (PHASE_REQUEST T1 VDD VSS) DEL250D1BWP12T30P140
XDEL2 (T1 T2 VDD VSS) DEL250D1BWP12T30P140
XDEL3 (T2 T3 VDD VSS) DEL250D1BWP12T30P140
XDEL4 (T3 T4 VDD VSS) DEL250D1BWP12T30P140
XDEL5 (T4 T5 VDD VSS) DEL250D1BWP12T30P140
XDEL6 (T5 T6 VDD VSS) DEL250D1BWP12T30P140
XDEL7 (T6 T7 VDD VSS) DEL250D1BWP12T30P140
XDEL8 (T7 T8 VDD VSS) DEL250D1BWP12T30P140
XDEL9 (T8 T9 VDD VSS) DEL250D1BWP12T30P140
XDEL10 (T9 T10 VDD VSS) DEL250D1BWP12T30P140
XDEL11 (T10 T11 VDD VSS) DEL250D1BWP12T30P140
XTAP9 (T11 T9 SEL9 W9 VDD VSS) MUX2D1BWP12T30P140
XTAP7 (W9 T7 SEL7 W7 VDD VSS) MUX2D1BWP12T30P140
XTAP6 (W7 T6 SEL6 W6 VDD VSS) MUX2D1BWP12T30P140
XTAP5 (W6 T5 SEL5 W5 VDD VSS) MUX2D1BWP12T30P140
XTAP4 (W5 T4 SEL4 DELIVERED VDD VSS) MUX2D1BWP12T30P140
// BEGIN SARADC RNL
// @RNL(author="saradc topology") {
// (-14,59) @TEXT("Settling window / delay chain and selected taps",size=1.9,halign="start",textcolor="#223d52");
// #XDEL1 @SET-SYMBOL $S_DEL250D1BWP12T30P140;
// #XDEL1 @PLACE(0,25) => @ORIENT("R0");
// #XDEL2 @SET-SYMBOL $S_DEL250D1BWP12T30P140;
// #XDEL2 @PLACE(27,25) => @ORIENT("R0");
// #XDEL3 @SET-SYMBOL $S_DEL250D1BWP12T30P140;
// #XDEL3 @PLACE(54,25) => @ORIENT("R0");
// #XDEL4 @SET-SYMBOL $S_DEL250D1BWP12T30P140;
// #XDEL4 @PLACE(81,25) => @ORIENT("R0");
// #XDEL5 @SET-SYMBOL $S_DEL250D1BWP12T30P140;
// #XDEL5 @PLACE(108,25) => @ORIENT("R0");
// #XDEL6 @SET-SYMBOL $S_DEL250D1BWP12T30P140;
// #XDEL6 @PLACE(135,25) => @ORIENT("R0");
// #XDEL7 @SET-SYMBOL $S_DEL250D1BWP12T30P140;
// #XDEL7 @PLACE(162,25) => @ORIENT("R0");
// #XDEL8 @SET-SYMBOL $S_DEL250D1BWP12T30P140;
// #XDEL8 @PLACE(189,25) => @ORIENT("R0");
// #XDEL9 @SET-SYMBOL $S_DEL250D1BWP12T30P140;
// #XDEL9 @PLACE(216,25) => @ORIENT("R0");
// #XDEL10 @SET-SYMBOL $S_DEL250D1BWP12T30P140;
// #XDEL10 @PLACE(243,25) => @ORIENT("R0");
// #XDEL11 @SET-SYMBOL $S_DEL250D1BWP12T30P140;
// #XDEL11 @PLACE(270,25) => @ORIENT("R0");
// #XTAP4 @SET-SYMBOL $S_MUX2D1BWP12T30P140;
// #XTAP4 @PLACE(0,-24) => @ORIENT("R0");
// #XTAP5 @SET-SYMBOL $S_MUX2D1BWP12T30P140;
// #XTAP5 @PLACE(54,-24) => @ORIENT("R0");
// #XTAP6 @SET-SYMBOL $S_MUX2D1BWP12T30P140;
// #XTAP6 @PLACE(108,-24) => @ORIENT("R0");
// #XTAP7 @SET-SYMBOL $S_MUX2D1BWP12T30P140;
// #XTAP7 @PLACE(162,-24) => @ORIENT("R0");
// #XTAP9 @SET-SYMBOL $S_MUX2D1BWP12T30P140;
// #XTAP9 @PLACE(216,-24) => @ORIENT("R0");
// &"T1" @WIRE(mode="straight",linecolor="#30485d",linewidth=0.16) {#XDEL1:2 (13.5,25) (13.5,25) #XDEL2:1};
// &"T2" @WIRE(mode="straight",linecolor="#30485d",linewidth=0.16) {#XDEL2:2 (40.5,25) (40.5,25) #XDEL3:1};
// &"T3" @WIRE(mode="straight",linecolor="#30485d",linewidth=0.16) {#XDEL3:2 (67.5,25) (67.5,25) #XDEL4:1};
// &"T4" @WIRE(mode="straight",linecolor="#30485d",linewidth=0.16) {#XDEL4:2 (94.5,25) (94.5,25) #XDEL5:1};
// &"T5" @WIRE(mode="straight",linecolor="#30485d",linewidth=0.16) {#XDEL5:2 (121.5,25) (121.5,25) #XDEL6:1};
// &"T6" @WIRE(mode="straight",linecolor="#30485d",linewidth=0.16) {#XDEL6:2 (148.5,25) (148.5,25) #XDEL7:1};
// &"T7" @WIRE(mode="straight",linecolor="#30485d",linewidth=0.16) {#XDEL7:2 (175.5,25) (175.5,25) #XDEL8:1};
// &"T8" @WIRE(mode="straight",linecolor="#30485d",linewidth=0.16) {#XDEL8:2 (202.5,25) (202.5,25) #XDEL9:1};
// &"T9" @WIRE(mode="straight",linecolor="#30485d",linewidth=0.16) {#XDEL9:2 (229.5,25) (229.5,25) #XDEL10:1};
// &"T10" @WIRE(mode="straight",linecolor="#30485d",linewidth=0.16) {#XDEL10:2 (256.5,25) (256.5,25) #XDEL11:1};
// &"PHASE_REQUEST" @WIRE(mode="straight",linecolor="#30485d",linewidth=0.16) {#XDEL1:1 (-16,25)};
// (-16.4,25) @TEXT("PHASE_REQUEST",size=1.1,halign="end",valign="middle");
// &"VDD" @WIRE(mode="straight",linecolor="#30485d",linewidth=0.16) {#XDEL1:3 (0,36)};
// (0,36.4) @TEXT("VDD",size=1.1,halign="middle",valign="bottom");
// &"VSS" @WIRE(mode="straight",linecolor="#30485d",linewidth=0.16) {#XDEL1:4 (0,14)};
// (0,13.6) @TEXT("VSS",size=1.1,halign="middle",valign="top");
// &"VDD" @WIRE(mode="straight",linecolor="#30485d",linewidth=0.16) {#XDEL2:3 (27,36)};
// (27,36.4) @TEXT("VDD",size=1.1,halign="middle",valign="bottom");
// &"VSS" @WIRE(mode="straight",linecolor="#30485d",linewidth=0.16) {#XDEL2:4 (27,14)};
// (27,13.6) @TEXT("VSS",size=1.1,halign="middle",valign="top");
// &"VDD" @WIRE(mode="straight",linecolor="#30485d",linewidth=0.16) {#XDEL3:3 (54,36)};
// (54,36.4) @TEXT("VDD",size=1.1,halign="middle",valign="bottom");
// &"VSS" @WIRE(mode="straight",linecolor="#30485d",linewidth=0.16) {#XDEL3:4 (54,14)};
// (54,13.6) @TEXT("VSS",size=1.1,halign="middle",valign="top");
// &"VDD" @WIRE(mode="straight",linecolor="#30485d",linewidth=0.16) {#XDEL4:3 (81,36)};
// (81,36.4) @TEXT("VDD",size=1.1,halign="middle",valign="bottom");
// &"VSS" @WIRE(mode="straight",linecolor="#30485d",linewidth=0.16) {#XDEL4:4 (81,14)};
// (81,13.6) @TEXT("VSS",size=1.1,halign="middle",valign="top");
// &"VDD" @WIRE(mode="straight",linecolor="#30485d",linewidth=0.16) {#XDEL5:3 (108,36)};
// (108,36.4) @TEXT("VDD",size=1.1,halign="middle",valign="bottom");
// &"VSS" @WIRE(mode="straight",linecolor="#30485d",linewidth=0.16) {#XDEL5:4 (108,14)};
// (108,13.6) @TEXT("VSS",size=1.1,halign="middle",valign="top");
// &"VDD" @WIRE(mode="straight",linecolor="#30485d",linewidth=0.16) {#XDEL6:3 (135,36)};
// (135,36.4) @TEXT("VDD",size=1.1,halign="middle",valign="bottom");
// &"VSS" @WIRE(mode="straight",linecolor="#30485d",linewidth=0.16) {#XDEL6:4 (135,14)};
// (135,13.6) @TEXT("VSS",size=1.1,halign="middle",valign="top");
// &"VDD" @WIRE(mode="straight",linecolor="#30485d",linewidth=0.16) {#XDEL7:3 (162,36)};
// (162,36.4) @TEXT("VDD",size=1.1,halign="middle",valign="bottom");
// &"VSS" @WIRE(mode="straight",linecolor="#30485d",linewidth=0.16) {#XDEL7:4 (162,14)};
// (162,13.6) @TEXT("VSS",size=1.1,halign="middle",valign="top");
// &"VDD" @WIRE(mode="straight",linecolor="#30485d",linewidth=0.16) {#XDEL8:3 (189,36)};
// (189,36.4) @TEXT("VDD",size=1.1,halign="middle",valign="bottom");
// &"VSS" @WIRE(mode="straight",linecolor="#30485d",linewidth=0.16) {#XDEL8:4 (189,14)};
// (189,13.6) @TEXT("VSS",size=1.1,halign="middle",valign="top");
// &"VDD" @WIRE(mode="straight",linecolor="#30485d",linewidth=0.16) {#XDEL9:3 (216,36)};
// (216,36.4) @TEXT("VDD",size=1.1,halign="middle",valign="bottom");
// &"VSS" @WIRE(mode="straight",linecolor="#30485d",linewidth=0.16) {#XDEL9:4 (216,14)};
// (216,13.6) @TEXT("VSS",size=1.1,halign="middle",valign="top");
// &"VDD" @WIRE(mode="straight",linecolor="#30485d",linewidth=0.16) {#XDEL10:3 (243,36)};
// (243,36.4) @TEXT("VDD",size=1.1,halign="middle",valign="bottom");
// &"VSS" @WIRE(mode="straight",linecolor="#30485d",linewidth=0.16) {#XDEL10:4 (243,14)};
// (243,13.6) @TEXT("VSS",size=1.1,halign="middle",valign="top");
// &"T11" @WIRE(mode="straight",linecolor="#30485d",linewidth=0.16) {#XDEL11:2 (286,25)};
// (286.4,25) @TEXT("T11",size=1.1,halign="start",valign="middle");
// &"VDD" @WIRE(mode="straight",linecolor="#30485d",linewidth=0.16) {#XDEL11:3 (270,36)};
// (270,36.4) @TEXT("VDD",size=1.1,halign="middle",valign="bottom");
// &"VSS" @WIRE(mode="straight",linecolor="#30485d",linewidth=0.16) {#XDEL11:4 (270,14)};
// (270,13.6) @TEXT("VSS",size=1.1,halign="middle",valign="top");
// &"T11" @WIRE(mode="straight",linecolor="#30485d",linewidth=0.16) {#XTAP9:1 (200,-20.7)};
// (199.6,-20.7) @TEXT("T11",size=1.1,halign="end",valign="middle");
// &"T9" @WIRE(mode="straight",linecolor="#30485d",linewidth=0.16) {#XTAP9:2 (200,-24)};
// (199.6,-24) @TEXT("T9",size=1.1,halign="end",valign="middle");
// &"SEL9" @WIRE(mode="straight",linecolor="#30485d",linewidth=0.16) {#XTAP9:3 (200,-27.3)};
// (199.6,-27.3) @TEXT("SEL9",size=1.1,halign="end",valign="middle");
// &"W9" @WIRE(mode="straight",linecolor="#30485d",linewidth=0.16) {#XTAP9:4 (232,-24)};
// (232.4,-24) @TEXT("W9",size=1.1,halign="start",valign="middle");
// &"VDD" @WIRE(mode="straight",linecolor="#30485d",linewidth=0.16) {#XTAP9:5 (216,-12.4)};
// (216,-12) @TEXT("VDD",size=1.1,halign="middle",valign="bottom");
// &"VSS" @WIRE(mode="straight",linecolor="#30485d",linewidth=0.16) {#XTAP9:6 (216,-35.6)};
// (216,-36) @TEXT("VSS",size=1.1,halign="middle",valign="top");
// &"W9" @WIRE(mode="straight",linecolor="#30485d",linewidth=0.16) {#XTAP7:1 (146,-20.7)};
// (145.6,-20.7) @TEXT("W9",size=1.1,halign="end",valign="middle");
// &"T7" @WIRE(mode="straight",linecolor="#30485d",linewidth=0.16) {#XTAP7:2 (146,-24)};
// (145.6,-24) @TEXT("T7",size=1.1,halign="end",valign="middle");
// &"SEL7" @WIRE(mode="straight",linecolor="#30485d",linewidth=0.16) {#XTAP7:3 (146,-27.3)};
// (145.6,-27.3) @TEXT("SEL7",size=1.1,halign="end",valign="middle");
// &"W7" @WIRE(mode="straight",linecolor="#30485d",linewidth=0.16) {#XTAP7:4 (178,-24)};
// (178.4,-24) @TEXT("W7",size=1.1,halign="start",valign="middle");
// &"VDD" @WIRE(mode="straight",linecolor="#30485d",linewidth=0.16) {#XTAP7:5 (162,-12.4)};
// (162,-12) @TEXT("VDD",size=1.1,halign="middle",valign="bottom");
// &"VSS" @WIRE(mode="straight",linecolor="#30485d",linewidth=0.16) {#XTAP7:6 (162,-35.6)};
// (162,-36) @TEXT("VSS",size=1.1,halign="middle",valign="top");
// &"W7" @WIRE(mode="straight",linecolor="#30485d",linewidth=0.16) {#XTAP6:1 (92,-20.7)};
// (91.6,-20.7) @TEXT("W7",size=1.1,halign="end",valign="middle");
// &"T6" @WIRE(mode="straight",linecolor="#30485d",linewidth=0.16) {#XTAP6:2 (92,-24)};
// (91.6,-24) @TEXT("T6",size=1.1,halign="end",valign="middle");
// &"SEL6" @WIRE(mode="straight",linecolor="#30485d",linewidth=0.16) {#XTAP6:3 (92,-27.3)};
// (91.6,-27.3) @TEXT("SEL6",size=1.1,halign="end",valign="middle");
// &"W6" @WIRE(mode="straight",linecolor="#30485d",linewidth=0.16) {#XTAP6:4 (124,-24)};
// (124.4,-24) @TEXT("W6",size=1.1,halign="start",valign="middle");
// &"VDD" @WIRE(mode="straight",linecolor="#30485d",linewidth=0.16) {#XTAP6:5 (108,-12.4)};
// (108,-12) @TEXT("VDD",size=1.1,halign="middle",valign="bottom");
// &"VSS" @WIRE(mode="straight",linecolor="#30485d",linewidth=0.16) {#XTAP6:6 (108,-35.6)};
// (108,-36) @TEXT("VSS",size=1.1,halign="middle",valign="top");
// &"W6" @WIRE(mode="straight",linecolor="#30485d",linewidth=0.16) {#XTAP5:1 (38,-20.7)};
// (37.6,-20.7) @TEXT("W6",size=1.1,halign="end",valign="middle");
// &"T5" @WIRE(mode="straight",linecolor="#30485d",linewidth=0.16) {#XTAP5:2 (38,-24)};
// (37.6,-24) @TEXT("T5",size=1.1,halign="end",valign="middle");
// &"SEL5" @WIRE(mode="straight",linecolor="#30485d",linewidth=0.16) {#XTAP5:3 (38,-27.3)};
// (37.6,-27.3) @TEXT("SEL5",size=1.1,halign="end",valign="middle");
// &"W5" @WIRE(mode="straight",linecolor="#30485d",linewidth=0.16) {#XTAP5:4 (70,-24)};
// (70.4,-24) @TEXT("W5",size=1.1,halign="start",valign="middle");
// &"VDD" @WIRE(mode="straight",linecolor="#30485d",linewidth=0.16) {#XTAP5:5 (54,-12.4)};
// (54,-12) @TEXT("VDD",size=1.1,halign="middle",valign="bottom");
// &"VSS" @WIRE(mode="straight",linecolor="#30485d",linewidth=0.16) {#XTAP5:6 (54,-35.6)};
// (54,-36) @TEXT("VSS",size=1.1,halign="middle",valign="top");
// &"W5" @WIRE(mode="straight",linecolor="#30485d",linewidth=0.16) {#XTAP4:1 (-16,-20.7)};
// (-16.4,-20.7) @TEXT("W5",size=1.1,halign="end",valign="middle");
// &"T4" @WIRE(mode="straight",linecolor="#30485d",linewidth=0.16) {#XTAP4:2 (-16,-24)};
// (-16.4,-24) @TEXT("T4",size=1.1,halign="end",valign="middle");
// &"SEL4" @WIRE(mode="straight",linecolor="#30485d",linewidth=0.16) {#XTAP4:3 (-16,-27.3)};
// (-16.4,-27.3) @TEXT("SEL4",size=1.1,halign="end",valign="middle");
// &"DELIVERED" @WIRE(mode="straight",linecolor="#30485d",linewidth=0.16) {#XTAP4:4 (16,-24)};
// (16.4,-24) @TEXT("DELIVERED",size=1.1,halign="start",valign="middle");
// &"VDD" @WIRE(mode="straight",linecolor="#30485d",linewidth=0.16) {#XTAP4:5 (0,-12.4)};
// (0,-12) @TEXT("VDD",size=1.1,halign="middle",valign="bottom");
// &"VSS" @WIRE(mode="straight",linecolor="#30485d",linewidth=0.16) {#XTAP4:6 (0,-35.6)};
// (0,-36) @TEXT("VSS",size=1.1,halign="middle",valign="top");
// }
// END SARADC RNL
ends sar8_se_window

subckt sar8_se_timing ACTIVE SAMPLE SEL9 SEL7 SEL6 SEL5 SEL4 COMP_P COMP_N CMP_CLK COMMIT DATA VDD VSS
XPR (COMP_P PR VDD VSS) BUFFD1BWP12T30P140
XNR (COMP_N NR VDD VSS) BUFFD1BWP12T30P140
XNRB (NR NRB VDD VSS) INVD1BWP12T30P140
XDATA (PR NRB DATA VDD VSS) AN2D1BWP12T30P140
XRAW (PR NR RAW VDD VSS) XOR2D1BWP12T30P140
XVD (RAW RAW_T VDD VSS) DEL200D1BWP12T30P140
XVALID (RAW RAW_T VALID VDD VSS) AN2D1BWP12T30P140
XSN (SAMPLE SN VDD VSS) INVD1BWP12T30P140
// VALID drives the inner NAND input: CMP_CLK falls first, so the internal node never floats
// when VALID falls (FF-cold terminal-voltage screen).
XW0 (VALID CMP_CLK WD VDD VSS) AN2D1BWP12T30P140
XW1 (WD SN WRITE VDD VSS) AN2D1BWP12T30P140
XCP (WRITE COMMIT VDD VSS) CKBD1BWP12T30P140
// Tracking clears PHASE, so PHASE_REQUEST and every tap settle high and READY is
// already high when sampling closes: the first trial needs no settling window.
// Each real commit toggles PHASE and launches the opposite transition.
// Two-flop Johnson phase: each register toggles on every second commit, and PHASE = PHA XOR PHB
// changes once per commit without hazards.
XPHA (COMMIT PHB_N SAMPLE VDD VSS PHA) sar8_se_store
XPHBN (PHB PHB_N VDD VSS) INVD1BWP12T30P140
XPHB (COMMIT PHA SAMPLE VDD VSS PHB) sar8_se_store
XPHX (PHA PHB PHASE VDD VSS) XOR2D1BWP12T30P140
XPHR (PHASE PHASE_REQUEST VDD VSS) INVD1BWP12T30P140
XWINDOW (PHASE_REQUEST SEL9 SEL7 SEL6 SEL5 SEL4 VDD VSS DELIVERED) sar8_se_window
XREADY (PHASE DELIVERED READY VDD VSS) XOR2D1BWP12T30P140
// Reset on the committed phase change; only the delayed edge can release reset.
XCLR (READY SN CLR_N VDD VSS) AN2D1BWP12T30P140
// The first compare waits two stages after sampling closes for the bootstrap
// gates to turn off. Reopening the sample clears LIVE through the qualifier.
XSND1 (SN SN_T1 VDD VSS) DEL250D1BWP12T30P140
XSND2 (SN_T1 SN_T2 VDD VSS) DEL250D1BWP12T30P140
XSNQ (SN SN_T2 SN_D VDD VSS) AN2D1BWP12T30P140
XLIVE (ACTIVE SN_D LIVE VDD VSS) AN2D1BWP12T30P140
XIDLE (RAW CLEARED VDD VSS) INVD1BWP12T30P140
XSET0 (LIVE CLEARED SET0 VDD VSS) AN2D1BWP12T30P140
XSET (SET0 READY SET VDD VSS) AN2D1BWP12T30P140
XHIGH (HIGH VDD VSS) TIEHBWP12T30P140
XCLOCK (HIGH SET CLR_N Q VDD VSS) LHCNDQD1BWP12T30P140
XCMP (Q CMP_CLK VDD VSS) CKBD1BWP12T30P140
// BEGIN SARADC RNL
// @RNL(author="saradc topology") {
// (-17,54) @TEXT("Asynchronous compare and commit timing",size=2.05,halign="start",textcolor="#223d52");
// (-17,37) @TEXT("Latch decision",size=1.35,halign="start",textcolor="#223d52");
// #XPR @SET-SYMBOL $S_BUFFD1BWP12T30P140;
// #XPR @PLACE(0,22) => @ORIENT("R0");
// #XNR @SET-SYMBOL $S_BUFFD1BWP12T30P140;
// #XNR @PLACE(39,22) => @ORIENT("R0");
// #XNRB @SET-SYMBOL $S_INVD1BWP12T30P140;
// #XNRB @PLACE(78,22) => @ORIENT("R0");
// #XDATA @SET-SYMBOL $S_AN2D1BWP12T30P140;
// #XDATA @PLACE(117,22) => @ORIENT("R0");
// #XRAW @SET-SYMBOL $S_XOR2D1BWP12T30P140;
// #XRAW @PLACE(156,22) => @ORIENT("R0");
// #XVD @SET-SYMBOL $S_DEL200D1BWP12T30P140;
// #XVD @PLACE(195,22) => @ORIENT("R0");
// #XVALID @SET-SYMBOL $S_AN2D1BWP12T30P140;
// #XVALID @PLACE(234,22) => @ORIENT("R0");
// (-17,-13) @TEXT("Commit and phase",size=1.35,halign="start",textcolor="#223d52");
// #XSN @SET-SYMBOL $S_INVD1BWP12T30P140;
// #XSN @PLACE(0,-28) => @ORIENT("R0");
// #XW0 @SET-SYMBOL $S_AN2D1BWP12T30P140;
// #XW0 @PLACE(39,-28) => @ORIENT("R0");
// #XW1 @SET-SYMBOL $S_AN2D1BWP12T30P140;
// #XW1 @PLACE(78,-28) => @ORIENT("R0");
// #XCP @SET-SYMBOL $S_CKBD1BWP12T30P140;
// #XCP @PLACE(117,-28) => @ORIENT("R0");
// #XPHA @SET-SYMBOL $S_sar8_se_store;
// #XPHA @PLACE(156,-28) => @ORIENT("R0");
// #XPHBN @SET-SYMBOL $S_INVD1BWP12T30P140;
// #XPHBN @PLACE(195,-28) => @ORIENT("R0");
// #XPHB @SET-SYMBOL $S_sar8_se_store;
// #XPHB @PLACE(234,-28) => @ORIENT("R0");
// #XPHX @SET-SYMBOL $S_XOR2D1BWP12T30P140;
// #XPHX @PLACE(273,-28) => @ORIENT("R0");
// (-17,-63) @TEXT("Settling window",size=1.35,halign="start",textcolor="#223d52");
// #XPHR @SET-SYMBOL $S_INVD1BWP12T30P140;
// #XPHR @PLACE(0,-78) => @ORIENT("R0");
// #XWINDOW @SET-SYMBOL $S_sar8_se_window;
// #XWINDOW @PLACE(39,-78) => @ORIENT("R0");
// #XREADY @SET-SYMBOL $S_XOR2D1BWP12T30P140;
// #XREADY @PLACE(78,-78) => @ORIENT("R0");
// #XCLR @SET-SYMBOL $S_AN2D1BWP12T30P140;
// #XCLR @PLACE(117,-78) => @ORIENT("R0");
// #XSND1 @SET-SYMBOL $S_DEL250D1BWP12T30P140;
// #XSND1 @PLACE(156,-78) => @ORIENT("R0");
// #XSND2 @SET-SYMBOL $S_DEL250D1BWP12T30P140;
// #XSND2 @PLACE(195,-78) => @ORIENT("R0");
// #XSNQ @SET-SYMBOL $S_AN2D1BWP12T30P140;
// #XSNQ @PLACE(234,-78) => @ORIENT("R0");
// (-17,-113) @TEXT("Comparator clock",size=1.35,halign="start",textcolor="#223d52");
// #XLIVE @SET-SYMBOL $S_AN2D1BWP12T30P140;
// #XLIVE @PLACE(0,-128) => @ORIENT("R0");
// #XIDLE @SET-SYMBOL $S_INVD1BWP12T30P140;
// #XIDLE @PLACE(39,-128) => @ORIENT("R0");
// #XSET0 @SET-SYMBOL $S_AN2D1BWP12T30P140;
// #XSET0 @PLACE(78,-128) => @ORIENT("R0");
// #XSET @SET-SYMBOL $S_AN2D1BWP12T30P140;
// #XSET @PLACE(117,-128) => @ORIENT("R0");
// #XHIGH @SET-SYMBOL $S_TIEHBWP12T30P140;
// #XHIGH @PLACE(156,-128) => @ORIENT("R0");
// #XCLOCK @SET-SYMBOL $S_LHCNDQD1BWP12T30P140;
// #XCLOCK @PLACE(195,-128) => @ORIENT("R0");
// #XCMP @SET-SYMBOL $S_CKBD1BWP12T30P140;
// #XCMP @PLACE(234,-128) => @ORIENT("R0");
// &"NRB" @WIRE(mode="straight",linecolor="#30485d",linewidth=0.16) {#XNRB:2 (94.5,22) (94.5,20.35) #XDATA:2};
// &"RAW_T" @WIRE(mode="straight",linecolor="#30485d",linewidth=0.16) {#XVD:2 (214.5,22) (214.5,20.35) #XVALID:2};
// &"WD" @WIRE(mode="straight",linecolor="#30485d",linewidth=0.16) {#XW0:3 (58.5,-28) (58.5,-26.35) #XW1:1};
// &"WRITE" @WIRE(mode="straight",linecolor="#30485d",linewidth=0.16) {#XW1:3 (97.5,-28) (97.5,-28) #XCP:1};
// &"PHB_N" @WIRE(mode="straight",linecolor="#30485d",linewidth=0.16) {#XPHA:2 (185.5,-26.35) (185.5,-28) #XPHBN:2};
// &"PHASE_REQUEST" @WIRE(mode="straight",linecolor="#30485d",linewidth=0.16) {#XPHR:2 (16.5,-78) (16.5,-69.75) #XWINDOW:1};
// &"DELIVERED" @WIRE(mode="straight",linecolor="#30485d",linewidth=0.16) {#XWINDOW:9 (58.5,-78) (58.5,-79.65) #XREADY:2};
// &"SN_T1" @WIRE(mode="straight",linecolor="#30485d",linewidth=0.16) {#XSND1:2 (175.5,-78) (175.5,-78) #XSND2:1};
// &"SN_T2" @WIRE(mode="straight",linecolor="#30485d",linewidth=0.16) {#XSND2:2 (214.5,-78) (214.5,-79.65) #XSNQ:2};
// &"CLEARED" @WIRE(mode="straight",linecolor="#30485d",linewidth=0.16) {#XIDLE:2 (55.5,-128) (55.5,-129.65) #XSET0:2};
// &"SET0" @WIRE(mode="straight",linecolor="#30485d",linewidth=0.16) {#XSET0:3 (97.5,-128) (97.5,-126.35) #XSET:1};
// &"HIGH" @WIRE(mode="straight",linecolor="#30485d",linewidth=0.16) {#XHIGH:1 (175.5,-128) (175.5,-124.7) #XCLOCK:1};
// &"Q" @WIRE(mode="straight",linecolor="#30485d",linewidth=0.16) {#XCLOCK:4 (214.5,-128) (214.5,-128) #XCMP:1};
// &"COMP_P" @WIRE(mode="straight",linecolor="#30485d",linewidth=0.16) {#XPR:1 (-16,22)};
// (-16.4,22) @TEXT("COMP_P",size=1.1,halign="end",valign="middle");
// &"PR" @WIRE(mode="straight",linecolor="#30485d",linewidth=0.16) {#XPR:2 (16,22)};
// (16.4,22) @TEXT("PR",size=1.1,halign="start",valign="middle");
// &"VDD" @WIRE(mode="straight",linecolor="#30485d",linewidth=0.16) {#XPR:3 (0,33)};
// (0,33.4) @TEXT("VDD",size=1.1,halign="middle",valign="bottom");
// &"VSS" @WIRE(mode="straight",linecolor="#30485d",linewidth=0.16) {#XPR:4 (0,11)};
// (0,10.6) @TEXT("VSS",size=1.1,halign="middle",valign="top");
// &"COMP_N" @WIRE(mode="straight",linecolor="#30485d",linewidth=0.16) {#XNR:1 (23,22)};
// (22.6,22) @TEXT("COMP_N",size=1.1,halign="end",valign="middle");
// &"NR" @WIRE(mode="straight",linecolor="#30485d",linewidth=0.16) {#XNR:2 (55,22)};
// (55.4,22) @TEXT("NR",size=1.1,halign="start",valign="middle");
// &"VDD" @WIRE(mode="straight",linecolor="#30485d",linewidth=0.16) {#XNR:3 (39,33)};
// (39,33.4) @TEXT("VDD",size=1.1,halign="middle",valign="bottom");
// &"VSS" @WIRE(mode="straight",linecolor="#30485d",linewidth=0.16) {#XNR:4 (39,11)};
// (39,10.6) @TEXT("VSS",size=1.1,halign="middle",valign="top");
// &"NR" @WIRE(mode="straight",linecolor="#30485d",linewidth=0.16) {#XNRB:1 (68,22)};
// (67.6,22) @TEXT("NR",size=1.1,halign="end",valign="middle");
// &"VDD" @WIRE(mode="straight",linecolor="#30485d",linewidth=0.16) {#XNRB:3 (78,32)};
// (78,32.4) @TEXT("VDD",size=1.1,halign="middle",valign="bottom");
// &"VSS" @WIRE(mode="straight",linecolor="#30485d",linewidth=0.16) {#XNRB:4 (78,12)};
// (78,11.6) @TEXT("VSS",size=1.1,halign="middle",valign="top");
// &"PR" @WIRE(mode="straight",linecolor="#30485d",linewidth=0.16) {#XDATA:1 (101,23.65)};
// (100.6,23.65) @TEXT("PR",size=1.1,halign="end",valign="middle");
// &"DATA" @WIRE(mode="straight",linecolor="#30485d",linewidth=0.16) {#XDATA:3 (133,22)};
// (133.4,22) @TEXT("DATA",size=1.1,halign="start",valign="middle");
// &"VDD" @WIRE(mode="straight",linecolor="#30485d",linewidth=0.16) {#XDATA:4 (117,33)};
// (117,33.4) @TEXT("VDD",size=1.1,halign="middle",valign="bottom");
// &"VSS" @WIRE(mode="straight",linecolor="#30485d",linewidth=0.16) {#XDATA:5 (117,11)};
// (117,10.6) @TEXT("VSS",size=1.1,halign="middle",valign="top");
// &"PR" @WIRE(mode="straight",linecolor="#30485d",linewidth=0.16) {#XRAW:1 (140,23.65)};
// (139.6,23.65) @TEXT("PR",size=1.1,halign="end",valign="middle");
// &"NR" @WIRE(mode="straight",linecolor="#30485d",linewidth=0.16) {#XRAW:2 (140,20.35)};
// (139.6,20.35) @TEXT("NR",size=1.1,halign="end",valign="middle");
// &"RAW" @WIRE(mode="straight",linecolor="#30485d",linewidth=0.16) {#XRAW:3 (172,22)};
// (172.4,22) @TEXT("RAW",size=1.1,halign="start",valign="middle");
// &"VDD" @WIRE(mode="straight",linecolor="#30485d",linewidth=0.16) {#XRAW:4 (156,33)};
// (156,33.4) @TEXT("VDD",size=1.1,halign="middle",valign="bottom");
// &"VSS" @WIRE(mode="straight",linecolor="#30485d",linewidth=0.16) {#XRAW:5 (156,11)};
// (156,10.6) @TEXT("VSS",size=1.1,halign="middle",valign="top");
// &"RAW" @WIRE(mode="straight",linecolor="#30485d",linewidth=0.16) {#XVD:1 (179,22)};
// (178.6,22) @TEXT("RAW",size=1.1,halign="end",valign="middle");
// &"VDD" @WIRE(mode="straight",linecolor="#30485d",linewidth=0.16) {#XVD:3 (195,33)};
// (195,33.4) @TEXT("VDD",size=1.1,halign="middle",valign="bottom");
// &"VSS" @WIRE(mode="straight",linecolor="#30485d",linewidth=0.16) {#XVD:4 (195,11)};
// (195,10.6) @TEXT("VSS",size=1.1,halign="middle",valign="top");
// &"RAW" @WIRE(mode="straight",linecolor="#30485d",linewidth=0.16) {#XVALID:1 (218,23.65)};
// (217.6,23.65) @TEXT("RAW",size=1.1,halign="end",valign="middle");
// &"VALID" @WIRE(mode="straight",linecolor="#30485d",linewidth=0.16) {#XVALID:3 (250,22)};
// (250.4,22) @TEXT("VALID",size=1.1,halign="start",valign="middle");
// &"VDD" @WIRE(mode="straight",linecolor="#30485d",linewidth=0.16) {#XVALID:4 (234,33)};
// (234,33.4) @TEXT("VDD",size=1.1,halign="middle",valign="bottom");
// &"VSS" @WIRE(mode="straight",linecolor="#30485d",linewidth=0.16) {#XVALID:5 (234,11)};
// (234,10.6) @TEXT("VSS",size=1.1,halign="middle",valign="top");
// &"SAMPLE" @WIRE(mode="straight",linecolor="#30485d",linewidth=0.16) {#XSN:1 (-10,-28)};
// (-10.4,-28) @TEXT("SAMPLE",size=1.1,halign="end",valign="middle");
// &"SN" @WIRE(mode="straight",linecolor="#30485d",linewidth=0.16) {#XSN:2 (10,-28)};
// (10.4,-28) @TEXT("SN",size=1.1,halign="start",valign="middle");
// &"VDD" @WIRE(mode="straight",linecolor="#30485d",linewidth=0.16) {#XSN:3 (0,-18)};
// (0,-17.6) @TEXT("VDD",size=1.1,halign="middle",valign="bottom");
// &"VSS" @WIRE(mode="straight",linecolor="#30485d",linewidth=0.16) {#XSN:4 (0,-38)};
// (0,-38.4) @TEXT("VSS",size=1.1,halign="middle",valign="top");
// &"VALID" @WIRE(mode="straight",linecolor="#30485d",linewidth=0.16) {#XW0:1 (23,-26.35)};
// (22.6,-26.35) @TEXT("VALID",size=1.1,halign="end",valign="middle");
// &"CMP_CLK" @WIRE(mode="straight",linecolor="#30485d",linewidth=0.16) {#XW0:2 (23,-29.65)};
// (22.6,-29.65) @TEXT("CMP_CLK",size=1.1,halign="end",valign="middle");
// &"VDD" @WIRE(mode="straight",linecolor="#30485d",linewidth=0.16) {#XW0:4 (39,-17)};
// (39,-16.6) @TEXT("VDD",size=1.1,halign="middle",valign="bottom");
// &"VSS" @WIRE(mode="straight",linecolor="#30485d",linewidth=0.16) {#XW0:5 (39,-39)};
// (39,-39.4) @TEXT("VSS",size=1.1,halign="middle",valign="top");
// &"SN" @WIRE(mode="straight",linecolor="#30485d",linewidth=0.16) {#XW1:2 (62,-29.65)};
// (61.6,-29.65) @TEXT("SN",size=1.1,halign="end",valign="middle");
// &"VDD" @WIRE(mode="straight",linecolor="#30485d",linewidth=0.16) {#XW1:4 (78,-17)};
// (78,-16.6) @TEXT("VDD",size=1.1,halign="middle",valign="bottom");
// &"VSS" @WIRE(mode="straight",linecolor="#30485d",linewidth=0.16) {#XW1:5 (78,-39)};
// (78,-39.4) @TEXT("VSS",size=1.1,halign="middle",valign="top");
// &"COMMIT" @WIRE(mode="straight",linecolor="#30485d",linewidth=0.16) {#XCP:2 (133,-28)};
// (133.4,-28) @TEXT("COMMIT",size=1.1,halign="start",valign="middle");
// &"VDD" @WIRE(mode="straight",linecolor="#30485d",linewidth=0.16) {#XCP:3 (117,-17)};
// (117,-16.6) @TEXT("VDD",size=1.1,halign="middle",valign="bottom");
// &"VSS" @WIRE(mode="straight",linecolor="#30485d",linewidth=0.16) {#XCP:4 (117,-39)};
// (117,-39.4) @TEXT("VSS",size=1.1,halign="middle",valign="top");
// &"COMMIT" @WIRE(mode="straight",linecolor="#30485d",linewidth=0.16) {#XPHA:1 (140,-26.35)};
// (139.6,-26.35) @TEXT("COMMIT",size=1.1,halign="end",valign="middle");
// &"SAMPLE" @WIRE(mode="straight",linecolor="#30485d",linewidth=0.16) {#XPHA:3 (140,-29.65)};
// (139.6,-29.65) @TEXT("SAMPLE",size=1.1,halign="end",valign="middle");
// &"VDD" @WIRE(mode="straight",linecolor="#30485d",linewidth=0.16) {#XPHA:4 (156,-17)};
// (156,-16.6) @TEXT("VDD",size=1.1,halign="middle",valign="bottom");
// &"VSS" @WIRE(mode="straight",linecolor="#30485d",linewidth=0.16) {#XPHA:5 (156,-39)};
// (156,-39.4) @TEXT("VSS",size=1.1,halign="middle",valign="top");
// &"PHA" @WIRE(mode="straight",linecolor="#30485d",linewidth=0.16) {#XPHA:6 (172,-29.65)};
// (172.4,-29.65) @TEXT("PHA",size=1.1,halign="start",valign="middle");
// &"PHB" @WIRE(mode="straight",linecolor="#30485d",linewidth=0.16) {#XPHBN:1 (185,-28)};
// (184.6,-28) @TEXT("PHB",size=1.1,halign="end",valign="middle");
// &"VDD" @WIRE(mode="straight",linecolor="#30485d",linewidth=0.16) {#XPHBN:3 (195,-18)};
// (195,-17.6) @TEXT("VDD",size=1.1,halign="middle",valign="bottom");
// &"VSS" @WIRE(mode="straight",linecolor="#30485d",linewidth=0.16) {#XPHBN:4 (195,-38)};
// (195,-38.4) @TEXT("VSS",size=1.1,halign="middle",valign="top");
// &"COMMIT" @WIRE(mode="straight",linecolor="#30485d",linewidth=0.16) {#XPHB:1 (218,-26.35)};
// (217.6,-26.35) @TEXT("COMMIT",size=1.1,halign="end",valign="middle");
// &"PHA" @WIRE(mode="straight",linecolor="#30485d",linewidth=0.16) {#XPHB:2 (250,-26.35)};
// (250.4,-26.35) @TEXT("PHA",size=1.1,halign="start",valign="middle");
// &"SAMPLE" @WIRE(mode="straight",linecolor="#30485d",linewidth=0.16) {#XPHB:3 (218,-29.65)};
// (217.6,-29.65) @TEXT("SAMPLE",size=1.1,halign="end",valign="middle");
// &"VDD" @WIRE(mode="straight",linecolor="#30485d",linewidth=0.16) {#XPHB:4 (234,-17)};
// (234,-16.6) @TEXT("VDD",size=1.1,halign="middle",valign="bottom");
// &"VSS" @WIRE(mode="straight",linecolor="#30485d",linewidth=0.16) {#XPHB:5 (234,-39)};
// (234,-39.4) @TEXT("VSS",size=1.1,halign="middle",valign="top");
// &"PHB" @WIRE(mode="straight",linecolor="#30485d",linewidth=0.16) {#XPHB:6 (250,-29.65)};
// (250.4,-29.65) @TEXT("PHB",size=1.1,halign="start",valign="middle");
// &"PHA" @WIRE(mode="straight",linecolor="#30485d",linewidth=0.16) {#XPHX:1 (257,-26.35)};
// (256.6,-26.35) @TEXT("PHA",size=1.1,halign="end",valign="middle");
// &"PHB" @WIRE(mode="straight",linecolor="#30485d",linewidth=0.16) {#XPHX:2 (257,-29.65)};
// (256.6,-29.65) @TEXT("PHB",size=1.1,halign="end",valign="middle");
// &"PHASE" @WIRE(mode="straight",linecolor="#30485d",linewidth=0.16) {#XPHX:3 (289,-28)};
// (289.4,-28) @TEXT("PHASE",size=1.1,halign="start",valign="middle");
// &"VDD" @WIRE(mode="straight",linecolor="#30485d",linewidth=0.16) {#XPHX:4 (273,-17)};
// (273,-16.6) @TEXT("VDD",size=1.1,halign="middle",valign="bottom");
// &"VSS" @WIRE(mode="straight",linecolor="#30485d",linewidth=0.16) {#XPHX:5 (273,-39)};
// (273,-39.4) @TEXT("VSS",size=1.1,halign="middle",valign="top");
// &"PHASE" @WIRE(mode="straight",linecolor="#30485d",linewidth=0.16) {#XPHR:1 (-10,-78)};
// (-10.4,-78) @TEXT("PHASE",size=1.1,halign="end",valign="middle");
// &"VDD" @WIRE(mode="straight",linecolor="#30485d",linewidth=0.16) {#XPHR:3 (0,-68)};
// (0,-67.6) @TEXT("VDD",size=1.1,halign="middle",valign="bottom");
// &"VSS" @WIRE(mode="straight",linecolor="#30485d",linewidth=0.16) {#XPHR:4 (0,-88)};
// (0,-88.4) @TEXT("VSS",size=1.1,halign="middle",valign="top");
// &"SEL9" @WIRE(mode="straight",linecolor="#30485d",linewidth=0.16) {#XWINDOW:2 (23,-73.05)};
// (22.6,-73.05) @TEXT("SEL9",size=1.1,halign="end",valign="middle");
// &"SEL7" @WIRE(mode="straight",linecolor="#30485d",linewidth=0.16) {#XWINDOW:3 (23,-76.35)};
// (22.6,-76.35) @TEXT("SEL7",size=1.1,halign="end",valign="middle");
// &"SEL6" @WIRE(mode="straight",linecolor="#30485d",linewidth=0.16) {#XWINDOW:4 (23,-79.65)};
// (22.6,-79.65) @TEXT("SEL6",size=1.1,halign="end",valign="middle");
// &"SEL5" @WIRE(mode="straight",linecolor="#30485d",linewidth=0.16) {#XWINDOW:5 (23,-82.95)};
// (22.6,-82.95) @TEXT("SEL5",size=1.1,halign="end",valign="middle");
// &"SEL4" @WIRE(mode="straight",linecolor="#30485d",linewidth=0.16) {#XWINDOW:6 (23,-86.25)};
// (22.6,-86.25) @TEXT("SEL4",size=1.1,halign="end",valign="middle");
// &"VDD" @WIRE(mode="straight",linecolor="#30485d",linewidth=0.16) {#XWINDOW:7 (39,-61.45)};
// (39,-61.05) @TEXT("VDD",size=1.1,halign="middle",valign="bottom");
// &"VSS" @WIRE(mode="straight",linecolor="#30485d",linewidth=0.16) {#XWINDOW:8 (39,-94.55)};
// (39,-94.95) @TEXT("VSS",size=1.1,halign="middle",valign="top");
// &"PHASE" @WIRE(mode="straight",linecolor="#30485d",linewidth=0.16) {#XREADY:1 (62,-76.35)};
// (61.6,-76.35) @TEXT("PHASE",size=1.1,halign="end",valign="middle");
// &"READY" @WIRE(mode="straight",linecolor="#30485d",linewidth=0.16) {#XREADY:3 (94,-78)};
// (94.4,-78) @TEXT("READY",size=1.1,halign="start",valign="middle");
// &"VDD" @WIRE(mode="straight",linecolor="#30485d",linewidth=0.16) {#XREADY:4 (78,-67)};
// (78,-66.6) @TEXT("VDD",size=1.1,halign="middle",valign="bottom");
// &"VSS" @WIRE(mode="straight",linecolor="#30485d",linewidth=0.16) {#XREADY:5 (78,-89)};
// (78,-89.4) @TEXT("VSS",size=1.1,halign="middle",valign="top");
// &"READY" @WIRE(mode="straight",linecolor="#30485d",linewidth=0.16) {#XCLR:1 (101,-76.35)};
// (100.6,-76.35) @TEXT("READY",size=1.1,halign="end",valign="middle");
// &"SN" @WIRE(mode="straight",linecolor="#30485d",linewidth=0.16) {#XCLR:2 (101,-79.65)};
// (100.6,-79.65) @TEXT("SN",size=1.1,halign="end",valign="middle");
// &"CLR_N" @WIRE(mode="straight",linecolor="#30485d",linewidth=0.16) {#XCLR:3 (133,-78)};
// (133.4,-78) @TEXT("CLR_N",size=1.1,halign="start",valign="middle");
// &"VDD" @WIRE(mode="straight",linecolor="#30485d",linewidth=0.16) {#XCLR:4 (117,-67)};
// (117,-66.6) @TEXT("VDD",size=1.1,halign="middle",valign="bottom");
// &"VSS" @WIRE(mode="straight",linecolor="#30485d",linewidth=0.16) {#XCLR:5 (117,-89)};
// (117,-89.4) @TEXT("VSS",size=1.1,halign="middle",valign="top");
// &"SN" @WIRE(mode="straight",linecolor="#30485d",linewidth=0.16) {#XSND1:1 (140,-78)};
// (139.6,-78) @TEXT("SN",size=1.1,halign="end",valign="middle");
// &"VDD" @WIRE(mode="straight",linecolor="#30485d",linewidth=0.16) {#XSND1:3 (156,-67)};
// (156,-66.6) @TEXT("VDD",size=1.1,halign="middle",valign="bottom");
// &"VSS" @WIRE(mode="straight",linecolor="#30485d",linewidth=0.16) {#XSND1:4 (156,-89)};
// (156,-89.4) @TEXT("VSS",size=1.1,halign="middle",valign="top");
// &"VDD" @WIRE(mode="straight",linecolor="#30485d",linewidth=0.16) {#XSND2:3 (195,-67)};
// (195,-66.6) @TEXT("VDD",size=1.1,halign="middle",valign="bottom");
// &"VSS" @WIRE(mode="straight",linecolor="#30485d",linewidth=0.16) {#XSND2:4 (195,-89)};
// (195,-89.4) @TEXT("VSS",size=1.1,halign="middle",valign="top");
// &"SN" @WIRE(mode="straight",linecolor="#30485d",linewidth=0.16) {#XSNQ:1 (218,-76.35)};
// (217.6,-76.35) @TEXT("SN",size=1.1,halign="end",valign="middle");
// &"SN_D" @WIRE(mode="straight",linecolor="#30485d",linewidth=0.16) {#XSNQ:3 (250,-78)};
// (250.4,-78) @TEXT("SN_D",size=1.1,halign="start",valign="middle");
// &"VDD" @WIRE(mode="straight",linecolor="#30485d",linewidth=0.16) {#XSNQ:4 (234,-67)};
// (234,-66.6) @TEXT("VDD",size=1.1,halign="middle",valign="bottom");
// &"VSS" @WIRE(mode="straight",linecolor="#30485d",linewidth=0.16) {#XSNQ:5 (234,-89)};
// (234,-89.4) @TEXT("VSS",size=1.1,halign="middle",valign="top");
// &"ACTIVE" @WIRE(mode="straight",linecolor="#30485d",linewidth=0.16) {#XLIVE:1 (-16,-126.35)};
// (-16.4,-126.35) @TEXT("ACTIVE",size=1.1,halign="end",valign="middle");
// &"SN_D" @WIRE(mode="straight",linecolor="#30485d",linewidth=0.16) {#XLIVE:2 (-16,-129.65)};
// (-16.4,-129.65) @TEXT("SN_D",size=1.1,halign="end",valign="middle");
// &"LIVE" @WIRE(mode="straight",linecolor="#30485d",linewidth=0.16) {#XLIVE:3 (16,-128)};
// (16.4,-128) @TEXT("LIVE",size=1.1,halign="start",valign="middle");
// &"VDD" @WIRE(mode="straight",linecolor="#30485d",linewidth=0.16) {#XLIVE:4 (0,-117)};
// (0,-116.6) @TEXT("VDD",size=1.1,halign="middle",valign="bottom");
// &"VSS" @WIRE(mode="straight",linecolor="#30485d",linewidth=0.16) {#XLIVE:5 (0,-139)};
// (0,-139.4) @TEXT("VSS",size=1.1,halign="middle",valign="top");
// &"RAW" @WIRE(mode="straight",linecolor="#30485d",linewidth=0.16) {#XIDLE:1 (29,-128)};
// (28.6,-128) @TEXT("RAW",size=1.1,halign="end",valign="middle");
// &"VDD" @WIRE(mode="straight",linecolor="#30485d",linewidth=0.16) {#XIDLE:3 (39,-118)};
// (39,-117.6) @TEXT("VDD",size=1.1,halign="middle",valign="bottom");
// &"VSS" @WIRE(mode="straight",linecolor="#30485d",linewidth=0.16) {#XIDLE:4 (39,-138)};
// (39,-138.4) @TEXT("VSS",size=1.1,halign="middle",valign="top");
// &"LIVE" @WIRE(mode="straight",linecolor="#30485d",linewidth=0.16) {#XSET0:1 (62,-126.35)};
// (61.6,-126.35) @TEXT("LIVE",size=1.1,halign="end",valign="middle");
// &"VDD" @WIRE(mode="straight",linecolor="#30485d",linewidth=0.16) {#XSET0:4 (78,-117)};
// (78,-116.6) @TEXT("VDD",size=1.1,halign="middle",valign="bottom");
// &"VSS" @WIRE(mode="straight",linecolor="#30485d",linewidth=0.16) {#XSET0:5 (78,-139)};
// (78,-139.4) @TEXT("VSS",size=1.1,halign="middle",valign="top");
// &"READY" @WIRE(mode="straight",linecolor="#30485d",linewidth=0.16) {#XSET:2 (101,-129.65)};
// (100.6,-129.65) @TEXT("READY",size=1.1,halign="end",valign="middle");
// &"SET" @WIRE(mode="straight",linecolor="#30485d",linewidth=0.16) {#XSET:3 (133,-128)};
// (133.4,-128) @TEXT("SET",size=1.1,halign="start",valign="middle");
// &"VDD" @WIRE(mode="straight",linecolor="#30485d",linewidth=0.16) {#XSET:4 (117,-117)};
// (117,-116.6) @TEXT("VDD",size=1.1,halign="middle",valign="bottom");
// &"VSS" @WIRE(mode="straight",linecolor="#30485d",linewidth=0.16) {#XSET:5 (117,-139)};
// (117,-139.4) @TEXT("VSS",size=1.1,halign="middle",valign="top");
// &"VDD" @WIRE(mode="straight",linecolor="#30485d",linewidth=0.16) {#XHIGH:2 (156,-117)};
// (156,-116.6) @TEXT("VDD",size=1.1,halign="middle",valign="bottom");
// &"VSS" @WIRE(mode="straight",linecolor="#30485d",linewidth=0.16) {#XHIGH:3 (156,-139)};
// (156,-139.4) @TEXT("VSS",size=1.1,halign="middle",valign="top");
// &"SET" @WIRE(mode="straight",linecolor="#30485d",linewidth=0.16) {#XCLOCK:2 (179,-128)};
// (178.6,-128) @TEXT("SET",size=1.1,halign="end",valign="middle");
// &"CLR_N" @WIRE(mode="straight",linecolor="#30485d",linewidth=0.16) {#XCLOCK:3 (179,-131.3)};
// (178.6,-131.3) @TEXT("CLR_N",size=1.1,halign="end",valign="middle");
// &"VDD" @WIRE(mode="straight",linecolor="#30485d",linewidth=0.16) {#XCLOCK:5 (195,-116.4)};
// (195,-116) @TEXT("VDD",size=1.1,halign="middle",valign="bottom");
// &"VSS" @WIRE(mode="straight",linecolor="#30485d",linewidth=0.16) {#XCLOCK:6 (195,-139.6)};
// (195,-140) @TEXT("VSS",size=1.1,halign="middle",valign="top");
// &"CMP_CLK" @WIRE(mode="straight",linecolor="#30485d",linewidth=0.16) {#XCMP:2 (250,-128)};
// (250.4,-128) @TEXT("CMP_CLK",size=1.1,halign="start",valign="middle");
// &"VDD" @WIRE(mode="straight",linecolor="#30485d",linewidth=0.16) {#XCMP:3 (234,-117)};
// (234,-116.6) @TEXT("VDD",size=1.1,halign="middle",valign="bottom");
// &"VSS" @WIRE(mode="straight",linecolor="#30485d",linewidth=0.16) {#XCMP:4 (234,-139)};
// (234,-139.4) @TEXT("VSS",size=1.1,halign="middle",valign="top");
// }
// END SARADC RNL
ends sar8_se_timing

subckt sar8_se_store CK DATA RESET VDD VSS Q
XDR (DATA RESET DIN VDD VSS) OR2D1BWP12T30P140
XCLR (RESET RST_N VDD VSS) INVD1BWP12T30P140
XREG (DIN CK RST_N Q VDD VSS) DFCNQD1BWP12T30P140
// BEGIN SARADC RNL
// @RNL(author="saradc topology") {
// #XDR @SET-SYMBOL $S_OR2D1BWP12T30P140;
// #XDR @PLACE(0,0) => @ORIENT("R0");
// #XCLR @SET-SYMBOL $S_INVD1BWP12T30P140;
// #XCLR @PLACE(0,-33) => @ORIENT("R0");
// #XREG @SET-SYMBOL $S_DFCNQD1BWP12T30P140;
// #XREG @PLACE(0,-66) => @ORIENT("R0");
// &"RESET" @WIRE(mode="straight",linecolor="#30485d",linewidth=0.16) {#XDR:2 (-10,-1.65) (-10,-33) #XCLR:1};
// &"DIN" @WIRE(mode="straight",linecolor="#30485d",linewidth=0.16) {#XDR:3 (3,0) (3,-62.6) #XREG:1};
// &"RST_N" @WIRE(mode="straight",linecolor="#30485d",linewidth=0.16) {#XCLR:2 (0,-33) (0,-69.4) #XREG:3};
// (-89,30) @TEXT("sar8_se_store / source-derived connections",size=1.4,halign="start",textcolor="#223d52");
// &"DATA" @WIRE(mode="straight",linecolor="#30485d",linewidth=0.16) {#XDR:1 (-16,1.65)};
// (-16.4,1.65) @TEXT("DATA",size=1.1,halign="end",valign="middle");
// &"VDD" @WIRE(mode="straight",linecolor="#30485d",linewidth=0.16) {#XDR:4 (0,11)};
// (0,11.4) @TEXT("VDD",size=1.1,halign="middle",valign="bottom");
// &"VSS" @WIRE(mode="straight",linecolor="#30485d",linewidth=0.16) {#XDR:5 (0,-11)};
// (0,-11.4) @TEXT("VSS",size=1.1,halign="middle",valign="top");
// &"VDD" @WIRE(mode="straight",linecolor="#30485d",linewidth=0.16) {#XCLR:3 (0,-23)};
// (0,-22.6) @TEXT("VDD",size=1.1,halign="middle",valign="bottom");
// &"VSS" @WIRE(mode="straight",linecolor="#30485d",linewidth=0.16) {#XCLR:4 (0,-43)};
// (0,-43.4) @TEXT("VSS",size=1.1,halign="middle",valign="top");
// &"CK" @WIRE(mode="straight",linecolor="#30485d",linewidth=0.16) {#XREG:2 (-10,-66)};
// (-10.4,-66) @TEXT("CK",size=1.1,halign="end",valign="middle");
// &"Q" @WIRE(mode="straight",linecolor="#30485d",linewidth=0.16) {#XREG:4 (10,-66)};
// (10.4,-66) @TEXT("Q",size=1.1,halign="start",valign="middle");
// &"VDD" @WIRE(mode="straight",linecolor="#30485d",linewidth=0.16) {#XREG:5 (0,-56)};
// (0,-55.6) @TEXT("VDD",size=1.1,halign="middle",valign="bottom");
// &"VSS" @WIRE(mode="straight",linecolor="#30485d",linewidth=0.16) {#XREG:6 (0,-76)};
// (0,-76.4) @TEXT("VSS",size=1.1,halign="middle",valign="top");
// }
// END SARADC RNL
ends sar8_se_store

subckt sar8_se_ctrl CMP_CLK CODE0 CODE1 CODE2 CODE3 CODE4 CODE5 CODE6 CODE7 COMP_N COMP_P D0 D1 D2 D3 D4 D5 D6 D7 COMMIT SAMPLE VDD VSS ACTIVE
XTIM (ACTIVE SAMPLE SEL9 SEL7 SEL6 SEL5 SEL4 COMP_P COMP_N CMP_CLK COMMIT DATA VDD VSS) sar8_se_timing
XWORD (CODE0 CODE1 CODE2 CODE3 CODE4 CODE5 CODE6 CODE7 DATA DONE D0 D1 D2 D3 D4 D5 D6 D7 NEXT0 NEXT1 NEXT2 NEXT3 NEXT4 NEXT5 NEXT6 NEXT7 TRIAL6 TRIAL5 TRIAL4 TRIAL3 TRIAL2 VDD VSS) sar8_next_word
// Sticky tap selects: the commit of bit k sets the select for bit k-1 until the
// next accepted sample. Each feeds only the window multiplexers.
// The OR is INV+INV+ND2: a trial glitch while the select is already set must not lift a
// floating PMOS stack node above the rail (FF-cold terminal-voltage screen).
XSEL9_QB (SEL9 SEL9_QB VDD VSS) INVD1BWP12T30P140
XSEL9_TB (TRIAL6 SEL9_TB VDD VSS) INVD1BWP12T30P140
XSEL9_D (SEL9_QB SEL9_TB SEL9_D VDD VSS) ND2D1BWP12T30P140
XSEL9 (COMMIT SEL9_D SAMPLE VDD VSS SEL9) sar8_se_store
XSEL7_QB (SEL7 SEL7_QB VDD VSS) INVD1BWP12T30P140
XSEL7_TB (TRIAL5 SEL7_TB VDD VSS) INVD1BWP12T30P140
XSEL7_D (SEL7_QB SEL7_TB SEL7_D VDD VSS) ND2D1BWP12T30P140
XSEL7 (COMMIT SEL7_D SAMPLE VDD VSS SEL7) sar8_se_store
XSEL6_QB (SEL6 SEL6_QB VDD VSS) INVD1BWP12T30P140
XSEL6_TB (TRIAL4 SEL6_TB VDD VSS) INVD1BWP12T30P140
XSEL6_D (SEL6_QB SEL6_TB SEL6_D VDD VSS) ND2D1BWP12T30P140
XSEL6 (COMMIT SEL6_D SAMPLE VDD VSS SEL6) sar8_se_store
XSEL5_QB (SEL5 SEL5_QB VDD VSS) INVD1BWP12T30P140
XSEL5_TB (TRIAL3 SEL5_TB VDD VSS) INVD1BWP12T30P140
XSEL5_D (SEL5_QB SEL5_TB SEL5_D VDD VSS) ND2D1BWP12T30P140
XSEL5 (COMMIT SEL5_D SAMPLE VDD VSS SEL5) sar8_se_store
XSEL4_QB (SEL4 SEL4_QB VDD VSS) INVD1BWP12T30P140
XSEL4_TB (TRIAL2 SEL4_TB VDD VSS) INVD1BWP12T30P140
XSEL4_D (SEL4_QB SEL4_TB SEL4_D VDD VSS) ND2D1BWP12T30P140
XSEL4 (COMMIT SEL4_D SAMPLE VDD VSS SEL4) sar8_se_store
XDONE (COMMIT CODE0 SAMPLE VDD VSS DONE) sar8_se_store
XACTIVE (DONE ACTIVE VDD VSS) INVD1BWP12T30P140
XBIT0 (COMMIT NEXT0 SAMPLE VDD VSS CODE0) sar8_se_store
XBIT1 (COMMIT NEXT1 SAMPLE VDD VSS CODE1) sar8_se_store
XBIT2 (COMMIT NEXT2 SAMPLE VDD VSS CODE2) sar8_se_store
XBIT3 (COMMIT NEXT3 SAMPLE VDD VSS CODE3) sar8_se_store
XBIT4 (COMMIT NEXT4 SAMPLE VDD VSS CODE4) sar8_se_store
XBIT5 (COMMIT NEXT5 SAMPLE VDD VSS CODE5) sar8_se_store
XBIT6 (COMMIT NEXT6 SAMPLE VDD VSS CODE6) sar8_se_store
XMSBD (NEXT7 MSBD VDD VSS) INVD1BWP12T30P140
XBIT7 (COMMIT MSBD SAMPLE VDD VSS MSBQ) sar8_se_store
XMSBQ (MSBQ CODE7 VDD VSS) INVD1BWP12T30P140
// BEGIN SARADC RNL
// @RNL(author="saradc topology") {
// (-18,84) @TEXT("Single-edge SAR",size=2.15,halign="start",textcolor="#223d52");
// (-18,67) @TEXT("Compare / timing",size=1.25,halign="start",textcolor="#223d52");
// (56,67) @TEXT("Next trial word",size=1.25,halign="start",textcolor="#223d52");
// (147,67) @TEXT("Completion",size=1.25,halign="start",textcolor="#223d52");
// #XTIM @SET-SYMBOL $S_sar8_se_timing;
// #XTIM @PLACE(0,44) => @ORIENT("R0");
// #XWORD @SET-SYMBOL $S_sar8_next_word;
// #XWORD @PLACE(57,44) => @ORIENT("R0");
// #XDONE @SET-SYMBOL $S_sar8_se_store;
// #XDONE @PLACE(114,44) => @ORIENT("R0");
// #XACTIVE @SET-SYMBOL $S_INVD1BWP12T30P140;
// #XACTIVE @PLACE(171,44) => @ORIENT("R0");
// (-18,20) @TEXT("Registered settling taps",size=1.35,halign="start",textcolor="#223d52");
// #XSEL9_QB @SET-SYMBOL $S_INVD1BWP12T30P140;
// #XSEL9_QB @PLACE(0,0) => @ORIENT("R0");
// #XSEL9_TB @SET-SYMBOL $S_INVD1BWP12T30P140;
// #XSEL9_TB @PLACE(31,0) => @ORIENT("R0");
// #XSEL9_D @SET-SYMBOL $S_ND2D1BWP12T30P140;
// #XSEL9_D @PLACE(62,0) => @ORIENT("R0");
// #XSEL9 @SET-SYMBOL $S_sar8_se_store;
// #XSEL9 @PLACE(93,0) => @ORIENT("R0");
// #XSEL7_QB @SET-SYMBOL $S_INVD1BWP12T30P140;
// #XSEL7_QB @PLACE(0,-26) => @ORIENT("R0");
// #XSEL7_TB @SET-SYMBOL $S_INVD1BWP12T30P140;
// #XSEL7_TB @PLACE(31,-26) => @ORIENT("R0");
// #XSEL7_D @SET-SYMBOL $S_ND2D1BWP12T30P140;
// #XSEL7_D @PLACE(62,-26) => @ORIENT("R0");
// #XSEL7 @SET-SYMBOL $S_sar8_se_store;
// #XSEL7 @PLACE(93,-26) => @ORIENT("R0");
// #XSEL6_QB @SET-SYMBOL $S_INVD1BWP12T30P140;
// #XSEL6_QB @PLACE(0,-52) => @ORIENT("R0");
// #XSEL6_TB @SET-SYMBOL $S_INVD1BWP12T30P140;
// #XSEL6_TB @PLACE(31,-52) => @ORIENT("R0");
// #XSEL6_D @SET-SYMBOL $S_ND2D1BWP12T30P140;
// #XSEL6_D @PLACE(62,-52) => @ORIENT("R0");
// #XSEL6 @SET-SYMBOL $S_sar8_se_store;
// #XSEL6 @PLACE(93,-52) => @ORIENT("R0");
// #XSEL5_QB @SET-SYMBOL $S_INVD1BWP12T30P140;
// #XSEL5_QB @PLACE(0,-78) => @ORIENT("R0");
// #XSEL5_TB @SET-SYMBOL $S_INVD1BWP12T30P140;
// #XSEL5_TB @PLACE(31,-78) => @ORIENT("R0");
// #XSEL5_D @SET-SYMBOL $S_ND2D1BWP12T30P140;
// #XSEL5_D @PLACE(62,-78) => @ORIENT("R0");
// #XSEL5 @SET-SYMBOL $S_sar8_se_store;
// #XSEL5 @PLACE(93,-78) => @ORIENT("R0");
// #XSEL4_QB @SET-SYMBOL $S_INVD1BWP12T30P140;
// #XSEL4_QB @PLACE(0,-104) => @ORIENT("R0");
// #XSEL4_TB @SET-SYMBOL $S_INVD1BWP12T30P140;
// #XSEL4_TB @PLACE(31,-104) => @ORIENT("R0");
// #XSEL4_D @SET-SYMBOL $S_ND2D1BWP12T30P140;
// #XSEL4_D @PLACE(62,-104) => @ORIENT("R0");
// #XSEL4 @SET-SYMBOL $S_sar8_se_store;
// #XSEL4 @PLACE(93,-104) => @ORIENT("R0");
// (122,20) @TEXT("Bit stores",size=1.35,halign="start",textcolor="#223d52");
// #XBIT0 @SET-SYMBOL $S_sar8_se_store;
// #XBIT0 @PLACE(140,0) => @ORIENT("R0");
// #XBIT1 @SET-SYMBOL $S_sar8_se_store;
// #XBIT1 @PLACE(174,0) => @ORIENT("R0");
// #XBIT2 @SET-SYMBOL $S_sar8_se_store;
// #XBIT2 @PLACE(140,-28) => @ORIENT("R0");
// #XBIT3 @SET-SYMBOL $S_sar8_se_store;
// #XBIT3 @PLACE(174,-28) => @ORIENT("R0");
// #XBIT4 @SET-SYMBOL $S_sar8_se_store;
// #XBIT4 @PLACE(140,-56) => @ORIENT("R0");
// #XBIT5 @SET-SYMBOL $S_sar8_se_store;
// #XBIT5 @PLACE(174,-56) => @ORIENT("R0");
// #XBIT6 @SET-SYMBOL $S_sar8_se_store;
// #XBIT6 @PLACE(140,-84) => @ORIENT("R0");
// #XBIT7 @SET-SYMBOL $S_sar8_se_store;
// #XBIT7 @PLACE(174,-84) => @ORIENT("R0");
// #XMSBD @SET-SYMBOL $S_INVD1BWP12T30P140;
// #XMSBD @PLACE(140,-112) => @ORIENT("R0");
// #XMSBQ @SET-SYMBOL $S_INVD1BWP12T30P140;
// #XMSBQ @PLACE(182,-112) => @ORIENT("R0");
// &"SEL9_TB" @WIRE(mode="straight",linecolor="#30485d",linewidth=0.16) {#XSEL9_TB:2 (46.5,0) (46.5,-1.7) #XSEL9_D:2};
// &"SEL9_D" @WIRE(mode="straight",linecolor="#30485d",linewidth=0.16) {#XSEL9_D:3 (87.5,0) (87.5,1.65) #XSEL9:2};
// &"SEL7_TB" @WIRE(mode="straight",linecolor="#30485d",linewidth=0.16) {#XSEL7_TB:2 (46.5,-26) (46.5,-27.7) #XSEL7_D:2};
// &"SEL7_D" @WIRE(mode="straight",linecolor="#30485d",linewidth=0.16) {#XSEL7_D:3 (87.5,-26) (87.5,-24.35) #XSEL7:2};
// &"SEL6_TB" @WIRE(mode="straight",linecolor="#30485d",linewidth=0.16) {#XSEL6_TB:2 (46.5,-52) (46.5,-53.7) #XSEL6_D:2};
// &"SEL6_D" @WIRE(mode="straight",linecolor="#30485d",linewidth=0.16) {#XSEL6_D:3 (87.5,-52) (87.5,-50.35) #XSEL6:2};
// &"SEL5_TB" @WIRE(mode="straight",linecolor="#30485d",linewidth=0.16) {#XSEL5_TB:2 (46.5,-78) (46.5,-79.7) #XSEL5_D:2};
// &"SEL5_D" @WIRE(mode="straight",linecolor="#30485d",linewidth=0.16) {#XSEL5_D:3 (87.5,-78) (87.5,-76.35) #XSEL5:2};
// &"SEL4_TB" @WIRE(mode="straight",linecolor="#30485d",linewidth=0.16) {#XSEL4_TB:2 (46.5,-104) (46.5,-105.7) #XSEL4_D:2};
// &"SEL4_D" @WIRE(mode="straight",linecolor="#30485d",linewidth=0.16) {#XSEL4_D:3 (87.5,-104) (87.5,-102.35) #XSEL4:2};
// &"MSBD" @WIRE(mode="straight",linecolor="#30485d",linewidth=0.16) {#XMSBD:2 (167,-112) (167,-82.35) #XBIT7:2};
// &"MSBQ" @WIRE(mode="straight",linecolor="#30485d",linewidth=0.16) {#XBIT7:6 (181,-85.65) (181,-112) #XMSBQ:1};
// &"ACTIVE" @WIRE(mode="straight",linecolor="#30485d",linewidth=0.16) {#XTIM:1 (16,48.95)};
// (16.4,48.95) @TEXT("ACTIVE",size=1.1,halign="start",valign="middle");
// &"SAMPLE" @WIRE(mode="straight",linecolor="#30485d",linewidth=0.16) {#XTIM:2 (-16,55.55)};
// (-16.4,55.55) @TEXT("SAMPLE",size=1.1,halign="end",valign="middle");
// &"SEL9" @WIRE(mode="straight",linecolor="#30485d",linewidth=0.16) {#XTIM:3 (-16,52.25)};
// (-16.4,52.25) @TEXT("SEL9",size=1.1,halign="end",valign="middle");
// &"SEL7" @WIRE(mode="straight",linecolor="#30485d",linewidth=0.16) {#XTIM:4 (-16,48.95)};
// (-16.4,48.95) @TEXT("SEL7",size=1.1,halign="end",valign="middle");
// &"SEL6" @WIRE(mode="straight",linecolor="#30485d",linewidth=0.16) {#XTIM:5 (-16,45.65)};
// (-16.4,45.65) @TEXT("SEL6",size=1.1,halign="end",valign="middle");
// &"SEL5" @WIRE(mode="straight",linecolor="#30485d",linewidth=0.16) {#XTIM:6 (-16,42.35)};
// (-16.4,42.35) @TEXT("SEL5",size=1.1,halign="end",valign="middle");
// &"SEL4" @WIRE(mode="straight",linecolor="#30485d",linewidth=0.16) {#XTIM:7 (-16,39.05)};
// (-16.4,39.05) @TEXT("SEL4",size=1.1,halign="end",valign="middle");
// &"COMP_P" @WIRE(mode="straight",linecolor="#30485d",linewidth=0.16) {#XTIM:8 (-16,35.75)};
// (-16.4,35.75) @TEXT("COMP_P",size=1.1,halign="end",valign="middle");
// &"COMP_N" @WIRE(mode="straight",linecolor="#30485d",linewidth=0.16) {#XTIM:9 (-16,32.45)};
// (-16.4,32.45) @TEXT("COMP_N",size=1.1,halign="end",valign="middle");
// &"CMP_CLK" @WIRE(mode="straight",linecolor="#30485d",linewidth=0.16) {#XTIM:10 (16,45.65)};
// (16.4,45.65) @TEXT("CMP_CLK",size=1.1,halign="start",valign="middle");
// &"COMMIT" @WIRE(mode="straight",linecolor="#30485d",linewidth=0.16) {#XTIM:11 (16,42.35)};
// (16.4,42.35) @TEXT("COMMIT",size=1.1,halign="start",valign="middle");
// &"DATA" @WIRE(mode="straight",linecolor="#30485d",linewidth=0.16) {#XTIM:12 (16,39.05)};
// (16.4,39.05) @TEXT("DATA",size=1.1,halign="start",valign="middle");
// &"VDD" @WIRE(mode="straight",linecolor="#30485d",linewidth=0.16) {#XTIM:13 (0,63.85)};
// (0,64.25) @TEXT("VDD",size=1.1,halign="middle",valign="bottom");
// &"VSS" @WIRE(mode="straight",linecolor="#30485d",linewidth=0.16) {#XTIM:14 (0,24.15)};
// (0,23.75) @TEXT("VSS",size=1.1,halign="middle",valign="top");
// {&"CODE0" &"CODE1" &"CODE2" &"CODE3" &"CODE4" &"CODE5" &"CODE6" &"CODE7"} @WIRE(mode="straight",linewidth=0.3) {#XWORD:1 (73,50.6)};
// (73.4,50.6) @TEXT("CODE[7:0]",size=1.1,halign="start",valign="middle");
// &"DATA" @WIRE(mode="straight",linecolor="#30485d",linewidth=0.16) {#XWORD:9 (73,47.3)};
// (73.4,47.3) @TEXT("DATA",size=1.1,halign="start",valign="middle");
// &"DONE" @WIRE(mode="straight",linecolor="#30485d",linewidth=0.16) {#XWORD:10 (41,44)};
// (40.6,44) @TEXT("DONE",size=1.1,halign="end",valign="middle");
// {&"D0" &"D1" &"D2" &"D3" &"D4" &"D5" &"D6" &"D7"} @WIRE(mode="straight",linewidth=0.3) {#XWORD:11 (73,44)};
// (73.4,44) @TEXT("D[7:0]",size=1.1,halign="start",valign="middle");
// {&"NEXT0" &"NEXT1" &"NEXT2" &"NEXT3" &"NEXT4" &"NEXT5" &"NEXT6" &"NEXT7"} @WIRE(mode="straight",linewidth=0.3) {#XWORD:19 (73,40.7)};
// (73.4,40.7) @TEXT("NEXT[7:0]",size=1.1,halign="start",valign="middle");
// {&"TRIAL6" &"TRIAL5" &"TRIAL4" &"TRIAL3" &"TRIAL2"} @WIRE(mode="straight",linewidth=0.3) {#XWORD:27 (73,37.4)};
// (73.4,37.4) @TEXT("TRIAL[2:6]",size=1.1,halign="start",valign="middle");
// &"VDD" @WIRE(mode="straight",linecolor="#30485d",linewidth=0.16) {#XWORD:32 (57,58.9)};
// (57,59.3) @TEXT("VDD",size=1.1,halign="middle",valign="bottom");
// &"VSS" @WIRE(mode="straight",linecolor="#30485d",linewidth=0.16) {#XWORD:33 (57,29.1)};
// (57,28.7) @TEXT("VSS",size=1.1,halign="middle",valign="top");
// &"SEL9" @WIRE(mode="straight",linecolor="#30485d",linewidth=0.16) {#XSEL9_QB:1 (-10,0)};
// (-10.4,0) @TEXT("SEL9",size=1.1,halign="end",valign="middle");
// &"SEL9_QB" @WIRE(mode="straight",linecolor="#30485d",linewidth=0.16) {#XSEL9_QB:2 (10,0)};
// (10.4,0) @TEXT("SEL9_QB",size=1.1,halign="start",valign="middle");
// &"VDD" @WIRE(mode="straight",linecolor="#30485d",linewidth=0.16) {#XSEL9_QB:3 (0,10)};
// (0,10.4) @TEXT("VDD",size=1.1,halign="middle",valign="bottom");
// &"VSS" @WIRE(mode="straight",linecolor="#30485d",linewidth=0.16) {#XSEL9_QB:4 (0,-10)};
// (0,-10.4) @TEXT("VSS",size=1.1,halign="middle",valign="top");
// &"TRIAL6" @WIRE(mode="straight",linecolor="#30485d",linewidth=0.16) {#XSEL9_TB:1 (21,0)};
// (20.6,0) @TEXT("TRIAL6",size=1.1,halign="end",valign="middle");
// &"VDD" @WIRE(mode="straight",linecolor="#30485d",linewidth=0.16) {#XSEL9_TB:3 (31,10)};
// (31,10.4) @TEXT("VDD",size=1.1,halign="middle",valign="bottom");
// &"VSS" @WIRE(mode="straight",linecolor="#30485d",linewidth=0.16) {#XSEL9_TB:4 (31,-10)};
// (31,-10.4) @TEXT("VSS",size=1.1,halign="middle",valign="top");
// &"SEL9_QB" @WIRE(mode="straight",linecolor="#30485d",linewidth=0.16) {#XSEL9_D:1 (52,1.7)};
// (51.6,1.7) @TEXT("SEL9_QB",size=1.1,halign="end",valign="middle");
// &"VDD" @WIRE(mode="straight",linecolor="#30485d",linewidth=0.16) {#XSEL9_D:4 (62,10)};
// (62,10.4) @TEXT("VDD",size=1.1,halign="middle",valign="bottom");
// &"VSS" @WIRE(mode="straight",linecolor="#30485d",linewidth=0.16) {#XSEL9_D:5 (62,-10)};
// (62,-10.4) @TEXT("VSS",size=1.1,halign="middle",valign="top");
// &"COMMIT" @WIRE(mode="straight",linecolor="#30485d",linewidth=0.16) {#XSEL9:1 (77,1.65)};
// (76.6,1.65) @TEXT("COMMIT",size=1.1,halign="end",valign="middle");
// &"SAMPLE" @WIRE(mode="straight",linecolor="#30485d",linewidth=0.16) {#XSEL9:3 (77,-1.65)};
// (76.6,-1.65) @TEXT("SAMPLE",size=1.1,halign="end",valign="middle");
// &"VDD" @WIRE(mode="straight",linecolor="#30485d",linewidth=0.16) {#XSEL9:4 (93,11)};
// (93,11.4) @TEXT("VDD",size=1.1,halign="middle",valign="bottom");
// &"VSS" @WIRE(mode="straight",linecolor="#30485d",linewidth=0.16) {#XSEL9:5 (93,-11)};
// (93,-11.4) @TEXT("VSS",size=1.1,halign="middle",valign="top");
// &"SEL9" @WIRE(mode="straight",linecolor="#30485d",linewidth=0.16) {#XSEL9:6 (109,-1.65)};
// (109.4,-1.65) @TEXT("SEL9",size=1.1,halign="start",valign="middle");
// &"SEL7" @WIRE(mode="straight",linecolor="#30485d",linewidth=0.16) {#XSEL7_QB:1 (-10,-26)};
// (-10.4,-26) @TEXT("SEL7",size=1.1,halign="end",valign="middle");
// &"SEL7_QB" @WIRE(mode="straight",linecolor="#30485d",linewidth=0.16) {#XSEL7_QB:2 (10,-26)};
// (10.4,-26) @TEXT("SEL7_QB",size=1.1,halign="start",valign="middle");
// &"VDD" @WIRE(mode="straight",linecolor="#30485d",linewidth=0.16) {#XSEL7_QB:3 (0,-16)};
// (0,-15.6) @TEXT("VDD",size=1.1,halign="middle",valign="bottom");
// &"VSS" @WIRE(mode="straight",linecolor="#30485d",linewidth=0.16) {#XSEL7_QB:4 (0,-36)};
// (0,-36.4) @TEXT("VSS",size=1.1,halign="middle",valign="top");
// &"TRIAL5" @WIRE(mode="straight",linecolor="#30485d",linewidth=0.16) {#XSEL7_TB:1 (21,-26)};
// (20.6,-26) @TEXT("TRIAL5",size=1.1,halign="end",valign="middle");
// &"VDD" @WIRE(mode="straight",linecolor="#30485d",linewidth=0.16) {#XSEL7_TB:3 (31,-16)};
// (31,-15.6) @TEXT("VDD",size=1.1,halign="middle",valign="bottom");
// &"VSS" @WIRE(mode="straight",linecolor="#30485d",linewidth=0.16) {#XSEL7_TB:4 (31,-36)};
// (31,-36.4) @TEXT("VSS",size=1.1,halign="middle",valign="top");
// &"SEL7_QB" @WIRE(mode="straight",linecolor="#30485d",linewidth=0.16) {#XSEL7_D:1 (52,-24.3)};
// (51.6,-24.3) @TEXT("SEL7_QB",size=1.1,halign="end",valign="middle");
// &"VDD" @WIRE(mode="straight",linecolor="#30485d",linewidth=0.16) {#XSEL7_D:4 (62,-16)};
// (62,-15.6) @TEXT("VDD",size=1.1,halign="middle",valign="bottom");
// &"VSS" @WIRE(mode="straight",linecolor="#30485d",linewidth=0.16) {#XSEL7_D:5 (62,-36)};
// (62,-36.4) @TEXT("VSS",size=1.1,halign="middle",valign="top");
// &"COMMIT" @WIRE(mode="straight",linecolor="#30485d",linewidth=0.16) {#XSEL7:1 (77,-24.35)};
// (76.6,-24.35) @TEXT("COMMIT",size=1.1,halign="end",valign="middle");
// &"SAMPLE" @WIRE(mode="straight",linecolor="#30485d",linewidth=0.16) {#XSEL7:3 (77,-27.65)};
// (76.6,-27.65) @TEXT("SAMPLE",size=1.1,halign="end",valign="middle");
// &"VDD" @WIRE(mode="straight",linecolor="#30485d",linewidth=0.16) {#XSEL7:4 (93,-15)};
// (93,-14.6) @TEXT("VDD",size=1.1,halign="middle",valign="bottom");
// &"VSS" @WIRE(mode="straight",linecolor="#30485d",linewidth=0.16) {#XSEL7:5 (93,-37)};
// (93,-37.4) @TEXT("VSS",size=1.1,halign="middle",valign="top");
// &"SEL7" @WIRE(mode="straight",linecolor="#30485d",linewidth=0.16) {#XSEL7:6 (109,-27.65)};
// (109.4,-27.65) @TEXT("SEL7",size=1.1,halign="start",valign="middle");
// &"SEL6" @WIRE(mode="straight",linecolor="#30485d",linewidth=0.16) {#XSEL6_QB:1 (-10,-52)};
// (-10.4,-52) @TEXT("SEL6",size=1.1,halign="end",valign="middle");
// &"SEL6_QB" @WIRE(mode="straight",linecolor="#30485d",linewidth=0.16) {#XSEL6_QB:2 (10,-52)};
// (10.4,-52) @TEXT("SEL6_QB",size=1.1,halign="start",valign="middle");
// &"VDD" @WIRE(mode="straight",linecolor="#30485d",linewidth=0.16) {#XSEL6_QB:3 (0,-42)};
// (0,-41.6) @TEXT("VDD",size=1.1,halign="middle",valign="bottom");
// &"VSS" @WIRE(mode="straight",linecolor="#30485d",linewidth=0.16) {#XSEL6_QB:4 (0,-62)};
// (0,-62.4) @TEXT("VSS",size=1.1,halign="middle",valign="top");
// &"TRIAL4" @WIRE(mode="straight",linecolor="#30485d",linewidth=0.16) {#XSEL6_TB:1 (21,-52)};
// (20.6,-52) @TEXT("TRIAL4",size=1.1,halign="end",valign="middle");
// &"VDD" @WIRE(mode="straight",linecolor="#30485d",linewidth=0.16) {#XSEL6_TB:3 (31,-42)};
// (31,-41.6) @TEXT("VDD",size=1.1,halign="middle",valign="bottom");
// &"VSS" @WIRE(mode="straight",linecolor="#30485d",linewidth=0.16) {#XSEL6_TB:4 (31,-62)};
// (31,-62.4) @TEXT("VSS",size=1.1,halign="middle",valign="top");
// &"SEL6_QB" @WIRE(mode="straight",linecolor="#30485d",linewidth=0.16) {#XSEL6_D:1 (52,-50.3)};
// (51.6,-50.3) @TEXT("SEL6_QB",size=1.1,halign="end",valign="middle");
// &"VDD" @WIRE(mode="straight",linecolor="#30485d",linewidth=0.16) {#XSEL6_D:4 (62,-42)};
// (62,-41.6) @TEXT("VDD",size=1.1,halign="middle",valign="bottom");
// &"VSS" @WIRE(mode="straight",linecolor="#30485d",linewidth=0.16) {#XSEL6_D:5 (62,-62)};
// (62,-62.4) @TEXT("VSS",size=1.1,halign="middle",valign="top");
// &"COMMIT" @WIRE(mode="straight",linecolor="#30485d",linewidth=0.16) {#XSEL6:1 (77,-50.35)};
// (76.6,-50.35) @TEXT("COMMIT",size=1.1,halign="end",valign="middle");
// &"SAMPLE" @WIRE(mode="straight",linecolor="#30485d",linewidth=0.16) {#XSEL6:3 (77,-53.65)};
// (76.6,-53.65) @TEXT("SAMPLE",size=1.1,halign="end",valign="middle");
// &"VDD" @WIRE(mode="straight",linecolor="#30485d",linewidth=0.16) {#XSEL6:4 (93,-41)};
// (93,-40.6) @TEXT("VDD",size=1.1,halign="middle",valign="bottom");
// &"VSS" @WIRE(mode="straight",linecolor="#30485d",linewidth=0.16) {#XSEL6:5 (93,-63)};
// (93,-63.4) @TEXT("VSS",size=1.1,halign="middle",valign="top");
// &"SEL6" @WIRE(mode="straight",linecolor="#30485d",linewidth=0.16) {#XSEL6:6 (109,-53.65)};
// (109.4,-53.65) @TEXT("SEL6",size=1.1,halign="start",valign="middle");
// &"SEL5" @WIRE(mode="straight",linecolor="#30485d",linewidth=0.16) {#XSEL5_QB:1 (-10,-78)};
// (-10.4,-78) @TEXT("SEL5",size=1.1,halign="end",valign="middle");
// &"SEL5_QB" @WIRE(mode="straight",linecolor="#30485d",linewidth=0.16) {#XSEL5_QB:2 (10,-78)};
// (10.4,-78) @TEXT("SEL5_QB",size=1.1,halign="start",valign="middle");
// &"VDD" @WIRE(mode="straight",linecolor="#30485d",linewidth=0.16) {#XSEL5_QB:3 (0,-68)};
// (0,-67.6) @TEXT("VDD",size=1.1,halign="middle",valign="bottom");
// &"VSS" @WIRE(mode="straight",linecolor="#30485d",linewidth=0.16) {#XSEL5_QB:4 (0,-88)};
// (0,-88.4) @TEXT("VSS",size=1.1,halign="middle",valign="top");
// &"TRIAL3" @WIRE(mode="straight",linecolor="#30485d",linewidth=0.16) {#XSEL5_TB:1 (21,-78)};
// (20.6,-78) @TEXT("TRIAL3",size=1.1,halign="end",valign="middle");
// &"VDD" @WIRE(mode="straight",linecolor="#30485d",linewidth=0.16) {#XSEL5_TB:3 (31,-68)};
// (31,-67.6) @TEXT("VDD",size=1.1,halign="middle",valign="bottom");
// &"VSS" @WIRE(mode="straight",linecolor="#30485d",linewidth=0.16) {#XSEL5_TB:4 (31,-88)};
// (31,-88.4) @TEXT("VSS",size=1.1,halign="middle",valign="top");
// &"SEL5_QB" @WIRE(mode="straight",linecolor="#30485d",linewidth=0.16) {#XSEL5_D:1 (52,-76.3)};
// (51.6,-76.3) @TEXT("SEL5_QB",size=1.1,halign="end",valign="middle");
// &"VDD" @WIRE(mode="straight",linecolor="#30485d",linewidth=0.16) {#XSEL5_D:4 (62,-68)};
// (62,-67.6) @TEXT("VDD",size=1.1,halign="middle",valign="bottom");
// &"VSS" @WIRE(mode="straight",linecolor="#30485d",linewidth=0.16) {#XSEL5_D:5 (62,-88)};
// (62,-88.4) @TEXT("VSS",size=1.1,halign="middle",valign="top");
// &"COMMIT" @WIRE(mode="straight",linecolor="#30485d",linewidth=0.16) {#XSEL5:1 (77,-76.35)};
// (76.6,-76.35) @TEXT("COMMIT",size=1.1,halign="end",valign="middle");
// &"SAMPLE" @WIRE(mode="straight",linecolor="#30485d",linewidth=0.16) {#XSEL5:3 (77,-79.65)};
// (76.6,-79.65) @TEXT("SAMPLE",size=1.1,halign="end",valign="middle");
// &"VDD" @WIRE(mode="straight",linecolor="#30485d",linewidth=0.16) {#XSEL5:4 (93,-67)};
// (93,-66.6) @TEXT("VDD",size=1.1,halign="middle",valign="bottom");
// &"VSS" @WIRE(mode="straight",linecolor="#30485d",linewidth=0.16) {#XSEL5:5 (93,-89)};
// (93,-89.4) @TEXT("VSS",size=1.1,halign="middle",valign="top");
// &"SEL5" @WIRE(mode="straight",linecolor="#30485d",linewidth=0.16) {#XSEL5:6 (109,-79.65)};
// (109.4,-79.65) @TEXT("SEL5",size=1.1,halign="start",valign="middle");
// &"SEL4" @WIRE(mode="straight",linecolor="#30485d",linewidth=0.16) {#XSEL4_QB:1 (-10,-104)};
// (-10.4,-104) @TEXT("SEL4",size=1.1,halign="end",valign="middle");
// &"SEL4_QB" @WIRE(mode="straight",linecolor="#30485d",linewidth=0.16) {#XSEL4_QB:2 (10,-104)};
// (10.4,-104) @TEXT("SEL4_QB",size=1.1,halign="start",valign="middle");
// &"VDD" @WIRE(mode="straight",linecolor="#30485d",linewidth=0.16) {#XSEL4_QB:3 (0,-94)};
// (0,-93.6) @TEXT("VDD",size=1.1,halign="middle",valign="bottom");
// &"VSS" @WIRE(mode="straight",linecolor="#30485d",linewidth=0.16) {#XSEL4_QB:4 (0,-114)};
// (0,-114.4) @TEXT("VSS",size=1.1,halign="middle",valign="top");
// &"TRIAL2" @WIRE(mode="straight",linecolor="#30485d",linewidth=0.16) {#XSEL4_TB:1 (21,-104)};
// (20.6,-104) @TEXT("TRIAL2",size=1.1,halign="end",valign="middle");
// &"VDD" @WIRE(mode="straight",linecolor="#30485d",linewidth=0.16) {#XSEL4_TB:3 (31,-94)};
// (31,-93.6) @TEXT("VDD",size=1.1,halign="middle",valign="bottom");
// &"VSS" @WIRE(mode="straight",linecolor="#30485d",linewidth=0.16) {#XSEL4_TB:4 (31,-114)};
// (31,-114.4) @TEXT("VSS",size=1.1,halign="middle",valign="top");
// &"SEL4_QB" @WIRE(mode="straight",linecolor="#30485d",linewidth=0.16) {#XSEL4_D:1 (52,-102.3)};
// (51.6,-102.3) @TEXT("SEL4_QB",size=1.1,halign="end",valign="middle");
// &"VDD" @WIRE(mode="straight",linecolor="#30485d",linewidth=0.16) {#XSEL4_D:4 (62,-94)};
// (62,-93.6) @TEXT("VDD",size=1.1,halign="middle",valign="bottom");
// &"VSS" @WIRE(mode="straight",linecolor="#30485d",linewidth=0.16) {#XSEL4_D:5 (62,-114)};
// (62,-114.4) @TEXT("VSS",size=1.1,halign="middle",valign="top");
// &"COMMIT" @WIRE(mode="straight",linecolor="#30485d",linewidth=0.16) {#XSEL4:1 (77,-102.35)};
// (76.6,-102.35) @TEXT("COMMIT",size=1.1,halign="end",valign="middle");
// &"SAMPLE" @WIRE(mode="straight",linecolor="#30485d",linewidth=0.16) {#XSEL4:3 (77,-105.65)};
// (76.6,-105.65) @TEXT("SAMPLE",size=1.1,halign="end",valign="middle");
// &"VDD" @WIRE(mode="straight",linecolor="#30485d",linewidth=0.16) {#XSEL4:4 (93,-93)};
// (93,-92.6) @TEXT("VDD",size=1.1,halign="middle",valign="bottom");
// &"VSS" @WIRE(mode="straight",linecolor="#30485d",linewidth=0.16) {#XSEL4:5 (93,-115)};
// (93,-115.4) @TEXT("VSS",size=1.1,halign="middle",valign="top");
// &"SEL4" @WIRE(mode="straight",linecolor="#30485d",linewidth=0.16) {#XSEL4:6 (109,-105.65)};
// (109.4,-105.65) @TEXT("SEL4",size=1.1,halign="start",valign="middle");
// &"COMMIT" @WIRE(mode="straight",linecolor="#30485d",linewidth=0.16) {#XDONE:1 (98,45.65)};
// (97.6,45.65) @TEXT("COMMIT",size=1.1,halign="end",valign="middle");
// &"CODE0" @WIRE(mode="straight",linecolor="#30485d",linewidth=0.16) {#XDONE:2 (130,45.65)};
// (130.4,45.65) @TEXT("CODE0",size=1.1,halign="start",valign="middle");
// &"SAMPLE" @WIRE(mode="straight",linecolor="#30485d",linewidth=0.16) {#XDONE:3 (98,42.35)};
// (97.6,42.35) @TEXT("SAMPLE",size=1.1,halign="end",valign="middle");
// &"VDD" @WIRE(mode="straight",linecolor="#30485d",linewidth=0.16) {#XDONE:4 (114,55)};
// (114,55.4) @TEXT("VDD",size=1.1,halign="middle",valign="bottom");
// &"VSS" @WIRE(mode="straight",linecolor="#30485d",linewidth=0.16) {#XDONE:5 (114,33)};
// (114,32.6) @TEXT("VSS",size=1.1,halign="middle",valign="top");
// &"DONE" @WIRE(mode="straight",linecolor="#30485d",linewidth=0.16) {#XDONE:6 (130,42.35)};
// (130.4,42.35) @TEXT("DONE",size=1.1,halign="start",valign="middle");
// &"DONE" @WIRE(mode="straight",linecolor="#30485d",linewidth=0.16) {#XACTIVE:1 (161,44)};
// (160.6,44) @TEXT("DONE",size=1.1,halign="end",valign="middle");
// &"ACTIVE" @WIRE(mode="straight",linecolor="#30485d",linewidth=0.16) {#XACTIVE:2 (181,44)};
// (181.4,44) @TEXT("ACTIVE",size=1.1,halign="start",valign="middle");
// &"VDD" @WIRE(mode="straight",linecolor="#30485d",linewidth=0.16) {#XACTIVE:3 (171,54)};
// (171,54.4) @TEXT("VDD",size=1.1,halign="middle",valign="bottom");
// &"VSS" @WIRE(mode="straight",linecolor="#30485d",linewidth=0.16) {#XACTIVE:4 (171,34)};
// (171,33.6) @TEXT("VSS",size=1.1,halign="middle",valign="top");
// &"COMMIT" @WIRE(mode="straight",linecolor="#30485d",linewidth=0.16) {#XBIT0:1 (124,1.65)};
// (123.6,1.65) @TEXT("COMMIT",size=1.1,halign="end",valign="middle");
// &"NEXT0" @WIRE(mode="straight",linecolor="#30485d",linewidth=0.16) {#XBIT0:2 (156,1.65)};
// (156.4,1.65) @TEXT("NEXT0",size=1.1,halign="start",valign="middle");
// &"SAMPLE" @WIRE(mode="straight",linecolor="#30485d",linewidth=0.16) {#XBIT0:3 (124,-1.65)};
// (123.6,-1.65) @TEXT("SAMPLE",size=1.1,halign="end",valign="middle");
// &"VDD" @WIRE(mode="straight",linecolor="#30485d",linewidth=0.16) {#XBIT0:4 (140,11)};
// (140,11.4) @TEXT("VDD",size=1.1,halign="middle",valign="bottom");
// &"VSS" @WIRE(mode="straight",linecolor="#30485d",linewidth=0.16) {#XBIT0:5 (140,-11)};
// (140,-11.4) @TEXT("VSS",size=1.1,halign="middle",valign="top");
// &"CODE0" @WIRE(mode="straight",linecolor="#30485d",linewidth=0.16) {#XBIT0:6 (156,-1.65)};
// (156.4,-1.65) @TEXT("CODE0",size=1.1,halign="start",valign="middle");
// &"COMMIT" @WIRE(mode="straight",linecolor="#30485d",linewidth=0.16) {#XBIT1:1 (158,1.65)};
// (157.6,1.65) @TEXT("COMMIT",size=1.1,halign="end",valign="middle");
// &"NEXT1" @WIRE(mode="straight",linecolor="#30485d",linewidth=0.16) {#XBIT1:2 (190,1.65)};
// (190.4,1.65) @TEXT("NEXT1",size=1.1,halign="start",valign="middle");
// &"SAMPLE" @WIRE(mode="straight",linecolor="#30485d",linewidth=0.16) {#XBIT1:3 (158,-1.65)};
// (157.6,-1.65) @TEXT("SAMPLE",size=1.1,halign="end",valign="middle");
// &"VDD" @WIRE(mode="straight",linecolor="#30485d",linewidth=0.16) {#XBIT1:4 (174,11)};
// (174,11.4) @TEXT("VDD",size=1.1,halign="middle",valign="bottom");
// &"VSS" @WIRE(mode="straight",linecolor="#30485d",linewidth=0.16) {#XBIT1:5 (174,-11)};
// (174,-11.4) @TEXT("VSS",size=1.1,halign="middle",valign="top");
// &"CODE1" @WIRE(mode="straight",linecolor="#30485d",linewidth=0.16) {#XBIT1:6 (190,-1.65)};
// (190.4,-1.65) @TEXT("CODE1",size=1.1,halign="start",valign="middle");
// &"COMMIT" @WIRE(mode="straight",linecolor="#30485d",linewidth=0.16) {#XBIT2:1 (124,-26.35)};
// (123.6,-26.35) @TEXT("COMMIT",size=1.1,halign="end",valign="middle");
// &"NEXT2" @WIRE(mode="straight",linecolor="#30485d",linewidth=0.16) {#XBIT2:2 (156,-26.35)};
// (156.4,-26.35) @TEXT("NEXT2",size=1.1,halign="start",valign="middle");
// &"SAMPLE" @WIRE(mode="straight",linecolor="#30485d",linewidth=0.16) {#XBIT2:3 (124,-29.65)};
// (123.6,-29.65) @TEXT("SAMPLE",size=1.1,halign="end",valign="middle");
// &"VDD" @WIRE(mode="straight",linecolor="#30485d",linewidth=0.16) {#XBIT2:4 (140,-17)};
// (140,-16.6) @TEXT("VDD",size=1.1,halign="middle",valign="bottom");
// &"VSS" @WIRE(mode="straight",linecolor="#30485d",linewidth=0.16) {#XBIT2:5 (140,-39)};
// (140,-39.4) @TEXT("VSS",size=1.1,halign="middle",valign="top");
// &"CODE2" @WIRE(mode="straight",linecolor="#30485d",linewidth=0.16) {#XBIT2:6 (156,-29.65)};
// (156.4,-29.65) @TEXT("CODE2",size=1.1,halign="start",valign="middle");
// &"COMMIT" @WIRE(mode="straight",linecolor="#30485d",linewidth=0.16) {#XBIT3:1 (158,-26.35)};
// (157.6,-26.35) @TEXT("COMMIT",size=1.1,halign="end",valign="middle");
// &"NEXT3" @WIRE(mode="straight",linecolor="#30485d",linewidth=0.16) {#XBIT3:2 (190,-26.35)};
// (190.4,-26.35) @TEXT("NEXT3",size=1.1,halign="start",valign="middle");
// &"SAMPLE" @WIRE(mode="straight",linecolor="#30485d",linewidth=0.16) {#XBIT3:3 (158,-29.65)};
// (157.6,-29.65) @TEXT("SAMPLE",size=1.1,halign="end",valign="middle");
// &"VDD" @WIRE(mode="straight",linecolor="#30485d",linewidth=0.16) {#XBIT3:4 (174,-17)};
// (174,-16.6) @TEXT("VDD",size=1.1,halign="middle",valign="bottom");
// &"VSS" @WIRE(mode="straight",linecolor="#30485d",linewidth=0.16) {#XBIT3:5 (174,-39)};
// (174,-39.4) @TEXT("VSS",size=1.1,halign="middle",valign="top");
// &"CODE3" @WIRE(mode="straight",linecolor="#30485d",linewidth=0.16) {#XBIT3:6 (190,-29.65)};
// (190.4,-29.65) @TEXT("CODE3",size=1.1,halign="start",valign="middle");
// &"COMMIT" @WIRE(mode="straight",linecolor="#30485d",linewidth=0.16) {#XBIT4:1 (124,-54.35)};
// (123.6,-54.35) @TEXT("COMMIT",size=1.1,halign="end",valign="middle");
// &"NEXT4" @WIRE(mode="straight",linecolor="#30485d",linewidth=0.16) {#XBIT4:2 (156,-54.35)};
// (156.4,-54.35) @TEXT("NEXT4",size=1.1,halign="start",valign="middle");
// &"SAMPLE" @WIRE(mode="straight",linecolor="#30485d",linewidth=0.16) {#XBIT4:3 (124,-57.65)};
// (123.6,-57.65) @TEXT("SAMPLE",size=1.1,halign="end",valign="middle");
// &"VDD" @WIRE(mode="straight",linecolor="#30485d",linewidth=0.16) {#XBIT4:4 (140,-45)};
// (140,-44.6) @TEXT("VDD",size=1.1,halign="middle",valign="bottom");
// &"VSS" @WIRE(mode="straight",linecolor="#30485d",linewidth=0.16) {#XBIT4:5 (140,-67)};
// (140,-67.4) @TEXT("VSS",size=1.1,halign="middle",valign="top");
// &"CODE4" @WIRE(mode="straight",linecolor="#30485d",linewidth=0.16) {#XBIT4:6 (156,-57.65)};
// (156.4,-57.65) @TEXT("CODE4",size=1.1,halign="start",valign="middle");
// &"COMMIT" @WIRE(mode="straight",linecolor="#30485d",linewidth=0.16) {#XBIT5:1 (158,-54.35)};
// (157.6,-54.35) @TEXT("COMMIT",size=1.1,halign="end",valign="middle");
// &"NEXT5" @WIRE(mode="straight",linecolor="#30485d",linewidth=0.16) {#XBIT5:2 (190,-54.35)};
// (190.4,-54.35) @TEXT("NEXT5",size=1.1,halign="start",valign="middle");
// &"SAMPLE" @WIRE(mode="straight",linecolor="#30485d",linewidth=0.16) {#XBIT5:3 (158,-57.65)};
// (157.6,-57.65) @TEXT("SAMPLE",size=1.1,halign="end",valign="middle");
// &"VDD" @WIRE(mode="straight",linecolor="#30485d",linewidth=0.16) {#XBIT5:4 (174,-45)};
// (174,-44.6) @TEXT("VDD",size=1.1,halign="middle",valign="bottom");
// &"VSS" @WIRE(mode="straight",linecolor="#30485d",linewidth=0.16) {#XBIT5:5 (174,-67)};
// (174,-67.4) @TEXT("VSS",size=1.1,halign="middle",valign="top");
// &"CODE5" @WIRE(mode="straight",linecolor="#30485d",linewidth=0.16) {#XBIT5:6 (190,-57.65)};
// (190.4,-57.65) @TEXT("CODE5",size=1.1,halign="start",valign="middle");
// &"COMMIT" @WIRE(mode="straight",linecolor="#30485d",linewidth=0.16) {#XBIT6:1 (124,-82.35)};
// (123.6,-82.35) @TEXT("COMMIT",size=1.1,halign="end",valign="middle");
// &"NEXT6" @WIRE(mode="straight",linecolor="#30485d",linewidth=0.16) {#XBIT6:2 (156,-82.35)};
// (156.4,-82.35) @TEXT("NEXT6",size=1.1,halign="start",valign="middle");
// &"SAMPLE" @WIRE(mode="straight",linecolor="#30485d",linewidth=0.16) {#XBIT6:3 (124,-85.65)};
// (123.6,-85.65) @TEXT("SAMPLE",size=1.1,halign="end",valign="middle");
// &"VDD" @WIRE(mode="straight",linecolor="#30485d",linewidth=0.16) {#XBIT6:4 (140,-73)};
// (140,-72.6) @TEXT("VDD",size=1.1,halign="middle",valign="bottom");
// &"VSS" @WIRE(mode="straight",linecolor="#30485d",linewidth=0.16) {#XBIT6:5 (140,-95)};
// (140,-95.4) @TEXT("VSS",size=1.1,halign="middle",valign="top");
// &"CODE6" @WIRE(mode="straight",linecolor="#30485d",linewidth=0.16) {#XBIT6:6 (156,-85.65)};
// (156.4,-85.65) @TEXT("CODE6",size=1.1,halign="start",valign="middle");
// &"NEXT7" @WIRE(mode="straight",linecolor="#30485d",linewidth=0.16) {#XMSBD:1 (130,-112)};
// (129.6,-112) @TEXT("NEXT7",size=1.1,halign="end",valign="middle");
// &"VDD" @WIRE(mode="straight",linecolor="#30485d",linewidth=0.16) {#XMSBD:3 (140,-102)};
// (140,-101.6) @TEXT("VDD",size=1.1,halign="middle",valign="bottom");
// &"VSS" @WIRE(mode="straight",linecolor="#30485d",linewidth=0.16) {#XMSBD:4 (140,-122)};
// (140,-122.4) @TEXT("VSS",size=1.1,halign="middle",valign="top");
// &"COMMIT" @WIRE(mode="straight",linecolor="#30485d",linewidth=0.16) {#XBIT7:1 (158,-82.35)};
// (157.6,-82.35) @TEXT("COMMIT",size=1.1,halign="end",valign="middle");
// &"SAMPLE" @WIRE(mode="straight",linecolor="#30485d",linewidth=0.16) {#XBIT7:3 (158,-85.65)};
// (157.6,-85.65) @TEXT("SAMPLE",size=1.1,halign="end",valign="middle");
// &"VDD" @WIRE(mode="straight",linecolor="#30485d",linewidth=0.16) {#XBIT7:4 (174,-73)};
// (174,-72.6) @TEXT("VDD",size=1.1,halign="middle",valign="bottom");
// &"VSS" @WIRE(mode="straight",linecolor="#30485d",linewidth=0.16) {#XBIT7:5 (174,-95)};
// (174,-95.4) @TEXT("VSS",size=1.1,halign="middle",valign="top");
// &"CODE7" @WIRE(mode="straight",linecolor="#30485d",linewidth=0.16) {#XMSBQ:2 (192,-112)};
// (192.4,-112) @TEXT("CODE7",size=1.1,halign="start",valign="middle");
// &"VDD" @WIRE(mode="straight",linecolor="#30485d",linewidth=0.16) {#XMSBQ:3 (182,-102)};
// (182,-101.6) @TEXT("VDD",size=1.1,halign="middle",valign="bottom");
// &"VSS" @WIRE(mode="straight",linecolor="#30485d",linewidth=0.16) {#XMSBQ:4 (182,-122)};
// (182,-122.4) @TEXT("VSS",size=1.1,halign="middle",valign="top");
// }
// END SARADC RNL
ends sar8_se_ctrl

subckt sar8_se_acquire REQUEST VDD VSS TRACK
XDEL (REQUEST TAP VDD VSS) DEL200D1BWP12T30P140
XQUAL (REQUEST TAP ACCEPTED VDD VSS) AN2D1BWP12T30P140
XOUT (ACCEPTED TRACK VDD VSS) CKBD1BWP12T30P140
// BEGIN SARADC RNL
// @RNL(author="saradc topology") {
// #XDEL @SET-SYMBOL $S_DEL200D1BWP12T30P140;
// #XDEL @PLACE(0,0) => @ORIENT("R0");
// #XQUAL @SET-SYMBOL $S_AN2D1BWP12T30P140;
// #XQUAL @PLACE(0,-33) => @ORIENT("R0");
// #XOUT @SET-SYMBOL $S_CKBD1BWP12T30P140;
// #XOUT @PLACE(0,-66) => @ORIENT("R0");
// &"REQUEST" @WIRE(mode="straight",linecolor="#30485d",linewidth=0.16) {#XDEL:1 (-13,0) (-13,-31.35) #XQUAL:1};
// &"TAP" @WIRE(mode="straight",linecolor="#30485d",linewidth=0.16) {#XDEL:2 (0,0) (0,-34.65) #XQUAL:2};
// &"ACCEPTED" @WIRE(mode="straight",linecolor="#30485d",linewidth=0.16) {#XQUAL:3 (0,-33) (0,-66) #XOUT:1};
// (-89,30) @TEXT("sar8_se_acquire / source-derived connections",size=1.4,halign="start",textcolor="#223d52");
// &"VDD" @WIRE(mode="straight",linecolor="#30485d",linewidth=0.16) {#XDEL:3 (0,11)};
// (0,11.4) @TEXT("VDD",size=1.1,halign="middle",valign="bottom");
// &"VSS" @WIRE(mode="straight",linecolor="#30485d",linewidth=0.16) {#XDEL:4 (0,-11)};
// (0,-11.4) @TEXT("VSS",size=1.1,halign="middle",valign="top");
// &"VDD" @WIRE(mode="straight",linecolor="#30485d",linewidth=0.16) {#XQUAL:4 (0,-22)};
// (0,-21.6) @TEXT("VDD",size=1.1,halign="middle",valign="bottom");
// &"VSS" @WIRE(mode="straight",linecolor="#30485d",linewidth=0.16) {#XQUAL:5 (0,-44)};
// (0,-44.4) @TEXT("VSS",size=1.1,halign="middle",valign="top");
// &"TRACK" @WIRE(mode="straight",linecolor="#30485d",linewidth=0.16) {#XOUT:2 (16,-66)};
// (16.4,-66) @TEXT("TRACK",size=1.1,halign="start",valign="middle");
// &"VDD" @WIRE(mode="straight",linecolor="#30485d",linewidth=0.16) {#XOUT:3 (0,-55)};
// (0,-54.6) @TEXT("VDD",size=1.1,halign="middle",valign="bottom");
// &"VSS" @WIRE(mode="straight",linecolor="#30485d",linewidth=0.16) {#XOUT:4 (0,-77)};
// (0,-77.4) @TEXT("VSS",size=1.1,halign="middle",valign="top");
// }
// END SARADC RNL
ends sar8_se_acquire

subckt tb_cdac
// Isolated CDAC: precharge top plates, release, then single-bit steps and full-scale reversal.
VDPRE (d_pre 0) vsource type=pwl wave=[0 0.9 40n 0.9 40.1n 0]
VDCM (d_cm 0) vsource dc=0.45
XDPN (d_n d_cm d_pre VDD! 0) b_tb_switch
XDPP (d_p d_cm d_pre VDD! 0) b_tb_switch
VDgnn0 (d_gnn0 0) vsource type=pwl wave=[0 0.90000000000000002 5.9900000000000014e-08 0.90000000000000002 6.0000000000000008e-08 0 7.9900000000000007e-08 0 8.0000000000000002e-08 0.90000000000000002 9.9900000000000014e-08 0.90000000000000002 1.0000000000000001e-07 0.90000000000000002 1.1990000000000001e-07 0.90000000000000002 1.2000000000000002e-07 0.90000000000000002 1.399e-07 0.90000000000000002 1.4000000000000001e-07 0.90000000000000002 1.599e-07 0.90000000000000002 1.6e-07 0.90000000000000002 1.7990000000000002e-07 0.90000000000000002 1.8000000000000002e-07 0.90000000000000002 1.9990000000000001e-07 0.90000000000000002 2.0000000000000002e-07 0.90000000000000002 2.199e-07 0.90000000000000002 2.2000000000000001e-07 0 2.3990000000000002e-07 0 2.4000000000000003e-07 0.90000000000000002]
VDgnn1 (d_gnn1 0) vsource type=pwl wave=[0 0.90000000000000002 5.9900000000000014e-08 0.90000000000000002 6.0000000000000008e-08 0.90000000000000002 7.9900000000000007e-08 0.90000000000000002 8.0000000000000002e-08 0 9.9900000000000014e-08 0 1.0000000000000001e-07 0.90000000000000002 1.1990000000000001e-07 0.90000000000000002 1.2000000000000002e-07 0.90000000000000002 1.399e-07 0.90000000000000002 1.4000000000000001e-07 0.90000000000000002 1.599e-07 0.90000000000000002 1.6e-07 0.90000000000000002 1.7990000000000002e-07 0.90000000000000002 1.8000000000000002e-07 0.90000000000000002 1.9990000000000001e-07 0.90000000000000002 2.0000000000000002e-07 0.90000000000000002 2.199e-07 0.90000000000000002 2.2000000000000001e-07 0 2.3990000000000002e-07 0 2.4000000000000003e-07 0.90000000000000002]
VDgnn2 (d_gnn2 0) vsource type=pwl wave=[0 0.90000000000000002 5.9900000000000014e-08 0.90000000000000002 6.0000000000000008e-08 0.90000000000000002 7.9900000000000007e-08 0.90000000000000002 8.0000000000000002e-08 0.90000000000000002 9.9900000000000014e-08 0.90000000000000002 1.0000000000000001e-07 0 1.1990000000000001e-07 0 1.2000000000000002e-07 0.90000000000000002 1.399e-07 0.90000000000000002 1.4000000000000001e-07 0.90000000000000002 1.599e-07 0.90000000000000002 1.6e-07 0.90000000000000002 1.7990000000000002e-07 0.90000000000000002 1.8000000000000002e-07 0.90000000000000002 1.9990000000000001e-07 0.90000000000000002 2.0000000000000002e-07 0.90000000000000002 2.199e-07 0.90000000000000002 2.2000000000000001e-07 0 2.3990000000000002e-07 0 2.4000000000000003e-07 0.90000000000000002]
VDgnn3 (d_gnn3 0) vsource type=pwl wave=[0 0.90000000000000002 5.9900000000000014e-08 0.90000000000000002 6.0000000000000008e-08 0.90000000000000002 7.9900000000000007e-08 0.90000000000000002 8.0000000000000002e-08 0.90000000000000002 9.9900000000000014e-08 0.90000000000000002 1.0000000000000001e-07 0.90000000000000002 1.1990000000000001e-07 0.90000000000000002 1.2000000000000002e-07 0 1.399e-07 0 1.4000000000000001e-07 0.90000000000000002 1.599e-07 0.90000000000000002 1.6e-07 0.90000000000000002 1.7990000000000002e-07 0.90000000000000002 1.8000000000000002e-07 0.90000000000000002 1.9990000000000001e-07 0.90000000000000002 2.0000000000000002e-07 0.90000000000000002 2.199e-07 0.90000000000000002 2.2000000000000001e-07 0 2.3990000000000002e-07 0 2.4000000000000003e-07 0.90000000000000002]
VDgnn4 (d_gnn4 0) vsource type=pwl wave=[0 0.90000000000000002 5.9900000000000014e-08 0.90000000000000002 6.0000000000000008e-08 0.90000000000000002 7.9900000000000007e-08 0.90000000000000002 8.0000000000000002e-08 0.90000000000000002 9.9900000000000014e-08 0.90000000000000002 1.0000000000000001e-07 0.90000000000000002 1.1990000000000001e-07 0.90000000000000002 1.2000000000000002e-07 0.90000000000000002 1.399e-07 0.90000000000000002 1.4000000000000001e-07 0 1.599e-07 0 1.6e-07 0.90000000000000002 1.7990000000000002e-07 0.90000000000000002 1.8000000000000002e-07 0.90000000000000002 1.9990000000000001e-07 0.90000000000000002 2.0000000000000002e-07 0.90000000000000002 2.199e-07 0.90000000000000002 2.2000000000000001e-07 0 2.3990000000000002e-07 0 2.4000000000000003e-07 0.90000000000000002]
VDgnn5 (d_gnn5 0) vsource type=pwl wave=[0 0.90000000000000002 5.9900000000000014e-08 0.90000000000000002 6.0000000000000008e-08 0.90000000000000002 7.9900000000000007e-08 0.90000000000000002 8.0000000000000002e-08 0.90000000000000002 9.9900000000000014e-08 0.90000000000000002 1.0000000000000001e-07 0.90000000000000002 1.1990000000000001e-07 0.90000000000000002 1.2000000000000002e-07 0.90000000000000002 1.399e-07 0.90000000000000002 1.4000000000000001e-07 0.90000000000000002 1.599e-07 0.90000000000000002 1.6e-07 0 1.7990000000000002e-07 0 1.8000000000000002e-07 0.90000000000000002 1.9990000000000001e-07 0.90000000000000002 2.0000000000000002e-07 0.90000000000000002 2.199e-07 0.90000000000000002 2.2000000000000001e-07 0 2.3990000000000002e-07 0 2.4000000000000003e-07 0.90000000000000002]
VDgnn6 (d_gnn6 0) vsource type=pwl wave=[0 0.90000000000000002 5.9900000000000014e-08 0.90000000000000002 6.0000000000000008e-08 0.90000000000000002 7.9900000000000007e-08 0.90000000000000002 8.0000000000000002e-08 0.90000000000000002 9.9900000000000014e-08 0.90000000000000002 1.0000000000000001e-07 0.90000000000000002 1.1990000000000001e-07 0.90000000000000002 1.2000000000000002e-07 0.90000000000000002 1.399e-07 0.90000000000000002 1.4000000000000001e-07 0.90000000000000002 1.599e-07 0.90000000000000002 1.6e-07 0.90000000000000002 1.7990000000000002e-07 0.90000000000000002 1.8000000000000002e-07 0 1.9990000000000001e-07 0 2.0000000000000002e-07 0.90000000000000002 2.199e-07 0.90000000000000002 2.2000000000000001e-07 0 2.3990000000000002e-07 0 2.4000000000000003e-07 0.90000000000000002]
VDgnn7 (d_gnn7 0) vsource type=pwl wave=[0 0.90000000000000002 5.9900000000000014e-08 0.90000000000000002 6.0000000000000008e-08 0.90000000000000002 7.9900000000000007e-08 0.90000000000000002 8.0000000000000002e-08 0.90000000000000002 9.9900000000000014e-08 0.90000000000000002 1.0000000000000001e-07 0.90000000000000002 1.1990000000000001e-07 0.90000000000000002 1.2000000000000002e-07 0.90000000000000002 1.399e-07 0.90000000000000002 1.4000000000000001e-07 0.90000000000000002 1.599e-07 0.90000000000000002 1.6e-07 0.90000000000000002 1.7990000000000002e-07 0.90000000000000002 1.8000000000000002e-07 0.90000000000000002 1.9990000000000001e-07 0.90000000000000002 2.0000000000000002e-07 0 2.199e-07 0 2.2000000000000001e-07 0 2.3990000000000002e-07 0 2.4000000000000003e-07 0.90000000000000002]
VDgnp0 (d_gnp0 0) vsource type=pwl wave=[0 0.90000000000000002 5.9900000000000014e-08 0.90000000000000002 6.0000000000000008e-08 0 7.9900000000000007e-08 0 8.0000000000000002e-08 0.90000000000000002 9.9900000000000014e-08 0.90000000000000002 1.0000000000000001e-07 0.90000000000000002 1.1990000000000001e-07 0.90000000000000002 1.2000000000000002e-07 0.90000000000000002 1.399e-07 0.90000000000000002 1.4000000000000001e-07 0.90000000000000002 1.599e-07 0.90000000000000002 1.6e-07 0.90000000000000002 1.7990000000000002e-07 0.90000000000000002 1.8000000000000002e-07 0.90000000000000002 1.9990000000000001e-07 0.90000000000000002 2.0000000000000002e-07 0.90000000000000002 2.199e-07 0.90000000000000002 2.2000000000000001e-07 0 2.3990000000000002e-07 0 2.4000000000000003e-07 0.90000000000000002]
VDgnp1 (d_gnp1 0) vsource type=pwl wave=[0 0.90000000000000002 5.9900000000000014e-08 0.90000000000000002 6.0000000000000008e-08 0.90000000000000002 7.9900000000000007e-08 0.90000000000000002 8.0000000000000002e-08 0 9.9900000000000014e-08 0 1.0000000000000001e-07 0.90000000000000002 1.1990000000000001e-07 0.90000000000000002 1.2000000000000002e-07 0.90000000000000002 1.399e-07 0.90000000000000002 1.4000000000000001e-07 0.90000000000000002 1.599e-07 0.90000000000000002 1.6e-07 0.90000000000000002 1.7990000000000002e-07 0.90000000000000002 1.8000000000000002e-07 0.90000000000000002 1.9990000000000001e-07 0.90000000000000002 2.0000000000000002e-07 0.90000000000000002 2.199e-07 0.90000000000000002 2.2000000000000001e-07 0 2.3990000000000002e-07 0 2.4000000000000003e-07 0.90000000000000002]
VDgnp2 (d_gnp2 0) vsource type=pwl wave=[0 0.90000000000000002 5.9900000000000014e-08 0.90000000000000002 6.0000000000000008e-08 0.90000000000000002 7.9900000000000007e-08 0.90000000000000002 8.0000000000000002e-08 0.90000000000000002 9.9900000000000014e-08 0.90000000000000002 1.0000000000000001e-07 0 1.1990000000000001e-07 0 1.2000000000000002e-07 0.90000000000000002 1.399e-07 0.90000000000000002 1.4000000000000001e-07 0.90000000000000002 1.599e-07 0.90000000000000002 1.6e-07 0.90000000000000002 1.7990000000000002e-07 0.90000000000000002 1.8000000000000002e-07 0.90000000000000002 1.9990000000000001e-07 0.90000000000000002 2.0000000000000002e-07 0.90000000000000002 2.199e-07 0.90000000000000002 2.2000000000000001e-07 0 2.3990000000000002e-07 0 2.4000000000000003e-07 0.90000000000000002]
VDgnp3 (d_gnp3 0) vsource type=pwl wave=[0 0.90000000000000002 5.9900000000000014e-08 0.90000000000000002 6.0000000000000008e-08 0.90000000000000002 7.9900000000000007e-08 0.90000000000000002 8.0000000000000002e-08 0.90000000000000002 9.9900000000000014e-08 0.90000000000000002 1.0000000000000001e-07 0.90000000000000002 1.1990000000000001e-07 0.90000000000000002 1.2000000000000002e-07 0 1.399e-07 0 1.4000000000000001e-07 0.90000000000000002 1.599e-07 0.90000000000000002 1.6e-07 0.90000000000000002 1.7990000000000002e-07 0.90000000000000002 1.8000000000000002e-07 0.90000000000000002 1.9990000000000001e-07 0.90000000000000002 2.0000000000000002e-07 0.90000000000000002 2.199e-07 0.90000000000000002 2.2000000000000001e-07 0 2.3990000000000002e-07 0 2.4000000000000003e-07 0.90000000000000002]
VDgnp4 (d_gnp4 0) vsource type=pwl wave=[0 0.90000000000000002 5.9900000000000014e-08 0.90000000000000002 6.0000000000000008e-08 0.90000000000000002 7.9900000000000007e-08 0.90000000000000002 8.0000000000000002e-08 0.90000000000000002 9.9900000000000014e-08 0.90000000000000002 1.0000000000000001e-07 0.90000000000000002 1.1990000000000001e-07 0.90000000000000002 1.2000000000000002e-07 0.90000000000000002 1.399e-07 0.90000000000000002 1.4000000000000001e-07 0 1.599e-07 0 1.6e-07 0.90000000000000002 1.7990000000000002e-07 0.90000000000000002 1.8000000000000002e-07 0.90000000000000002 1.9990000000000001e-07 0.90000000000000002 2.0000000000000002e-07 0.90000000000000002 2.199e-07 0.90000000000000002 2.2000000000000001e-07 0 2.3990000000000002e-07 0 2.4000000000000003e-07 0.90000000000000002]
VDgnp5 (d_gnp5 0) vsource type=pwl wave=[0 0.90000000000000002 5.9900000000000014e-08 0.90000000000000002 6.0000000000000008e-08 0.90000000000000002 7.9900000000000007e-08 0.90000000000000002 8.0000000000000002e-08 0.90000000000000002 9.9900000000000014e-08 0.90000000000000002 1.0000000000000001e-07 0.90000000000000002 1.1990000000000001e-07 0.90000000000000002 1.2000000000000002e-07 0.90000000000000002 1.399e-07 0.90000000000000002 1.4000000000000001e-07 0.90000000000000002 1.599e-07 0.90000000000000002 1.6e-07 0 1.7990000000000002e-07 0 1.8000000000000002e-07 0.90000000000000002 1.9990000000000001e-07 0.90000000000000002 2.0000000000000002e-07 0.90000000000000002 2.199e-07 0.90000000000000002 2.2000000000000001e-07 0 2.3990000000000002e-07 0 2.4000000000000003e-07 0.90000000000000002]
VDgnp6 (d_gnp6 0) vsource type=pwl wave=[0 0.90000000000000002 5.9900000000000014e-08 0.90000000000000002 6.0000000000000008e-08 0.90000000000000002 7.9900000000000007e-08 0.90000000000000002 8.0000000000000002e-08 0.90000000000000002 9.9900000000000014e-08 0.90000000000000002 1.0000000000000001e-07 0.90000000000000002 1.1990000000000001e-07 0.90000000000000002 1.2000000000000002e-07 0.90000000000000002 1.399e-07 0.90000000000000002 1.4000000000000001e-07 0.90000000000000002 1.599e-07 0.90000000000000002 1.6e-07 0.90000000000000002 1.7990000000000002e-07 0.90000000000000002 1.8000000000000002e-07 0 1.9990000000000001e-07 0 2.0000000000000002e-07 0.90000000000000002 2.199e-07 0.90000000000000002 2.2000000000000001e-07 0 2.3990000000000002e-07 0 2.4000000000000003e-07 0.90000000000000002]
VDgnp7 (d_gnp7 0) vsource type=pwl wave=[0 0.90000000000000002 5.9900000000000014e-08 0.90000000000000002 6.0000000000000008e-08 0.90000000000000002 7.9900000000000007e-08 0.90000000000000002 8.0000000000000002e-08 0.90000000000000002 9.9900000000000014e-08 0.90000000000000002 1.0000000000000001e-07 0.90000000000000002 1.1990000000000001e-07 0.90000000000000002 1.2000000000000002e-07 0.90000000000000002 1.399e-07 0.90000000000000002 1.4000000000000001e-07 0.90000000000000002 1.599e-07 0.90000000000000002 1.6e-07 0.90000000000000002 1.7990000000000002e-07 0.90000000000000002 1.8000000000000002e-07 0.90000000000000002 1.9990000000000001e-07 0.90000000000000002 2.0000000000000002e-07 0 2.199e-07 0 2.2000000000000001e-07 0 2.3990000000000002e-07 0 2.4000000000000003e-07 0.90000000000000002]
VDgpn0 (d_gpn0 0) vsource type=pwl wave=[0 0 5.9900000000000014e-08 0 6.0000000000000008e-08 0.90000000000000002 7.9900000000000007e-08 0.90000000000000002 8.0000000000000002e-08 0 9.9900000000000014e-08 0 1.0000000000000001e-07 0 1.1990000000000001e-07 0 1.2000000000000002e-07 0 1.399e-07 0 1.4000000000000001e-07 0 1.599e-07 0 1.6e-07 0 1.7990000000000002e-07 0 1.8000000000000002e-07 0 1.9990000000000001e-07 0 2.0000000000000002e-07 0 2.199e-07 0 2.2000000000000001e-07 0.90000000000000002 2.3990000000000002e-07 0.90000000000000002 2.4000000000000003e-07 0]
VDgpn1 (d_gpn1 0) vsource type=pwl wave=[0 0 5.9900000000000014e-08 0 6.0000000000000008e-08 0 7.9900000000000007e-08 0 8.0000000000000002e-08 0.90000000000000002 9.9900000000000014e-08 0.90000000000000002 1.0000000000000001e-07 0 1.1990000000000001e-07 0 1.2000000000000002e-07 0 1.399e-07 0 1.4000000000000001e-07 0 1.599e-07 0 1.6e-07 0 1.7990000000000002e-07 0 1.8000000000000002e-07 0 1.9990000000000001e-07 0 2.0000000000000002e-07 0 2.199e-07 0 2.2000000000000001e-07 0.90000000000000002 2.3990000000000002e-07 0.90000000000000002 2.4000000000000003e-07 0]
VDgpn2 (d_gpn2 0) vsource type=pwl wave=[0 0 5.9900000000000014e-08 0 6.0000000000000008e-08 0 7.9900000000000007e-08 0 8.0000000000000002e-08 0 9.9900000000000014e-08 0 1.0000000000000001e-07 0.90000000000000002 1.1990000000000001e-07 0.90000000000000002 1.2000000000000002e-07 0 1.399e-07 0 1.4000000000000001e-07 0 1.599e-07 0 1.6e-07 0 1.7990000000000002e-07 0 1.8000000000000002e-07 0 1.9990000000000001e-07 0 2.0000000000000002e-07 0 2.199e-07 0 2.2000000000000001e-07 0.90000000000000002 2.3990000000000002e-07 0.90000000000000002 2.4000000000000003e-07 0]
VDgpn3 (d_gpn3 0) vsource type=pwl wave=[0 0 5.9900000000000014e-08 0 6.0000000000000008e-08 0 7.9900000000000007e-08 0 8.0000000000000002e-08 0 9.9900000000000014e-08 0 1.0000000000000001e-07 0 1.1990000000000001e-07 0 1.2000000000000002e-07 0.90000000000000002 1.399e-07 0.90000000000000002 1.4000000000000001e-07 0 1.599e-07 0 1.6e-07 0 1.7990000000000002e-07 0 1.8000000000000002e-07 0 1.9990000000000001e-07 0 2.0000000000000002e-07 0 2.199e-07 0 2.2000000000000001e-07 0.90000000000000002 2.3990000000000002e-07 0.90000000000000002 2.4000000000000003e-07 0]
VDgpn4 (d_gpn4 0) vsource type=pwl wave=[0 0 5.9900000000000014e-08 0 6.0000000000000008e-08 0 7.9900000000000007e-08 0 8.0000000000000002e-08 0 9.9900000000000014e-08 0 1.0000000000000001e-07 0 1.1990000000000001e-07 0 1.2000000000000002e-07 0 1.399e-07 0 1.4000000000000001e-07 0.90000000000000002 1.599e-07 0.90000000000000002 1.6e-07 0 1.7990000000000002e-07 0 1.8000000000000002e-07 0 1.9990000000000001e-07 0 2.0000000000000002e-07 0 2.199e-07 0 2.2000000000000001e-07 0.90000000000000002 2.3990000000000002e-07 0.90000000000000002 2.4000000000000003e-07 0]
VDgpn5 (d_gpn5 0) vsource type=pwl wave=[0 0 5.9900000000000014e-08 0 6.0000000000000008e-08 0 7.9900000000000007e-08 0 8.0000000000000002e-08 0 9.9900000000000014e-08 0 1.0000000000000001e-07 0 1.1990000000000001e-07 0 1.2000000000000002e-07 0 1.399e-07 0 1.4000000000000001e-07 0 1.599e-07 0 1.6e-07 0.90000000000000002 1.7990000000000002e-07 0.90000000000000002 1.8000000000000002e-07 0 1.9990000000000001e-07 0 2.0000000000000002e-07 0 2.199e-07 0 2.2000000000000001e-07 0.90000000000000002 2.3990000000000002e-07 0.90000000000000002 2.4000000000000003e-07 0]
VDgpn6 (d_gpn6 0) vsource type=pwl wave=[0 0 5.9900000000000014e-08 0 6.0000000000000008e-08 0 7.9900000000000007e-08 0 8.0000000000000002e-08 0 9.9900000000000014e-08 0 1.0000000000000001e-07 0 1.1990000000000001e-07 0 1.2000000000000002e-07 0 1.399e-07 0 1.4000000000000001e-07 0 1.599e-07 0 1.6e-07 0 1.7990000000000002e-07 0 1.8000000000000002e-07 0.90000000000000002 1.9990000000000001e-07 0.90000000000000002 2.0000000000000002e-07 0 2.199e-07 0 2.2000000000000001e-07 0.90000000000000002 2.3990000000000002e-07 0.90000000000000002 2.4000000000000003e-07 0]
VDgpn7 (d_gpn7 0) vsource type=pwl wave=[0 0 5.9900000000000014e-08 0 6.0000000000000008e-08 0 7.9900000000000007e-08 0 8.0000000000000002e-08 0 9.9900000000000014e-08 0 1.0000000000000001e-07 0 1.1990000000000001e-07 0 1.2000000000000002e-07 0 1.399e-07 0 1.4000000000000001e-07 0 1.599e-07 0 1.6e-07 0 1.7990000000000002e-07 0 1.8000000000000002e-07 0 1.9990000000000001e-07 0 2.0000000000000002e-07 0.90000000000000002 2.199e-07 0.90000000000000002 2.2000000000000001e-07 0.90000000000000002 2.3990000000000002e-07 0.90000000000000002 2.4000000000000003e-07 0]
VDgpp0 (d_gpp0 0) vsource type=pwl wave=[0 0 5.9900000000000014e-08 0 6.0000000000000008e-08 0.90000000000000002 7.9900000000000007e-08 0.90000000000000002 8.0000000000000002e-08 0 9.9900000000000014e-08 0 1.0000000000000001e-07 0 1.1990000000000001e-07 0 1.2000000000000002e-07 0 1.399e-07 0 1.4000000000000001e-07 0 1.599e-07 0 1.6e-07 0 1.7990000000000002e-07 0 1.8000000000000002e-07 0 1.9990000000000001e-07 0 2.0000000000000002e-07 0 2.199e-07 0 2.2000000000000001e-07 0.90000000000000002 2.3990000000000002e-07 0.90000000000000002 2.4000000000000003e-07 0]
VDgpp1 (d_gpp1 0) vsource type=pwl wave=[0 0 5.9900000000000014e-08 0 6.0000000000000008e-08 0 7.9900000000000007e-08 0 8.0000000000000002e-08 0.90000000000000002 9.9900000000000014e-08 0.90000000000000002 1.0000000000000001e-07 0 1.1990000000000001e-07 0 1.2000000000000002e-07 0 1.399e-07 0 1.4000000000000001e-07 0 1.599e-07 0 1.6e-07 0 1.7990000000000002e-07 0 1.8000000000000002e-07 0 1.9990000000000001e-07 0 2.0000000000000002e-07 0 2.199e-07 0 2.2000000000000001e-07 0.90000000000000002 2.3990000000000002e-07 0.90000000000000002 2.4000000000000003e-07 0]
VDgpp2 (d_gpp2 0) vsource type=pwl wave=[0 0 5.9900000000000014e-08 0 6.0000000000000008e-08 0 7.9900000000000007e-08 0 8.0000000000000002e-08 0 9.9900000000000014e-08 0 1.0000000000000001e-07 0.90000000000000002 1.1990000000000001e-07 0.90000000000000002 1.2000000000000002e-07 0 1.399e-07 0 1.4000000000000001e-07 0 1.599e-07 0 1.6e-07 0 1.7990000000000002e-07 0 1.8000000000000002e-07 0 1.9990000000000001e-07 0 2.0000000000000002e-07 0 2.199e-07 0 2.2000000000000001e-07 0.90000000000000002 2.3990000000000002e-07 0.90000000000000002 2.4000000000000003e-07 0]
VDgpp3 (d_gpp3 0) vsource type=pwl wave=[0 0 5.9900000000000014e-08 0 6.0000000000000008e-08 0 7.9900000000000007e-08 0 8.0000000000000002e-08 0 9.9900000000000014e-08 0 1.0000000000000001e-07 0 1.1990000000000001e-07 0 1.2000000000000002e-07 0.90000000000000002 1.399e-07 0.90000000000000002 1.4000000000000001e-07 0 1.599e-07 0 1.6e-07 0 1.7990000000000002e-07 0 1.8000000000000002e-07 0 1.9990000000000001e-07 0 2.0000000000000002e-07 0 2.199e-07 0 2.2000000000000001e-07 0.90000000000000002 2.3990000000000002e-07 0.90000000000000002 2.4000000000000003e-07 0]
VDgpp4 (d_gpp4 0) vsource type=pwl wave=[0 0 5.9900000000000014e-08 0 6.0000000000000008e-08 0 7.9900000000000007e-08 0 8.0000000000000002e-08 0 9.9900000000000014e-08 0 1.0000000000000001e-07 0 1.1990000000000001e-07 0 1.2000000000000002e-07 0 1.399e-07 0 1.4000000000000001e-07 0.90000000000000002 1.599e-07 0.90000000000000002 1.6e-07 0 1.7990000000000002e-07 0 1.8000000000000002e-07 0 1.9990000000000001e-07 0 2.0000000000000002e-07 0 2.199e-07 0 2.2000000000000001e-07 0.90000000000000002 2.3990000000000002e-07 0.90000000000000002 2.4000000000000003e-07 0]
VDgpp5 (d_gpp5 0) vsource type=pwl wave=[0 0 5.9900000000000014e-08 0 6.0000000000000008e-08 0 7.9900000000000007e-08 0 8.0000000000000002e-08 0 9.9900000000000014e-08 0 1.0000000000000001e-07 0 1.1990000000000001e-07 0 1.2000000000000002e-07 0 1.399e-07 0 1.4000000000000001e-07 0 1.599e-07 0 1.6e-07 0.90000000000000002 1.7990000000000002e-07 0.90000000000000002 1.8000000000000002e-07 0 1.9990000000000001e-07 0 2.0000000000000002e-07 0 2.199e-07 0 2.2000000000000001e-07 0.90000000000000002 2.3990000000000002e-07 0.90000000000000002 2.4000000000000003e-07 0]
VDgpp6 (d_gpp6 0) vsource type=pwl wave=[0 0 5.9900000000000014e-08 0 6.0000000000000008e-08 0 7.9900000000000007e-08 0 8.0000000000000002e-08 0 9.9900000000000014e-08 0 1.0000000000000001e-07 0 1.1990000000000001e-07 0 1.2000000000000002e-07 0 1.399e-07 0 1.4000000000000001e-07 0 1.599e-07 0 1.6e-07 0 1.7990000000000002e-07 0 1.8000000000000002e-07 0.90000000000000002 1.9990000000000001e-07 0.90000000000000002 2.0000000000000002e-07 0 2.199e-07 0 2.2000000000000001e-07 0.90000000000000002 2.3990000000000002e-07 0.90000000000000002 2.4000000000000003e-07 0]
VDgpp7 (d_gpp7 0) vsource type=pwl wave=[0 0 5.9900000000000014e-08 0 6.0000000000000008e-08 0 7.9900000000000007e-08 0 8.0000000000000002e-08 0 9.9900000000000014e-08 0 1.0000000000000001e-07 0 1.1990000000000001e-07 0 1.2000000000000002e-07 0 1.399e-07 0 1.4000000000000001e-07 0 1.599e-07 0 1.6e-07 0 1.7990000000000002e-07 0 1.8000000000000002e-07 0 1.9990000000000001e-07 0 2.0000000000000002e-07 0.90000000000000002 2.199e-07 0.90000000000000002 2.2000000000000001e-07 0.90000000000000002 2.3990000000000002e-07 0.90000000000000002 2.4000000000000003e-07 0]
XDAC (d_gnn0 d_gnn1 d_gnn2 d_gnn3 d_gnn4 d_gnn5 d_gnn6 d_gnn7 d_gnp0 d_gnp1 d_gnp2 d_gnp3 d_gnp4 d_gnp5 d_gnp6 d_gnp7 d_gpn0 d_gpn1 d_gpn2 d_gpn3 d_gpn4 d_gpn5 d_gpn6 d_gpn7 d_gpp0 d_gpp1 d_gpp2 d_gpp3 d_gpp4 d_gpp5 d_gpp6 d_gpp7 d_n d_p VDD! d_rn d_rp 0) sar8j_r1_cdac
VDRN (d_rns 0) vsource dc=0
VDRP (d_rps 0) vsource dc=0.9
RDRN (d_rns d_rn) resistor r=50
RDRP (d_rps d_rp) resistor r=50
CDRN (d_rn 0) capacitor c=4p
CDRP (d_rp 0) capacitor c=4p

// BEGIN SARADC RNL
// @RNL(author="saradc topology") {
// #VDPRE @SET-SYMBOL $VOLTAGE_SOURCE;
// #VDPRE @PLACE(-70,0) => @ORIENT("R0");
// #VDPRE @TEXT("VDPRE",key="name",size=1.3,halign="start") => @PLACE(-67,3);
// #VDPRE @TEXT("",key="value",size=0.9,halign="start") => @PLACE(-67,-4);
// #VDPRE @TEXT("",key="model");
// #VDCM @SET-SYMBOL $VOLTAGE_SOURCE;
// #VDCM @PLACE(-70,-33) => @ORIENT("R0");
// #VDCM @TEXT("VDCM",key="name",size=1.3,halign="start") => @PLACE(-67,-30);
// #VDCM @TEXT("",key="value",size=0.9,halign="start") => @PLACE(-67,-37);
// #VDCM @TEXT("",key="model");
// #VDgnn0 @SET-SYMBOL $VOLTAGE_SOURCE;
// #VDgnn0 @PLACE(-70,-66) => @ORIENT("R0");
// #VDgnn0 @TEXT("VDgnn0",key="name",size=1.3,halign="start") => @PLACE(-67,-63);
// #VDgnn0 @TEXT("",key="value",size=0.9,halign="start") => @PLACE(-67,-70);
// #VDgnn0 @TEXT("",key="model");
// #VDgnn1 @SET-SYMBOL $VOLTAGE_SOURCE;
// #VDgnn1 @PLACE(-70,-99) => @ORIENT("R0");
// #VDgnn1 @TEXT("VDgnn1",key="name",size=1.3,halign="start") => @PLACE(-67,-96);
// #VDgnn1 @TEXT("",key="value",size=0.9,halign="start") => @PLACE(-67,-103);
// #VDgnn1 @TEXT("",key="model");
// #VDgnn2 @SET-SYMBOL $VOLTAGE_SOURCE;
// #VDgnn2 @PLACE(-70,-132) => @ORIENT("R0");
// #VDgnn2 @TEXT("VDgnn2",key="name",size=1.3,halign="start") => @PLACE(-67,-129);
// #VDgnn2 @TEXT("",key="value",size=0.9,halign="start") => @PLACE(-67,-136);
// #VDgnn2 @TEXT("",key="model");
// #VDgnn3 @SET-SYMBOL $VOLTAGE_SOURCE;
// #VDgnn3 @PLACE(-70,-165) => @ORIENT("R0");
// #VDgnn3 @TEXT("VDgnn3",key="name",size=1.3,halign="start") => @PLACE(-67,-162);
// #VDgnn3 @TEXT("",key="value",size=0.9,halign="start") => @PLACE(-67,-169);
// #VDgnn3 @TEXT("",key="model");
// #VDgnn4 @SET-SYMBOL $VOLTAGE_SOURCE;
// #VDgnn4 @PLACE(-70,-198) => @ORIENT("R0");
// #VDgnn4 @TEXT("VDgnn4",key="name",size=1.3,halign="start") => @PLACE(-67,-195);
// #VDgnn4 @TEXT("",key="value",size=0.9,halign="start") => @PLACE(-67,-202);
// #VDgnn4 @TEXT("",key="model");
// #VDgnn5 @SET-SYMBOL $VOLTAGE_SOURCE;
// #VDgnn5 @PLACE(-70,-231) => @ORIENT("R0");
// #VDgnn5 @TEXT("VDgnn5",key="name",size=1.3,halign="start") => @PLACE(-67,-228);
// #VDgnn5 @TEXT("",key="value",size=0.9,halign="start") => @PLACE(-67,-235);
// #VDgnn5 @TEXT("",key="model");
// #VDgnn6 @SET-SYMBOL $VOLTAGE_SOURCE;
// #VDgnn6 @PLACE(-70,-264) => @ORIENT("R0");
// #VDgnn6 @TEXT("VDgnn6",key="name",size=1.3,halign="start") => @PLACE(-67,-261);
// #VDgnn6 @TEXT("",key="value",size=0.9,halign="start") => @PLACE(-67,-268);
// #VDgnn6 @TEXT("",key="model");
// #VDgnn7 @SET-SYMBOL $VOLTAGE_SOURCE;
// #VDgnn7 @PLACE(-70,-297) => @ORIENT("R0");
// #VDgnn7 @TEXT("VDgnn7",key="name",size=1.3,halign="start") => @PLACE(-67,-294);
// #VDgnn7 @TEXT("",key="value",size=0.9,halign="start") => @PLACE(-67,-301);
// #VDgnn7 @TEXT("",key="model");
// #VDgnp0 @SET-SYMBOL $VOLTAGE_SOURCE;
// #VDgnp0 @PLACE(-70,-330) => @ORIENT("R0");
// #VDgnp0 @TEXT("VDgnp0",key="name",size=1.3,halign="start") => @PLACE(-67,-327);
// #VDgnp0 @TEXT("",key="value",size=0.9,halign="start") => @PLACE(-67,-334);
// #VDgnp0 @TEXT("",key="model");
// #VDgnp1 @SET-SYMBOL $VOLTAGE_SOURCE;
// #VDgnp1 @PLACE(-70,-363) => @ORIENT("R0");
// #VDgnp1 @TEXT("VDgnp1",key="name",size=1.3,halign="start") => @PLACE(-67,-360);
// #VDgnp1 @TEXT("",key="value",size=0.9,halign="start") => @PLACE(-67,-367);
// #VDgnp1 @TEXT("",key="model");
// #VDgnp2 @SET-SYMBOL $VOLTAGE_SOURCE;
// #VDgnp2 @PLACE(-15,0) => @ORIENT("R0");
// #VDgnp2 @TEXT("VDgnp2",key="name",size=1.3,halign="start") => @PLACE(-12,3);
// #VDgnp2 @TEXT("",key="value",size=0.9,halign="start") => @PLACE(-12,-4);
// #VDgnp2 @TEXT("",key="model");
// #VDgnp3 @SET-SYMBOL $VOLTAGE_SOURCE;
// #VDgnp3 @PLACE(-15,-33) => @ORIENT("R0");
// #VDgnp3 @TEXT("VDgnp3",key="name",size=1.3,halign="start") => @PLACE(-12,-30);
// #VDgnp3 @TEXT("",key="value",size=0.9,halign="start") => @PLACE(-12,-37);
// #VDgnp3 @TEXT("",key="model");
// #VDgnp4 @SET-SYMBOL $VOLTAGE_SOURCE;
// #VDgnp4 @PLACE(-15,-66) => @ORIENT("R0");
// #VDgnp4 @TEXT("VDgnp4",key="name",size=1.3,halign="start") => @PLACE(-12,-63);
// #VDgnp4 @TEXT("",key="value",size=0.9,halign="start") => @PLACE(-12,-70);
// #VDgnp4 @TEXT("",key="model");
// #VDgnp5 @SET-SYMBOL $VOLTAGE_SOURCE;
// #VDgnp5 @PLACE(-15,-99) => @ORIENT("R0");
// #VDgnp5 @TEXT("VDgnp5",key="name",size=1.3,halign="start") => @PLACE(-12,-96);
// #VDgnp5 @TEXT("",key="value",size=0.9,halign="start") => @PLACE(-12,-103);
// #VDgnp5 @TEXT("",key="model");
// #VDgnp6 @SET-SYMBOL $VOLTAGE_SOURCE;
// #VDgnp6 @PLACE(-15,-132) => @ORIENT("R0");
// #VDgnp6 @TEXT("VDgnp6",key="name",size=1.3,halign="start") => @PLACE(-12,-129);
// #VDgnp6 @TEXT("",key="value",size=0.9,halign="start") => @PLACE(-12,-136);
// #VDgnp6 @TEXT("",key="model");
// #VDgnp7 @SET-SYMBOL $VOLTAGE_SOURCE;
// #VDgnp7 @PLACE(-15,-165) => @ORIENT("R0");
// #VDgnp7 @TEXT("VDgnp7",key="name",size=1.3,halign="start") => @PLACE(-12,-162);
// #VDgnp7 @TEXT("",key="value",size=0.9,halign="start") => @PLACE(-12,-169);
// #VDgnp7 @TEXT("",key="model");
// #VDgpn0 @SET-SYMBOL $VOLTAGE_SOURCE;
// #VDgpn0 @PLACE(-15,-198) => @ORIENT("R0");
// #VDgpn0 @TEXT("VDgpn0",key="name",size=1.3,halign="start") => @PLACE(-12,-195);
// #VDgpn0 @TEXT("",key="value",size=0.9,halign="start") => @PLACE(-12,-202);
// #VDgpn0 @TEXT("",key="model");
// #VDgpn1 @SET-SYMBOL $VOLTAGE_SOURCE;
// #VDgpn1 @PLACE(-15,-231) => @ORIENT("R0");
// #VDgpn1 @TEXT("VDgpn1",key="name",size=1.3,halign="start") => @PLACE(-12,-228);
// #VDgpn1 @TEXT("",key="value",size=0.9,halign="start") => @PLACE(-12,-235);
// #VDgpn1 @TEXT("",key="model");
// #VDgpn2 @SET-SYMBOL $VOLTAGE_SOURCE;
// #VDgpn2 @PLACE(-15,-264) => @ORIENT("R0");
// #VDgpn2 @TEXT("VDgpn2",key="name",size=1.3,halign="start") => @PLACE(-12,-261);
// #VDgpn2 @TEXT("",key="value",size=0.9,halign="start") => @PLACE(-12,-268);
// #VDgpn2 @TEXT("",key="model");
// #VDgpn3 @SET-SYMBOL $VOLTAGE_SOURCE;
// #VDgpn3 @PLACE(-15,-297) => @ORIENT("R0");
// #VDgpn3 @TEXT("VDgpn3",key="name",size=1.3,halign="start") => @PLACE(-12,-294);
// #VDgpn3 @TEXT("",key="value",size=0.9,halign="start") => @PLACE(-12,-301);
// #VDgpn3 @TEXT("",key="model");
// #VDgpn4 @SET-SYMBOL $VOLTAGE_SOURCE;
// #VDgpn4 @PLACE(-15,-330) => @ORIENT("R0");
// #VDgpn4 @TEXT("VDgpn4",key="name",size=1.3,halign="start") => @PLACE(-12,-327);
// #VDgpn4 @TEXT("",key="value",size=0.9,halign="start") => @PLACE(-12,-334);
// #VDgpn4 @TEXT("",key="model");
// #VDgpn5 @SET-SYMBOL $VOLTAGE_SOURCE;
// #VDgpn5 @PLACE(-15,-363) => @ORIENT("R0");
// #VDgpn5 @TEXT("VDgpn5",key="name",size=1.3,halign="start") => @PLACE(-12,-360);
// #VDgpn5 @TEXT("",key="value",size=0.9,halign="start") => @PLACE(-12,-367);
// #VDgpn5 @TEXT("",key="model");
// #VDgpn6 @SET-SYMBOL $VOLTAGE_SOURCE;
// #VDgpn6 @PLACE(40,0) => @ORIENT("R0");
// #VDgpn6 @TEXT("VDgpn6",key="name",size=1.3,halign="start") => @PLACE(43,3);
// #VDgpn6 @TEXT("",key="value",size=0.9,halign="start") => @PLACE(43,-4);
// #VDgpn6 @TEXT("",key="model");
// #VDgpn7 @SET-SYMBOL $VOLTAGE_SOURCE;
// #VDgpn7 @PLACE(40,-33) => @ORIENT("R0");
// #VDgpn7 @TEXT("VDgpn7",key="name",size=1.3,halign="start") => @PLACE(43,-30);
// #VDgpn7 @TEXT("",key="value",size=0.9,halign="start") => @PLACE(43,-37);
// #VDgpn7 @TEXT("",key="model");
// #VDgpp0 @SET-SYMBOL $VOLTAGE_SOURCE;
// #VDgpp0 @PLACE(40,-66) => @ORIENT("R0");
// #VDgpp0 @TEXT("VDgpp0",key="name",size=1.3,halign="start") => @PLACE(43,-63);
// #VDgpp0 @TEXT("",key="value",size=0.9,halign="start") => @PLACE(43,-70);
// #VDgpp0 @TEXT("",key="model");
// #VDgpp1 @SET-SYMBOL $VOLTAGE_SOURCE;
// #VDgpp1 @PLACE(40,-99) => @ORIENT("R0");
// #VDgpp1 @TEXT("VDgpp1",key="name",size=1.3,halign="start") => @PLACE(43,-96);
// #VDgpp1 @TEXT("",key="value",size=0.9,halign="start") => @PLACE(43,-103);
// #VDgpp1 @TEXT("",key="model");
// #VDgpp2 @SET-SYMBOL $VOLTAGE_SOURCE;
// #VDgpp2 @PLACE(40,-132) => @ORIENT("R0");
// #VDgpp2 @TEXT("VDgpp2",key="name",size=1.3,halign="start") => @PLACE(43,-129);
// #VDgpp2 @TEXT("",key="value",size=0.9,halign="start") => @PLACE(43,-136);
// #VDgpp2 @TEXT("",key="model");
// #VDgpp3 @SET-SYMBOL $VOLTAGE_SOURCE;
// #VDgpp3 @PLACE(40,-165) => @ORIENT("R0");
// #VDgpp3 @TEXT("VDgpp3",key="name",size=1.3,halign="start") => @PLACE(43,-162);
// #VDgpp3 @TEXT("",key="value",size=0.9,halign="start") => @PLACE(43,-169);
// #VDgpp3 @TEXT("",key="model");
// #VDgpp4 @SET-SYMBOL $VOLTAGE_SOURCE;
// #VDgpp4 @PLACE(40,-198) => @ORIENT("R0");
// #VDgpp4 @TEXT("VDgpp4",key="name",size=1.3,halign="start") => @PLACE(43,-195);
// #VDgpp4 @TEXT("",key="value",size=0.9,halign="start") => @PLACE(43,-202);
// #VDgpp4 @TEXT("",key="model");
// #VDgpp5 @SET-SYMBOL $VOLTAGE_SOURCE;
// #VDgpp5 @PLACE(40,-231) => @ORIENT("R0");
// #VDgpp5 @TEXT("VDgpp5",key="name",size=1.3,halign="start") => @PLACE(43,-228);
// #VDgpp5 @TEXT("",key="value",size=0.9,halign="start") => @PLACE(43,-235);
// #VDgpp5 @TEXT("",key="model");
// #VDgpp6 @SET-SYMBOL $VOLTAGE_SOURCE;
// #VDgpp6 @PLACE(40,-264) => @ORIENT("R0");
// #VDgpp6 @TEXT("VDgpp6",key="name",size=1.3,halign="start") => @PLACE(43,-261);
// #VDgpp6 @TEXT("",key="value",size=0.9,halign="start") => @PLACE(43,-268);
// #VDgpp6 @TEXT("",key="model");
// #VDgpp7 @SET-SYMBOL $VOLTAGE_SOURCE;
// #VDgpp7 @PLACE(40,-297) => @ORIENT("R0");
// #VDgpp7 @TEXT("VDgpp7",key="name",size=1.3,halign="start") => @PLACE(43,-294);
// #VDgpp7 @TEXT("",key="value",size=0.9,halign="start") => @PLACE(43,-301);
// #VDgpp7 @TEXT("",key="model");
// #VDRN @SET-SYMBOL $VOLTAGE_SOURCE;
// #VDRN @PLACE(40,-330) => @ORIENT("R0");
// #VDRN @TEXT("VDRN",key="name",size=1.3,halign="start") => @PLACE(43,-327);
// #VDRN @TEXT("",key="value",size=0.9,halign="start") => @PLACE(43,-334);
// #VDRN @TEXT("",key="model");
// #VDRP @SET-SYMBOL $VOLTAGE_SOURCE;
// #VDRP @PLACE(40,-363) => @ORIENT("R0");
// #VDRP @TEXT("VDRP",key="name",size=1.3,halign="start") => @PLACE(43,-360);
// #VDRP @TEXT("",key="value",size=0.9,halign="start") => @PLACE(43,-367);
// #VDRP @TEXT("",key="model");
// #XDPN @SET-SYMBOL $S_b_tb_switch;
// #XDPN @PLACE(0,0) => @ORIENT("R0");
// #XDPP @SET-SYMBOL $S_b_tb_switch;
// #XDPP @PLACE(0,-33) => @ORIENT("R0");
// #XDAC @SET-SYMBOL $S_sar8j_r1_cdac;
// #XDAC @PLACE(0,-66) => @ORIENT("R0");
// #RDRN @SET-SYMBOL $RESISTOR;
// #RDRN @PLACE(90,0) => @ORIENT("R0");
// #RDRN @TEXT("RDRN",key="name",size=1.3,halign="start") => @PLACE(93,3);
// #RDRN @TEXT("r=50",key="value",size=0.9,halign="start") => @PLACE(93,-4);
// #RDRN @TEXT("",key="model");
// #RDRP @SET-SYMBOL $RESISTOR;
// #RDRP @PLACE(90,-33) => @ORIENT("R0");
// #RDRP @TEXT("RDRP",key="name",size=1.3,halign="start") => @PLACE(93,-30);
// #RDRP @TEXT("r=50",key="value",size=0.9,halign="start") => @PLACE(93,-37);
// #RDRP @TEXT("",key="model");
// #CDRN @SET-SYMBOL $CAPACITOR;
// #CDRN @PLACE(90,-66) => @ORIENT("R0");
// #CDRN @TEXT("CDRN",key="name",size=1.3,halign="start") => @PLACE(93,-63);
// #CDRN @TEXT("c=4p",key="value",size=0.9,halign="start") => @PLACE(93,-70);
// #CDRN @TEXT("",key="model");
// #CDRP @SET-SYMBOL $CAPACITOR;
// #CDRP @PLACE(90,-99) => @ORIENT("R0");
// #CDRP @TEXT("CDRP",key="name",size=1.3,halign="start") => @PLACE(93,-96);
// #CDRP @TEXT("c=4p",key="value",size=0.9,halign="start") => @PLACE(93,-103);
// #CDRP @TEXT("",key="model");
// &"d_n" @WIRE(mode="straight",linecolor="#30485d",linewidth=0.16) {#XDPN:1 (-10.5,3.3) (-10.5,-58) #XDAC:33};
// &"d_p" @WIRE(mode="straight",linecolor="#30485d",linewidth=0.16) {#XDPP:1 (-6.5,-29.7) (-6.5,-58) #XDAC:34};
// (-89,30) @TEXT("tb_cdac / source-derived connections",size=1.4,halign="start",textcolor="#223d52");
// &"d_pre" @WIRE(mode="straight",linecolor="#30485d",linewidth=0.16) {#VDPRE:1 (-70,5)};
// (-70,5.4) @TEXT("d_pre",size=1.1,halign="middle",valign="bottom");
// &"0" @WIRE(mode="straight",linecolor="#30485d",linewidth=0.16) {#VDPRE:2 (-70,-5)};
// (-70,-5.4) @TEXT("0",size=1.1,halign="middle",valign="top");
// &"d_cm" @WIRE(mode="straight",linecolor="#30485d",linewidth=0.16) {#VDCM:1 (-70,-28)};
// (-70,-27.6) @TEXT("d_cm",size=1.1,halign="middle",valign="bottom");
// &"0" @WIRE(mode="straight",linecolor="#30485d",linewidth=0.16) {#VDCM:2 (-70,-38)};
// (-70,-38.4) @TEXT("0",size=1.1,halign="middle",valign="top");
// &"d_cm" @WIRE(mode="straight",linecolor="#30485d",linewidth=0.16) {#XDPN:2 (-16,0)};
// (-16.4,0) @TEXT("d_cm",size=1.1,halign="end",valign="middle");
// &"d_pre" @WIRE(mode="straight",linecolor="#30485d",linewidth=0.16) {#XDPN:3 (-16,-3.3)};
// (-16.4,-3.3) @TEXT("d_pre",size=1.1,halign="end",valign="middle");
// &"VDD!" @WIRE(mode="straight",linecolor="#30485d",linewidth=0.16) {#XDPN:4 (0,11.6)};
// (0,12) @TEXT("VDD!",size=1.1,halign="middle",valign="bottom");
// &"0" @WIRE(mode="straight",linecolor="#30485d",linewidth=0.16) {#XDPN:5 (0,-11.6)};
// (0,-12) @TEXT("0",size=1.1,halign="middle",valign="top");
// &"d_cm" @WIRE(mode="straight",linecolor="#30485d",linewidth=0.16) {#XDPP:2 (-16,-33)};
// (-16.4,-33) @TEXT("d_cm",size=1.1,halign="end",valign="middle");
// &"d_pre" @WIRE(mode="straight",linecolor="#30485d",linewidth=0.16) {#XDPP:3 (-16,-36.3)};
// (-16.4,-36.3) @TEXT("d_pre",size=1.1,halign="end",valign="middle");
// &"VDD!" @WIRE(mode="straight",linecolor="#30485d",linewidth=0.16) {#XDPP:4 (0,-21.4)};
// (0,-21) @TEXT("VDD!",size=1.1,halign="middle",valign="bottom");
// &"0" @WIRE(mode="straight",linecolor="#30485d",linewidth=0.16) {#XDPP:5 (0,-44.6)};
// (0,-45) @TEXT("0",size=1.1,halign="middle",valign="top");
// &"d_gnn0" @WIRE(mode="straight",linecolor="#30485d",linewidth=0.16) {#VDgnn0:1 (-70,-61)};
// (-70,-60.6) @TEXT("d_gnn0",size=1.1,halign="middle",valign="bottom");
// &"0" @WIRE(mode="straight",linecolor="#30485d",linewidth=0.16) {#VDgnn0:2 (-70,-71)};
// (-70,-71.4) @TEXT("0",size=1.1,halign="middle",valign="top");
// &"d_gnn1" @WIRE(mode="straight",linecolor="#30485d",linewidth=0.16) {#VDgnn1:1 (-70,-94)};
// (-70,-93.6) @TEXT("d_gnn1",size=1.1,halign="middle",valign="bottom");
// &"0" @WIRE(mode="straight",linecolor="#30485d",linewidth=0.16) {#VDgnn1:2 (-70,-104)};
// (-70,-104.4) @TEXT("0",size=1.1,halign="middle",valign="top");
// &"d_gnn2" @WIRE(mode="straight",linecolor="#30485d",linewidth=0.16) {#VDgnn2:1 (-70,-127)};
// (-70,-126.6) @TEXT("d_gnn2",size=1.1,halign="middle",valign="bottom");
// &"0" @WIRE(mode="straight",linecolor="#30485d",linewidth=0.16) {#VDgnn2:2 (-70,-137)};
// (-70,-137.4) @TEXT("0",size=1.1,halign="middle",valign="top");
// &"d_gnn3" @WIRE(mode="straight",linecolor="#30485d",linewidth=0.16) {#VDgnn3:1 (-70,-160)};
// (-70,-159.6) @TEXT("d_gnn3",size=1.1,halign="middle",valign="bottom");
// &"0" @WIRE(mode="straight",linecolor="#30485d",linewidth=0.16) {#VDgnn3:2 (-70,-170)};
// (-70,-170.4) @TEXT("0",size=1.1,halign="middle",valign="top");
// &"d_gnn4" @WIRE(mode="straight",linecolor="#30485d",linewidth=0.16) {#VDgnn4:1 (-70,-193)};
// (-70,-192.6) @TEXT("d_gnn4",size=1.1,halign="middle",valign="bottom");
// &"0" @WIRE(mode="straight",linecolor="#30485d",linewidth=0.16) {#VDgnn4:2 (-70,-203)};
// (-70,-203.4) @TEXT("0",size=1.1,halign="middle",valign="top");
// &"d_gnn5" @WIRE(mode="straight",linecolor="#30485d",linewidth=0.16) {#VDgnn5:1 (-70,-226)};
// (-70,-225.6) @TEXT("d_gnn5",size=1.1,halign="middle",valign="bottom");
// &"0" @WIRE(mode="straight",linecolor="#30485d",linewidth=0.16) {#VDgnn5:2 (-70,-236)};
// (-70,-236.4) @TEXT("0",size=1.1,halign="middle",valign="top");
// &"d_gnn6" @WIRE(mode="straight",linecolor="#30485d",linewidth=0.16) {#VDgnn6:1 (-70,-259)};
// (-70,-258.6) @TEXT("d_gnn6",size=1.1,halign="middle",valign="bottom");
// &"0" @WIRE(mode="straight",linecolor="#30485d",linewidth=0.16) {#VDgnn6:2 (-70,-269)};
// (-70,-269.4) @TEXT("0",size=1.1,halign="middle",valign="top");
// &"d_gnn7" @WIRE(mode="straight",linecolor="#30485d",linewidth=0.16) {#VDgnn7:1 (-70,-292)};
// (-70,-291.6) @TEXT("d_gnn7",size=1.1,halign="middle",valign="bottom");
// &"0" @WIRE(mode="straight",linecolor="#30485d",linewidth=0.16) {#VDgnn7:2 (-70,-302)};
// (-70,-302.4) @TEXT("0",size=1.1,halign="middle",valign="top");
// &"d_gnp0" @WIRE(mode="straight",linecolor="#30485d",linewidth=0.16) {#VDgnp0:1 (-70,-325)};
// (-70,-324.6) @TEXT("d_gnp0",size=1.1,halign="middle",valign="bottom");
// &"0" @WIRE(mode="straight",linecolor="#30485d",linewidth=0.16) {#VDgnp0:2 (-70,-335)};
// (-70,-335.4) @TEXT("0",size=1.1,halign="middle",valign="top");
// &"d_gnp1" @WIRE(mode="straight",linecolor="#30485d",linewidth=0.16) {#VDgnp1:1 (-70,-358)};
// (-70,-357.6) @TEXT("d_gnp1",size=1.1,halign="middle",valign="bottom");
// &"0" @WIRE(mode="straight",linecolor="#30485d",linewidth=0.16) {#VDgnp1:2 (-70,-368)};
// (-70,-368.4) @TEXT("0",size=1.1,halign="middle",valign="top");
// &"d_gnp2" @WIRE(mode="straight",linecolor="#30485d",linewidth=0.16) {#VDgnp2:1 (-15,5)};
// (-15,5.4) @TEXT("d_gnp2",size=1.1,halign="middle",valign="bottom");
// &"0" @WIRE(mode="straight",linecolor="#30485d",linewidth=0.16) {#VDgnp2:2 (-15,-5)};
// (-15,-5.4) @TEXT("0",size=1.1,halign="middle",valign="top");
// &"d_gnp3" @WIRE(mode="straight",linecolor="#30485d",linewidth=0.16) {#VDgnp3:1 (-15,-28)};
// (-15,-27.6) @TEXT("d_gnp3",size=1.1,halign="middle",valign="bottom");
// &"0" @WIRE(mode="straight",linecolor="#30485d",linewidth=0.16) {#VDgnp3:2 (-15,-38)};
// (-15,-38.4) @TEXT("0",size=1.1,halign="middle",valign="top");
// &"d_gnp4" @WIRE(mode="straight",linecolor="#30485d",linewidth=0.16) {#VDgnp4:1 (-15,-61)};
// (-15,-60.6) @TEXT("d_gnp4",size=1.1,halign="middle",valign="bottom");
// &"0" @WIRE(mode="straight",linecolor="#30485d",linewidth=0.16) {#VDgnp4:2 (-15,-71)};
// (-15,-71.4) @TEXT("0",size=1.1,halign="middle",valign="top");
// &"d_gnp5" @WIRE(mode="straight",linecolor="#30485d",linewidth=0.16) {#VDgnp5:1 (-15,-94)};
// (-15,-93.6) @TEXT("d_gnp5",size=1.1,halign="middle",valign="bottom");
// &"0" @WIRE(mode="straight",linecolor="#30485d",linewidth=0.16) {#VDgnp5:2 (-15,-104)};
// (-15,-104.4) @TEXT("0",size=1.1,halign="middle",valign="top");
// &"d_gnp6" @WIRE(mode="straight",linecolor="#30485d",linewidth=0.16) {#VDgnp6:1 (-15,-127)};
// (-15,-126.6) @TEXT("d_gnp6",size=1.1,halign="middle",valign="bottom");
// &"0" @WIRE(mode="straight",linecolor="#30485d",linewidth=0.16) {#VDgnp6:2 (-15,-137)};
// (-15,-137.4) @TEXT("0",size=1.1,halign="middle",valign="top");
// &"d_gnp7" @WIRE(mode="straight",linecolor="#30485d",linewidth=0.16) {#VDgnp7:1 (-15,-160)};
// (-15,-159.6) @TEXT("d_gnp7",size=1.1,halign="middle",valign="bottom");
// &"0" @WIRE(mode="straight",linecolor="#30485d",linewidth=0.16) {#VDgnp7:2 (-15,-170)};
// (-15,-170.4) @TEXT("0",size=1.1,halign="middle",valign="top");
// &"d_gpn0" @WIRE(mode="straight",linecolor="#30485d",linewidth=0.16) {#VDgpn0:1 (-15,-193)};
// (-15,-192.6) @TEXT("d_gpn0",size=1.1,halign="middle",valign="bottom");
// &"0" @WIRE(mode="straight",linecolor="#30485d",linewidth=0.16) {#VDgpn0:2 (-15,-203)};
// (-15,-203.4) @TEXT("0",size=1.1,halign="middle",valign="top");
// &"d_gpn1" @WIRE(mode="straight",linecolor="#30485d",linewidth=0.16) {#VDgpn1:1 (-15,-226)};
// (-15,-225.6) @TEXT("d_gpn1",size=1.1,halign="middle",valign="bottom");
// &"0" @WIRE(mode="straight",linecolor="#30485d",linewidth=0.16) {#VDgpn1:2 (-15,-236)};
// (-15,-236.4) @TEXT("0",size=1.1,halign="middle",valign="top");
// &"d_gpn2" @WIRE(mode="straight",linecolor="#30485d",linewidth=0.16) {#VDgpn2:1 (-15,-259)};
// (-15,-258.6) @TEXT("d_gpn2",size=1.1,halign="middle",valign="bottom");
// &"0" @WIRE(mode="straight",linecolor="#30485d",linewidth=0.16) {#VDgpn2:2 (-15,-269)};
// (-15,-269.4) @TEXT("0",size=1.1,halign="middle",valign="top");
// &"d_gpn3" @WIRE(mode="straight",linecolor="#30485d",linewidth=0.16) {#VDgpn3:1 (-15,-292)};
// (-15,-291.6) @TEXT("d_gpn3",size=1.1,halign="middle",valign="bottom");
// &"0" @WIRE(mode="straight",linecolor="#30485d",linewidth=0.16) {#VDgpn3:2 (-15,-302)};
// (-15,-302.4) @TEXT("0",size=1.1,halign="middle",valign="top");
// &"d_gpn4" @WIRE(mode="straight",linecolor="#30485d",linewidth=0.16) {#VDgpn4:1 (-15,-325)};
// (-15,-324.6) @TEXT("d_gpn4",size=1.1,halign="middle",valign="bottom");
// &"0" @WIRE(mode="straight",linecolor="#30485d",linewidth=0.16) {#VDgpn4:2 (-15,-335)};
// (-15,-335.4) @TEXT("0",size=1.1,halign="middle",valign="top");
// &"d_gpn5" @WIRE(mode="straight",linecolor="#30485d",linewidth=0.16) {#VDgpn5:1 (-15,-358)};
// (-15,-357.6) @TEXT("d_gpn5",size=1.1,halign="middle",valign="bottom");
// &"0" @WIRE(mode="straight",linecolor="#30485d",linewidth=0.16) {#VDgpn5:2 (-15,-368)};
// (-15,-368.4) @TEXT("0",size=1.1,halign="middle",valign="top");
// &"d_gpn6" @WIRE(mode="straight",linecolor="#30485d",linewidth=0.16) {#VDgpn6:1 (40,5)};
// (40,5.4) @TEXT("d_gpn6",size=1.1,halign="middle",valign="bottom");
// &"0" @WIRE(mode="straight",linecolor="#30485d",linewidth=0.16) {#VDgpn6:2 (40,-5)};
// (40,-5.4) @TEXT("0",size=1.1,halign="middle",valign="top");
// &"d_gpn7" @WIRE(mode="straight",linecolor="#30485d",linewidth=0.16) {#VDgpn7:1 (40,-28)};
// (40,-27.6) @TEXT("d_gpn7",size=1.1,halign="middle",valign="bottom");
// &"0" @WIRE(mode="straight",linecolor="#30485d",linewidth=0.16) {#VDgpn7:2 (40,-38)};
// (40,-38.4) @TEXT("0",size=1.1,halign="middle",valign="top");
// &"d_gpp0" @WIRE(mode="straight",linecolor="#30485d",linewidth=0.16) {#VDgpp0:1 (40,-61)};
// (40,-60.6) @TEXT("d_gpp0",size=1.1,halign="middle",valign="bottom");
// &"0" @WIRE(mode="straight",linecolor="#30485d",linewidth=0.16) {#VDgpp0:2 (40,-71)};
// (40,-71.4) @TEXT("0",size=1.1,halign="middle",valign="top");
// &"d_gpp1" @WIRE(mode="straight",linecolor="#30485d",linewidth=0.16) {#VDgpp1:1 (40,-94)};
// (40,-93.6) @TEXT("d_gpp1",size=1.1,halign="middle",valign="bottom");
// &"0" @WIRE(mode="straight",linecolor="#30485d",linewidth=0.16) {#VDgpp1:2 (40,-104)};
// (40,-104.4) @TEXT("0",size=1.1,halign="middle",valign="top");
// &"d_gpp2" @WIRE(mode="straight",linecolor="#30485d",linewidth=0.16) {#VDgpp2:1 (40,-127)};
// (40,-126.6) @TEXT("d_gpp2",size=1.1,halign="middle",valign="bottom");
// &"0" @WIRE(mode="straight",linecolor="#30485d",linewidth=0.16) {#VDgpp2:2 (40,-137)};
// (40,-137.4) @TEXT("0",size=1.1,halign="middle",valign="top");
// &"d_gpp3" @WIRE(mode="straight",linecolor="#30485d",linewidth=0.16) {#VDgpp3:1 (40,-160)};
// (40,-159.6) @TEXT("d_gpp3",size=1.1,halign="middle",valign="bottom");
// &"0" @WIRE(mode="straight",linecolor="#30485d",linewidth=0.16) {#VDgpp3:2 (40,-170)};
// (40,-170.4) @TEXT("0",size=1.1,halign="middle",valign="top");
// &"d_gpp4" @WIRE(mode="straight",linecolor="#30485d",linewidth=0.16) {#VDgpp4:1 (40,-193)};
// (40,-192.6) @TEXT("d_gpp4",size=1.1,halign="middle",valign="bottom");
// &"0" @WIRE(mode="straight",linecolor="#30485d",linewidth=0.16) {#VDgpp4:2 (40,-203)};
// (40,-203.4) @TEXT("0",size=1.1,halign="middle",valign="top");
// &"d_gpp5" @WIRE(mode="straight",linecolor="#30485d",linewidth=0.16) {#VDgpp5:1 (40,-226)};
// (40,-225.6) @TEXT("d_gpp5",size=1.1,halign="middle",valign="bottom");
// &"0" @WIRE(mode="straight",linecolor="#30485d",linewidth=0.16) {#VDgpp5:2 (40,-236)};
// (40,-236.4) @TEXT("0",size=1.1,halign="middle",valign="top");
// &"d_gpp6" @WIRE(mode="straight",linecolor="#30485d",linewidth=0.16) {#VDgpp6:1 (40,-259)};
// (40,-258.6) @TEXT("d_gpp6",size=1.1,halign="middle",valign="bottom");
// &"0" @WIRE(mode="straight",linecolor="#30485d",linewidth=0.16) {#VDgpp6:2 (40,-269)};
// (40,-269.4) @TEXT("0",size=1.1,halign="middle",valign="top");
// &"d_gpp7" @WIRE(mode="straight",linecolor="#30485d",linewidth=0.16) {#VDgpp7:1 (40,-292)};
// (40,-291.6) @TEXT("d_gpp7",size=1.1,halign="middle",valign="bottom");
// &"0" @WIRE(mode="straight",linecolor="#30485d",linewidth=0.16) {#VDgpp7:2 (40,-302)};
// (40,-302.4) @TEXT("0",size=1.1,halign="middle",valign="top");
// {&"d_gnn0" &"d_gnn1" &"d_gnn2" &"d_gnn3" &"d_gnn4" &"d_gnn5" &"d_gnn6" &"d_gnn7"} @WIRE(mode="straight",linewidth=0.3) {#XDAC:1 (-16,-77)};
// (-16,-77.4) @TEXT("d_gnn[7:0]",size=1.1,halign="middle",valign="top");
// {&"d_gnp0" &"d_gnp1" &"d_gnp2" &"d_gnp3" &"d_gnp4" &"d_gnp5" &"d_gnp6" &"d_gnp7"} @WIRE(mode="straight",linewidth=0.3) {#XDAC:9 (-8,-77)};
// (-8,-77.4) @TEXT("d_gnp[7:0]",size=1.1,halign="middle",valign="top");
// {&"d_gpn0" &"d_gpn1" &"d_gpn2" &"d_gpn3" &"d_gpn4" &"d_gpn5" &"d_gpn6" &"d_gpn7"} @WIRE(mode="straight",linewidth=0.3) {#XDAC:17 (0,-77)};
// (0,-77.4) @TEXT("d_gpn[7:0]",size=1.1,halign="middle",valign="top");
// {&"d_gpp0" &"d_gpp1" &"d_gpp2" &"d_gpp3" &"d_gpp4" &"d_gpp5" &"d_gpp6" &"d_gpp7"} @WIRE(mode="straight",linewidth=0.3) {#XDAC:25 (8,-77)};
// (8,-77.4) @TEXT("d_gpp[7:0]",size=1.1,halign="middle",valign="top");
// &"VDD!" @WIRE(mode="straight",linecolor="#30485d",linewidth=0.16) {#XDAC:35 (8,-55)};
// (8,-54.6) @TEXT("VDD!",size=1.1,halign="middle",valign="bottom");
// &"d_rn" @WIRE(mode="straight",linecolor="#30485d",linewidth=0.16) {#XDAC:36 (-23,-64.35)};
// (-23.4,-64.35) @TEXT("d_rn",size=1.1,halign="end",valign="middle");
// &"d_rp" @WIRE(mode="straight",linecolor="#30485d",linewidth=0.16) {#XDAC:37 (-23,-67.65)};
// (-23.4,-67.65) @TEXT("d_rp",size=1.1,halign="end",valign="middle");
// &"0" @WIRE(mode="straight",linecolor="#30485d",linewidth=0.16) {#XDAC:38 (16,-77)};
// (16,-77.4) @TEXT("0",size=1.1,halign="middle",valign="top");
// &"d_rns" @WIRE(mode="straight",linecolor="#30485d",linewidth=0.16) {#VDRN:1 (40,-325)};
// (40,-324.6) @TEXT("d_rns",size=1.1,halign="middle",valign="bottom");
// &"0" @WIRE(mode="straight",linecolor="#30485d",linewidth=0.16) {#VDRN:2 (40,-335)};
// (40,-335.4) @TEXT("0",size=1.1,halign="middle",valign="top");
// &"d_rps" @WIRE(mode="straight",linecolor="#30485d",linewidth=0.16) {#VDRP:1 (40,-358)};
// (40,-357.6) @TEXT("d_rps",size=1.1,halign="middle",valign="bottom");
// &"0" @WIRE(mode="straight",linecolor="#30485d",linewidth=0.16) {#VDRP:2 (40,-368)};
// (40,-368.4) @TEXT("0",size=1.1,halign="middle",valign="top");
// &"d_rns" @WIRE(mode="straight",linecolor="#30485d",linewidth=0.16) {#RDRN:1 (90,5)};
// (90,5.4) @TEXT("d_rns",size=1.1,halign="middle",valign="bottom");
// &"d_rn" @WIRE(mode="straight",linecolor="#30485d",linewidth=0.16) {#RDRN:2 (90,-5)};
// (90,-5.4) @TEXT("d_rn",size=1.1,halign="middle",valign="top");
// &"d_rps" @WIRE(mode="straight",linecolor="#30485d",linewidth=0.16) {#RDRP:1 (90,-28)};
// (90,-27.6) @TEXT("d_rps",size=1.1,halign="middle",valign="bottom");
// &"d_rp" @WIRE(mode="straight",linecolor="#30485d",linewidth=0.16) {#RDRP:2 (90,-38)};
// (90,-38.4) @TEXT("d_rp",size=1.1,halign="middle",valign="top");
// &"d_rn" @WIRE(mode="straight",linecolor="#30485d",linewidth=0.16) {#CDRN:1 (90,-61)};
// (90,-60.6) @TEXT("d_rn",size=1.1,halign="middle",valign="bottom");
// &"0" @WIRE(mode="straight",linecolor="#30485d",linewidth=0.16) {#CDRN:2 (90,-71)};
// (90,-71.4) @TEXT("0",size=1.1,halign="middle",valign="top");
// &"d_rp" @WIRE(mode="straight",linecolor="#30485d",linewidth=0.16) {#CDRP:1 (90,-94)};
// (90,-93.6) @TEXT("d_rp",size=1.1,halign="middle",valign="bottom");
// &"0" @WIRE(mode="straight",linecolor="#30485d",linewidth=0.16) {#CDRP:2 (90,-104)};
// (90,-104.4) @TEXT("0",size=1.1,halign="middle",valign="top");
// }
// END SARADC RNL
ends tb_cdac

subckt tb_comparator
// Comparator delay/reset at stated differential inputs; native MOM plus receiver gate loads.
VCCLOCK (c_clock 0) vsource type=pulse val0=0 val1=0.9 delay=5n rise=100p fall=100p width=4.9n period=10n
VCN (c_n 0) vsource dc=0.45
VCP (c_p 0) vsource type=pwl wave=[0 0.55000000000000004 9.900000000000001e-09 0.55000000000000004 1e-08 0.34999999999999998 1.99e-08 0.34999999999999998 2e-08 0.47999999999999998 2.9900000000000003e-08 0.47999999999999998 3.0000000000000004e-08 0.42000000000000004 3.99e-08 0.42000000000000004 4.0000000000000001e-08 0.45351562500000003 4.9899999999999997e-08 0.45351562500000003 4.9999999999999998e-08 0.44648437499999999 5.9900000000000014e-08 0.44648437499999999 6.0000000000000008e-08 0.45100000000000001 6.990000000000001e-08 0.45100000000000001 7.0000000000000005e-08 0.44900000000000001 7.9900000000000007e-08 0.44900000000000001 8.0000000000000002e-08 0.4501 8.9900000000000004e-08 0.4501 8.9999999999999999e-08 0.44990000000000002]
XCOMP (c_clock c_outn c_outp VDD! c_n c_p 0) sar_strongarm_t28
CCN (c_outn 0) cfmom_2t nr=8 lr=2.5u w=50n s=50n stm=1 spm=3 multi=2 mismatchflag=1
CCP (c_outp 0) cfmom_2t nr=8 lr=2.5u w=50n s=50n stm=1 spm=3 multi=2 mismatchflag=1
XCRN (c_outn c_unusedn VDD! 0) INVD1BWP12T30P140
XCRP (c_outp c_unusedp VDD! 0) INVD1BWP12T30P140
// Independent floating-input kickback fixture, same nominal CDAC-side MOM geometry.
VKINIT (k_init 0) vsource type=pwl wave=[0 0.9 10n 0.9 10.1n 0]
VKP (k_sp 0) vsource dc=0.4505
VKN (k_sn 0) vsource dc=0.4495
XKP (k_p k_sp k_init VDD! 0) b_tb_switch
XKN (k_n k_sn k_init VDD! 0) b_tb_switch
CKP (k_p 0) cfmom_2t nr=8 lr=2u w=50n s=50n stm=1 spm=3 multi=256 mismatchflag=1
CKN (k_n 0) cfmom_2t nr=8 lr=2u w=50n s=50n stm=1 spm=3 multi=256 mismatchflag=1
VKC (k_clock 0) vsource type=pulse val0=0 val1=0.9 delay=15n rise=100p fall=100p width=4.9n period=1000n
XKCOMP (k_clock k_outn k_outp VDD! k_n k_p 0) sar_strongarm_t28
CKON (k_outn 0) capacitor c=10f
CKOP (k_outp 0) capacitor c=10f

// BEGIN SARADC RNL
// @RNL(author="saradc topology") {
// #VCCLOCK @SET-SYMBOL $VOLTAGE_SOURCE;
// #VCCLOCK @PLACE(-70,0) => @ORIENT("R0");
// #VCCLOCK @TEXT("VCCLOCK",key="name",size=1.3,halign="start") => @PLACE(-67,3);
// #VCCLOCK @TEXT("",key="value",size=0.9,halign="start") => @PLACE(-67,-4);
// #VCCLOCK @TEXT("",key="model");
// #VCN @SET-SYMBOL $VOLTAGE_SOURCE;
// #VCN @PLACE(-70,-33) => @ORIENT("R0");
// #VCN @TEXT("VCN",key="name",size=1.3,halign="start") => @PLACE(-67,-30);
// #VCN @TEXT("",key="value",size=0.9,halign="start") => @PLACE(-67,-37);
// #VCN @TEXT("",key="model");
// #VCP @SET-SYMBOL $VOLTAGE_SOURCE;
// #VCP @PLACE(-70,-66) => @ORIENT("R0");
// #VCP @TEXT("VCP",key="name",size=1.3,halign="start") => @PLACE(-67,-63);
// #VCP @TEXT("",key="value",size=0.9,halign="start") => @PLACE(-67,-70);
// #VCP @TEXT("",key="model");
// #VKINIT @SET-SYMBOL $VOLTAGE_SOURCE;
// #VKINIT @PLACE(-70,-99) => @ORIENT("R0");
// #VKINIT @TEXT("VKINIT",key="name",size=1.3,halign="start") => @PLACE(-67,-96);
// #VKINIT @TEXT("",key="value",size=0.9,halign="start") => @PLACE(-67,-103);
// #VKINIT @TEXT("",key="model");
// #VKP @SET-SYMBOL $VOLTAGE_SOURCE;
// #VKP @PLACE(-70,-132) => @ORIENT("R0");
// #VKP @TEXT("VKP",key="name",size=1.3,halign="start") => @PLACE(-67,-129);
// #VKP @TEXT("",key="value",size=0.9,halign="start") => @PLACE(-67,-136);
// #VKP @TEXT("",key="model");
// #VKN @SET-SYMBOL $VOLTAGE_SOURCE;
// #VKN @PLACE(-70,-165) => @ORIENT("R0");
// #VKN @TEXT("VKN",key="name",size=1.3,halign="start") => @PLACE(-67,-162);
// #VKN @TEXT("",key="value",size=0.9,halign="start") => @PLACE(-67,-169);
// #VKN @TEXT("",key="model");
// #VKC @SET-SYMBOL $VOLTAGE_SOURCE;
// #VKC @PLACE(-70,-198) => @ORIENT("R0");
// #VKC @TEXT("VKC",key="name",size=1.3,halign="start") => @PLACE(-67,-195);
// #VKC @TEXT("",key="value",size=0.9,halign="start") => @PLACE(-67,-202);
// #VKC @TEXT("",key="model");
// #XCOMP @SET-SYMBOL $S_sar_strongarm_t28;
// #XCOMP @PLACE(0,0) => @ORIENT("R0");
// #XCRN @SET-SYMBOL $S_INVD1BWP12T30P140;
// #XCRN @PLACE(0,-33) => @ORIENT("R0");
// #XCRP @SET-SYMBOL $S_INVD1BWP12T30P140;
// #XCRP @PLACE(0,-66) => @ORIENT("R0");
// #XKP @SET-SYMBOL $S_b_tb_switch;
// #XKP @PLACE(0,-99) => @ORIENT("R0");
// #XKN @SET-SYMBOL $S_b_tb_switch;
// #XKN @PLACE(0,-132) => @ORIENT("R0");
// #XKCOMP @SET-SYMBOL $S_sar_strongarm_t28;
// #XKCOMP @PLACE(0,-165) => @ORIENT("R0");
// #CCN @SET-SYMBOL $CAPACITOR;
// #CCN @PLACE(90,0) => @ORIENT("R0");
// #CCN @TEXT("CCN",key="name",size=1.3,halign="start") => @PLACE(93,3);
// #CCN @TEXT("nr=8 lr=2.5u w=50n multi=2",key="value",size=0.9,halign="start") => @PLACE(93,-4);
// #CCN @TEXT("",key="model");
// #CCP @SET-SYMBOL $CAPACITOR;
// #CCP @PLACE(90,-33) => @ORIENT("R0");
// #CCP @TEXT("CCP",key="name",size=1.3,halign="start") => @PLACE(93,-30);
// #CCP @TEXT("nr=8 lr=2.5u w=50n multi=2",key="value",size=0.9,halign="start") => @PLACE(93,-37);
// #CCP @TEXT("",key="model");
// #CKP @SET-SYMBOL $CAPACITOR;
// #CKP @PLACE(90,-66) => @ORIENT("R0");
// #CKP @TEXT("CKP",key="name",size=1.3,halign="start") => @PLACE(93,-63);
// #CKP @TEXT("nr=8 lr=2u w=50n multi=256",key="value",size=0.9,halign="start") => @PLACE(93,-70);
// #CKP @TEXT("",key="model");
// #CKN @SET-SYMBOL $CAPACITOR;
// #CKN @PLACE(90,-99) => @ORIENT("R0");
// #CKN @TEXT("CKN",key="name",size=1.3,halign="start") => @PLACE(93,-96);
// #CKN @TEXT("nr=8 lr=2u w=50n multi=256",key="value",size=0.9,halign="start") => @PLACE(93,-103);
// #CKN @TEXT("",key="model");
// #CKON @SET-SYMBOL $CAPACITOR;
// #CKON @PLACE(90,-132) => @ORIENT("R0");
// #CKON @TEXT("CKON",key="name",size=1.3,halign="start") => @PLACE(93,-129);
// #CKON @TEXT("c=10f",key="value",size=0.9,halign="start") => @PLACE(93,-136);
// #CKON @TEXT("",key="model");
// #CKOP @SET-SYMBOL $CAPACITOR;
// #CKOP @PLACE(90,-165) => @ORIENT("R0");
// #CKOP @TEXT("CKOP",key="name",size=1.3,halign="start") => @PLACE(93,-162);
// #CKOP @TEXT("c=10f",key="value",size=0.9,halign="start") => @PLACE(93,-169);
// #CKOP @TEXT("",key="model");
// &"c_clock" @WIRE(mode="straight",linecolor="#30485d",linewidth=0.16) {#VCCLOCK:1 (-41.5,2) (-41.5,3.3) #XCOMP:1};
// &"c_n" @WIRE(mode="straight",linecolor="#30485d",linewidth=0.16) {#VCN:1 (-41.5,-31) (-41.5,0) #XCOMP:5};
// &"c_p" @WIRE(mode="straight",linecolor="#30485d",linewidth=0.16) {#VCP:1 (-41.5,-64) (-41.5,-3.3) #XCOMP:6};
// &"k_sp" @WIRE(mode="straight",linecolor="#30485d",linewidth=0.16) {#VKP:1 (-41.5,-130) (-41.5,-99) #XKP:2};
// &"k_sn" @WIRE(mode="straight",linecolor="#30485d",linewidth=0.16) {#VKN:1 (-41.5,-163) (-41.5,-132) #XKN:2};
// &"k_clock" @WIRE(mode="straight",linecolor="#30485d",linewidth=0.16) {#VKC:1 (-41.5,-196) (-41.5,-161.7) #XKCOMP:1};
// &"k_outn" @WIRE(mode="straight",linecolor="#30485d",linewidth=0.16) {#XKCOMP:2 (51.5,-163.35) (51.5,-130) #CKON:1};
// &"k_outp" @WIRE(mode="straight",linecolor="#30485d",linewidth=0.16) {#XKCOMP:3 (51.5,-166.65) (51.5,-163) #CKOP:1};
// (-89,30) @TEXT("tb_comparator / source-derived connections",size=1.4,halign="start",textcolor="#223d52");
// &"0" @WIRE(mode="straight",linecolor="#30485d",linewidth=0.16) {#VCCLOCK:2 (-70,-5)};
// (-70,-5.4) @TEXT("0",size=1.1,halign="middle",valign="top");
// &"0" @WIRE(mode="straight",linecolor="#30485d",linewidth=0.16) {#VCN:2 (-70,-38)};
// (-70,-38.4) @TEXT("0",size=1.1,halign="middle",valign="top");
// &"0" @WIRE(mode="straight",linecolor="#30485d",linewidth=0.16) {#VCP:2 (-70,-71)};
// (-70,-71.4) @TEXT("0",size=1.1,halign="middle",valign="top");
// &"c_outn" @WIRE(mode="straight",linecolor="#30485d",linewidth=0.16) {#XCOMP:2 (16,1.65)};
// (16.4,1.65) @TEXT("c_outn",size=1.1,halign="start",valign="middle");
// &"c_outp" @WIRE(mode="straight",linecolor="#30485d",linewidth=0.16) {#XCOMP:3 (16,-1.65)};
// (16.4,-1.65) @TEXT("c_outp",size=1.1,halign="start",valign="middle");
// &"VDD!" @WIRE(mode="straight",linecolor="#30485d",linewidth=0.16) {#XCOMP:4 (0,11.6)};
// (0,12) @TEXT("VDD!",size=1.1,halign="middle",valign="bottom");
// &"0" @WIRE(mode="straight",linecolor="#30485d",linewidth=0.16) {#XCOMP:7 (0,-11.6)};
// (0,-12) @TEXT("0",size=1.1,halign="middle",valign="top");
// &"c_outn" @WIRE(mode="straight",linecolor="#30485d",linewidth=0.16) {#CCN:1 (90,5)};
// (90,5.4) @TEXT("c_outn",size=1.1,halign="middle",valign="bottom");
// &"0" @WIRE(mode="straight",linecolor="#30485d",linewidth=0.16) {#CCN:2 (90,-5)};
// (90,-5.4) @TEXT("0",size=1.1,halign="middle",valign="top");
// &"c_outp" @WIRE(mode="straight",linecolor="#30485d",linewidth=0.16) {#CCP:1 (90,-28)};
// (90,-27.6) @TEXT("c_outp",size=1.1,halign="middle",valign="bottom");
// &"0" @WIRE(mode="straight",linecolor="#30485d",linewidth=0.16) {#CCP:2 (90,-38)};
// (90,-38.4) @TEXT("0",size=1.1,halign="middle",valign="top");
// &"c_outn" @WIRE(mode="straight",linecolor="#30485d",linewidth=0.16) {#XCRN:1 (-10,-33)};
// (-10.4,-33) @TEXT("c_outn",size=1.1,halign="end",valign="middle");
// &"c_unusedn" @WIRE(mode="straight",linecolor="#30485d",linewidth=0.16) {#XCRN:2 (10,-33)};
// (10.4,-33) @TEXT("c_unusedn",size=1.1,halign="start",valign="middle");
// &"VDD!" @WIRE(mode="straight",linecolor="#30485d",linewidth=0.16) {#XCRN:3 (0,-23)};
// (0,-22.6) @TEXT("VDD!",size=1.1,halign="middle",valign="bottom");
// &"0" @WIRE(mode="straight",linecolor="#30485d",linewidth=0.16) {#XCRN:4 (0,-43)};
// (0,-43.4) @TEXT("0",size=1.1,halign="middle",valign="top");
// &"c_outp" @WIRE(mode="straight",linecolor="#30485d",linewidth=0.16) {#XCRP:1 (-10,-66)};
// (-10.4,-66) @TEXT("c_outp",size=1.1,halign="end",valign="middle");
// &"c_unusedp" @WIRE(mode="straight",linecolor="#30485d",linewidth=0.16) {#XCRP:2 (10,-66)};
// (10.4,-66) @TEXT("c_unusedp",size=1.1,halign="start",valign="middle");
// &"VDD!" @WIRE(mode="straight",linecolor="#30485d",linewidth=0.16) {#XCRP:3 (0,-56)};
// (0,-55.6) @TEXT("VDD!",size=1.1,halign="middle",valign="bottom");
// &"0" @WIRE(mode="straight",linecolor="#30485d",linewidth=0.16) {#XCRP:4 (0,-76)};
// (0,-76.4) @TEXT("0",size=1.1,halign="middle",valign="top");
// &"k_init" @WIRE(mode="straight",linecolor="#30485d",linewidth=0.16) {#VKINIT:1 (-70,-94)};
// (-70,-93.6) @TEXT("k_init",size=1.1,halign="middle",valign="bottom");
// &"0" @WIRE(mode="straight",linecolor="#30485d",linewidth=0.16) {#VKINIT:2 (-70,-104)};
// (-70,-104.4) @TEXT("0",size=1.1,halign="middle",valign="top");
// &"0" @WIRE(mode="straight",linecolor="#30485d",linewidth=0.16) {#VKP:2 (-70,-137)};
// (-70,-137.4) @TEXT("0",size=1.1,halign="middle",valign="top");
// &"0" @WIRE(mode="straight",linecolor="#30485d",linewidth=0.16) {#VKN:2 (-70,-170)};
// (-70,-170.4) @TEXT("0",size=1.1,halign="middle",valign="top");
// &"k_p" @WIRE(mode="straight",linecolor="#30485d",linewidth=0.16) {#XKP:1 (-16,-95.7)};
// (-16.4,-95.7) @TEXT("k_p",size=1.1,halign="end",valign="middle");
// &"k_init" @WIRE(mode="straight",linecolor="#30485d",linewidth=0.16) {#XKP:3 (-16,-102.3)};
// (-16.4,-102.3) @TEXT("k_init",size=1.1,halign="end",valign="middle");
// &"VDD!" @WIRE(mode="straight",linecolor="#30485d",linewidth=0.16) {#XKP:4 (0,-87.4)};
// (0,-87) @TEXT("VDD!",size=1.1,halign="middle",valign="bottom");
// &"0" @WIRE(mode="straight",linecolor="#30485d",linewidth=0.16) {#XKP:5 (0,-110.6)};
// (0,-111) @TEXT("0",size=1.1,halign="middle",valign="top");
// &"k_n" @WIRE(mode="straight",linecolor="#30485d",linewidth=0.16) {#XKN:1 (-16,-128.7)};
// (-16.4,-128.7) @TEXT("k_n",size=1.1,halign="end",valign="middle");
// &"k_init" @WIRE(mode="straight",linecolor="#30485d",linewidth=0.16) {#XKN:3 (-16,-135.3)};
// (-16.4,-135.3) @TEXT("k_init",size=1.1,halign="end",valign="middle");
// &"VDD!" @WIRE(mode="straight",linecolor="#30485d",linewidth=0.16) {#XKN:4 (0,-120.4)};
// (0,-120) @TEXT("VDD!",size=1.1,halign="middle",valign="bottom");
// &"0" @WIRE(mode="straight",linecolor="#30485d",linewidth=0.16) {#XKN:5 (0,-143.6)};
// (0,-144) @TEXT("0",size=1.1,halign="middle",valign="top");
// &"k_p" @WIRE(mode="straight",linecolor="#30485d",linewidth=0.16) {#CKP:1 (90,-61)};
// (90,-60.6) @TEXT("k_p",size=1.1,halign="middle",valign="bottom");
// &"0" @WIRE(mode="straight",linecolor="#30485d",linewidth=0.16) {#CKP:2 (90,-71)};
// (90,-71.4) @TEXT("0",size=1.1,halign="middle",valign="top");
// &"k_n" @WIRE(mode="straight",linecolor="#30485d",linewidth=0.16) {#CKN:1 (90,-94)};
// (90,-93.6) @TEXT("k_n",size=1.1,halign="middle",valign="bottom");
// &"0" @WIRE(mode="straight",linecolor="#30485d",linewidth=0.16) {#CKN:2 (90,-104)};
// (90,-104.4) @TEXT("0",size=1.1,halign="middle",valign="top");
// &"0" @WIRE(mode="straight",linecolor="#30485d",linewidth=0.16) {#VKC:2 (-70,-203)};
// (-70,-203.4) @TEXT("0",size=1.1,halign="middle",valign="top");
// &"VDD!" @WIRE(mode="straight",linecolor="#30485d",linewidth=0.16) {#XKCOMP:4 (0,-153.4)};
// (0,-153) @TEXT("VDD!",size=1.1,halign="middle",valign="bottom");
// &"k_n" @WIRE(mode="straight",linecolor="#30485d",linewidth=0.16) {#XKCOMP:5 (-16,-165)};
// (-16.4,-165) @TEXT("k_n",size=1.1,halign="end",valign="middle");
// &"k_p" @WIRE(mode="straight",linecolor="#30485d",linewidth=0.16) {#XKCOMP:6 (-16,-168.3)};
// (-16.4,-168.3) @TEXT("k_p",size=1.1,halign="end",valign="middle");
// &"0" @WIRE(mode="straight",linecolor="#30485d",linewidth=0.16) {#XKCOMP:7 (0,-176.6)};
// (0,-177) @TEXT("0",size=1.1,halign="middle",valign="top");
// &"0" @WIRE(mode="straight",linecolor="#30485d",linewidth=0.16) {#CKON:2 (90,-137)};
// (90,-137.4) @TEXT("0",size=1.1,halign="middle",valign="top");
// &"0" @WIRE(mode="straight",linecolor="#30485d",linewidth=0.16) {#CKOP:2 (90,-170)};
// (90,-170.4) @TEXT("0",size=1.1,halign="middle",valign="top");
// }
// END SARADC RNL
ends tb_comparator

subckt tb_reference
// Reference storage, nonoverlap and gate-drive test with the ACTUAL CDAC as the load.
VRRESET (r_reset 0) vsource type=pwl wave=[0 0.9 20n 0.9 20.1n 0]
VRPHI (r_phi 0) vsource type=pulse val0=0 val1=0.9 delay=50n rise=100p fall=100p width=1.9n period=80n
VRB0 (r_bit0 0) vsource type=pwl wave=[0 0 4.4900000000000005e-08 0 4.5000000000000006e-08 0 1.2490000000000001e-07 0 1.2500000000000002e-07 0 2.0490000000000001e-07 0 2.0500000000000002e-07 0.90000000000000002 2.8490000000000002e-07 0.90000000000000002 2.8500000000000002e-07 0.90000000000000002 3.6489999999999999e-07 0.90000000000000002 3.65e-07 0 4.4490000000000002e-07 0 4.4500000000000003e-07 0]
VRB1 (r_bit1 0) vsource type=pwl wave=[0 0 4.4900000000000005e-08 0 4.5000000000000006e-08 0 1.2490000000000001e-07 0 1.2500000000000002e-07 0 2.0490000000000001e-07 0 2.0500000000000002e-07 0.90000000000000002 2.8490000000000002e-07 0.90000000000000002 2.8500000000000002e-07 0 3.6489999999999999e-07 0 3.65e-07 0.90000000000000002 4.4490000000000002e-07 0.90000000000000002 4.4500000000000003e-07 0]
VRB2 (r_bit2 0) vsource type=pwl wave=[0 0 4.4900000000000005e-08 0 4.5000000000000006e-08 0 1.2490000000000001e-07 0 1.2500000000000002e-07 0 2.0490000000000001e-07 0 2.0500000000000002e-07 0.90000000000000002 2.8490000000000002e-07 0.90000000000000002 2.8500000000000002e-07 0.90000000000000002 3.6489999999999999e-07 0.90000000000000002 3.65e-07 0 4.4490000000000002e-07 0 4.4500000000000003e-07 0]
VRB3 (r_bit3 0) vsource type=pwl wave=[0 0 4.4900000000000005e-08 0 4.5000000000000006e-08 0 1.2490000000000001e-07 0 1.2500000000000002e-07 0 2.0490000000000001e-07 0 2.0500000000000002e-07 0.90000000000000002 2.8490000000000002e-07 0.90000000000000002 2.8500000000000002e-07 0 3.6489999999999999e-07 0 3.65e-07 0.90000000000000002 4.4490000000000002e-07 0.90000000000000002 4.4500000000000003e-07 0]
VRB4 (r_bit4 0) vsource type=pwl wave=[0 0 4.4900000000000005e-08 0 4.5000000000000006e-08 0 1.2490000000000001e-07 0 1.2500000000000002e-07 0 2.0490000000000001e-07 0 2.0500000000000002e-07 0.90000000000000002 2.8490000000000002e-07 0.90000000000000002 2.8500000000000002e-07 0.90000000000000002 3.6489999999999999e-07 0.90000000000000002 3.65e-07 0 4.4490000000000002e-07 0 4.4500000000000003e-07 0]
VRB5 (r_bit5 0) vsource type=pwl wave=[0 0 4.4900000000000005e-08 0 4.5000000000000006e-08 0 1.2490000000000001e-07 0 1.2500000000000002e-07 0 2.0490000000000001e-07 0 2.0500000000000002e-07 0.90000000000000002 2.8490000000000002e-07 0.90000000000000002 2.8500000000000002e-07 0 3.6489999999999999e-07 0 3.65e-07 0.90000000000000002 4.4490000000000002e-07 0.90000000000000002 4.4500000000000003e-07 0]
VRB6 (r_bit6 0) vsource type=pwl wave=[0 0 4.4900000000000005e-08 0 4.5000000000000006e-08 0 1.2490000000000001e-07 0 1.2500000000000002e-07 0 2.0490000000000001e-07 0 2.0500000000000002e-07 0.90000000000000002 2.8490000000000002e-07 0.90000000000000002 2.8500000000000002e-07 0.90000000000000002 3.6489999999999999e-07 0.90000000000000002 3.65e-07 0 4.4490000000000002e-07 0 4.4500000000000003e-07 0]
VRB7 (r_bit7 0) vsource type=pwl wave=[0 0.90000000000000002 4.4900000000000005e-08 0.90000000000000002 4.5000000000000006e-08 0.90000000000000002 1.2490000000000001e-07 0.90000000000000002 1.2500000000000002e-07 0 2.0490000000000001e-07 0 2.0500000000000002e-07 0.90000000000000002 2.8490000000000002e-07 0.90000000000000002 2.8500000000000002e-07 0 3.6489999999999999e-07 0 3.65e-07 0.90000000000000002 4.4490000000000002e-07 0.90000000000000002 4.4500000000000003e-07 0.90000000000000002]
XREF (r_bit0 r_bit1 r_bit2 r_bit3 r_bit4 r_bit5 r_bit6 r_bit7 r_bit0 r_bit1 r_bit2 r_bit3 r_bit4 r_bit5 r_bit6 r_bit7 r_gnn0 r_gnn1 r_gnn2 r_gnn3 r_gnn4 r_gnn5 r_gnn6 r_gnn7 r_gnp0 r_gnp1 r_gnp2 r_gnp3 r_gnp4 r_gnp5 r_gnp6 r_gnp7 r_gpn0 r_gpn1 r_gpn2 r_gpn3 r_gpn4 r_gpn5 r_gpn6 r_gpn7 r_gpp0 r_gpp1 r_gpp2 r_gpp3 r_gpp4 r_gpp5 r_gpp6 r_gpp7 r_phi r_reset VDD! 0 r_done r_reset) sar8i_refword
XRLOAD (r_gnn0 r_gnn1 r_gnn2 r_gnn3 r_gnn4 r_gnn5 r_gnn6 r_gnn7 r_gnp0 r_gnp1 r_gnp2 r_gnp3 r_gnp4 r_gnp5 r_gnp6 r_gnp7 r_gpn0 r_gpn1 r_gpn2 r_gpn3 r_gpn4 r_gpn5 r_gpn6 r_gpn7 r_gpp0 r_gpp1 r_gpp2 r_gpp3 r_gpp4 r_gpp5 r_gpp6 r_gpp7 r_n r_p VDD! r_rn r_rp 0) sar8j_r1_cdac
VRRN (r_rns 0) vsource dc=0
VRRP (r_rps 0) vsource dc=0.9
RRRN (r_rns r_rn) resistor r=50
RRRP (r_rps r_rp) resistor r=50
CRRN (r_rn 0) capacitor c=4p
CRRP (r_rp 0) capacitor c=4p
RRNLEAK (r_n 0) resistor r=1e12
RRPLEAK (r_p 0) resistor r=1e12

// BEGIN SARADC RNL
// @RNL(author="saradc topology") {
// #VRRESET @SET-SYMBOL $VOLTAGE_SOURCE;
// #VRRESET @PLACE(-70,0) => @ORIENT("R0");
// #VRRESET @TEXT("VRRESET",key="name",size=1.3,halign="start") => @PLACE(-67,3);
// #VRRESET @TEXT("",key="value",size=0.9,halign="start") => @PLACE(-67,-4);
// #VRRESET @TEXT("",key="model");
// #VRPHI @SET-SYMBOL $VOLTAGE_SOURCE;
// #VRPHI @PLACE(-70,-33) => @ORIENT("R0");
// #VRPHI @TEXT("VRPHI",key="name",size=1.3,halign="start") => @PLACE(-67,-30);
// #VRPHI @TEXT("",key="value",size=0.9,halign="start") => @PLACE(-67,-37);
// #VRPHI @TEXT("",key="model");
// #VRB0 @SET-SYMBOL $VOLTAGE_SOURCE;
// #VRB0 @PLACE(-70,-66) => @ORIENT("R0");
// #VRB0 @TEXT("VRB0",key="name",size=1.3,halign="start") => @PLACE(-67,-63);
// #VRB0 @TEXT("",key="value",size=0.9,halign="start") => @PLACE(-67,-70);
// #VRB0 @TEXT("",key="model");
// #VRB1 @SET-SYMBOL $VOLTAGE_SOURCE;
// #VRB1 @PLACE(-70,-99) => @ORIENT("R0");
// #VRB1 @TEXT("VRB1",key="name",size=1.3,halign="start") => @PLACE(-67,-96);
// #VRB1 @TEXT("",key="value",size=0.9,halign="start") => @PLACE(-67,-103);
// #VRB1 @TEXT("",key="model");
// #VRB2 @SET-SYMBOL $VOLTAGE_SOURCE;
// #VRB2 @PLACE(-70,-132) => @ORIENT("R0");
// #VRB2 @TEXT("VRB2",key="name",size=1.3,halign="start") => @PLACE(-67,-129);
// #VRB2 @TEXT("",key="value",size=0.9,halign="start") => @PLACE(-67,-136);
// #VRB2 @TEXT("",key="model");
// #VRB3 @SET-SYMBOL $VOLTAGE_SOURCE;
// #VRB3 @PLACE(-70,-165) => @ORIENT("R0");
// #VRB3 @TEXT("VRB3",key="name",size=1.3,halign="start") => @PLACE(-67,-162);
// #VRB3 @TEXT("",key="value",size=0.9,halign="start") => @PLACE(-67,-169);
// #VRB3 @TEXT("",key="model");
// #VRB4 @SET-SYMBOL $VOLTAGE_SOURCE;
// #VRB4 @PLACE(-70,-198) => @ORIENT("R0");
// #VRB4 @TEXT("VRB4",key="name",size=1.3,halign="start") => @PLACE(-67,-195);
// #VRB4 @TEXT("",key="value",size=0.9,halign="start") => @PLACE(-67,-202);
// #VRB4 @TEXT("",key="model");
// #VRB5 @SET-SYMBOL $VOLTAGE_SOURCE;
// #VRB5 @PLACE(-70,-231) => @ORIENT("R0");
// #VRB5 @TEXT("VRB5",key="name",size=1.3,halign="start") => @PLACE(-67,-228);
// #VRB5 @TEXT("",key="value",size=0.9,halign="start") => @PLACE(-67,-235);
// #VRB5 @TEXT("",key="model");
// #VRB6 @SET-SYMBOL $VOLTAGE_SOURCE;
// #VRB6 @PLACE(-70,-264) => @ORIENT("R0");
// #VRB6 @TEXT("VRB6",key="name",size=1.3,halign="start") => @PLACE(-67,-261);
// #VRB6 @TEXT("",key="value",size=0.9,halign="start") => @PLACE(-67,-268);
// #VRB6 @TEXT("",key="model");
// #VRB7 @SET-SYMBOL $VOLTAGE_SOURCE;
// #VRB7 @PLACE(-70,-297) => @ORIENT("R0");
// #VRB7 @TEXT("VRB7",key="name",size=1.3,halign="start") => @PLACE(-67,-294);
// #VRB7 @TEXT("",key="value",size=0.9,halign="start") => @PLACE(-67,-301);
// #VRB7 @TEXT("",key="model");
// #VRRN @SET-SYMBOL $VOLTAGE_SOURCE;
// #VRRN @PLACE(-70,-330) => @ORIENT("R0");
// #VRRN @TEXT("VRRN",key="name",size=1.3,halign="start") => @PLACE(-67,-327);
// #VRRN @TEXT("",key="value",size=0.9,halign="start") => @PLACE(-67,-334);
// #VRRN @TEXT("",key="model");
// #VRRP @SET-SYMBOL $VOLTAGE_SOURCE;
// #VRRP @PLACE(-70,-363) => @ORIENT("R0");
// #VRRP @TEXT("VRRP",key="name",size=1.3,halign="start") => @PLACE(-67,-360);
// #VRRP @TEXT("",key="value",size=0.9,halign="start") => @PLACE(-67,-367);
// #VRRP @TEXT("",key="model");
// #XREF @SET-SYMBOL $S_sar8i_refword;
// #XREF @PLACE(0,0) => @ORIENT("R0");
// #XRLOAD @SET-SYMBOL $S_sar8j_r1_cdac;
// #XRLOAD @PLACE(0,-33) => @ORIENT("R0");
// #RRRN @SET-SYMBOL $RESISTOR;
// #RRRN @PLACE(90,0) => @ORIENT("R0");
// #RRRN @TEXT("RRRN",key="name",size=1.3,halign="start") => @PLACE(93,3);
// #RRRN @TEXT("r=50",key="value",size=0.9,halign="start") => @PLACE(93,-4);
// #RRRN @TEXT("",key="model");
// #RRRP @SET-SYMBOL $RESISTOR;
// #RRRP @PLACE(90,-33) => @ORIENT("R0");
// #RRRP @TEXT("RRRP",key="name",size=1.3,halign="start") => @PLACE(93,-30);
// #RRRP @TEXT("r=50",key="value",size=0.9,halign="start") => @PLACE(93,-37);
// #RRRP @TEXT("",key="model");
// #CRRN @SET-SYMBOL $CAPACITOR;
// #CRRN @PLACE(90,-66) => @ORIENT("R0");
// #CRRN @TEXT("CRRN",key="name",size=1.3,halign="start") => @PLACE(93,-63);
// #CRRN @TEXT("c=4p",key="value",size=0.9,halign="start") => @PLACE(93,-70);
// #CRRN @TEXT("",key="model");
// #CRRP @SET-SYMBOL $CAPACITOR;
// #CRRP @PLACE(90,-99) => @ORIENT("R0");
// #CRRP @TEXT("CRRP",key="name",size=1.3,halign="start") => @PLACE(93,-96);
// #CRRP @TEXT("c=4p",key="value",size=0.9,halign="start") => @PLACE(93,-103);
// #CRRP @TEXT("",key="model");
// #RRNLEAK @SET-SYMBOL $RESISTOR;
// #RRNLEAK @PLACE(90,-132) => @ORIENT("R0");
// #RRNLEAK @TEXT("RRNLEAK",key="name",size=1.3,halign="start") => @PLACE(93,-129);
// #RRNLEAK @TEXT("r=1e12",key="value",size=0.9,halign="start") => @PLACE(93,-136);
// #RRNLEAK @TEXT("",key="model");
// #RRPLEAK @SET-SYMBOL $RESISTOR;
// #RRPLEAK @PLACE(90,-165) => @ORIENT("R0");
// #RRPLEAK @TEXT("RRPLEAK",key="name",size=1.3,halign="start") => @PLACE(93,-162);
// #RRPLEAK @TEXT("r=1e12",key="value",size=0.9,halign="start") => @PLACE(93,-169);
// #RRPLEAK @TEXT("",key="model");
// &"r_phi" @WIRE(mode="straight",linecolor="#30485d",linewidth=0.16) {#VRPHI:1 (-45,-31) (-45,1.65) #XREF:49};
// &"r_n" @WIRE(mode="straight",linecolor="#30485d",linewidth=0.16) {#XRLOAD:33 (41,-25) (41,-130) #RRNLEAK:1};
// (-89,30) @TEXT("tb_reference / source-derived connections",size=1.4,halign="start",textcolor="#223d52");
// &"r_reset" @WIRE(mode="straight",linecolor="#30485d",linewidth=0.16) {#VRRESET:1 (-70,5)};
// (-70,5.4) @TEXT("r_reset",size=1.1,halign="middle",valign="bottom");
// &"0" @WIRE(mode="straight",linecolor="#30485d",linewidth=0.16) {#VRRESET:2 (-70,-5)};
// (-70,-5.4) @TEXT("0",size=1.1,halign="middle",valign="top");
// &"0" @WIRE(mode="straight",linecolor="#30485d",linewidth=0.16) {#VRPHI:2 (-70,-38)};
// (-70,-38.4) @TEXT("0",size=1.1,halign="middle",valign="top");
// &"r_bit0" @WIRE(mode="straight",linecolor="#30485d",linewidth=0.16) {#VRB0:1 (-70,-61)};
// (-70,-60.6) @TEXT("r_bit0",size=1.1,halign="middle",valign="bottom");
// &"0" @WIRE(mode="straight",linecolor="#30485d",linewidth=0.16) {#VRB0:2 (-70,-71)};
// (-70,-71.4) @TEXT("0",size=1.1,halign="middle",valign="top");
// &"r_bit1" @WIRE(mode="straight",linecolor="#30485d",linewidth=0.16) {#VRB1:1 (-70,-94)};
// (-70,-93.6) @TEXT("r_bit1",size=1.1,halign="middle",valign="bottom");
// &"0" @WIRE(mode="straight",linecolor="#30485d",linewidth=0.16) {#VRB1:2 (-70,-104)};
// (-70,-104.4) @TEXT("0",size=1.1,halign="middle",valign="top");
// &"r_bit2" @WIRE(mode="straight",linecolor="#30485d",linewidth=0.16) {#VRB2:1 (-70,-127)};
// (-70,-126.6) @TEXT("r_bit2",size=1.1,halign="middle",valign="bottom");
// &"0" @WIRE(mode="straight",linecolor="#30485d",linewidth=0.16) {#VRB2:2 (-70,-137)};
// (-70,-137.4) @TEXT("0",size=1.1,halign="middle",valign="top");
// &"r_bit3" @WIRE(mode="straight",linecolor="#30485d",linewidth=0.16) {#VRB3:1 (-70,-160)};
// (-70,-159.6) @TEXT("r_bit3",size=1.1,halign="middle",valign="bottom");
// &"0" @WIRE(mode="straight",linecolor="#30485d",linewidth=0.16) {#VRB3:2 (-70,-170)};
// (-70,-170.4) @TEXT("0",size=1.1,halign="middle",valign="top");
// &"r_bit4" @WIRE(mode="straight",linecolor="#30485d",linewidth=0.16) {#VRB4:1 (-70,-193)};
// (-70,-192.6) @TEXT("r_bit4",size=1.1,halign="middle",valign="bottom");
// &"0" @WIRE(mode="straight",linecolor="#30485d",linewidth=0.16) {#VRB4:2 (-70,-203)};
// (-70,-203.4) @TEXT("0",size=1.1,halign="middle",valign="top");
// &"r_bit5" @WIRE(mode="straight",linecolor="#30485d",linewidth=0.16) {#VRB5:1 (-70,-226)};
// (-70,-225.6) @TEXT("r_bit5",size=1.1,halign="middle",valign="bottom");
// &"0" @WIRE(mode="straight",linecolor="#30485d",linewidth=0.16) {#VRB5:2 (-70,-236)};
// (-70,-236.4) @TEXT("0",size=1.1,halign="middle",valign="top");
// &"r_bit6" @WIRE(mode="straight",linecolor="#30485d",linewidth=0.16) {#VRB6:1 (-70,-259)};
// (-70,-258.6) @TEXT("r_bit6",size=1.1,halign="middle",valign="bottom");
// &"0" @WIRE(mode="straight",linecolor="#30485d",linewidth=0.16) {#VRB6:2 (-70,-269)};
// (-70,-269.4) @TEXT("0",size=1.1,halign="middle",valign="top");
// &"r_bit7" @WIRE(mode="straight",linecolor="#30485d",linewidth=0.16) {#VRB7:1 (-70,-292)};
// (-70,-291.6) @TEXT("r_bit7",size=1.1,halign="middle",valign="bottom");
// &"0" @WIRE(mode="straight",linecolor="#30485d",linewidth=0.16) {#VRB7:2 (-70,-302)};
// (-70,-302.4) @TEXT("0",size=1.1,halign="middle",valign="top");
// {&"r_bit0" &"r_bit1" &"r_bit2" &"r_bit3" &"r_bit4" &"r_bit5" &"r_bit6" &"r_bit7"} @WIRE(mode="straight",linewidth=0.3) {#XREF:1 (23,4.95)};
// (23.4,4.95) @TEXT("r_bit[7:0]",size=1.1,halign="start",valign="middle");
// {&"r_bit0" &"r_bit1" &"r_bit2" &"r_bit3" &"r_bit4" &"r_bit5" &"r_bit6" &"r_bit7"} @WIRE(mode="straight",linewidth=0.3) {#XREF:9 (23,1.65)};
// (23.4,1.65) @TEXT("r_bit[7:0]",size=1.1,halign="start",valign="middle");
// {&"r_gnn0" &"r_gnn1" &"r_gnn2" &"r_gnn3" &"r_gnn4" &"r_gnn5" &"r_gnn6" &"r_gnn7"} @WIRE(mode="straight",linewidth=0.3) {#XREF:17 (-16,13.25)};
// (-16,13.65) @TEXT("r_gnn[7:0]",size=1.1,halign="middle",valign="bottom");
// {&"r_gnp0" &"r_gnp1" &"r_gnp2" &"r_gnp3" &"r_gnp4" &"r_gnp5" &"r_gnp6" &"r_gnp7"} @WIRE(mode="straight",linewidth=0.3) {#XREF:25 (-8,13.25)};
// (-8,13.65) @TEXT("r_gnp[7:0]",size=1.1,halign="middle",valign="bottom");
// {&"r_gpn0" &"r_gpn1" &"r_gpn2" &"r_gpn3" &"r_gpn4" &"r_gpn5" &"r_gpn6" &"r_gpn7"} @WIRE(mode="straight",linewidth=0.3) {#XREF:33 (0,13.25)};
// (0,13.65) @TEXT("r_gpn[7:0]",size=1.1,halign="middle",valign="bottom");
// {&"r_gpp0" &"r_gpp1" &"r_gpp2" &"r_gpp3" &"r_gpp4" &"r_gpp5" &"r_gpp6" &"r_gpp7"} @WIRE(mode="straight",linewidth=0.3) {#XREF:41 (8,13.25)};
// (8,13.65) @TEXT("r_gpp[7:0]",size=1.1,halign="middle",valign="bottom");
// &"r_reset" @WIRE(mode="straight",linecolor="#30485d",linewidth=0.16) {#XREF:50 (-23,-1.65)};
// (-23.4,-1.65) @TEXT("r_reset",size=1.1,halign="end",valign="middle");
// &"VDD!" @WIRE(mode="straight",linecolor="#30485d",linewidth=0.16) {#XREF:51 (16,13.25)};
// (16,13.65) @TEXT("VDD!",size=1.1,halign="middle",valign="bottom");
// &"0" @WIRE(mode="straight",linecolor="#30485d",linewidth=0.16) {#XREF:52 (0,-13.25)};
// (0,-13.65) @TEXT("0",size=1.1,halign="middle",valign="top");
// &"r_done" @WIRE(mode="straight",linecolor="#30485d",linewidth=0.16) {#XREF:53 (23,-1.65)};
// (23.4,-1.65) @TEXT("r_done",size=1.1,halign="start",valign="middle");
// &"r_reset" @WIRE(mode="straight",linecolor="#30485d",linewidth=0.16) {#XREF:54 (23,-4.95)};
// (23.4,-4.95) @TEXT("r_reset",size=1.1,halign="start",valign="middle");
// {&"r_gnn0" &"r_gnn1" &"r_gnn2" &"r_gnn3" &"r_gnn4" &"r_gnn5" &"r_gnn6" &"r_gnn7"} @WIRE(mode="straight",linewidth=0.3) {#XRLOAD:1 (-16,-44)};
// (-16,-44.4) @TEXT("r_gnn[7:0]",size=1.1,halign="middle",valign="top");
// {&"r_gnp0" &"r_gnp1" &"r_gnp2" &"r_gnp3" &"r_gnp4" &"r_gnp5" &"r_gnp6" &"r_gnp7"} @WIRE(mode="straight",linewidth=0.3) {#XRLOAD:9 (-8,-44)};
// (-8,-44.4) @TEXT("r_gnp[7:0]",size=1.1,halign="middle",valign="top");
// {&"r_gpn0" &"r_gpn1" &"r_gpn2" &"r_gpn3" &"r_gpn4" &"r_gpn5" &"r_gpn6" &"r_gpn7"} @WIRE(mode="straight",linewidth=0.3) {#XRLOAD:17 (0,-44)};
// (0,-44.4) @TEXT("r_gpn[7:0]",size=1.1,halign="middle",valign="top");
// {&"r_gpp0" &"r_gpp1" &"r_gpp2" &"r_gpp3" &"r_gpp4" &"r_gpp5" &"r_gpp6" &"r_gpp7"} @WIRE(mode="straight",linewidth=0.3) {#XRLOAD:25 (8,-44)};
// (8,-44.4) @TEXT("r_gpp[7:0]",size=1.1,halign="middle",valign="top");
// &"r_p" @WIRE(mode="straight",linecolor="#30485d",linewidth=0.16) {#XRLOAD:34 (0,-22)};
// (0,-21.6) @TEXT("r_p",size=1.1,halign="middle",valign="bottom");
// &"VDD!" @WIRE(mode="straight",linecolor="#30485d",linewidth=0.16) {#XRLOAD:35 (8,-22)};
// (8,-21.6) @TEXT("VDD!",size=1.1,halign="middle",valign="bottom");
// &"r_rn" @WIRE(mode="straight",linecolor="#30485d",linewidth=0.16) {#XRLOAD:36 (-23,-31.35)};
// (-23.4,-31.35) @TEXT("r_rn",size=1.1,halign="end",valign="middle");
// &"r_rp" @WIRE(mode="straight",linecolor="#30485d",linewidth=0.16) {#XRLOAD:37 (-23,-34.65)};
// (-23.4,-34.65) @TEXT("r_rp",size=1.1,halign="end",valign="middle");
// &"0" @WIRE(mode="straight",linecolor="#30485d",linewidth=0.16) {#XRLOAD:38 (16,-44)};
// (16,-44.4) @TEXT("0",size=1.1,halign="middle",valign="top");
// &"r_rns" @WIRE(mode="straight",linecolor="#30485d",linewidth=0.16) {#VRRN:1 (-70,-325)};
// (-70,-324.6) @TEXT("r_rns",size=1.1,halign="middle",valign="bottom");
// &"0" @WIRE(mode="straight",linecolor="#30485d",linewidth=0.16) {#VRRN:2 (-70,-335)};
// (-70,-335.4) @TEXT("0",size=1.1,halign="middle",valign="top");
// &"r_rps" @WIRE(mode="straight",linecolor="#30485d",linewidth=0.16) {#VRRP:1 (-70,-358)};
// (-70,-357.6) @TEXT("r_rps",size=1.1,halign="middle",valign="bottom");
// &"0" @WIRE(mode="straight",linecolor="#30485d",linewidth=0.16) {#VRRP:2 (-70,-368)};
// (-70,-368.4) @TEXT("0",size=1.1,halign="middle",valign="top");
// &"r_rns" @WIRE(mode="straight",linecolor="#30485d",linewidth=0.16) {#RRRN:1 (90,5)};
// (90,5.4) @TEXT("r_rns",size=1.1,halign="middle",valign="bottom");
// &"r_rn" @WIRE(mode="straight",linecolor="#30485d",linewidth=0.16) {#RRRN:2 (90,-5)};
// (90,-5.4) @TEXT("r_rn",size=1.1,halign="middle",valign="top");
// &"r_rps" @WIRE(mode="straight",linecolor="#30485d",linewidth=0.16) {#RRRP:1 (90,-28)};
// (90,-27.6) @TEXT("r_rps",size=1.1,halign="middle",valign="bottom");
// &"r_rp" @WIRE(mode="straight",linecolor="#30485d",linewidth=0.16) {#RRRP:2 (90,-38)};
// (90,-38.4) @TEXT("r_rp",size=1.1,halign="middle",valign="top");
// &"r_rn" @WIRE(mode="straight",linecolor="#30485d",linewidth=0.16) {#CRRN:1 (90,-61)};
// (90,-60.6) @TEXT("r_rn",size=1.1,halign="middle",valign="bottom");
// &"0" @WIRE(mode="straight",linecolor="#30485d",linewidth=0.16) {#CRRN:2 (90,-71)};
// (90,-71.4) @TEXT("0",size=1.1,halign="middle",valign="top");
// &"r_rp" @WIRE(mode="straight",linecolor="#30485d",linewidth=0.16) {#CRRP:1 (90,-94)};
// (90,-93.6) @TEXT("r_rp",size=1.1,halign="middle",valign="bottom");
// &"0" @WIRE(mode="straight",linecolor="#30485d",linewidth=0.16) {#CRRP:2 (90,-104)};
// (90,-104.4) @TEXT("0",size=1.1,halign="middle",valign="top");
// &"0" @WIRE(mode="straight",linecolor="#30485d",linewidth=0.16) {#RRNLEAK:2 (90,-137)};
// (90,-137.4) @TEXT("0",size=1.1,halign="middle",valign="top");
// &"r_p" @WIRE(mode="straight",linecolor="#30485d",linewidth=0.16) {#RRPLEAK:1 (90,-160)};
// (90,-159.6) @TEXT("r_p",size=1.1,halign="middle",valign="bottom");
// &"0" @WIRE(mode="straight",linecolor="#30485d",linewidth=0.16) {#RRPLEAK:2 (90,-170)};
// (90,-170.4) @TEXT("0",size=1.1,halign="middle",valign="top");
// }
// END SARADC RNL
ends tb_reference

subckt tb_sampler
// Standalone sampler: normal initial 60 ns low / 40 ns high, 50 ohm source.
VBCLOCK (b_clock 0) vsource type=pulse val0=0 val1=0.9 delay=60n rise=100p fall=100p width=39.9n period=100n
VBIN (b_source 0) vsource type=pwl wave=[0 0.2 120n 0.2 120.1n 0.8]
RBIN (b_source b_in) resistor r=50
XBOOT (b_clock b_hold b_in) sar_bootstrap_flat_8b_p
CBLOAD (b_hold 0) cfmom_2t nr=8 lr=2u w=50n s=50n stm=1 spm=3 multi=256 mismatchflag=1

// BEGIN SARADC RNL
// @RNL(author="saradc topology") {
// #VBCLOCK @SET-SYMBOL $VOLTAGE_SOURCE;
// #VBCLOCK @PLACE(-70,0) => @ORIENT("R0");
// #VBCLOCK @TEXT("VBCLOCK",key="name",size=1.3,halign="start") => @PLACE(-67,3);
// #VBCLOCK @TEXT("",key="value",size=0.9,halign="start") => @PLACE(-67,-4);
// #VBCLOCK @TEXT("",key="model");
// #VBIN @SET-SYMBOL $VOLTAGE_SOURCE;
// #VBIN @PLACE(-70,-33) => @ORIENT("R0");
// #VBIN @TEXT("VBIN",key="name",size=1.3,halign="start") => @PLACE(-67,-30);
// #VBIN @TEXT("",key="value",size=0.9,halign="start") => @PLACE(-67,-37);
// #VBIN @TEXT("",key="model");
// #XBOOT @SET-SYMBOL $S_sar_bootstrap_flat_8b_p;
// #XBOOT @PLACE(0,0) => @ORIENT("R0");
// #RBIN @SET-SYMBOL $RESISTOR;
// #RBIN @PLACE(90,0) => @ORIENT("R0");
// #RBIN @TEXT("RBIN",key="name",size=1.3,halign="start") => @PLACE(93,3);
// #RBIN @TEXT("r=50",key="value",size=0.9,halign="start") => @PLACE(93,-4);
// #RBIN @TEXT("",key="model");
// #CBLOAD @SET-SYMBOL $CAPACITOR;
// #CBLOAD @PLACE(90,-33) => @ORIENT("R0");
// #CBLOAD @TEXT("CBLOAD",key="name",size=1.3,halign="start") => @PLACE(93,-30);
// #CBLOAD @TEXT("nr=8 lr=2u w=50n multi=256",key="value",size=0.9,halign="start") => @PLACE(93,-37);
// #CBLOAD @TEXT("",key="model");
// &"b_clock" @WIRE(mode="straight",linecolor="#30485d",linewidth=0.16) {#VBCLOCK:1 (-41.5,2) (-41.5,1.65) #XBOOT:1};
// &"b_in" @WIRE(mode="straight",linecolor="#30485d",linewidth=0.16) {#RBIN:2 (38.5,-2) (38.5,-1.65) #XBOOT:3};
// &"b_hold" @WIRE(mode="straight",linecolor="#30485d",linewidth=0.16) {#XBOOT:2 (51.5,0) (51.5,-31) #CBLOAD:1};
// (-89,30) @TEXT("tb_sampler / source-derived connections",size=1.4,halign="start",textcolor="#223d52");
// &"0" @WIRE(mode="straight",linecolor="#30485d",linewidth=0.16) {#VBCLOCK:2 (-70,-5)};
// (-70,-5.4) @TEXT("0",size=1.1,halign="middle",valign="top");
// &"b_source" @WIRE(mode="straight",linecolor="#30485d",linewidth=0.16) {#VBIN:1 (-70,-28)};
// (-70,-27.6) @TEXT("b_source",size=1.1,halign="middle",valign="bottom");
// &"0" @WIRE(mode="straight",linecolor="#30485d",linewidth=0.16) {#VBIN:2 (-70,-38)};
// (-70,-38.4) @TEXT("0",size=1.1,halign="middle",valign="top");
// &"b_source" @WIRE(mode="straight",linecolor="#30485d",linewidth=0.16) {#RBIN:1 (90,5)};
// (90,5.4) @TEXT("b_source",size=1.1,halign="middle",valign="bottom");
// &"0" @WIRE(mode="straight",linecolor="#30485d",linewidth=0.16) {#CBLOAD:2 (90,-38)};
// (90,-38.4) @TEXT("0",size=1.1,halign="middle",valign="top");
// }
// END SARADC RNL
ends tb_sampler

subckt tb_sar
// Native SAR and native delays; electrical VA sampler/CDAC/reference/comparator provide the environment.
VSCLOCK (s_clock 0) vsource type=pulse val0=0 val1=0.9 delay=60n rise=100p fall=100p width=39.9n period=100n
VSs_ps (s_ps 0) vsource type=pwl wave=[0 0.0017578125000000111 1.5980000000000001e-07 0.0017578125000000111 1.5990000000000002e-07 0.0439453125 2.5979999999999998e-07 0.0439453125 2.5989999999999999e-07 0.4482421875 3.5979999999999998e-07 0.4482421875 3.5989999999999999e-07 0.45175781250000002 4.5979999999999997e-07 0.45175781250000002 4.5989999999999998e-07 0.85605468750000002 5.5980000000000002e-07 0.85605468750000002 5.5990000000000003e-07 0.89824218750000007]
VSs_ns (s_ns 0) vsource type=pwl wave=[0 0.89824218749999996 1.5980000000000001e-07 0.89824218749999996 1.5990000000000002e-07 0.85605468750000002 2.5979999999999998e-07 0.85605468750000002 2.5989999999999999e-07 0.45175781250000002 3.5979999999999998e-07 0.45175781250000002 3.5989999999999999e-07 0.4482421875 4.5979999999999997e-07 0.4482421875 4.5989999999999998e-07 0.0439453125 5.5980000000000002e-07 0.0439453125 5.5990000000000003e-07 0.0017578124999999556]
XSAR (s_d0 s_d1 s_d2 s_d3 s_d4 s_d5 s_d6 s_d7 s_clock VDD! s_n s_p s_rn s_rp 0) tb_sar_top
RSIN (s_ns s_n) resistor r=50
RSIP (s_ps s_p) resistor r=50
VSRN (s_rns 0) vsource dc=0
VSRP (s_rps 0) vsource dc=0.9
RSRN (s_rns s_rn) resistor r=50
RSRP (s_rps s_rp) resistor r=50
CSRN (s_rn 0) capacitor c=4p
CSRP (s_rp 0) capacitor c=4p
XSPROBE (s_d0 s_d1 s_d2 s_d3 s_d4 s_d5 s_d6 s_d7 s_clock VDD! 0) b_behavior_observer model_id=901
CSL0 (s_d0 0) capacitor c=5f
CSL1 (s_d1 0) capacitor c=5f
CSL2 (s_d2 0) capacitor c=5f
CSL3 (s_d3 0) capacitor c=5f
CSL4 (s_d4 0) capacitor c=5f
CSL5 (s_d5 0) capacitor c=5f
CSL6 (s_d6 0) capacitor c=5f
CSL7 (s_d7 0) capacitor c=5f
// A second real SAR receives no comparator response. A new acquisition must
// clear it without a false write/update; this adds no watchdog to the design.
XSTALLED (f_d0 f_d1 f_d2 f_d3 f_d4 f_d5 f_d6 f_d7 s_clock VDD! f_n f_p f_rn f_rp 0) tb_sar_stalled_top
RFIN (s_ns f_n) resistor r=50
RFIP (s_ps f_p) resistor r=50
VFRN (f_rns 0) vsource dc=0
VFRP (f_rps 0) vsource dc=0.9
RFRN (f_rns f_rn) resistor r=50
RFRP (f_rps f_rp) resistor r=50
CFRN (f_rn 0) capacitor c=4p
CFRP (f_rp 0) capacitor c=4p
CFL0 (f_d0 0) capacitor c=5f
CFL1 (f_d1 0) capacitor c=5f
CFL2 (f_d2 0) capacitor c=5f
CFL3 (f_d3 0) capacitor c=5f
CFL4 (f_d4 0) capacitor c=5f
CFL5 (f_d5 0) capacitor c=5f
CFL6 (f_d6 0) capacitor c=5f
CFL7 (f_d7 0) capacitor c=5f

// BEGIN SARADC RNL
// @RNL(author="saradc topology") {
// #VSCLOCK @SET-SYMBOL $VOLTAGE_SOURCE;
// #VSCLOCK @PLACE(-70,0) => @ORIENT("R0");
// #VSCLOCK @TEXT("VSCLOCK",key="name",size=1.3,halign="start") => @PLACE(-67,3);
// #VSCLOCK @TEXT("",key="value",size=0.9,halign="start") => @PLACE(-67,-4);
// #VSCLOCK @TEXT("",key="model");
// #VSs_ps @SET-SYMBOL $VOLTAGE_SOURCE;
// #VSs_ps @PLACE(-70,-33) => @ORIENT("R0");
// #VSs_ps @TEXT("VSs_ps",key="name",size=1.3,halign="start") => @PLACE(-67,-30);
// #VSs_ps @TEXT("",key="value",size=0.9,halign="start") => @PLACE(-67,-37);
// #VSs_ps @TEXT("",key="model");
// #VSs_ns @SET-SYMBOL $VOLTAGE_SOURCE;
// #VSs_ns @PLACE(-70,-66) => @ORIENT("R0");
// #VSs_ns @TEXT("VSs_ns",key="name",size=1.3,halign="start") => @PLACE(-67,-63);
// #VSs_ns @TEXT("",key="value",size=0.9,halign="start") => @PLACE(-67,-70);
// #VSs_ns @TEXT("",key="model");
// #VSRN @SET-SYMBOL $VOLTAGE_SOURCE;
// #VSRN @PLACE(-70,-99) => @ORIENT("R0");
// #VSRN @TEXT("VSRN",key="name",size=1.3,halign="start") => @PLACE(-67,-96);
// #VSRN @TEXT("",key="value",size=0.9,halign="start") => @PLACE(-67,-103);
// #VSRN @TEXT("",key="model");
// #VSRP @SET-SYMBOL $VOLTAGE_SOURCE;
// #VSRP @PLACE(-70,-132) => @ORIENT("R0");
// #VSRP @TEXT("VSRP",key="name",size=1.3,halign="start") => @PLACE(-67,-129);
// #VSRP @TEXT("",key="value",size=0.9,halign="start") => @PLACE(-67,-136);
// #VSRP @TEXT("",key="model");
// #VFRN @SET-SYMBOL $VOLTAGE_SOURCE;
// #VFRN @PLACE(-70,-165) => @ORIENT("R0");
// #VFRN @TEXT("VFRN",key="name",size=1.3,halign="start") => @PLACE(-67,-162);
// #VFRN @TEXT("",key="value",size=0.9,halign="start") => @PLACE(-67,-169);
// #VFRN @TEXT("",key="model");
// #VFRP @SET-SYMBOL $VOLTAGE_SOURCE;
// #VFRP @PLACE(-70,-198) => @ORIENT("R0");
// #VFRP @TEXT("VFRP",key="name",size=1.3,halign="start") => @PLACE(-67,-195);
// #VFRP @TEXT("",key="value",size=0.9,halign="start") => @PLACE(-67,-202);
// #VFRP @TEXT("",key="model");
// #XSAR @SET-SYMBOL $S_tb_sar_top;
// #XSAR @PLACE(0,0) => @ORIENT("R0");
// #XSPROBE @SET-SYMBOL $S_b_behavior_observer;
// #XSPROBE @PLACE(0,-33) => @ORIENT("R0");
// #XSTALLED @SET-SYMBOL $S_tb_sar_stalled_top;
// #XSTALLED @PLACE(0,-66) => @ORIENT("R0");
// #RSIN @SET-SYMBOL $RESISTOR;
// #RSIN @PLACE(90,0) => @ORIENT("R0");
// #RSIN @TEXT("RSIN",key="name",size=1.3,halign="start") => @PLACE(93,3);
// #RSIN @TEXT("r=50",key="value",size=0.9,halign="start") => @PLACE(93,-4);
// #RSIN @TEXT("",key="model");
// #RSIP @SET-SYMBOL $RESISTOR;
// #RSIP @PLACE(90,-33) => @ORIENT("R0");
// #RSIP @TEXT("RSIP",key="name",size=1.3,halign="start") => @PLACE(93,-30);
// #RSIP @TEXT("r=50",key="value",size=0.9,halign="start") => @PLACE(93,-37);
// #RSIP @TEXT("",key="model");
// #RSRN @SET-SYMBOL $RESISTOR;
// #RSRN @PLACE(90,-66) => @ORIENT("R0");
// #RSRN @TEXT("RSRN",key="name",size=1.3,halign="start") => @PLACE(93,-63);
// #RSRN @TEXT("r=50",key="value",size=0.9,halign="start") => @PLACE(93,-70);
// #RSRN @TEXT("",key="model");
// #RSRP @SET-SYMBOL $RESISTOR;
// #RSRP @PLACE(90,-99) => @ORIENT("R0");
// #RSRP @TEXT("RSRP",key="name",size=1.3,halign="start") => @PLACE(93,-96);
// #RSRP @TEXT("r=50",key="value",size=0.9,halign="start") => @PLACE(93,-103);
// #RSRP @TEXT("",key="model");
// #CSRN @SET-SYMBOL $CAPACITOR;
// #CSRN @PLACE(90,-132) => @ORIENT("R0");
// #CSRN @TEXT("CSRN",key="name",size=1.3,halign="start") => @PLACE(93,-129);
// #CSRN @TEXT("c=4p",key="value",size=0.9,halign="start") => @PLACE(93,-136);
// #CSRN @TEXT("",key="model");
// #CSRP @SET-SYMBOL $CAPACITOR;
// #CSRP @PLACE(90,-165) => @ORIENT("R0");
// #CSRP @TEXT("CSRP",key="name",size=1.3,halign="start") => @PLACE(93,-162);
// #CSRP @TEXT("c=4p",key="value",size=0.9,halign="start") => @PLACE(93,-169);
// #CSRP @TEXT("",key="model");
// #CSL0 @SET-SYMBOL $CAPACITOR;
// #CSL0 @PLACE(90,-198) => @ORIENT("R0");
// #CSL0 @TEXT("CSL0",key="name",size=1.3,halign="start") => @PLACE(93,-195);
// #CSL0 @TEXT("c=5f",key="value",size=0.9,halign="start") => @PLACE(93,-202);
// #CSL0 @TEXT("",key="model");
// #CSL1 @SET-SYMBOL $CAPACITOR;
// #CSL1 @PLACE(90,-231) => @ORIENT("R0");
// #CSL1 @TEXT("CSL1",key="name",size=1.3,halign="start") => @PLACE(93,-228);
// #CSL1 @TEXT("c=5f",key="value",size=0.9,halign="start") => @PLACE(93,-235);
// #CSL1 @TEXT("",key="model");
// #CSL2 @SET-SYMBOL $CAPACITOR;
// #CSL2 @PLACE(90,-264) => @ORIENT("R0");
// #CSL2 @TEXT("CSL2",key="name",size=1.3,halign="start") => @PLACE(93,-261);
// #CSL2 @TEXT("c=5f",key="value",size=0.9,halign="start") => @PLACE(93,-268);
// #CSL2 @TEXT("",key="model");
// #CSL3 @SET-SYMBOL $CAPACITOR;
// #CSL3 @PLACE(90,-297) => @ORIENT("R0");
// #CSL3 @TEXT("CSL3",key="name",size=1.3,halign="start") => @PLACE(93,-294);
// #CSL3 @TEXT("c=5f",key="value",size=0.9,halign="start") => @PLACE(93,-301);
// #CSL3 @TEXT("",key="model");
// #CSL4 @SET-SYMBOL $CAPACITOR;
// #CSL4 @PLACE(90,-330) => @ORIENT("R0");
// #CSL4 @TEXT("CSL4",key="name",size=1.3,halign="start") => @PLACE(93,-327);
// #CSL4 @TEXT("c=5f",key="value",size=0.9,halign="start") => @PLACE(93,-334);
// #CSL4 @TEXT("",key="model");
// #CSL5 @SET-SYMBOL $CAPACITOR;
// #CSL5 @PLACE(90,-363) => @ORIENT("R0");
// #CSL5 @TEXT("CSL5",key="name",size=1.3,halign="start") => @PLACE(93,-360);
// #CSL5 @TEXT("c=5f",key="value",size=0.9,halign="start") => @PLACE(93,-367);
// #CSL5 @TEXT("",key="model");
// #CSL6 @SET-SYMBOL $CAPACITOR;
// #CSL6 @PLACE(145,0) => @ORIENT("R0");
// #CSL6 @TEXT("CSL6",key="name",size=1.3,halign="start") => @PLACE(148,3);
// #CSL6 @TEXT("c=5f",key="value",size=0.9,halign="start") => @PLACE(148,-4);
// #CSL6 @TEXT("",key="model");
// #CSL7 @SET-SYMBOL $CAPACITOR;
// #CSL7 @PLACE(145,-33) => @ORIENT("R0");
// #CSL7 @TEXT("CSL7",key="name",size=1.3,halign="start") => @PLACE(148,-30);
// #CSL7 @TEXT("c=5f",key="value",size=0.9,halign="start") => @PLACE(148,-37);
// #CSL7 @TEXT("",key="model");
// #RFIN @SET-SYMBOL $RESISTOR;
// #RFIN @PLACE(145,-66) => @ORIENT("R0");
// #RFIN @TEXT("RFIN",key="name",size=1.3,halign="start") => @PLACE(148,-63);
// #RFIN @TEXT("r=50",key="value",size=0.9,halign="start") => @PLACE(148,-70);
// #RFIN @TEXT("",key="model");
// #RFIP @SET-SYMBOL $RESISTOR;
// #RFIP @PLACE(145,-99) => @ORIENT("R0");
// #RFIP @TEXT("RFIP",key="name",size=1.3,halign="start") => @PLACE(148,-96);
// #RFIP @TEXT("r=50",key="value",size=0.9,halign="start") => @PLACE(148,-103);
// #RFIP @TEXT("",key="model");
// #RFRN @SET-SYMBOL $RESISTOR;
// #RFRN @PLACE(145,-132) => @ORIENT("R0");
// #RFRN @TEXT("RFRN",key="name",size=1.3,halign="start") => @PLACE(148,-129);
// #RFRN @TEXT("r=50",key="value",size=0.9,halign="start") => @PLACE(148,-136);
// #RFRN @TEXT("",key="model");
// #RFRP @SET-SYMBOL $RESISTOR;
// #RFRP @PLACE(145,-165) => @ORIENT("R0");
// #RFRP @TEXT("RFRP",key="name",size=1.3,halign="start") => @PLACE(148,-162);
// #RFRP @TEXT("r=50",key="value",size=0.9,halign="start") => @PLACE(148,-169);
// #RFRP @TEXT("",key="model");
// #CFRN @SET-SYMBOL $CAPACITOR;
// #CFRN @PLACE(145,-198) => @ORIENT("R0");
// #CFRN @TEXT("CFRN",key="name",size=1.3,halign="start") => @PLACE(148,-195);
// #CFRN @TEXT("c=4p",key="value",size=0.9,halign="start") => @PLACE(148,-202);
// #CFRN @TEXT("",key="model");
// #CFRP @SET-SYMBOL $CAPACITOR;
// #CFRP @PLACE(145,-231) => @ORIENT("R0");
// #CFRP @TEXT("CFRP",key="name",size=1.3,halign="start") => @PLACE(148,-228);
// #CFRP @TEXT("c=4p",key="value",size=0.9,halign="start") => @PLACE(148,-235);
// #CFRP @TEXT("",key="model");
// #CFL0 @SET-SYMBOL $CAPACITOR;
// #CFL0 @PLACE(145,-264) => @ORIENT("R0");
// #CFL0 @TEXT("CFL0",key="name",size=1.3,halign="start") => @PLACE(148,-261);
// #CFL0 @TEXT("c=5f",key="value",size=0.9,halign="start") => @PLACE(148,-268);
// #CFL0 @TEXT("",key="model");
// #CFL1 @SET-SYMBOL $CAPACITOR;
// #CFL1 @PLACE(145,-297) => @ORIENT("R0");
// #CFL1 @TEXT("CFL1",key="name",size=1.3,halign="start") => @PLACE(148,-294);
// #CFL1 @TEXT("c=5f",key="value",size=0.9,halign="start") => @PLACE(148,-301);
// #CFL1 @TEXT("",key="model");
// #CFL2 @SET-SYMBOL $CAPACITOR;
// #CFL2 @PLACE(145,-330) => @ORIENT("R0");
// #CFL2 @TEXT("CFL2",key="name",size=1.3,halign="start") => @PLACE(148,-327);
// #CFL2 @TEXT("c=5f",key="value",size=0.9,halign="start") => @PLACE(148,-334);
// #CFL2 @TEXT("",key="model");
// #CFL3 @SET-SYMBOL $CAPACITOR;
// #CFL3 @PLACE(145,-363) => @ORIENT("R0");
// #CFL3 @TEXT("CFL3",key="name",size=1.3,halign="start") => @PLACE(148,-360);
// #CFL3 @TEXT("c=5f",key="value",size=0.9,halign="start") => @PLACE(148,-367);
// #CFL3 @TEXT("",key="model");
// #CFL4 @SET-SYMBOL $CAPACITOR;
// #CFL4 @PLACE(200,0) => @ORIENT("R0");
// #CFL4 @TEXT("CFL4",key="name",size=1.3,halign="start") => @PLACE(203,3);
// #CFL4 @TEXT("c=5f",key="value",size=0.9,halign="start") => @PLACE(203,-4);
// #CFL4 @TEXT("",key="model");
// #CFL5 @SET-SYMBOL $CAPACITOR;
// #CFL5 @PLACE(200,-33) => @ORIENT("R0");
// #CFL5 @TEXT("CFL5",key="name",size=1.3,halign="start") => @PLACE(203,-30);
// #CFL5 @TEXT("c=5f",key="value",size=0.9,halign="start") => @PLACE(203,-37);
// #CFL5 @TEXT("",key="model");
// #CFL6 @SET-SYMBOL $CAPACITOR;
// #CFL6 @PLACE(200,-66) => @ORIENT("R0");
// #CFL6 @TEXT("CFL6",key="name",size=1.3,halign="start") => @PLACE(203,-63);
// #CFL6 @TEXT("c=5f",key="value",size=0.9,halign="start") => @PLACE(203,-70);
// #CFL6 @TEXT("",key="model");
// #CFL7 @SET-SYMBOL $CAPACITOR;
// #CFL7 @PLACE(200,-99) => @ORIENT("R0");
// #CFL7 @TEXT("CFL7",key="name",size=1.3,halign="start") => @PLACE(203,-96);
// #CFL7 @TEXT("c=5f",key="value",size=0.9,halign="start") => @PLACE(203,-103);
// #CFL7 @TEXT("",key="model");
// &"s_n" @WIRE(mode="straight",linecolor="#30485d",linewidth=0.16) {#XSAR:11 (38.5,3.3) (38.5,-2) #RSIN:2};
// &"s_p" @WIRE(mode="straight",linecolor="#30485d",linewidth=0.16) {#XSAR:12 (38.5,0) (38.5,-35) #RSIP:2};
// (-89,30) @TEXT("tb_sar / source-derived connections",size=1.4,halign="start",textcolor="#223d52");
// &"s_clock" @WIRE(mode="straight",linecolor="#30485d",linewidth=0.16) {#VSCLOCK:1 (-70,5)};
// (-70,5.4) @TEXT("s_clock",size=1.1,halign="middle",valign="bottom");
// &"0" @WIRE(mode="straight",linecolor="#30485d",linewidth=0.16) {#VSCLOCK:2 (-70,-5)};
// (-70,-5.4) @TEXT("0",size=1.1,halign="middle",valign="top");
// &"s_ps" @WIRE(mode="straight",linecolor="#30485d",linewidth=0.16) {#VSs_ps:1 (-70,-28)};
// (-70,-27.6) @TEXT("s_ps",size=1.1,halign="middle",valign="bottom");
// &"0" @WIRE(mode="straight",linecolor="#30485d",linewidth=0.16) {#VSs_ps:2 (-70,-38)};
// (-70,-38.4) @TEXT("0",size=1.1,halign="middle",valign="top");
// &"s_ns" @WIRE(mode="straight",linecolor="#30485d",linewidth=0.16) {#VSs_ns:1 (-70,-61)};
// (-70,-60.6) @TEXT("s_ns",size=1.1,halign="middle",valign="bottom");
// &"0" @WIRE(mode="straight",linecolor="#30485d",linewidth=0.16) {#VSs_ns:2 (-70,-71)};
// (-70,-71.4) @TEXT("0",size=1.1,halign="middle",valign="top");
// {&"s_d0" &"s_d1" &"s_d2" &"s_d3" &"s_d4" &"s_d5" &"s_d6" &"s_d7"} @WIRE(mode="straight",linewidth=0.3) {#XSAR:1 (16,0)};
// (16.4,0) @TEXT("s_d[7:0]",size=1.1,halign="start",valign="middle");
// &"s_clock" @WIRE(mode="straight",linecolor="#30485d",linewidth=0.16) {#XSAR:9 (-16,6.6)};
// (-16.4,6.6) @TEXT("s_clock",size=1.1,halign="end",valign="middle");
// &"VDD!" @WIRE(mode="straight",linecolor="#30485d",linewidth=0.16) {#XSAR:10 (0,14.9)};
// (0,15.3) @TEXT("VDD!",size=1.1,halign="middle",valign="bottom");
// &"s_rn" @WIRE(mode="straight",linecolor="#30485d",linewidth=0.16) {#XSAR:13 (-16,-3.3)};
// (-16.4,-3.3) @TEXT("s_rn",size=1.1,halign="end",valign="middle");
// &"s_rp" @WIRE(mode="straight",linecolor="#30485d",linewidth=0.16) {#XSAR:14 (-16,-6.6)};
// (-16.4,-6.6) @TEXT("s_rp",size=1.1,halign="end",valign="middle");
// &"0" @WIRE(mode="straight",linecolor="#30485d",linewidth=0.16) {#XSAR:15 (0,-14.9)};
// (0,-15.3) @TEXT("0",size=1.1,halign="middle",valign="top");
// &"s_ns" @WIRE(mode="straight",linecolor="#30485d",linewidth=0.16) {#RSIN:1 (90,5)};
// (90,5.4) @TEXT("s_ns",size=1.1,halign="middle",valign="bottom");
// &"s_ps" @WIRE(mode="straight",linecolor="#30485d",linewidth=0.16) {#RSIP:1 (90,-28)};
// (90,-27.6) @TEXT("s_ps",size=1.1,halign="middle",valign="bottom");
// &"s_rns" @WIRE(mode="straight",linecolor="#30485d",linewidth=0.16) {#VSRN:1 (-70,-94)};
// (-70,-93.6) @TEXT("s_rns",size=1.1,halign="middle",valign="bottom");
// &"0" @WIRE(mode="straight",linecolor="#30485d",linewidth=0.16) {#VSRN:2 (-70,-104)};
// (-70,-104.4) @TEXT("0",size=1.1,halign="middle",valign="top");
// &"s_rps" @WIRE(mode="straight",linecolor="#30485d",linewidth=0.16) {#VSRP:1 (-70,-127)};
// (-70,-126.6) @TEXT("s_rps",size=1.1,halign="middle",valign="bottom");
// &"0" @WIRE(mode="straight",linecolor="#30485d",linewidth=0.16) {#VSRP:2 (-70,-137)};
// (-70,-137.4) @TEXT("0",size=1.1,halign="middle",valign="top");
// &"s_rns" @WIRE(mode="straight",linecolor="#30485d",linewidth=0.16) {#RSRN:1 (90,-61)};
// (90,-60.6) @TEXT("s_rns",size=1.1,halign="middle",valign="bottom");
// &"s_rn" @WIRE(mode="straight",linecolor="#30485d",linewidth=0.16) {#RSRN:2 (90,-71)};
// (90,-71.4) @TEXT("s_rn",size=1.1,halign="middle",valign="top");
// &"s_rps" @WIRE(mode="straight",linecolor="#30485d",linewidth=0.16) {#RSRP:1 (90,-94)};
// (90,-93.6) @TEXT("s_rps",size=1.1,halign="middle",valign="bottom");
// &"s_rp" @WIRE(mode="straight",linecolor="#30485d",linewidth=0.16) {#RSRP:2 (90,-104)};
// (90,-104.4) @TEXT("s_rp",size=1.1,halign="middle",valign="top");
// &"s_rn" @WIRE(mode="straight",linecolor="#30485d",linewidth=0.16) {#CSRN:1 (90,-127)};
// (90,-126.6) @TEXT("s_rn",size=1.1,halign="middle",valign="bottom");
// &"0" @WIRE(mode="straight",linecolor="#30485d",linewidth=0.16) {#CSRN:2 (90,-137)};
// (90,-137.4) @TEXT("0",size=1.1,halign="middle",valign="top");
// &"s_rp" @WIRE(mode="straight",linecolor="#30485d",linewidth=0.16) {#CSRP:1 (90,-160)};
// (90,-159.6) @TEXT("s_rp",size=1.1,halign="middle",valign="bottom");
// &"0" @WIRE(mode="straight",linecolor="#30485d",linewidth=0.16) {#CSRP:2 (90,-170)};
// (90,-170.4) @TEXT("0",size=1.1,halign="middle",valign="top");
// {&"s_d0" &"s_d1" &"s_d2" &"s_d3" &"s_d4" &"s_d5" &"s_d6" &"s_d7"} @WIRE(mode="straight",linewidth=0.3) {#XSPROBE:1 (16,-33)};
// (16.4,-33) @TEXT("s_d[7:0]",size=1.1,halign="start",valign="middle");
// &"s_clock" @WIRE(mode="straight",linecolor="#30485d",linewidth=0.16) {#XSPROBE:9 (-16,-33)};
// (-16.4,-33) @TEXT("s_clock",size=1.1,halign="end",valign="middle");
// &"VDD!" @WIRE(mode="straight",linecolor="#30485d",linewidth=0.16) {#XSPROBE:10 (0,-22)};
// (0,-21.6) @TEXT("VDD!",size=1.1,halign="middle",valign="bottom");
// &"0" @WIRE(mode="straight",linecolor="#30485d",linewidth=0.16) {#XSPROBE:11 (0,-44)};
// (0,-44.4) @TEXT("0",size=1.1,halign="middle",valign="top");
// &"s_d0" @WIRE(mode="straight",linecolor="#30485d",linewidth=0.16) {#CSL0:1 (90,-193)};
// (90,-192.6) @TEXT("s_d0",size=1.1,halign="middle",valign="bottom");
// &"0" @WIRE(mode="straight",linecolor="#30485d",linewidth=0.16) {#CSL0:2 (90,-203)};
// (90,-203.4) @TEXT("0",size=1.1,halign="middle",valign="top");
// &"s_d1" @WIRE(mode="straight",linecolor="#30485d",linewidth=0.16) {#CSL1:1 (90,-226)};
// (90,-225.6) @TEXT("s_d1",size=1.1,halign="middle",valign="bottom");
// &"0" @WIRE(mode="straight",linecolor="#30485d",linewidth=0.16) {#CSL1:2 (90,-236)};
// (90,-236.4) @TEXT("0",size=1.1,halign="middle",valign="top");
// &"s_d2" @WIRE(mode="straight",linecolor="#30485d",linewidth=0.16) {#CSL2:1 (90,-259)};
// (90,-258.6) @TEXT("s_d2",size=1.1,halign="middle",valign="bottom");
// &"0" @WIRE(mode="straight",linecolor="#30485d",linewidth=0.16) {#CSL2:2 (90,-269)};
// (90,-269.4) @TEXT("0",size=1.1,halign="middle",valign="top");
// &"s_d3" @WIRE(mode="straight",linecolor="#30485d",linewidth=0.16) {#CSL3:1 (90,-292)};
// (90,-291.6) @TEXT("s_d3",size=1.1,halign="middle",valign="bottom");
// &"0" @WIRE(mode="straight",linecolor="#30485d",linewidth=0.16) {#CSL3:2 (90,-302)};
// (90,-302.4) @TEXT("0",size=1.1,halign="middle",valign="top");
// &"s_d4" @WIRE(mode="straight",linecolor="#30485d",linewidth=0.16) {#CSL4:1 (90,-325)};
// (90,-324.6) @TEXT("s_d4",size=1.1,halign="middle",valign="bottom");
// &"0" @WIRE(mode="straight",linecolor="#30485d",linewidth=0.16) {#CSL4:2 (90,-335)};
// (90,-335.4) @TEXT("0",size=1.1,halign="middle",valign="top");
// &"s_d5" @WIRE(mode="straight",linecolor="#30485d",linewidth=0.16) {#CSL5:1 (90,-358)};
// (90,-357.6) @TEXT("s_d5",size=1.1,halign="middle",valign="bottom");
// &"0" @WIRE(mode="straight",linecolor="#30485d",linewidth=0.16) {#CSL5:2 (90,-368)};
// (90,-368.4) @TEXT("0",size=1.1,halign="middle",valign="top");
// &"s_d6" @WIRE(mode="straight",linecolor="#30485d",linewidth=0.16) {#CSL6:1 (145,5)};
// (145,5.4) @TEXT("s_d6",size=1.1,halign="middle",valign="bottom");
// &"0" @WIRE(mode="straight",linecolor="#30485d",linewidth=0.16) {#CSL6:2 (145,-5)};
// (145,-5.4) @TEXT("0",size=1.1,halign="middle",valign="top");
// &"s_d7" @WIRE(mode="straight",linecolor="#30485d",linewidth=0.16) {#CSL7:1 (145,-28)};
// (145,-27.6) @TEXT("s_d7",size=1.1,halign="middle",valign="bottom");
// &"0" @WIRE(mode="straight",linecolor="#30485d",linewidth=0.16) {#CSL7:2 (145,-38)};
// (145,-38.4) @TEXT("0",size=1.1,halign="middle",valign="top");
// {&"f_d0" &"f_d1" &"f_d2" &"f_d3" &"f_d4" &"f_d5" &"f_d6" &"f_d7"} @WIRE(mode="straight",linewidth=0.3) {#XSTALLED:1 (16,-66)};
// (16.4,-66) @TEXT("f_d[7:0]",size=1.1,halign="start",valign="middle");
// &"s_clock" @WIRE(mode="straight",linecolor="#30485d",linewidth=0.16) {#XSTALLED:9 (-16,-59.4)};
// (-16.4,-59.4) @TEXT("s_clock",size=1.1,halign="end",valign="middle");
// &"VDD!" @WIRE(mode="straight",linecolor="#30485d",linewidth=0.16) {#XSTALLED:10 (0,-51.1)};
// (0,-50.7) @TEXT("VDD!",size=1.1,halign="middle",valign="bottom");
// &"f_n" @WIRE(mode="straight",linecolor="#30485d",linewidth=0.16) {#XSTALLED:11 (-16,-62.7)};
// (-16.4,-62.7) @TEXT("f_n",size=1.1,halign="end",valign="middle");
// &"f_p" @WIRE(mode="straight",linecolor="#30485d",linewidth=0.16) {#XSTALLED:12 (-16,-66)};
// (-16.4,-66) @TEXT("f_p",size=1.1,halign="end",valign="middle");
// &"f_rn" @WIRE(mode="straight",linecolor="#30485d",linewidth=0.16) {#XSTALLED:13 (-16,-69.3)};
// (-16.4,-69.3) @TEXT("f_rn",size=1.1,halign="end",valign="middle");
// &"f_rp" @WIRE(mode="straight",linecolor="#30485d",linewidth=0.16) {#XSTALLED:14 (-16,-72.6)};
// (-16.4,-72.6) @TEXT("f_rp",size=1.1,halign="end",valign="middle");
// &"0" @WIRE(mode="straight",linecolor="#30485d",linewidth=0.16) {#XSTALLED:15 (0,-80.9)};
// (0,-81.3) @TEXT("0",size=1.1,halign="middle",valign="top");
// &"s_ns" @WIRE(mode="straight",linecolor="#30485d",linewidth=0.16) {#RFIN:1 (145,-61)};
// (145,-60.6) @TEXT("s_ns",size=1.1,halign="middle",valign="bottom");
// &"f_n" @WIRE(mode="straight",linecolor="#30485d",linewidth=0.16) {#RFIN:2 (145,-71)};
// (145,-71.4) @TEXT("f_n",size=1.1,halign="middle",valign="top");
// &"s_ps" @WIRE(mode="straight",linecolor="#30485d",linewidth=0.16) {#RFIP:1 (145,-94)};
// (145,-93.6) @TEXT("s_ps",size=1.1,halign="middle",valign="bottom");
// &"f_p" @WIRE(mode="straight",linecolor="#30485d",linewidth=0.16) {#RFIP:2 (145,-104)};
// (145,-104.4) @TEXT("f_p",size=1.1,halign="middle",valign="top");
// &"f_rns" @WIRE(mode="straight",linecolor="#30485d",linewidth=0.16) {#VFRN:1 (-70,-160)};
// (-70,-159.6) @TEXT("f_rns",size=1.1,halign="middle",valign="bottom");
// &"0" @WIRE(mode="straight",linecolor="#30485d",linewidth=0.16) {#VFRN:2 (-70,-170)};
// (-70,-170.4) @TEXT("0",size=1.1,halign="middle",valign="top");
// &"f_rps" @WIRE(mode="straight",linecolor="#30485d",linewidth=0.16) {#VFRP:1 (-70,-193)};
// (-70,-192.6) @TEXT("f_rps",size=1.1,halign="middle",valign="bottom");
// &"0" @WIRE(mode="straight",linecolor="#30485d",linewidth=0.16) {#VFRP:2 (-70,-203)};
// (-70,-203.4) @TEXT("0",size=1.1,halign="middle",valign="top");
// &"f_rns" @WIRE(mode="straight",linecolor="#30485d",linewidth=0.16) {#RFRN:1 (145,-127)};
// (145,-126.6) @TEXT("f_rns",size=1.1,halign="middle",valign="bottom");
// &"f_rn" @WIRE(mode="straight",linecolor="#30485d",linewidth=0.16) {#RFRN:2 (145,-137)};
// (145,-137.4) @TEXT("f_rn",size=1.1,halign="middle",valign="top");
// &"f_rps" @WIRE(mode="straight",linecolor="#30485d",linewidth=0.16) {#RFRP:1 (145,-160)};
// (145,-159.6) @TEXT("f_rps",size=1.1,halign="middle",valign="bottom");
// &"f_rp" @WIRE(mode="straight",linecolor="#30485d",linewidth=0.16) {#RFRP:2 (145,-170)};
// (145,-170.4) @TEXT("f_rp",size=1.1,halign="middle",valign="top");
// &"f_rn" @WIRE(mode="straight",linecolor="#30485d",linewidth=0.16) {#CFRN:1 (145,-193)};
// (145,-192.6) @TEXT("f_rn",size=1.1,halign="middle",valign="bottom");
// &"0" @WIRE(mode="straight",linecolor="#30485d",linewidth=0.16) {#CFRN:2 (145,-203)};
// (145,-203.4) @TEXT("0",size=1.1,halign="middle",valign="top");
// &"f_rp" @WIRE(mode="straight",linecolor="#30485d",linewidth=0.16) {#CFRP:1 (145,-226)};
// (145,-225.6) @TEXT("f_rp",size=1.1,halign="middle",valign="bottom");
// &"0" @WIRE(mode="straight",linecolor="#30485d",linewidth=0.16) {#CFRP:2 (145,-236)};
// (145,-236.4) @TEXT("0",size=1.1,halign="middle",valign="top");
// &"f_d0" @WIRE(mode="straight",linecolor="#30485d",linewidth=0.16) {#CFL0:1 (145,-259)};
// (145,-258.6) @TEXT("f_d0",size=1.1,halign="middle",valign="bottom");
// &"0" @WIRE(mode="straight",linecolor="#30485d",linewidth=0.16) {#CFL0:2 (145,-269)};
// (145,-269.4) @TEXT("0",size=1.1,halign="middle",valign="top");
// &"f_d1" @WIRE(mode="straight",linecolor="#30485d",linewidth=0.16) {#CFL1:1 (145,-292)};
// (145,-291.6) @TEXT("f_d1",size=1.1,halign="middle",valign="bottom");
// &"0" @WIRE(mode="straight",linecolor="#30485d",linewidth=0.16) {#CFL1:2 (145,-302)};
// (145,-302.4) @TEXT("0",size=1.1,halign="middle",valign="top");
// &"f_d2" @WIRE(mode="straight",linecolor="#30485d",linewidth=0.16) {#CFL2:1 (145,-325)};
// (145,-324.6) @TEXT("f_d2",size=1.1,halign="middle",valign="bottom");
// &"0" @WIRE(mode="straight",linecolor="#30485d",linewidth=0.16) {#CFL2:2 (145,-335)};
// (145,-335.4) @TEXT("0",size=1.1,halign="middle",valign="top");
// &"f_d3" @WIRE(mode="straight",linecolor="#30485d",linewidth=0.16) {#CFL3:1 (145,-358)};
// (145,-357.6) @TEXT("f_d3",size=1.1,halign="middle",valign="bottom");
// &"0" @WIRE(mode="straight",linecolor="#30485d",linewidth=0.16) {#CFL3:2 (145,-368)};
// (145,-368.4) @TEXT("0",size=1.1,halign="middle",valign="top");
// &"f_d4" @WIRE(mode="straight",linecolor="#30485d",linewidth=0.16) {#CFL4:1 (200,5)};
// (200,5.4) @TEXT("f_d4",size=1.1,halign="middle",valign="bottom");
// &"0" @WIRE(mode="straight",linecolor="#30485d",linewidth=0.16) {#CFL4:2 (200,-5)};
// (200,-5.4) @TEXT("0",size=1.1,halign="middle",valign="top");
// &"f_d5" @WIRE(mode="straight",linecolor="#30485d",linewidth=0.16) {#CFL5:1 (200,-28)};
// (200,-27.6) @TEXT("f_d5",size=1.1,halign="middle",valign="bottom");
// &"0" @WIRE(mode="straight",linecolor="#30485d",linewidth=0.16) {#CFL5:2 (200,-38)};
// (200,-38.4) @TEXT("0",size=1.1,halign="middle",valign="top");
// &"f_d6" @WIRE(mode="straight",linecolor="#30485d",linewidth=0.16) {#CFL6:1 (200,-61)};
// (200,-60.6) @TEXT("f_d6",size=1.1,halign="middle",valign="bottom");
// &"0" @WIRE(mode="straight",linecolor="#30485d",linewidth=0.16) {#CFL6:2 (200,-71)};
// (200,-71.4) @TEXT("0",size=1.1,halign="middle",valign="top");
// &"f_d7" @WIRE(mode="straight",linecolor="#30485d",linewidth=0.16) {#CFL7:1 (200,-94)};
// (200,-93.6) @TEXT("f_d7",size=1.1,halign="middle",valign="bottom");
// &"0" @WIRE(mode="straight",linecolor="#30485d",linewidth=0.16) {#CFL7:2 (200,-104)};
// (200,-104.4) @TEXT("0",size=1.1,halign="middle",valign="top");
// }
// END SARADC RNL
ends tb_sar

subckt tb_sar_top D0 D1 D2 D3 D4 D5 D6 D7 SAMPLE VDD! VINN VINP  VREFN VREFP 0
    XSEQ (SAMPLE_INT VDD! 0 SEQ_SAMPLE) sar8_se_acquire
    XDONE (ACTIVE DONE VDD! 0) INVD1BWP12T30P140
    XPRESET (DONE SEQ_SAMPLE PRESET VDD! 0) OR2D1BWP12T30P140
    XSAMPLE (SAMPLE SAMPLE_INT VDD! 0) CKBD1BWP12T30P140
    XBOOTN (SEQ_SAMPLE TOPN VINN) b_sampler_bridge
    XBOOTP (SEQ_SAMPLE TOPP VINP) b_sampler_bridge
    XCDAC (GNN0 GNN1 GNN2 GNN3 GNN4 GNN5 GNN6 GNN7 GNP0 GNP1 GNP2 GNP3  GNP4 GNP5 GNP6 GNP7 GPN0 GPN1 GPN2 GPN3 GPN4 GPN5 GPN6 GPN7 GPP0  GPP1 GPP2 GPP3 GPP4 GPP5 GPP6 GPP7 TOPN TOPP VDD! VREFN VREFP 0)  b_cdac
    XCTRL (CMP_CLK CODE0 CODE1 CODE2 CODE3 CODE4 CODE5 CODE6 CODE7 COMP_N  COMP_P D0 D1 D2 D3 D4 D5 D6 D7 PHI_U SEQ_SAMPLE VDD! 0 ACTIVE) sar8_se_ctrl
    XREF (CODE0 CODE1 CODE2 CODE3 CODE4 CODE5 CODE6 CODE7 D0 D1 D2 D3 D4  D5 D6 D7 GNN0 GNN1 GNN2 GNN3 GNN4 GNN5 GNN6 GNN7 GNP0 GNP1 GNP2  GNP3 GNP4 GNP5 GNP6 GNP7 GPN0 GPN1 GPN2 GPN3 GPN4 GPN5 GPN6 GPN7  GPP0 GPP1 GPP2 GPP3 GPP4 GPP5 GPP6 GPP7 PHI_U SAMPLE_INT VDD! 0 RST_DONE PRESET)  b_reference
    XCOMP (CMP_CLK COMP_N COMP_P VDD! TOPN TOPP 0) b_comparator
    CL_COMP_N (COMP_N 0) cfmom_2t nr=8 lr=2.5u w=50n s=50n stm=1 spm=3  multi=2 mismatchflag=1
    CL_COMP_P (COMP_P 0) cfmom_2t nr=8 lr=2.5u w=50n s=50n stm=1 spm=3  multi=2 mismatchflag=1
    CL_CMP_CLK (CMP_CLK 0) cfmom_2t nr=8 lr=2.5u w=50n s=50n stm=1 spm=3  multi=2 mismatchflag=1
// BEGIN SARADC RNL
// @RNL(author="saradc topology") {
// #XSEQ @SET-SYMBOL $S_sar8_se_acquire;
// #XSEQ @PLACE(0,0) => @ORIENT("R0");
// #XDONE @SET-SYMBOL $S_INVD1BWP12T30P140;
// #XDONE @PLACE(0,-33) => @ORIENT("R0");
// #XPRESET @SET-SYMBOL $S_OR2D1BWP12T30P140;
// #XPRESET @PLACE(0,-66) => @ORIENT("R0");
// #XSAMPLE @SET-SYMBOL $S_CKBD1BWP12T30P140;
// #XSAMPLE @PLACE(0,-99) => @ORIENT("R0");
// #XBOOTN @SET-SYMBOL $S_b_sampler_bridge;
// #XBOOTN @PLACE(0,-132) => @ORIENT("R0");
// #XBOOTP @SET-SYMBOL $S_b_sampler_bridge;
// #XBOOTP @PLACE(0,-165) => @ORIENT("R0");
// #XCDAC @SET-SYMBOL $S_b_cdac;
// #XCDAC @PLACE(0,-198) => @ORIENT("R0");
// #XCTRL @SET-SYMBOL $S_sar8_se_ctrl;
// #XCTRL @PLACE(0,-231) => @ORIENT("R0");
// #XREF @SET-SYMBOL $S_b_reference;
// #XREF @PLACE(0,-264) => @ORIENT("R0");
// #XCOMP @SET-SYMBOL $S_b_comparator;
// #XCOMP @PLACE(0,-297) => @ORIENT("R0");
// #CL_COMP_N @SET-SYMBOL $CAPACITOR;
// #CL_COMP_N @PLACE(90,0) => @ORIENT("R0");
// #CL_COMP_N @TEXT("CL_COMP_N",key="name",size=1.3,halign="start") => @PLACE(93,3);
// #CL_COMP_N @TEXT("nr=8 lr=2.5u w=50n multi=2",key="value",size=0.9,halign="start") => @PLACE(93,-4);
// #CL_COMP_N @TEXT("",key="model");
// #CL_COMP_P @SET-SYMBOL $CAPACITOR;
// #CL_COMP_P @PLACE(90,-33) => @ORIENT("R0");
// #CL_COMP_P @TEXT("CL_COMP_P",key="name",size=1.3,halign="start") => @PLACE(93,-30);
// #CL_COMP_P @TEXT("nr=8 lr=2.5u w=50n multi=2",key="value",size=0.9,halign="start") => @PLACE(93,-37);
// #CL_COMP_P @TEXT("",key="model");
// #CL_CMP_CLK @SET-SYMBOL $CAPACITOR;
// #CL_CMP_CLK @PLACE(90,-66) => @ORIENT("R0");
// #CL_CMP_CLK @TEXT("CL_CMP_CLK",key="name",size=1.3,halign="start") => @PLACE(93,-63);
// #CL_CMP_CLK @TEXT("nr=8 lr=2.5u w=50n multi=2",key="value",size=0.9,halign="start") => @PLACE(93,-70);
// #CL_CMP_CLK @TEXT("",key="model");
// &"DONE" @WIRE(mode="straight",linecolor="#30485d",linewidth=0.16) {#XDONE:2 (-3,-33) (-3,-64.35) #XPRESET:1};
// &"PHI_U" @WIRE(mode="straight",linecolor="#30485d",linewidth=0.16) {#XCTRL:20 (0,-234.3) (0,-265.65) #XREF:49};
// (-89,30) @TEXT("tb_sar_top / source-derived connections",size=1.4,halign="start",textcolor="#223d52");
// &"SAMPLE_INT" @WIRE(mode="straight",linecolor="#30485d",linewidth=0.16) {#XSEQ:1 (-16,0)};
// (-16.4,0) @TEXT("SAMPLE_INT",size=1.1,halign="end",valign="middle");
// &"VDD!" @WIRE(mode="straight",linecolor="#30485d",linewidth=0.16) {#XSEQ:2 (0,11)};
// (0,11.4) @TEXT("VDD!",size=1.1,halign="middle",valign="bottom");
// &"0" @WIRE(mode="straight",linecolor="#30485d",linewidth=0.16) {#XSEQ:3 (0,-11)};
// (0,-11.4) @TEXT("0",size=1.1,halign="middle",valign="top");
// &"SEQ_SAMPLE" @WIRE(mode="straight",linecolor="#30485d",linewidth=0.16) {#XSEQ:4 (16,0)};
// (16.4,0) @TEXT("SEQ_SAMPLE",size=1.1,halign="start",valign="middle");
// &"ACTIVE" @WIRE(mode="straight",linecolor="#30485d",linewidth=0.16) {#XDONE:1 (-10,-33)};
// (-10.4,-33) @TEXT("ACTIVE",size=1.1,halign="end",valign="middle");
// &"VDD!" @WIRE(mode="straight",linecolor="#30485d",linewidth=0.16) {#XDONE:3 (0,-23)};
// (0,-22.6) @TEXT("VDD!",size=1.1,halign="middle",valign="bottom");
// &"0" @WIRE(mode="straight",linecolor="#30485d",linewidth=0.16) {#XDONE:4 (0,-43)};
// (0,-43.4) @TEXT("0",size=1.1,halign="middle",valign="top");
// &"SEQ_SAMPLE" @WIRE(mode="straight",linecolor="#30485d",linewidth=0.16) {#XPRESET:2 (-16,-67.65)};
// (-16.4,-67.65) @TEXT("SEQ_SAMPLE",size=1.1,halign="end",valign="middle");
// &"PRESET" @WIRE(mode="straight",linecolor="#30485d",linewidth=0.16) {#XPRESET:3 (16,-66)};
// (16.4,-66) @TEXT("PRESET",size=1.1,halign="start",valign="middle");
// &"VDD!" @WIRE(mode="straight",linecolor="#30485d",linewidth=0.16) {#XPRESET:4 (0,-55)};
// (0,-54.6) @TEXT("VDD!",size=1.1,halign="middle",valign="bottom");
// &"0" @WIRE(mode="straight",linecolor="#30485d",linewidth=0.16) {#XPRESET:5 (0,-77)};
// (0,-77.4) @TEXT("0",size=1.1,halign="middle",valign="top");
// &"SAMPLE" @WIRE(mode="straight",linecolor="#30485d",linewidth=0.16) {#XSAMPLE:1 (-16,-99)};
// (-16.4,-99) @TEXT("SAMPLE",size=1.1,halign="end",valign="middle");
// &"SAMPLE_INT" @WIRE(mode="straight",linecolor="#30485d",linewidth=0.16) {#XSAMPLE:2 (16,-99)};
// (16.4,-99) @TEXT("SAMPLE_INT",size=1.1,halign="start",valign="middle");
// &"VDD!" @WIRE(mode="straight",linecolor="#30485d",linewidth=0.16) {#XSAMPLE:3 (0,-88)};
// (0,-87.6) @TEXT("VDD!",size=1.1,halign="middle",valign="bottom");
// &"0" @WIRE(mode="straight",linecolor="#30485d",linewidth=0.16) {#XSAMPLE:4 (0,-110)};
// (0,-110.4) @TEXT("0",size=1.1,halign="middle",valign="top");
// &"SEQ_SAMPLE" @WIRE(mode="straight",linecolor="#30485d",linewidth=0.16) {#XBOOTN:1 (-16,-130.35)};
// (-16.4,-130.35) @TEXT("SEQ_SAMPLE",size=1.1,halign="end",valign="middle");
// &"TOPN" @WIRE(mode="straight",linecolor="#30485d",linewidth=0.16) {#XBOOTN:2 (16,-132)};
// (16.4,-132) @TEXT("TOPN",size=1.1,halign="start",valign="middle");
// &"VINN" @WIRE(mode="straight",linecolor="#30485d",linewidth=0.16) {#XBOOTN:3 (-16,-133.65)};
// (-16.4,-133.65) @TEXT("VINN",size=1.1,halign="end",valign="middle");
// &"SEQ_SAMPLE" @WIRE(mode="straight",linecolor="#30485d",linewidth=0.16) {#XBOOTP:1 (-16,-163.35)};
// (-16.4,-163.35) @TEXT("SEQ_SAMPLE",size=1.1,halign="end",valign="middle");
// &"TOPP" @WIRE(mode="straight",linecolor="#30485d",linewidth=0.16) {#XBOOTP:2 (16,-165)};
// (16.4,-165) @TEXT("TOPP",size=1.1,halign="start",valign="middle");
// &"VINP" @WIRE(mode="straight",linecolor="#30485d",linewidth=0.16) {#XBOOTP:3 (-16,-166.65)};
// (-16.4,-166.65) @TEXT("VINP",size=1.1,halign="end",valign="middle");
// {&"GNN0" &"GNN1" &"GNN2" &"GNN3" &"GNN4" &"GNN5" &"GNN6" &"GNN7"} @WIRE(mode="straight",linewidth=0.3) {#XCDAC:1 (-16,-189.75)};
// (-16.4,-189.75) @TEXT("GNN[7:0]",size=1.1,halign="end",valign="middle");
// {&"GNP0" &"GNP1" &"GNP2" &"GNP3" &"GNP4" &"GNP5" &"GNP6" &"GNP7"} @WIRE(mode="straight",linewidth=0.3) {#XCDAC:9 (-16,-193.05)};
// (-16.4,-193.05) @TEXT("GNP[7:0]",size=1.1,halign="end",valign="middle");
// {&"GPN0" &"GPN1" &"GPN2" &"GPN3" &"GPN4" &"GPN5" &"GPN6" &"GPN7"} @WIRE(mode="straight",linewidth=0.3) {#XCDAC:17 (-16,-196.35)};
// (-16.4,-196.35) @TEXT("GPN[7:0]",size=1.1,halign="end",valign="middle");
// {&"GPP0" &"GPP1" &"GPP2" &"GPP3" &"GPP4" &"GPP5" &"GPP6" &"GPP7"} @WIRE(mode="straight",linewidth=0.3) {#XCDAC:25 (-16,-199.65)};
// (-16.4,-199.65) @TEXT("GPP[7:0]",size=1.1,halign="end",valign="middle");
// &"TOPN" @WIRE(mode="straight",linecolor="#30485d",linewidth=0.16) {#XCDAC:33 (16,-196.35)};
// (16.4,-196.35) @TEXT("TOPN",size=1.1,halign="start",valign="middle");
// &"TOPP" @WIRE(mode="straight",linecolor="#30485d",linewidth=0.16) {#XCDAC:34 (16,-199.65)};
// (16.4,-199.65) @TEXT("TOPP",size=1.1,halign="start",valign="middle");
// &"VDD!" @WIRE(mode="straight",linecolor="#30485d",linewidth=0.16) {#XCDAC:35 (0,-181.45)};
// (0,-181.05) @TEXT("VDD!",size=1.1,halign="middle",valign="bottom");
// &"VREFN" @WIRE(mode="straight",linecolor="#30485d",linewidth=0.16) {#XCDAC:36 (-16,-202.95)};
// (-16.4,-202.95) @TEXT("VREFN",size=1.1,halign="end",valign="middle");
// &"VREFP" @WIRE(mode="straight",linecolor="#30485d",linewidth=0.16) {#XCDAC:37 (-16,-206.25)};
// (-16.4,-206.25) @TEXT("VREFP",size=1.1,halign="end",valign="middle");
// &"0" @WIRE(mode="straight",linecolor="#30485d",linewidth=0.16) {#XCDAC:38 (0,-214.55)};
// (0,-214.95) @TEXT("0",size=1.1,halign="middle",valign="top");
// &"CMP_CLK" @WIRE(mode="straight",linecolor="#30485d",linewidth=0.16) {#XCTRL:1 (16,-224.4)};
// (16.4,-224.4) @TEXT("CMP_CLK",size=1.1,halign="start",valign="middle");
// {&"CODE0" &"CODE1" &"CODE2" &"CODE3" &"CODE4" &"CODE5" &"CODE6" &"CODE7"} @WIRE(mode="straight",linewidth=0.3) {#XCTRL:2 (16,-227.7)};
// (16.4,-227.7) @TEXT("CODE[7:0]",size=1.1,halign="start",valign="middle");
// &"COMP_N" @WIRE(mode="straight",linecolor="#30485d",linewidth=0.16) {#XCTRL:10 (-16,-227.7)};
// (-16.4,-227.7) @TEXT("COMP_N",size=1.1,halign="end",valign="middle");
// &"COMP_P" @WIRE(mode="straight",linecolor="#30485d",linewidth=0.16) {#XCTRL:11 (-16,-231)};
// (-16.4,-231) @TEXT("COMP_P",size=1.1,halign="end",valign="middle");
// {&"D0" &"D1" &"D2" &"D3" &"D4" &"D5" &"D6" &"D7"} @WIRE(mode="straight",linewidth=0.3) {#XCTRL:12 (16,-231)};
// (16.4,-231) @TEXT("D[7:0]",size=1.1,halign="start",valign="middle");
// &"SEQ_SAMPLE" @WIRE(mode="straight",linecolor="#30485d",linewidth=0.16) {#XCTRL:21 (-16,-234.3)};
// (-16.4,-234.3) @TEXT("SEQ_SAMPLE",size=1.1,halign="end",valign="middle");
// &"VDD!" @WIRE(mode="straight",linecolor="#30485d",linewidth=0.16) {#XCTRL:22 (0,-216.1)};
// (0,-215.7) @TEXT("VDD!",size=1.1,halign="middle",valign="bottom");
// &"0" @WIRE(mode="straight",linecolor="#30485d",linewidth=0.16) {#XCTRL:23 (0,-245.9)};
// (0,-246.3) @TEXT("0",size=1.1,halign="middle",valign="top");
// &"ACTIVE" @WIRE(mode="straight",linecolor="#30485d",linewidth=0.16) {#XCTRL:24 (16,-237.6)};
// (16.4,-237.6) @TEXT("ACTIVE",size=1.1,halign="start",valign="middle");
// {&"CODE0" &"CODE1" &"CODE2" &"CODE3" &"CODE4" &"CODE5" &"CODE6" &"CODE7"} @WIRE(mode="straight",linewidth=0.3) {#XREF:1 (-16,-259.05)};
// (-16.4,-259.05) @TEXT("CODE[7:0]",size=1.1,halign="end",valign="middle");
// {&"D0" &"D1" &"D2" &"D3" &"D4" &"D5" &"D6" &"D7"} @WIRE(mode="straight",linewidth=0.3) {#XREF:9 (-16,-262.35)};
// (-16.4,-262.35) @TEXT("D[7:0]",size=1.1,halign="end",valign="middle");
// {&"GNN0" &"GNN1" &"GNN2" &"GNN3" &"GNN4" &"GNN5" &"GNN6" &"GNN7"} @WIRE(mode="straight",linewidth=0.3) {#XREF:17 (16,-255.75)};
// (16.4,-255.75) @TEXT("GNN[7:0]",size=1.1,halign="start",valign="middle");
// {&"GNP0" &"GNP1" &"GNP2" &"GNP3" &"GNP4" &"GNP5" &"GNP6" &"GNP7"} @WIRE(mode="straight",linewidth=0.3) {#XREF:25 (16,-259.05)};
// (16.4,-259.05) @TEXT("GNP[7:0]",size=1.1,halign="start",valign="middle");
// {&"GPN0" &"GPN1" &"GPN2" &"GPN3" &"GPN4" &"GPN5" &"GPN6" &"GPN7"} @WIRE(mode="straight",linewidth=0.3) {#XREF:33 (16,-262.35)};
// (16.4,-262.35) @TEXT("GPN[7:0]",size=1.1,halign="start",valign="middle");
// {&"GPP0" &"GPP1" &"GPP2" &"GPP3" &"GPP4" &"GPP5" &"GPP6" &"GPP7"} @WIRE(mode="straight",linewidth=0.3) {#XREF:41 (16,-265.65)};
// (16.4,-265.65) @TEXT("GPP[7:0]",size=1.1,halign="start",valign="middle");
// &"SAMPLE_INT" @WIRE(mode="straight",linecolor="#30485d",linewidth=0.16) {#XREF:50 (-16,-268.95)};
// (-16.4,-268.95) @TEXT("SAMPLE_INT",size=1.1,halign="end",valign="middle");
// &"VDD!" @WIRE(mode="straight",linecolor="#30485d",linewidth=0.16) {#XREF:51 (0,-247.45)};
// (0,-247.05) @TEXT("VDD!",size=1.1,halign="middle",valign="bottom");
// &"0" @WIRE(mode="straight",linecolor="#30485d",linewidth=0.16) {#XREF:52 (0,-280.55)};
// (0,-280.95) @TEXT("0",size=1.1,halign="middle",valign="top");
// &"RST_DONE" @WIRE(mode="straight",linecolor="#30485d",linewidth=0.16) {#XREF:53 (16,-268.95)};
// (16.4,-268.95) @TEXT("RST_DONE",size=1.1,halign="start",valign="middle");
// &"PRESET" @WIRE(mode="straight",linecolor="#30485d",linewidth=0.16) {#XREF:54 (16,-272.25)};
// (16.4,-272.25) @TEXT("PRESET",size=1.1,halign="start",valign="middle");
// &"CMP_CLK" @WIRE(mode="straight",linecolor="#30485d",linewidth=0.16) {#XCOMP:1 (-16,-293.7)};
// (-16.4,-293.7) @TEXT("CMP_CLK",size=1.1,halign="end",valign="middle");
// &"COMP_N" @WIRE(mode="straight",linecolor="#30485d",linewidth=0.16) {#XCOMP:2 (16,-295.35)};
// (16.4,-295.35) @TEXT("COMP_N",size=1.1,halign="start",valign="middle");
// &"COMP_P" @WIRE(mode="straight",linecolor="#30485d",linewidth=0.16) {#XCOMP:3 (16,-298.65)};
// (16.4,-298.65) @TEXT("COMP_P",size=1.1,halign="start",valign="middle");
// &"VDD!" @WIRE(mode="straight",linecolor="#30485d",linewidth=0.16) {#XCOMP:4 (0,-285.4)};
// (0,-285) @TEXT("VDD!",size=1.1,halign="middle",valign="bottom");
// &"TOPN" @WIRE(mode="straight",linecolor="#30485d",linewidth=0.16) {#XCOMP:5 (-16,-297)};
// (-16.4,-297) @TEXT("TOPN",size=1.1,halign="end",valign="middle");
// &"TOPP" @WIRE(mode="straight",linecolor="#30485d",linewidth=0.16) {#XCOMP:6 (-16,-300.3)};
// (-16.4,-300.3) @TEXT("TOPP",size=1.1,halign="end",valign="middle");
// &"0" @WIRE(mode="straight",linecolor="#30485d",linewidth=0.16) {#XCOMP:7 (0,-308.6)};
// (0,-309) @TEXT("0",size=1.1,halign="middle",valign="top");
// &"COMP_N" @WIRE(mode="straight",linecolor="#30485d",linewidth=0.16) {#CL_COMP_N:1 (90,5)};
// (90,5.4) @TEXT("COMP_N",size=1.1,halign="middle",valign="bottom");
// &"0" @WIRE(mode="straight",linecolor="#30485d",linewidth=0.16) {#CL_COMP_N:2 (90,-5)};
// (90,-5.4) @TEXT("0",size=1.1,halign="middle",valign="top");
// &"COMP_P" @WIRE(mode="straight",linecolor="#30485d",linewidth=0.16) {#CL_COMP_P:1 (90,-28)};
// (90,-27.6) @TEXT("COMP_P",size=1.1,halign="middle",valign="bottom");
// &"0" @WIRE(mode="straight",linecolor="#30485d",linewidth=0.16) {#CL_COMP_P:2 (90,-38)};
// (90,-38.4) @TEXT("0",size=1.1,halign="middle",valign="top");
// &"CMP_CLK" @WIRE(mode="straight",linecolor="#30485d",linewidth=0.16) {#CL_CMP_CLK:1 (90,-61)};
// (90,-60.6) @TEXT("CMP_CLK",size=1.1,halign="middle",valign="bottom");
// &"0" @WIRE(mode="straight",linecolor="#30485d",linewidth=0.16) {#CL_CMP_CLK:2 (90,-71)};
// (90,-71.4) @TEXT("0",size=1.1,halign="middle",valign="top");
// }
// END SARADC RNL
ends tb_sar_top

subckt tb_sar_stalled_top D0 D1 D2 D3 D4 D5 D6 D7 SAMPLE VDD! VINN VINP  VREFN VREFP 0
    XSEQ (SAMPLE_INT VDD! 0 SEQ_SAMPLE) sar8_se_acquire
    XDONE (ACTIVE DONE VDD! 0) INVD1BWP12T30P140
    XPRESET (DONE SEQ_SAMPLE PRESET VDD! 0) OR2D1BWP12T30P140
    XSAMPLE (SAMPLE SAMPLE_INT VDD! 0) CKBD1BWP12T30P140
    XBOOTN (SEQ_SAMPLE TOPN VINN) b_sampler_bridge
    XBOOTP (SEQ_SAMPLE TOPP VINP) b_sampler_bridge
    XCDAC (GNN0 GNN1 GNN2 GNN3 GNN4 GNN5 GNN6 GNN7 GNP0 GNP1 GNP2 GNP3  GNP4 GNP5 GNP6 GNP7 GPN0 GPN1 GPN2 GPN3 GPN4 GPN5 GPN6 GPN7 GPP0  GPP1 GPP2 GPP3 GPP4 GPP5 GPP6 GPP7 TOPN TOPP VDD! VREFN VREFP 0)  b_cdac
    XCTRL (CMP_CLK CODE0 CODE1 CODE2 CODE3 CODE4 CODE5 CODE6 CODE7 COMP_N  COMP_P D0 D1 D2 D3 D4 D5 D6 D7 PHI_U SEQ_SAMPLE VDD! 0 ACTIVE) sar8_se_ctrl
    XREF (CODE0 CODE1 CODE2 CODE3 CODE4 CODE5 CODE6 CODE7 D0 D1 D2 D3 D4  D5 D6 D7 GNN0 GNN1 GNN2 GNN3 GNN4 GNN5 GNN6 GNN7 GNP0 GNP1 GNP2  GNP3 GNP4 GNP5 GNP6 GNP7 GPN0 GPN1 GPN2 GPN3 GPN4 GPN5 GPN6 GPN7  GPP0 GPP1 GPP2 GPP3 GPP4 GPP5 GPP6 GPP7 PHI_U SAMPLE_INT VDD! 0 RST_DONE PRESET)  b_reference
    XCOMP (CMP_CLK COMP_N COMP_P VDD! TOPN TOPP 0) b_comparator force_stuck=1
    CL_COMP_N (COMP_N 0) cfmom_2t nr=8 lr=2.5u w=50n s=50n stm=1 spm=3  multi=2 mismatchflag=1
    CL_COMP_P (COMP_P 0) cfmom_2t nr=8 lr=2.5u w=50n s=50n stm=1 spm=3  multi=2 mismatchflag=1
    CL_CMP_CLK (CMP_CLK 0) cfmom_2t nr=8 lr=2.5u w=50n s=50n stm=1 spm=3  multi=2 mismatchflag=1
// BEGIN SARADC RNL
// @RNL(author="saradc topology") {
// #XSEQ @SET-SYMBOL $S_sar8_se_acquire;
// #XSEQ @PLACE(0,0) => @ORIENT("R0");
// #XDONE @SET-SYMBOL $S_INVD1BWP12T30P140;
// #XDONE @PLACE(0,-33) => @ORIENT("R0");
// #XPRESET @SET-SYMBOL $S_OR2D1BWP12T30P140;
// #XPRESET @PLACE(0,-66) => @ORIENT("R0");
// #XSAMPLE @SET-SYMBOL $S_CKBD1BWP12T30P140;
// #XSAMPLE @PLACE(0,-99) => @ORIENT("R0");
// #XBOOTN @SET-SYMBOL $S_b_sampler_bridge;
// #XBOOTN @PLACE(0,-132) => @ORIENT("R0");
// #XBOOTP @SET-SYMBOL $S_b_sampler_bridge;
// #XBOOTP @PLACE(0,-165) => @ORIENT("R0");
// #XCDAC @SET-SYMBOL $S_b_cdac;
// #XCDAC @PLACE(0,-198) => @ORIENT("R0");
// #XCTRL @SET-SYMBOL $S_sar8_se_ctrl;
// #XCTRL @PLACE(0,-231) => @ORIENT("R0");
// #XREF @SET-SYMBOL $S_b_reference;
// #XREF @PLACE(0,-264) => @ORIENT("R0");
// #XCOMP @SET-SYMBOL $S_b_comparator;
// #XCOMP @PLACE(0,-297) => @ORIENT("R0");
// #CL_COMP_N @SET-SYMBOL $CAPACITOR;
// #CL_COMP_N @PLACE(90,0) => @ORIENT("R0");
// #CL_COMP_N @TEXT("CL_COMP_N",key="name",size=1.3,halign="start") => @PLACE(93,3);
// #CL_COMP_N @TEXT("nr=8 lr=2.5u w=50n multi=2",key="value",size=0.9,halign="start") => @PLACE(93,-4);
// #CL_COMP_N @TEXT("",key="model");
// #CL_COMP_P @SET-SYMBOL $CAPACITOR;
// #CL_COMP_P @PLACE(90,-33) => @ORIENT("R0");
// #CL_COMP_P @TEXT("CL_COMP_P",key="name",size=1.3,halign="start") => @PLACE(93,-30);
// #CL_COMP_P @TEXT("nr=8 lr=2.5u w=50n multi=2",key="value",size=0.9,halign="start") => @PLACE(93,-37);
// #CL_COMP_P @TEXT("",key="model");
// #CL_CMP_CLK @SET-SYMBOL $CAPACITOR;
// #CL_CMP_CLK @PLACE(90,-66) => @ORIENT("R0");
// #CL_CMP_CLK @TEXT("CL_CMP_CLK",key="name",size=1.3,halign="start") => @PLACE(93,-63);
// #CL_CMP_CLK @TEXT("nr=8 lr=2.5u w=50n multi=2",key="value",size=0.9,halign="start") => @PLACE(93,-70);
// #CL_CMP_CLK @TEXT("",key="model");
// &"DONE" @WIRE(mode="straight",linecolor="#30485d",linewidth=0.16) {#XDONE:2 (-3,-33) (-3,-64.35) #XPRESET:1};
// &"PHI_U" @WIRE(mode="straight",linecolor="#30485d",linewidth=0.16) {#XCTRL:20 (0,-234.3) (0,-265.65) #XREF:49};
// (-89,30) @TEXT("tb_sar_stalled_top / source-derived connections",size=1.4,halign="start",textcolor="#223d52");
// &"SAMPLE_INT" @WIRE(mode="straight",linecolor="#30485d",linewidth=0.16) {#XSEQ:1 (-16,0)};
// (-16.4,0) @TEXT("SAMPLE_INT",size=1.1,halign="end",valign="middle");
// &"VDD!" @WIRE(mode="straight",linecolor="#30485d",linewidth=0.16) {#XSEQ:2 (0,11)};
// (0,11.4) @TEXT("VDD!",size=1.1,halign="middle",valign="bottom");
// &"0" @WIRE(mode="straight",linecolor="#30485d",linewidth=0.16) {#XSEQ:3 (0,-11)};
// (0,-11.4) @TEXT("0",size=1.1,halign="middle",valign="top");
// &"SEQ_SAMPLE" @WIRE(mode="straight",linecolor="#30485d",linewidth=0.16) {#XSEQ:4 (16,0)};
// (16.4,0) @TEXT("SEQ_SAMPLE",size=1.1,halign="start",valign="middle");
// &"ACTIVE" @WIRE(mode="straight",linecolor="#30485d",linewidth=0.16) {#XDONE:1 (-10,-33)};
// (-10.4,-33) @TEXT("ACTIVE",size=1.1,halign="end",valign="middle");
// &"VDD!" @WIRE(mode="straight",linecolor="#30485d",linewidth=0.16) {#XDONE:3 (0,-23)};
// (0,-22.6) @TEXT("VDD!",size=1.1,halign="middle",valign="bottom");
// &"0" @WIRE(mode="straight",linecolor="#30485d",linewidth=0.16) {#XDONE:4 (0,-43)};
// (0,-43.4) @TEXT("0",size=1.1,halign="middle",valign="top");
// &"SEQ_SAMPLE" @WIRE(mode="straight",linecolor="#30485d",linewidth=0.16) {#XPRESET:2 (-16,-67.65)};
// (-16.4,-67.65) @TEXT("SEQ_SAMPLE",size=1.1,halign="end",valign="middle");
// &"PRESET" @WIRE(mode="straight",linecolor="#30485d",linewidth=0.16) {#XPRESET:3 (16,-66)};
// (16.4,-66) @TEXT("PRESET",size=1.1,halign="start",valign="middle");
// &"VDD!" @WIRE(mode="straight",linecolor="#30485d",linewidth=0.16) {#XPRESET:4 (0,-55)};
// (0,-54.6) @TEXT("VDD!",size=1.1,halign="middle",valign="bottom");
// &"0" @WIRE(mode="straight",linecolor="#30485d",linewidth=0.16) {#XPRESET:5 (0,-77)};
// (0,-77.4) @TEXT("0",size=1.1,halign="middle",valign="top");
// &"SAMPLE" @WIRE(mode="straight",linecolor="#30485d",linewidth=0.16) {#XSAMPLE:1 (-16,-99)};
// (-16.4,-99) @TEXT("SAMPLE",size=1.1,halign="end",valign="middle");
// &"SAMPLE_INT" @WIRE(mode="straight",linecolor="#30485d",linewidth=0.16) {#XSAMPLE:2 (16,-99)};
// (16.4,-99) @TEXT("SAMPLE_INT",size=1.1,halign="start",valign="middle");
// &"VDD!" @WIRE(mode="straight",linecolor="#30485d",linewidth=0.16) {#XSAMPLE:3 (0,-88)};
// (0,-87.6) @TEXT("VDD!",size=1.1,halign="middle",valign="bottom");
// &"0" @WIRE(mode="straight",linecolor="#30485d",linewidth=0.16) {#XSAMPLE:4 (0,-110)};
// (0,-110.4) @TEXT("0",size=1.1,halign="middle",valign="top");
// &"SEQ_SAMPLE" @WIRE(mode="straight",linecolor="#30485d",linewidth=0.16) {#XBOOTN:1 (-16,-130.35)};
// (-16.4,-130.35) @TEXT("SEQ_SAMPLE",size=1.1,halign="end",valign="middle");
// &"TOPN" @WIRE(mode="straight",linecolor="#30485d",linewidth=0.16) {#XBOOTN:2 (16,-132)};
// (16.4,-132) @TEXT("TOPN",size=1.1,halign="start",valign="middle");
// &"VINN" @WIRE(mode="straight",linecolor="#30485d",linewidth=0.16) {#XBOOTN:3 (-16,-133.65)};
// (-16.4,-133.65) @TEXT("VINN",size=1.1,halign="end",valign="middle");
// &"SEQ_SAMPLE" @WIRE(mode="straight",linecolor="#30485d",linewidth=0.16) {#XBOOTP:1 (-16,-163.35)};
// (-16.4,-163.35) @TEXT("SEQ_SAMPLE",size=1.1,halign="end",valign="middle");
// &"TOPP" @WIRE(mode="straight",linecolor="#30485d",linewidth=0.16) {#XBOOTP:2 (16,-165)};
// (16.4,-165) @TEXT("TOPP",size=1.1,halign="start",valign="middle");
// &"VINP" @WIRE(mode="straight",linecolor="#30485d",linewidth=0.16) {#XBOOTP:3 (-16,-166.65)};
// (-16.4,-166.65) @TEXT("VINP",size=1.1,halign="end",valign="middle");
// {&"GNN0" &"GNN1" &"GNN2" &"GNN3" &"GNN4" &"GNN5" &"GNN6" &"GNN7"} @WIRE(mode="straight",linewidth=0.3) {#XCDAC:1 (-16,-189.75)};
// (-16.4,-189.75) @TEXT("GNN[7:0]",size=1.1,halign="end",valign="middle");
// {&"GNP0" &"GNP1" &"GNP2" &"GNP3" &"GNP4" &"GNP5" &"GNP6" &"GNP7"} @WIRE(mode="straight",linewidth=0.3) {#XCDAC:9 (-16,-193.05)};
// (-16.4,-193.05) @TEXT("GNP[7:0]",size=1.1,halign="end",valign="middle");
// {&"GPN0" &"GPN1" &"GPN2" &"GPN3" &"GPN4" &"GPN5" &"GPN6" &"GPN7"} @WIRE(mode="straight",linewidth=0.3) {#XCDAC:17 (-16,-196.35)};
// (-16.4,-196.35) @TEXT("GPN[7:0]",size=1.1,halign="end",valign="middle");
// {&"GPP0" &"GPP1" &"GPP2" &"GPP3" &"GPP4" &"GPP5" &"GPP6" &"GPP7"} @WIRE(mode="straight",linewidth=0.3) {#XCDAC:25 (-16,-199.65)};
// (-16.4,-199.65) @TEXT("GPP[7:0]",size=1.1,halign="end",valign="middle");
// &"TOPN" @WIRE(mode="straight",linecolor="#30485d",linewidth=0.16) {#XCDAC:33 (16,-196.35)};
// (16.4,-196.35) @TEXT("TOPN",size=1.1,halign="start",valign="middle");
// &"TOPP" @WIRE(mode="straight",linecolor="#30485d",linewidth=0.16) {#XCDAC:34 (16,-199.65)};
// (16.4,-199.65) @TEXT("TOPP",size=1.1,halign="start",valign="middle");
// &"VDD!" @WIRE(mode="straight",linecolor="#30485d",linewidth=0.16) {#XCDAC:35 (0,-181.45)};
// (0,-181.05) @TEXT("VDD!",size=1.1,halign="middle",valign="bottom");
// &"VREFN" @WIRE(mode="straight",linecolor="#30485d",linewidth=0.16) {#XCDAC:36 (-16,-202.95)};
// (-16.4,-202.95) @TEXT("VREFN",size=1.1,halign="end",valign="middle");
// &"VREFP" @WIRE(mode="straight",linecolor="#30485d",linewidth=0.16) {#XCDAC:37 (-16,-206.25)};
// (-16.4,-206.25) @TEXT("VREFP",size=1.1,halign="end",valign="middle");
// &"0" @WIRE(mode="straight",linecolor="#30485d",linewidth=0.16) {#XCDAC:38 (0,-214.55)};
// (0,-214.95) @TEXT("0",size=1.1,halign="middle",valign="top");
// &"CMP_CLK" @WIRE(mode="straight",linecolor="#30485d",linewidth=0.16) {#XCTRL:1 (16,-224.4)};
// (16.4,-224.4) @TEXT("CMP_CLK",size=1.1,halign="start",valign="middle");
// {&"CODE0" &"CODE1" &"CODE2" &"CODE3" &"CODE4" &"CODE5" &"CODE6" &"CODE7"} @WIRE(mode="straight",linewidth=0.3) {#XCTRL:2 (16,-227.7)};
// (16.4,-227.7) @TEXT("CODE[7:0]",size=1.1,halign="start",valign="middle");
// &"COMP_N" @WIRE(mode="straight",linecolor="#30485d",linewidth=0.16) {#XCTRL:10 (-16,-227.7)};
// (-16.4,-227.7) @TEXT("COMP_N",size=1.1,halign="end",valign="middle");
// &"COMP_P" @WIRE(mode="straight",linecolor="#30485d",linewidth=0.16) {#XCTRL:11 (-16,-231)};
// (-16.4,-231) @TEXT("COMP_P",size=1.1,halign="end",valign="middle");
// {&"D0" &"D1" &"D2" &"D3" &"D4" &"D5" &"D6" &"D7"} @WIRE(mode="straight",linewidth=0.3) {#XCTRL:12 (16,-231)};
// (16.4,-231) @TEXT("D[7:0]",size=1.1,halign="start",valign="middle");
// &"SEQ_SAMPLE" @WIRE(mode="straight",linecolor="#30485d",linewidth=0.16) {#XCTRL:21 (-16,-234.3)};
// (-16.4,-234.3) @TEXT("SEQ_SAMPLE",size=1.1,halign="end",valign="middle");
// &"VDD!" @WIRE(mode="straight",linecolor="#30485d",linewidth=0.16) {#XCTRL:22 (0,-216.1)};
// (0,-215.7) @TEXT("VDD!",size=1.1,halign="middle",valign="bottom");
// &"0" @WIRE(mode="straight",linecolor="#30485d",linewidth=0.16) {#XCTRL:23 (0,-245.9)};
// (0,-246.3) @TEXT("0",size=1.1,halign="middle",valign="top");
// &"ACTIVE" @WIRE(mode="straight",linecolor="#30485d",linewidth=0.16) {#XCTRL:24 (16,-237.6)};
// (16.4,-237.6) @TEXT("ACTIVE",size=1.1,halign="start",valign="middle");
// {&"CODE0" &"CODE1" &"CODE2" &"CODE3" &"CODE4" &"CODE5" &"CODE6" &"CODE7"} @WIRE(mode="straight",linewidth=0.3) {#XREF:1 (-16,-259.05)};
// (-16.4,-259.05) @TEXT("CODE[7:0]",size=1.1,halign="end",valign="middle");
// {&"D0" &"D1" &"D2" &"D3" &"D4" &"D5" &"D6" &"D7"} @WIRE(mode="straight",linewidth=0.3) {#XREF:9 (-16,-262.35)};
// (-16.4,-262.35) @TEXT("D[7:0]",size=1.1,halign="end",valign="middle");
// {&"GNN0" &"GNN1" &"GNN2" &"GNN3" &"GNN4" &"GNN5" &"GNN6" &"GNN7"} @WIRE(mode="straight",linewidth=0.3) {#XREF:17 (16,-255.75)};
// (16.4,-255.75) @TEXT("GNN[7:0]",size=1.1,halign="start",valign="middle");
// {&"GNP0" &"GNP1" &"GNP2" &"GNP3" &"GNP4" &"GNP5" &"GNP6" &"GNP7"} @WIRE(mode="straight",linewidth=0.3) {#XREF:25 (16,-259.05)};
// (16.4,-259.05) @TEXT("GNP[7:0]",size=1.1,halign="start",valign="middle");
// {&"GPN0" &"GPN1" &"GPN2" &"GPN3" &"GPN4" &"GPN5" &"GPN6" &"GPN7"} @WIRE(mode="straight",linewidth=0.3) {#XREF:33 (16,-262.35)};
// (16.4,-262.35) @TEXT("GPN[7:0]",size=1.1,halign="start",valign="middle");
// {&"GPP0" &"GPP1" &"GPP2" &"GPP3" &"GPP4" &"GPP5" &"GPP6" &"GPP7"} @WIRE(mode="straight",linewidth=0.3) {#XREF:41 (16,-265.65)};
// (16.4,-265.65) @TEXT("GPP[7:0]",size=1.1,halign="start",valign="middle");
// &"SAMPLE_INT" @WIRE(mode="straight",linecolor="#30485d",linewidth=0.16) {#XREF:50 (-16,-268.95)};
// (-16.4,-268.95) @TEXT("SAMPLE_INT",size=1.1,halign="end",valign="middle");
// &"VDD!" @WIRE(mode="straight",linecolor="#30485d",linewidth=0.16) {#XREF:51 (0,-247.45)};
// (0,-247.05) @TEXT("VDD!",size=1.1,halign="middle",valign="bottom");
// &"0" @WIRE(mode="straight",linecolor="#30485d",linewidth=0.16) {#XREF:52 (0,-280.55)};
// (0,-280.95) @TEXT("0",size=1.1,halign="middle",valign="top");
// &"RST_DONE" @WIRE(mode="straight",linecolor="#30485d",linewidth=0.16) {#XREF:53 (16,-268.95)};
// (16.4,-268.95) @TEXT("RST_DONE",size=1.1,halign="start",valign="middle");
// &"PRESET" @WIRE(mode="straight",linecolor="#30485d",linewidth=0.16) {#XREF:54 (16,-272.25)};
// (16.4,-272.25) @TEXT("PRESET",size=1.1,halign="start",valign="middle");
// &"CMP_CLK" @WIRE(mode="straight",linecolor="#30485d",linewidth=0.16) {#XCOMP:1 (-16,-293.7)};
// (-16.4,-293.7) @TEXT("CMP_CLK",size=1.1,halign="end",valign="middle");
// &"COMP_N" @WIRE(mode="straight",linecolor="#30485d",linewidth=0.16) {#XCOMP:2 (16,-295.35)};
// (16.4,-295.35) @TEXT("COMP_N",size=1.1,halign="start",valign="middle");
// &"COMP_P" @WIRE(mode="straight",linecolor="#30485d",linewidth=0.16) {#XCOMP:3 (16,-298.65)};
// (16.4,-298.65) @TEXT("COMP_P",size=1.1,halign="start",valign="middle");
// &"VDD!" @WIRE(mode="straight",linecolor="#30485d",linewidth=0.16) {#XCOMP:4 (0,-285.4)};
// (0,-285) @TEXT("VDD!",size=1.1,halign="middle",valign="bottom");
// &"TOPN" @WIRE(mode="straight",linecolor="#30485d",linewidth=0.16) {#XCOMP:5 (-16,-297)};
// (-16.4,-297) @TEXT("TOPN",size=1.1,halign="end",valign="middle");
// &"TOPP" @WIRE(mode="straight",linecolor="#30485d",linewidth=0.16) {#XCOMP:6 (-16,-300.3)};
// (-16.4,-300.3) @TEXT("TOPP",size=1.1,halign="end",valign="middle");
// &"0" @WIRE(mode="straight",linecolor="#30485d",linewidth=0.16) {#XCOMP:7 (0,-308.6)};
// (0,-309) @TEXT("0",size=1.1,halign="middle",valign="top");
// &"COMP_N" @WIRE(mode="straight",linecolor="#30485d",linewidth=0.16) {#CL_COMP_N:1 (90,5)};
// (90,5.4) @TEXT("COMP_N",size=1.1,halign="middle",valign="bottom");
// &"0" @WIRE(mode="straight",linecolor="#30485d",linewidth=0.16) {#CL_COMP_N:2 (90,-5)};
// (90,-5.4) @TEXT("0",size=1.1,halign="middle",valign="top");
// &"COMP_P" @WIRE(mode="straight",linecolor="#30485d",linewidth=0.16) {#CL_COMP_P:1 (90,-28)};
// (90,-27.6) @TEXT("COMP_P",size=1.1,halign="middle",valign="bottom");
// &"0" @WIRE(mode="straight",linecolor="#30485d",linewidth=0.16) {#CL_COMP_P:2 (90,-38)};
// (90,-38.4) @TEXT("0",size=1.1,halign="middle",valign="top");
// &"CMP_CLK" @WIRE(mode="straight",linecolor="#30485d",linewidth=0.16) {#CL_CMP_CLK:1 (90,-61)};
// (90,-60.6) @TEXT("CMP_CLK",size=1.1,halign="middle",valign="bottom");
// &"0" @WIRE(mode="straight",linecolor="#30485d",linewidth=0.16) {#CL_CMP_CLK:2 (90,-71)};
// (90,-71.4) @TEXT("0",size=1.1,halign="middle",valign="top");
// }
// END SARADC RNL
ends tb_sar_stalled_top

subckt INVD1BWP12T30P140 A Y VDD VSS
// BEGIN SARADC RNL
// @RNL(author="saradc topology") {
// (-89,30) @TEXT("INVD1BWP12T30P140 / source-derived connections",size=1.4,halign="start",textcolor="#223d52");
// (-20,5) @TEXT("Interface view only - no transistor body is distributed here.",size=1.2,halign="start",textcolor="#223d52");
// (-20,-2) @TEXT("Ports: A, Y, VDD, VSS",size=0.9,halign="start",textcolor="#223d52");
// }
// END SARADC RNL
ends INVD1BWP12T30P140

subckt INVD2BWP12T30P140 I ZN VDD VSS
// BEGIN SARADC RNL
// @RNL(author="saradc topology") {
// (-89,30) @TEXT("INVD2BWP12T30P140 / source-derived connections",size=1.4,halign="start",textcolor="#223d52");
// (-20,5) @TEXT("Interface view only - no transistor body is distributed here.",size=1.2,halign="start",textcolor="#223d52");
// (-20,-2) @TEXT("Ports: I, ZN, VDD, VSS",size=0.9,halign="start",textcolor="#223d52");
// }
// END SARADC RNL
ends INVD2BWP12T30P140

subckt OR2D1BWP12T30P140 A1 A2 Z VDD VSS
// BEGIN SARADC RNL
// @RNL(author="saradc topology") {
// (-89,30) @TEXT("OR2D1BWP12T30P140 / source-derived connections",size=1.4,halign="start",textcolor="#223d52");
// (-20,5) @TEXT("Interface view only - no transistor body is distributed here.",size=1.2,halign="start",textcolor="#223d52");
// (-20,-2) @TEXT("Ports: A1, A2, Z, VDD, VSS",size=0.9,halign="start",textcolor="#223d52");
// }
// END SARADC RNL
ends OR2D1BWP12T30P140

subckt ND2D1BWP12T30P140 A B Y VDD VSS
// BEGIN SARADC RNL
// @RNL(author="saradc topology") {
// (-89,30) @TEXT("ND2D1BWP12T30P140 / source-derived connections",size=1.4,halign="start",textcolor="#223d52");
// (-20,5) @TEXT("Interface view only - no transistor body is distributed here.",size=1.2,halign="start",textcolor="#223d52");
// (-20,-2) @TEXT("Ports: A, B, Y, VDD, VSS",size=0.9,halign="start",textcolor="#223d52");
// }
// END SARADC RNL
ends ND2D1BWP12T30P140

subckt DFCNQD1BWP12T30P140 D CK RN Q VDD VSS
// BEGIN SARADC RNL
// @RNL(author="saradc topology") {
// (-89,30) @TEXT("DFCNQD1BWP12T30P140 / source-derived connections",size=1.4,halign="start",textcolor="#223d52");
// (-20,5) @TEXT("Interface view only - no transistor body is distributed here.",size=1.2,halign="start",textcolor="#223d52");
// (-20,-2) @TEXT("Ports: D, CK, RN, Q, VDD, VSS",size=0.9,halign="start",textcolor="#223d52");
// }
// END SARADC RNL
ends DFCNQD1BWP12T30P140

subckt AN2D1BWP12T30P140 A1 A2 Z VDD VSS
// BEGIN SARADC RNL
// @RNL(author="saradc topology") {
// (-89,30) @TEXT("AN2D1BWP12T30P140 / source-derived connections",size=1.4,halign="start",textcolor="#223d52");
// (-20,5) @TEXT("Interface view only - no transistor body is distributed here.",size=1.2,halign="start",textcolor="#223d52");
// (-20,-2) @TEXT("Ports: A1, A2, Z, VDD, VSS",size=0.9,halign="start",textcolor="#223d52");
// }
// END SARADC RNL
ends AN2D1BWP12T30P140

subckt XOR2D1BWP12T30P140 A1 A2 Z VDD VSS
// BEGIN SARADC RNL
// @RNL(author="saradc topology") {
// (-89,30) @TEXT("XOR2D1BWP12T30P140 / source-derived connections",size=1.4,halign="start",textcolor="#223d52");
// (-20,5) @TEXT("Interface view only - no transistor body is distributed here.",size=1.2,halign="start",textcolor="#223d52");
// (-20,-2) @TEXT("Ports: A1, A2, Z, VDD, VSS",size=0.9,halign="start",textcolor="#223d52");
// }
// END SARADC RNL
ends XOR2D1BWP12T30P140

subckt MUX2D1BWP12T30P140 I0 I1 S Z VDD VSS
// BEGIN SARADC RNL
// @RNL(author="saradc topology") {
// (-89,30) @TEXT("MUX2D1BWP12T30P140 / source-derived connections",size=1.4,halign="start",textcolor="#223d52");
// (-20,5) @TEXT("Interface view only - no transistor body is distributed here.",size=1.2,halign="start",textcolor="#223d52");
// (-20,-2) @TEXT("Ports: I0, I1, S, Z, VDD, VSS",size=0.9,halign="start",textcolor="#223d52");
// }
// END SARADC RNL
ends MUX2D1BWP12T30P140

subckt BUFFD1BWP12T30P140 I Z VDD VSS
// BEGIN SARADC RNL
// @RNL(author="saradc topology") {
// (-89,30) @TEXT("BUFFD1BWP12T30P140 / source-derived connections",size=1.4,halign="start",textcolor="#223d52");
// (-20,5) @TEXT("Interface view only - no transistor body is distributed here.",size=1.2,halign="start",textcolor="#223d52");
// (-20,-2) @TEXT("Ports: I, Z, VDD, VSS",size=0.9,halign="start",textcolor="#223d52");
// }
// END SARADC RNL
ends BUFFD1BWP12T30P140

subckt BUFFD2BWP12T30P140 I Z VDD VSS
// BEGIN SARADC RNL
// @RNL(author="saradc topology") {
// (-89,30) @TEXT("BUFFD2BWP12T30P140 / source-derived connections",size=1.4,halign="start",textcolor="#223d52");
// (-20,5) @TEXT("Interface view only - no transistor body is distributed here.",size=1.2,halign="start",textcolor="#223d52");
// (-20,-2) @TEXT("Ports: I, Z, VDD, VSS",size=0.9,halign="start",textcolor="#223d52");
// }
// END SARADC RNL
ends BUFFD2BWP12T30P140

subckt CKBD1BWP12T30P140 I Z VDD VSS
// BEGIN SARADC RNL
// @RNL(author="saradc topology") {
// (-89,30) @TEXT("CKBD1BWP12T30P140 / source-derived connections",size=1.4,halign="start",textcolor="#223d52");
// (-20,5) @TEXT("Interface view only - no transistor body is distributed here.",size=1.2,halign="start",textcolor="#223d52");
// (-20,-2) @TEXT("Ports: I, Z, VDD, VSS",size=0.9,halign="start",textcolor="#223d52");
// }
// END SARADC RNL
ends CKBD1BWP12T30P140

subckt LHCNDQD1BWP12T30P140 D E CDN Q VDD VSS
// BEGIN SARADC RNL
// @RNL(author="saradc topology") {
// (-89,30) @TEXT("LHCNDQD1BWP12T30P140 / source-derived connections",size=1.4,halign="start",textcolor="#223d52");
// (-20,5) @TEXT("Interface view only - no transistor body is distributed here.",size=1.2,halign="start",textcolor="#223d52");
// (-20,-2) @TEXT("Ports: D, E, CDN, Q, VDD, VSS",size=0.9,halign="start",textcolor="#223d52");
// }
// END SARADC RNL
ends LHCNDQD1BWP12T30P140

subckt TIEHBWP12T30P140 Z VDD VSS
// BEGIN SARADC RNL
// @RNL(author="saradc topology") {
// (-89,30) @TEXT("TIEHBWP12T30P140 / source-derived connections",size=1.4,halign="start",textcolor="#223d52");
// (-20,5) @TEXT("Interface view only - no transistor body is distributed here.",size=1.2,halign="start",textcolor="#223d52");
// (-20,-2) @TEXT("Ports: Z, VDD, VSS",size=0.9,halign="start",textcolor="#223d52");
// }
// END SARADC RNL
ends TIEHBWP12T30P140

subckt iprobe p n
// BEGIN SARADC RNL
// @RNL(author="saradc topology") {
// (-89,30) @TEXT("iprobe / source-derived connections",size=1.4,halign="start",textcolor="#223d52");
// (-20,5) @TEXT("Interface view only - no transistor body is distributed here.",size=1.2,halign="start",textcolor="#223d52");
// (-20,-2) @TEXT("Ports: p, n",size=0.9,halign="start",textcolor="#223d52");
// }
// END SARADC RNL
ends iprobe

subckt DEL025D1BWP12T30P140 I Z VDD VSS
// BEGIN SARADC RNL
// @RNL(author="saradc topology") {
// (-89,30) @TEXT("DEL025D1BWP12T30P140 / source-derived connections",size=1.4,halign="start",textcolor="#223d52");
// (-20,5) @TEXT("Interface view only - no transistor body is distributed here.",size=1.2,halign="start",textcolor="#223d52");
// (-20,-2) @TEXT("Ports: I, Z, VDD, VSS",size=0.9,halign="start",textcolor="#223d52");
// }
// END SARADC RNL
ends DEL025D1BWP12T30P140

subckt DEL050D1BWP12T30P140 I Z VDD VSS
// BEGIN SARADC RNL
// @RNL(author="saradc topology") {
// (-89,30) @TEXT("DEL050D1BWP12T30P140 / source-derived connections",size=1.4,halign="start",textcolor="#223d52");
// (-20,5) @TEXT("Interface view only - no transistor body is distributed here.",size=1.2,halign="start",textcolor="#223d52");
// (-20,-2) @TEXT("Ports: I, Z, VDD, VSS",size=0.9,halign="start",textcolor="#223d52");
// }
// END SARADC RNL
ends DEL050D1BWP12T30P140

subckt DEL075D1BWP12T30P140 I Z VDD VSS
// BEGIN SARADC RNL
// @RNL(author="saradc topology") {
// (-89,30) @TEXT("DEL075D1BWP12T30P140 / source-derived connections",size=1.4,halign="start",textcolor="#223d52");
// (-20,5) @TEXT("Interface view only - no transistor body is distributed here.",size=1.2,halign="start",textcolor="#223d52");
// (-20,-2) @TEXT("Ports: I, Z, VDD, VSS",size=0.9,halign="start",textcolor="#223d52");
// }
// END SARADC RNL
ends DEL075D1BWP12T30P140

subckt DEL100D1BWP12T30P140 I Z VDD VSS
// BEGIN SARADC RNL
// @RNL(author="saradc topology") {
// (-89,30) @TEXT("DEL100D1BWP12T30P140 / source-derived connections",size=1.4,halign="start",textcolor="#223d52");
// (-20,5) @TEXT("Interface view only - no transistor body is distributed here.",size=1.2,halign="start",textcolor="#223d52");
// (-20,-2) @TEXT("Ports: I, Z, VDD, VSS",size=0.9,halign="start",textcolor="#223d52");
// }
// END SARADC RNL
ends DEL100D1BWP12T30P140

subckt DEL150D1BWP12T30P140 I Z VDD VSS
// BEGIN SARADC RNL
// @RNL(author="saradc topology") {
// (-89,30) @TEXT("DEL150D1BWP12T30P140 / source-derived connections",size=1.4,halign="start",textcolor="#223d52");
// (-20,5) @TEXT("Interface view only - no transistor body is distributed here.",size=1.2,halign="start",textcolor="#223d52");
// (-20,-2) @TEXT("Ports: I, Z, VDD, VSS",size=0.9,halign="start",textcolor="#223d52");
// }
// END SARADC RNL
ends DEL150D1BWP12T30P140

subckt DEL200D1BWP12T30P140 I Z VDD VSS
// BEGIN SARADC RNL
// @RNL(author="saradc topology") {
// (-89,30) @TEXT("DEL200D1BWP12T30P140 / source-derived connections",size=1.4,halign="start",textcolor="#223d52");
// (-20,5) @TEXT("Interface view only - no transistor body is distributed here.",size=1.2,halign="start",textcolor="#223d52");
// (-20,-2) @TEXT("Ports: I, Z, VDD, VSS",size=0.9,halign="start",textcolor="#223d52");
// }
// END SARADC RNL
ends DEL200D1BWP12T30P140

subckt DEL250D1BWP12T30P140 I Z VDD VSS
// BEGIN SARADC RNL
// @RNL(author="saradc topology") {
// (-89,30) @TEXT("DEL250D1BWP12T30P140 / source-derived connections",size=1.4,halign="start",textcolor="#223d52");
// (-20,5) @TEXT("Interface view only - no transistor body is distributed here.",size=1.2,halign="start",textcolor="#223d52");
// (-20,-2) @TEXT("Ports: I, Z, VDD, VSS",size=0.9,halign="start",textcolor="#223d52");
// }
// END SARADC RNL
ends DEL250D1BWP12T30P140

subckt b_cdac GNN0 GNN1 GNN2 GNN3 GNN4 GNN5 GNN6 GNN7 GNP0 GNP1 GNP2 GNP3 GNP4 GNP5 GNP6 GNP7 GPN0 GPN1 GPN2 GPN3 GPN4 GPN5 GPN6 GPN7 GPP0 GPP1 GPP2 GPP3 GPP4 GPP5 GPP6 GPP7 TOPN TOPP VDD VREFN VREFP VSS
// BEGIN SARADC RNL
// @RNL(author="saradc topology") {
// (-89,30) @TEXT("b_cdac / source-derived connections",size=1.4,halign="start",textcolor="#223d52");
// (-20,5) @TEXT("Interface view only - no transistor body is distributed here.",size=1.2,halign="start",textcolor="#223d52");
// (-20,-2) @TEXT("Ports: GNN0, GNN1, GNN2, GNN3, GNN4, GNN5, GNN6, GNN7, GNP0, GNP1, GNP2, GNP3, GNP4, GNP5, GNP6, GNP7, GPN0, GPN1, GPN2, GPN3, GPN4, GPN5, GPN6, GPN7, GPP0, GPP1, GPP2, GPP3, GPP4, GPP5, GPP6, GPP7, TOPN, TOPP, VDD, VREFN, VREFP, VSS",size=0.9,halign="start",textcolor="#223d52");
// }
// END SARADC RNL
ends b_cdac

subckt b_cdac_bit GNN GNP GPN GPP TOPN TOPP VREFN VREFP VDD VSS
// BEGIN SARADC RNL
// @RNL(author="saradc topology") {
// (-89,30) @TEXT("b_cdac_bit / source-derived connections",size=1.4,halign="start",textcolor="#223d52");
// (-20,5) @TEXT("Interface view only - no transistor body is distributed here.",size=1.2,halign="start",textcolor="#223d52");
// (-20,-2) @TEXT("Ports: GNN, GNP, GPN, GPP, TOPN, TOPP, VREFN, VREFP, VDD, VSS",size=0.9,halign="start",textcolor="#223d52");
// }
// END SARADC RNL
ends b_cdac_bit

subckt b_comparator CLK OUTN OUTP VDD VINN VINP VSS
// BEGIN SARADC RNL
// @RNL(author="saradc topology") {
// (-89,30) @TEXT("b_comparator / source-derived connections",size=1.4,halign="start",textcolor="#223d52");
// (-20,5) @TEXT("Interface view only - no transistor body is distributed here.",size=1.2,halign="start",textcolor="#223d52");
// (-20,-2) @TEXT("Ports: CLK, OUTN, OUTP, VDD, VINN, VINP, VSS",size=0.9,halign="start",textcolor="#223d52");
// }
// END SARADC RNL
ends b_comparator

subckt b_reference CODE0 CODE1 CODE2 CODE3 CODE4 CODE5 CODE6 CODE7 D0 D1 D2 D3 D4 D5 D6 D7 GNN0 GNN1 GNN2 GNN3 GNN4 GNN5 GNN6 GNN7 GNP0 GNP1 GNP2 GNP3 GNP4 GNP5 GNP6 GNP7 GPN0 GPN1 GPN2 GPN3 GPN4 GPN5 GPN6 GPN7 GPP0 GPP1 GPP2 GPP3 GPP4 GPP5 GPP6 GPP7 PHI_U SAMPLE VDD VSS RST_DONE PRESET
// BEGIN SARADC RNL
// @RNL(author="saradc topology") {
// (-89,30) @TEXT("b_reference / source-derived connections",size=1.4,halign="start",textcolor="#223d52");
// (-20,5) @TEXT("Interface view only - no transistor body is distributed here.",size=1.2,halign="start",textcolor="#223d52");
// (-20,-2) @TEXT("Ports: CODE0, CODE1, CODE2, CODE3, CODE4, CODE5, CODE6, CODE7, D0, D1, D2, D3, D4, D5, D6, D7, GNN0, GNN1, GNN2, GNN3, GNN4, GNN5, GNN6, GNN7, GNP0, GNP1, GNP2, GNP3, GNP4, GNP5, GNP6, GNP7, GPN0, GPN1, GPN2, GPN3, GPN4, GPN5, GPN6, GPN7, GPP0, GPP1, GPP2, GPP3, GPP4, GPP5, GPP6, GPP7, PHI_U, SAMPLE, VDD, VSS, RST_DONE, PRESET",size=0.9,halign="start",textcolor="#223d52");
// }
// END SARADC RNL
ends b_reference

subckt b_edge A VDD VSS Y
// BEGIN SARADC RNL
// @RNL(author="saradc topology") {
// (-89,30) @TEXT("b_edge / source-derived connections",size=1.4,halign="start",textcolor="#223d52");
// (-20,5) @TEXT("Interface view only - no transistor body is distributed here.",size=1.2,halign="start",textcolor="#223d52");
// (-20,-2) @TEXT("Ports: A, VDD, VSS, Y",size=0.9,halign="start",textcolor="#223d52");
// }
// END SARADC RNL
ends b_edge

subckt b_idle ACTIVE SAMPLE VDD VSS PRESET SAMPLE_MATCH
// BEGIN SARADC RNL
// @RNL(author="saradc topology") {
// (-89,30) @TEXT("b_idle / source-derived connections",size=1.4,halign="start",textcolor="#223d52");
// (-20,5) @TEXT("Interface view only - no transistor body is distributed here.",size=1.2,halign="start",textcolor="#223d52");
// (-20,-2) @TEXT("Ports: ACTIVE, SAMPLE, VDD, VSS, PRESET, SAMPLE_MATCH",size=0.9,halign="start",textcolor="#223d52");
// }
// END SARADC RNL
ends b_idle

subckt b_sampler CLKS VOUT VIN VDD VSS
// BEGIN SARADC RNL
// @RNL(author="saradc topology") {
// (-89,30) @TEXT("b_sampler / source-derived connections",size=1.4,halign="start",textcolor="#223d52");
// (-20,5) @TEXT("Interface view only - no transistor body is distributed here.",size=1.2,halign="start",textcolor="#223d52");
// (-20,-2) @TEXT("Ports: CLKS, VOUT, VIN, VDD, VSS",size=0.9,halign="start",textcolor="#223d52");
// }
// END SARADC RNL
ends b_sampler

subckt b_sar CMP_CLK CODE0 CODE1 CODE2 CODE3 CODE4 CODE5 CODE6 CODE7 COMP_N COMP_P D0 D1 D2 D3 D4 D5 D6 D7 PHI_U SAMPLE VDD VSS ACTIVE
// BEGIN SARADC RNL
// @RNL(author="saradc topology") {
// (-89,30) @TEXT("b_sar / source-derived connections",size=1.4,halign="start",textcolor="#223d52");
// (-20,5) @TEXT("Interface view only - no transistor body is distributed here.",size=1.2,halign="start",textcolor="#223d52");
// (-20,-2) @TEXT("Ports: CMP_CLK, CODE0, CODE1, CODE2, CODE3, CODE4, CODE5, CODE6, CODE7, COMP_N, COMP_P, D0, D1, D2, D3, D4, D5, D6, D7, PHI_U, SAMPLE, VDD, VSS, ACTIVE",size=0.9,halign="start",textcolor="#223d52");
// }
// END SARADC RNL
ends b_sar

subckt sar_adc_b D0 D1 D2 D3 D4 D5 D6 D7 SAMPLE VDD VINN VINP VREFN VREFP VSS
// BEGIN SARADC RNL
// @RNL(author="saradc topology") {
// (-89,30) @TEXT("sar_adc_b / source-derived connections",size=1.4,halign="start",textcolor="#223d52");
// (-20,5) @TEXT("Interface view only - no transistor body is distributed here.",size=1.2,halign="start",textcolor="#223d52");
// (-20,-2) @TEXT("Ports: D0, D1, D2, D3, D4, D5, D6, D7, SAMPLE, VDD, VINN, VINP, VREFN, VREFP, VSS",size=0.9,halign="start",textcolor="#223d52");
// }
// END SARADC RNL
ends sar_adc_b

subckt b_delay A VDD VSS Y
// BEGIN SARADC RNL
// @RNL(author="saradc topology") {
// (-89,30) @TEXT("b_delay / source-derived connections",size=1.4,halign="start",textcolor="#223d52");
// (-20,5) @TEXT("Interface view only - no transistor body is distributed here.",size=1.2,halign="start",textcolor="#223d52");
// (-20,-2) @TEXT("Ports: A, VDD, VSS, Y",size=0.9,halign="start",textcolor="#223d52");
// }
// END SARADC RNL
ends b_delay

subckt b_behavior_observer D0 D1 D2 D3 D4 D5 D6 D7 SAMPLE VDD VSS
// BEGIN SARADC RNL
// @RNL(author="saradc topology") {
// (-89,30) @TEXT("b_behavior_observer / source-derived connections",size=1.4,halign="start",textcolor="#223d52");
// (-20,5) @TEXT("Interface view only - no transistor body is distributed here.",size=1.2,halign="start",textcolor="#223d52");
// (-20,-2) @TEXT("Ports: D0, D1, D2, D3, D4, D5, D6, D7, SAMPLE, VDD, VSS",size=0.9,halign="start",textcolor="#223d52");
// }
// END SARADC RNL
ends b_behavior_observer

subckt b_tb_switch A B EN VDD VSS
// BEGIN SARADC RNL
// @RNL(author="saradc topology") {
// (-89,30) @TEXT("b_tb_switch / source-derived connections",size=1.4,halign="start",textcolor="#223d52");
// (-20,5) @TEXT("Interface view only - no transistor body is distributed here.",size=1.2,halign="start",textcolor="#223d52");
// (-20,-2) @TEXT("Ports: A, B, EN, VDD, VSS",size=0.9,halign="start",textcolor="#223d52");
// }
// END SARADC RNL
ends b_tb_switch

subckt b_sampler_bridge CLKS VOUT Vin
// BEGIN SARADC RNL
// @RNL(author="saradc topology") {
// (-89,30) @TEXT("b_sampler_bridge / source-derived connections",size=1.4,halign="start",textcolor="#223d52");
// (-20,5) @TEXT("Interface view only - no transistor body is distributed here.",size=1.2,halign="start",textcolor="#223d52");
// (-20,-2) @TEXT("Ports: CLKS, VOUT, Vin",size=0.9,halign="start",textcolor="#223d52");
// }
// END SARADC RNL
ends b_sampler_bridge
