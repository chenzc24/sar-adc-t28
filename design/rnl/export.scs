// Display-only self-contained RNL export. Use design/dut.scs for simulation.

// BEGIN SARADC RNL
// @RNL(type="header") { @VERSION("0.3"); @USE-PACKAGE(name="rnl-std-fill") {};
// @DEVICE(name="*",model="nch*",terminals=["d","g","s","b"]);
// @DEVICE(name="*",model="pch*",terminals=["d","g","s","b"]);
// @USE-PACKAGE(name="sar8",version="0.1") {
//
// $S_sar_adc8_join_r4 = @DEFINE-SYMBOL {
// @LINE {(-11,9.9) (11,9.9) (11,-9.9) (-11,-9.9) (-11,9.9)};
// (-13,6.6) @PIN(terminal=9,direction="left");
// @LINE {(-13,6.6) (-11,6.6)};
// (-10.5,6.6) @TEXT("SAMPLE",size=1.1,halign="start",valign="middle");
// (-13,3.3) @PIN(terminal=11,direction="left");
// @LINE {(-13,3.3) (-11,3.3)};
// (-10.5,3.3) @TEXT("VINN",size=1.1,halign="start",valign="middle");
// (-13,0) @PIN(terminal=12,direction="left");
// @LINE {(-13,0) (-11,0)};
// (-10.5,0) @TEXT("VINP",size=1.1,halign="start",valign="middle");
// (-13,-3.3) @PIN(terminal=13,direction="left");
// @LINE {(-13,-3.3) (-11,-3.3)};
// (-10.5,-3.3) @TEXT("VREFN",size=1.1,halign="start",valign="middle");
// (-13,-6.6) @PIN(terminal=14,direction="left");
// @LINE {(-13,-6.6) (-11,-6.6)};
// (-10.5,-6.6) @TEXT("VREFP",size=1.1,halign="start",valign="middle");
// (13,0) @PIN(terminal=[1, 2, 3, 4, 5, 6, 7, 8],direction="right");
// @LINE {(13,0) (11,0)};
// (10.5,0) @TEXT("D[7:0]",size=1.1,halign="end",valign="middle");
// (0,11.9) @PIN(terminal=10,direction="up");
// @LINE {(0,11.9) (0,9.9)};
// (0,9.1) @TEXT("VDD!",size=1.1,halign="middle",valign="middle");
// (0,-11.9) @PIN(terminal=15,direction="down");
// @LINE {(0,-11.9) (0,-9.9)};
// (0,-9.1) @TEXT("0",size=1.1,halign="middle",valign="middle");
// ? @TEXT("${name}",key="name",size=1.6,halign="middle") => @PLACE(0,13.4);
// ? @TEXT("${model}",key="model",size=0.85,halign="middle") => @PLACE(0,-13.9);
// };
// # @SELECT-INSTANCE(model="sar_adc8_join_r4") => @SET-SYMBOL $S_sar_adc8_join_r4;
// $S_sar_bootstrap_flat_8b_p = @DEFINE-SYMBOL {
// @LINE {(-11,6) (11,6) (11,-6) (-11,-6) (-11,6)};
// (-13,1.65) @PIN(terminal=1,direction="left");
// @LINE {(-13,1.65) (-11,1.65)};
// (-10.5,1.65) @TEXT("CLKS",size=1.1,halign="start",valign="middle");
// (-13,-1.65) @PIN(terminal=3,direction="left");
// @LINE {(-13,-1.65) (-11,-1.65)};
// (-10.5,-1.65) @TEXT("Vin",size=1.1,halign="start",valign="middle");
// (13,0) @PIN(terminal=2,direction="right");
// @LINE {(13,0) (11,0)};
// (10.5,0) @TEXT("VOUT",size=1.1,halign="end",valign="middle");
// ? @TEXT("${name}",key="name",size=1.6,halign="middle") => @PLACE(0,9.5);
// ? @TEXT("${model}",key="model",size=0.85,halign="middle") => @PLACE(0,-10);
// };
// # @SELECT-INSTANCE(model="sar_bootstrap_flat_8b_p") => @SET-SYMBOL $S_sar_bootstrap_flat_8b_p;
// $S_sar8j_r1_sw_b0 = @DEFINE-SYMBOL {
// @LINE {(-11,7) (11,7) (11,-7) (-11,-7) (-11,7)};
// (0,12) @PIN(terminal=1,direction="up");
// @LINE {(0,12) (0,7)};
// (0,6.2) @TEXT("BOT",size=0.65,halign="middle",valign="middle");
// (-5,-12) @PIN(terminal=2,direction="down");
// @LINE {(-5,-12) (-5,-7)};
// (-5,-6.2) @TEXT("GN",size=0.65,halign="middle",valign="middle");
// (5,-12) @PIN(terminal=3,direction="down");
// @LINE {(5,-12) (5,-7)};
// (5,-6.2) @TEXT("GP",size=0.65,halign="middle",valign="middle");
// (-13,-4) @PIN(terminal=5,direction="left");
// @LINE {(-13,-4) (-11,-4)};
// (-10,-4) @TEXT("VREFN",size=0.65,halign="start",valign="middle");
// (-13,4) @PIN(terminal=6,direction="left");
// @LINE {(-13,4) (-11,4)};
// (-10,4) @TEXT("VREFP",size=0.65,halign="start",valign="middle");
// (13,4) @PIN(terminal=4,direction="right");
// @LINE {(13,4) (11,4)};
// (10,4) @TEXT("VDD",size=0.65,halign="end",valign="middle");
// (13,-4) @PIN(terminal=7,direction="right");
// @LINE {(13,-4) (11,-4)};
// (10,-4) @TEXT("VSS",size=0.65,halign="end",valign="middle");
// ? @TEXT("${name}",key="name",size=1.6,halign="middle") => @PLACE(0,10.5);
// ? @TEXT("${model}",key="model",size=0.85,halign="middle") => @PLACE(0,-11);
// };
// # @SELECT-INSTANCE(model="sar8j_r1_sw_b0") => @SET-SYMBOL $S_sar8j_r1_sw_b0;
// $S_sar8j_r1_sw_b1 = @DEFINE-SYMBOL {
// @LINE {(-11,7) (11,7) (11,-7) (-11,-7) (-11,7)};
// (0,12) @PIN(terminal=1,direction="up");
// @LINE {(0,12) (0,7)};
// (0,6.2) @TEXT("BOT",size=0.65,halign="middle",valign="middle");
// (-5,-12) @PIN(terminal=2,direction="down");
// @LINE {(-5,-12) (-5,-7)};
// (-5,-6.2) @TEXT("GN",size=0.65,halign="middle",valign="middle");
// (5,-12) @PIN(terminal=3,direction="down");
// @LINE {(5,-12) (5,-7)};
// (5,-6.2) @TEXT("GP",size=0.65,halign="middle",valign="middle");
// (-13,-4) @PIN(terminal=5,direction="left");
// @LINE {(-13,-4) (-11,-4)};
// (-10,-4) @TEXT("VREFN",size=0.65,halign="start",valign="middle");
// (-13,4) @PIN(terminal=6,direction="left");
// @LINE {(-13,4) (-11,4)};
// (-10,4) @TEXT("VREFP",size=0.65,halign="start",valign="middle");
// (13,4) @PIN(terminal=4,direction="right");
// @LINE {(13,4) (11,4)};
// (10,4) @TEXT("VDD",size=0.65,halign="end",valign="middle");
// (13,-4) @PIN(terminal=7,direction="right");
// @LINE {(13,-4) (11,-4)};
// (10,-4) @TEXT("VSS",size=0.65,halign="end",valign="middle");
// ? @TEXT("${name}",key="name",size=1.6,halign="middle") => @PLACE(0,10.5);
// ? @TEXT("${model}",key="model",size=0.85,halign="middle") => @PLACE(0,-11);
// };
// # @SELECT-INSTANCE(model="sar8j_r1_sw_b1") => @SET-SYMBOL $S_sar8j_r1_sw_b1;
// $S_sar8j_r1_sw_b2 = @DEFINE-SYMBOL {
// @LINE {(-11,7) (11,7) (11,-7) (-11,-7) (-11,7)};
// (0,12) @PIN(terminal=1,direction="up");
// @LINE {(0,12) (0,7)};
// (0,6.2) @TEXT("BOT",size=0.65,halign="middle",valign="middle");
// (-5,-12) @PIN(terminal=2,direction="down");
// @LINE {(-5,-12) (-5,-7)};
// (-5,-6.2) @TEXT("GN",size=0.65,halign="middle",valign="middle");
// (5,-12) @PIN(terminal=3,direction="down");
// @LINE {(5,-12) (5,-7)};
// (5,-6.2) @TEXT("GP",size=0.65,halign="middle",valign="middle");
// (-13,-4) @PIN(terminal=5,direction="left");
// @LINE {(-13,-4) (-11,-4)};
// (-10,-4) @TEXT("VREFN",size=0.65,halign="start",valign="middle");
// (-13,4) @PIN(terminal=6,direction="left");
// @LINE {(-13,4) (-11,4)};
// (-10,4) @TEXT("VREFP",size=0.65,halign="start",valign="middle");
// (13,4) @PIN(terminal=4,direction="right");
// @LINE {(13,4) (11,4)};
// (10,4) @TEXT("VDD",size=0.65,halign="end",valign="middle");
// (13,-4) @PIN(terminal=7,direction="right");
// @LINE {(13,-4) (11,-4)};
// (10,-4) @TEXT("VSS",size=0.65,halign="end",valign="middle");
// ? @TEXT("${name}",key="name",size=1.6,halign="middle") => @PLACE(0,10.5);
// ? @TEXT("${model}",key="model",size=0.85,halign="middle") => @PLACE(0,-11);
// };
// # @SELECT-INSTANCE(model="sar8j_r1_sw_b2") => @SET-SYMBOL $S_sar8j_r1_sw_b2;
// $S_sar8j_r1_sw_b3 = @DEFINE-SYMBOL {
// @LINE {(-11,7) (11,7) (11,-7) (-11,-7) (-11,7)};
// (0,12) @PIN(terminal=1,direction="up");
// @LINE {(0,12) (0,7)};
// (0,6.2) @TEXT("BOT",size=0.65,halign="middle",valign="middle");
// (-5,-12) @PIN(terminal=2,direction="down");
// @LINE {(-5,-12) (-5,-7)};
// (-5,-6.2) @TEXT("GN",size=0.65,halign="middle",valign="middle");
// (5,-12) @PIN(terminal=3,direction="down");
// @LINE {(5,-12) (5,-7)};
// (5,-6.2) @TEXT("GP",size=0.65,halign="middle",valign="middle");
// (-13,-4) @PIN(terminal=5,direction="left");
// @LINE {(-13,-4) (-11,-4)};
// (-10,-4) @TEXT("VREFN",size=0.65,halign="start",valign="middle");
// (-13,4) @PIN(terminal=6,direction="left");
// @LINE {(-13,4) (-11,4)};
// (-10,4) @TEXT("VREFP",size=0.65,halign="start",valign="middle");
// (13,4) @PIN(terminal=4,direction="right");
// @LINE {(13,4) (11,4)};
// (10,4) @TEXT("VDD",size=0.65,halign="end",valign="middle");
// (13,-4) @PIN(terminal=7,direction="right");
// @LINE {(13,-4) (11,-4)};
// (10,-4) @TEXT("VSS",size=0.65,halign="end",valign="middle");
// ? @TEXT("${name}",key="name",size=1.6,halign="middle") => @PLACE(0,10.5);
// ? @TEXT("${model}",key="model",size=0.85,halign="middle") => @PLACE(0,-11);
// };
// # @SELECT-INSTANCE(model="sar8j_r1_sw_b3") => @SET-SYMBOL $S_sar8j_r1_sw_b3;
// $S_sar8j_r1_sw_b4 = @DEFINE-SYMBOL {
// @LINE {(-11,7) (11,7) (11,-7) (-11,-7) (-11,7)};
// (0,12) @PIN(terminal=1,direction="up");
// @LINE {(0,12) (0,7)};
// (0,6.2) @TEXT("BOT",size=0.65,halign="middle",valign="middle");
// (-5,-12) @PIN(terminal=2,direction="down");
// @LINE {(-5,-12) (-5,-7)};
// (-5,-6.2) @TEXT("GN",size=0.65,halign="middle",valign="middle");
// (5,-12) @PIN(terminal=3,direction="down");
// @LINE {(5,-12) (5,-7)};
// (5,-6.2) @TEXT("GP",size=0.65,halign="middle",valign="middle");
// (-13,-4) @PIN(terminal=5,direction="left");
// @LINE {(-13,-4) (-11,-4)};
// (-10,-4) @TEXT("VREFN",size=0.65,halign="start",valign="middle");
// (-13,4) @PIN(terminal=6,direction="left");
// @LINE {(-13,4) (-11,4)};
// (-10,4) @TEXT("VREFP",size=0.65,halign="start",valign="middle");
// (13,4) @PIN(terminal=4,direction="right");
// @LINE {(13,4) (11,4)};
// (10,4) @TEXT("VDD",size=0.65,halign="end",valign="middle");
// (13,-4) @PIN(terminal=7,direction="right");
// @LINE {(13,-4) (11,-4)};
// (10,-4) @TEXT("VSS",size=0.65,halign="end",valign="middle");
// ? @TEXT("${name}",key="name",size=1.6,halign="middle") => @PLACE(0,10.5);
// ? @TEXT("${model}",key="model",size=0.85,halign="middle") => @PLACE(0,-11);
// };
// # @SELECT-INSTANCE(model="sar8j_r1_sw_b4") => @SET-SYMBOL $S_sar8j_r1_sw_b4;
// $S_sar8j_r1_sw_b5 = @DEFINE-SYMBOL {
// @LINE {(-11,7) (11,7) (11,-7) (-11,-7) (-11,7)};
// (0,12) @PIN(terminal=1,direction="up");
// @LINE {(0,12) (0,7)};
// (0,6.2) @TEXT("BOT",size=0.65,halign="middle",valign="middle");
// (-5,-12) @PIN(terminal=2,direction="down");
// @LINE {(-5,-12) (-5,-7)};
// (-5,-6.2) @TEXT("GN",size=0.65,halign="middle",valign="middle");
// (5,-12) @PIN(terminal=3,direction="down");
// @LINE {(5,-12) (5,-7)};
// (5,-6.2) @TEXT("GP",size=0.65,halign="middle",valign="middle");
// (-13,-4) @PIN(terminal=5,direction="left");
// @LINE {(-13,-4) (-11,-4)};
// (-10,-4) @TEXT("VREFN",size=0.65,halign="start",valign="middle");
// (-13,4) @PIN(terminal=6,direction="left");
// @LINE {(-13,4) (-11,4)};
// (-10,4) @TEXT("VREFP",size=0.65,halign="start",valign="middle");
// (13,4) @PIN(terminal=4,direction="right");
// @LINE {(13,4) (11,4)};
// (10,4) @TEXT("VDD",size=0.65,halign="end",valign="middle");
// (13,-4) @PIN(terminal=7,direction="right");
// @LINE {(13,-4) (11,-4)};
// (10,-4) @TEXT("VSS",size=0.65,halign="end",valign="middle");
// ? @TEXT("${name}",key="name",size=1.6,halign="middle") => @PLACE(0,10.5);
// ? @TEXT("${model}",key="model",size=0.85,halign="middle") => @PLACE(0,-11);
// };
// # @SELECT-INSTANCE(model="sar8j_r1_sw_b5") => @SET-SYMBOL $S_sar8j_r1_sw_b5;
// $S_sar8j_r1_sw_b6 = @DEFINE-SYMBOL {
// @LINE {(-11,7) (11,7) (11,-7) (-11,-7) (-11,7)};
// (0,12) @PIN(terminal=1,direction="up");
// @LINE {(0,12) (0,7)};
// (0,6.2) @TEXT("BOT",size=0.65,halign="middle",valign="middle");
// (-5,-12) @PIN(terminal=2,direction="down");
// @LINE {(-5,-12) (-5,-7)};
// (-5,-6.2) @TEXT("GN",size=0.65,halign="middle",valign="middle");
// (5,-12) @PIN(terminal=3,direction="down");
// @LINE {(5,-12) (5,-7)};
// (5,-6.2) @TEXT("GP",size=0.65,halign="middle",valign="middle");
// (-13,-4) @PIN(terminal=5,direction="left");
// @LINE {(-13,-4) (-11,-4)};
// (-10,-4) @TEXT("VREFN",size=0.65,halign="start",valign="middle");
// (-13,4) @PIN(terminal=6,direction="left");
// @LINE {(-13,4) (-11,4)};
// (-10,4) @TEXT("VREFP",size=0.65,halign="start",valign="middle");
// (13,4) @PIN(terminal=4,direction="right");
// @LINE {(13,4) (11,4)};
// (10,4) @TEXT("VDD",size=0.65,halign="end",valign="middle");
// (13,-4) @PIN(terminal=7,direction="right");
// @LINE {(13,-4) (11,-4)};
// (10,-4) @TEXT("VSS",size=0.65,halign="end",valign="middle");
// ? @TEXT("${name}",key="name",size=1.6,halign="middle") => @PLACE(0,10.5);
// ? @TEXT("${model}",key="model",size=0.85,halign="middle") => @PLACE(0,-11);
// };
// # @SELECT-INSTANCE(model="sar8j_r1_sw_b6") => @SET-SYMBOL $S_sar8j_r1_sw_b6;
// $S_sar8j_r1_sw_b7 = @DEFINE-SYMBOL {
// @LINE {(-11,7) (11,7) (11,-7) (-11,-7) (-11,7)};
// (0,12) @PIN(terminal=1,direction="up");
// @LINE {(0,12) (0,7)};
// (0,6.2) @TEXT("BOT",size=0.65,halign="middle",valign="middle");
// (-5,-12) @PIN(terminal=2,direction="down");
// @LINE {(-5,-12) (-5,-7)};
// (-5,-6.2) @TEXT("GN",size=0.65,halign="middle",valign="middle");
// (5,-12) @PIN(terminal=3,direction="down");
// @LINE {(5,-12) (5,-7)};
// (5,-6.2) @TEXT("GP",size=0.65,halign="middle",valign="middle");
// (-13,-4) @PIN(terminal=5,direction="left");
// @LINE {(-13,-4) (-11,-4)};
// (-10,-4) @TEXT("VREFN",size=0.65,halign="start",valign="middle");
// (-13,4) @PIN(terminal=6,direction="left");
// @LINE {(-13,4) (-11,4)};
// (-10,4) @TEXT("VREFP",size=0.65,halign="start",valign="middle");
// (13,4) @PIN(terminal=4,direction="right");
// @LINE {(13,4) (11,4)};
// (10,4) @TEXT("VDD",size=0.65,halign="end",valign="middle");
// (13,-4) @PIN(terminal=7,direction="right");
// @LINE {(13,-4) (11,-4)};
// (10,-4) @TEXT("VSS",size=0.65,halign="end",valign="middle");
// ? @TEXT("${name}",key="name",size=1.6,halign="middle") => @PLACE(0,10.5);
// ? @TEXT("${model}",key="model",size=0.85,halign="middle") => @PLACE(0,-11);
// };
// # @SELECT-INSTANCE(model="sar8j_r1_sw_b7") => @SET-SYMBOL $S_sar8j_r1_sw_b7;
// $S_sar8j_r1_cdac = @DEFINE-SYMBOL {
// @LINE {(-11,11.55) (11,11.55) (11,-11.55) (-11,-11.55) (-11,11.55)};
// (-13,8.25) @PIN(terminal=[1, 2, 3, 4, 5, 6, 7, 8],direction="left");
// @LINE {(-13,8.25) (-11,8.25)};
// (-10.5,8.25) @TEXT("GNN[7:0]",size=1.1,halign="start",valign="middle");
// (-13,4.95) @PIN(terminal=[9, 10, 11, 12, 13, 14, 15, 16],direction="left");
// @LINE {(-13,4.95) (-11,4.95)};
// (-10.5,4.95) @TEXT("GNP[7:0]",size=1.1,halign="start",valign="middle");
// (-13,1.65) @PIN(terminal=[17, 18, 19, 20, 21, 22, 23, 24],direction="left");
// @LINE {(-13,1.65) (-11,1.65)};
// (-10.5,1.65) @TEXT("GPN[7:0]",size=1.1,halign="start",valign="middle");
// (-13,-1.65) @PIN(terminal=[25, 26, 27, 28, 29, 30, 31, 32],direction="left");
// @LINE {(-13,-1.65) (-11,-1.65)};
// (-10.5,-1.65) @TEXT("GPP[7:0]",size=1.1,halign="start",valign="middle");
// (-13,-4.95) @PIN(terminal=36,direction="left");
// @LINE {(-13,-4.95) (-11,-4.95)};
// (-10.5,-4.95) @TEXT("VREFN",size=1.1,halign="start",valign="middle");
// (-13,-8.25) @PIN(terminal=37,direction="left");
// @LINE {(-13,-8.25) (-11,-8.25)};
// (-10.5,-8.25) @TEXT("VREFP",size=1.1,halign="start",valign="middle");
// (13,1.65) @PIN(terminal=33,direction="right");
// @LINE {(13,1.65) (11,1.65)};
// (10.5,1.65) @TEXT("TOPN",size=1.1,halign="end",valign="middle");
// (13,-1.65) @PIN(terminal=34,direction="right");
// @LINE {(13,-1.65) (11,-1.65)};
// (10.5,-1.65) @TEXT("TOPP",size=1.1,halign="end",valign="middle");
// (0,13.55) @PIN(terminal=35,direction="up");
// @LINE {(0,13.55) (0,11.55)};
// (0,10.75) @TEXT("VDD",size=1.1,halign="middle",valign="middle");
// (0,-13.55) @PIN(terminal=38,direction="down");
// @LINE {(0,-13.55) (0,-11.55)};
// (0,-10.75) @TEXT("VSS",size=1.1,halign="middle",valign="middle");
// ? @TEXT("${name}",key="name",size=1.6,halign="middle") => @PLACE(0,15.05);
// ? @TEXT("${model}",key="model",size=0.85,halign="middle") => @PLACE(0,-15.55);
// };
// # @SELECT-INSTANCE(model="sar8j_r1_cdac") => @SET-SYMBOL $S_sar8j_r1_cdac;
// $S_sar8p_delay_valid = @DEFINE-SYMBOL {
// @LINE {(-11,6) (11,6) (11,-6) (-11,-6) (-11,6)};
// (-13,0) @PIN(terminal=1,direction="left");
// @LINE {(-13,0) (-11,0)};
// (-10.5,0) @TEXT("A",size=1.1,halign="start",valign="middle");
// (13,0) @PIN(terminal=4,direction="right");
// @LINE {(13,0) (11,0)};
// (10.5,0) @TEXT("Y",size=1.1,halign="end",valign="middle");
// (0,8) @PIN(terminal=2,direction="up");
// @LINE {(0,8) (0,6)};
// (0,5.2) @TEXT("VDD",size=1.1,halign="middle",valign="middle");
// (0,-8) @PIN(terminal=3,direction="down");
// @LINE {(0,-8) (0,-6)};
// (0,-5.2) @TEXT("VSS",size=1.1,halign="middle",valign="middle");
// ? @TEXT("${name}",key="name",size=1.6,halign="middle") => @PLACE(0,9.5);
// ? @TEXT("${model}",key="model",size=0.85,halign="middle") => @PLACE(0,-10);
// };
// # @SELECT-INSTANCE(model="sar8p_delay_valid") => @SET-SYMBOL $S_sar8p_delay_valid;
// $S_sar8p_delay_write = @DEFINE-SYMBOL {
// @LINE {(-11,6) (11,6) (11,-6) (-11,-6) (-11,6)};
// (-13,0) @PIN(terminal=1,direction="left");
// @LINE {(-13,0) (-11,0)};
// (-10.5,0) @TEXT("A",size=1.1,halign="start",valign="middle");
// (13,0) @PIN(terminal=4,direction="right");
// @LINE {(13,0) (11,0)};
// (10.5,0) @TEXT("Y",size=1.1,halign="end",valign="middle");
// (0,8) @PIN(terminal=2,direction="up");
// @LINE {(0,8) (0,6)};
// (0,5.2) @TEXT("VDD",size=1.1,halign="middle",valign="middle");
// (0,-8) @PIN(terminal=3,direction="down");
// @LINE {(0,-8) (0,-6)};
// (0,-5.2) @TEXT("VSS",size=1.1,halign="middle",valign="middle");
// ? @TEXT("${name}",key="name",size=1.6,halign="middle") => @PLACE(0,9.5);
// ? @TEXT("${model}",key="model",size=0.85,halign="middle") => @PLACE(0,-10);
// };
// # @SELECT-INSTANCE(model="sar8p_delay_write") => @SET-SYMBOL $S_sar8p_delay_write;
// $S_sar8p_delay_quiet = @DEFINE-SYMBOL {
// @LINE {(-11,6) (11,6) (11,-6) (-11,-6) (-11,6)};
// (-13,0) @PIN(terminal=1,direction="left");
// @LINE {(-13,0) (-11,0)};
// (-10.5,0) @TEXT("A",size=1.1,halign="start",valign="middle");
// (13,0) @PIN(terminal=4,direction="right");
// @LINE {(13,0) (11,0)};
// (10.5,0) @TEXT("Y",size=1.1,halign="end",valign="middle");
// (0,8) @PIN(terminal=2,direction="up");
// @LINE {(0,8) (0,6)};
// (0,5.2) @TEXT("VDD",size=1.1,halign="middle",valign="middle");
// (0,-8) @PIN(terminal=3,direction="down");
// @LINE {(0,-8) (0,-6)};
// (0,-5.2) @TEXT("VSS",size=1.1,halign="middle",valign="middle");
// ? @TEXT("${name}",key="name",size=1.6,halign="middle") => @PLACE(0,9.5);
// ? @TEXT("${model}",key="model",size=0.85,halign="middle") => @PLACE(0,-10);
// };
// # @SELECT-INSTANCE(model="sar8p_delay_quiet") => @SET-SYMBOL $S_sar8p_delay_quiet;
// $S_sar8p_delay_capture = @DEFINE-SYMBOL {
// @LINE {(-11,6) (11,6) (11,-6) (-11,-6) (-11,6)};
// (-13,0) @PIN(terminal=1,direction="left");
// @LINE {(-13,0) (-11,0)};
// (-10.5,0) @TEXT("A",size=1.1,halign="start",valign="middle");
// (13,0) @PIN(terminal=4,direction="right");
// @LINE {(13,0) (11,0)};
// (10.5,0) @TEXT("Y",size=1.1,halign="end",valign="middle");
// (0,8) @PIN(terminal=2,direction="up");
// @LINE {(0,8) (0,6)};
// (0,5.2) @TEXT("VDD",size=1.1,halign="middle",valign="middle");
// (0,-8) @PIN(terminal=3,direction="down");
// @LINE {(0,-8) (0,-6)};
// (0,-5.2) @TEXT("VSS",size=1.1,halign="middle",valign="middle");
// ? @TEXT("${name}",key="name",size=1.6,halign="middle") => @PLACE(0,9.5);
// ? @TEXT("${model}",key="model",size=0.85,halign="middle") => @PLACE(0,-10);
// };
// # @SELECT-INSTANCE(model="sar8p_delay_capture") => @SET-SYMBOL $S_sar8p_delay_capture;
// $S_sar8p_delay_bbm = @DEFINE-SYMBOL {
// @LINE {(-11,6) (11,6) (11,-6) (-11,-6) (-11,6)};
// (-13,0) @PIN(terminal=1,direction="left");
// @LINE {(-13,0) (-11,0)};
// (-10.5,0) @TEXT("A",size=1.1,halign="start",valign="middle");
// (13,0) @PIN(terminal=4,direction="right");
// @LINE {(13,0) (11,0)};
// (10.5,0) @TEXT("Y",size=1.1,halign="end",valign="middle");
// (0,8) @PIN(terminal=2,direction="up");
// @LINE {(0,8) (0,6)};
// (0,5.2) @TEXT("VDD",size=1.1,halign="middle",valign="middle");
// (0,-8) @PIN(terminal=3,direction="down");
// @LINE {(0,-8) (0,-6)};
// (0,-5.2) @TEXT("VSS",size=1.1,halign="middle",valign="middle");
// ? @TEXT("${name}",key="name",size=1.6,halign="middle") => @PLACE(0,9.5);
// ? @TEXT("${model}",key="model",size=0.85,halign="middle") => @PLACE(0,-10);
// };
// # @SELECT-INSTANCE(model="sar8p_delay_bbm") => @SET-SYMBOL $S_sar8p_delay_bbm;
// $S_sar8r_delay = @DEFINE-SYMBOL {
// @LINE {(-11,6) (11,6) (11,-6) (-11,-6) (-11,6)};
// (-13,0) @PIN(terminal=1,direction="left");
// @LINE {(-13,0) (-11,0)};
// (-10.5,0) @TEXT("A",size=1.1,halign="start",valign="middle");
// (13,0) @PIN(terminal=4,direction="right");
// @LINE {(13,0) (11,0)};
// (10.5,0) @TEXT("Y",size=1.1,halign="end",valign="middle");
// (0,8) @PIN(terminal=2,direction="up");
// @LINE {(0,8) (0,6)};
// (0,5.2) @TEXT("VDD",size=1.1,halign="middle",valign="middle");
// (0,-8) @PIN(terminal=3,direction="down");
// @LINE {(0,-8) (0,-6)};
// (0,-5.2) @TEXT("VSS",size=1.1,halign="middle",valign="middle");
// ? @TEXT("${name}",key="name",size=1.6,halign="middle") => @PLACE(0,9.5);
// ? @TEXT("${model}",key="model",size=0.85,halign="middle") => @PLACE(0,-10);
// };
// # @SELECT-INSTANCE(model="sar8r_delay") => @SET-SYMBOL $S_sar8r_delay;
// $S_sar8r_edge = @DEFINE-SYMBOL {
// @LINE {(-11,6) (11,6) (11,-6) (-11,-6) (-11,6)};
// (-13,0) @PIN(terminal=1,direction="left");
// @LINE {(-13,0) (-11,0)};
// (-10.5,0) @TEXT("A",size=1.1,halign="start",valign="middle");
// (13,0) @PIN(terminal=4,direction="right");
// @LINE {(13,0) (11,0)};
// (10.5,0) @TEXT("Y",size=1.1,halign="end",valign="middle");
// (0,8) @PIN(terminal=2,direction="up");
// @LINE {(0,8) (0,6)};
// (0,5.2) @TEXT("VDD",size=1.1,halign="middle",valign="middle");
// (0,-8) @PIN(terminal=3,direction="down");
// @LINE {(0,-8) (0,-6)};
// (0,-5.2) @TEXT("VSS",size=1.1,halign="middle",valign="middle");
// ? @TEXT("${name}",key="name",size=1.6,halign="middle") => @PLACE(0,9.5);
// ? @TEXT("${model}",key="model",size=0.85,halign="middle") => @PLACE(0,-10);
// };
// # @SELECT-INSTANCE(model="sar8r_edge") => @SET-SYMBOL $S_sar8r_edge;
// $S_sar8s_step = @DEFINE-SYMBOL {
// @LINE {(-11,6) (11,6) (11,-6) (-11,-6) (-11,6)};
// (-13,0) @PIN(terminal=1,direction="left");
// @LINE {(-13,0) (-11,0)};
// (-10.5,0) @TEXT("A",size=1.1,halign="start",valign="middle");
// (13,0) @PIN(terminal=4,direction="right");
// @LINE {(13,0) (11,0)};
// (10.5,0) @TEXT("Y",size=1.1,halign="end",valign="middle");
// (0,8) @PIN(terminal=2,direction="up");
// @LINE {(0,8) (0,6)};
// (0,5.2) @TEXT("VDD",size=1.1,halign="middle",valign="middle");
// (0,-8) @PIN(terminal=3,direction="down");
// @LINE {(0,-8) (0,-6)};
// (0,-5.2) @TEXT("VSS",size=1.1,halign="middle",valign="middle");
// ? @TEXT("${name}",key="name",size=1.6,halign="middle") => @PLACE(0,9.5);
// ? @TEXT("${model}",key="model",size=0.85,halign="middle") => @PLACE(0,-10);
// };
// # @SELECT-INSTANCE(model="sar8s_step") => @SET-SYMBOL $S_sar8s_step;
// $S_sar8i_guard = @DEFINE-SYMBOL {
// @LINE {(-11,6) (11,6) (11,-6) (-11,-6) (-11,6)};
// (-13,0) @PIN(terminal=1,direction="left");
// @LINE {(-13,0) (-11,0)};
// (-10.5,0) @TEXT("A",size=1.1,halign="start",valign="middle");
// (13,0) @PIN(terminal=4,direction="right");
// @LINE {(13,0) (11,0)};
// (10.5,0) @TEXT("Y",size=1.1,halign="end",valign="middle");
// (0,8) @PIN(terminal=2,direction="up");
// @LINE {(0,8) (0,6)};
// (0,5.2) @TEXT("VDD",size=1.1,halign="middle",valign="middle");
// (0,-8) @PIN(terminal=3,direction="down");
// @LINE {(0,-8) (0,-6)};
// (0,-5.2) @TEXT("VSS",size=1.1,halign="middle",valign="middle");
// ? @TEXT("${name}",key="name",size=1.6,halign="middle") => @PLACE(0,9.5);
// ? @TEXT("${model}",key="model",size=0.85,halign="middle") => @PLACE(0,-10);
// };
// # @SELECT-INSTANCE(model="sar8i_guard") => @SET-SYMBOL $S_sar8i_guard;
// $S_sar8p_inv = @DEFINE-SYMBOL {
// (-7,0) @PIN(terminal=1,direction="left");
// @LINE {(-7,0) (-5,0)};
// (7,0) @PIN(terminal=4,direction="right");
// @LINE {(5,0) (7,0)};
// (0,7) @PIN(terminal=2,direction="up");
// @LINE {(0,7) (0,5)};
// (0,-7) @PIN(terminal=3,direction="down");
// @LINE {(0,-7) (0,-5)};
// @LINE {(-5,5) (-5,-5) (4,0) (-5,5)};
// (4.5,0) @CIRCLE(radius=0.5);
// ? @TEXT("${name}",key="name",size=1.6,halign="middle") => @PLACE(0,8.5);
// ? @TEXT("${model}",key="model",size=0.85,halign="middle") => @PLACE(0,-9);
// };
// # @SELECT-INSTANCE(model="sar8p_inv") => @SET-SYMBOL $S_sar8p_inv;
// $S_sar8p_clkbuf = @DEFINE-SYMBOL {
// (-7,0) @PIN(terminal=1,direction="left");
// @LINE {(-7,0) (-5,0)};
// (7,0) @PIN(terminal=4,direction="right");
// @LINE {(5,0) (7,0)};
// (0,7) @PIN(terminal=2,direction="up");
// @LINE {(0,7) (0,5)};
// (0,-7) @PIN(terminal=3,direction="down");
// @LINE {(0,-7) (0,-5)};
// @LINE {(-5,5) (-5,-5) (4,0) (-5,5)};
// ? @TEXT("${name}",key="name",size=1.6,halign="middle") => @PLACE(0,8.5);
// ? @TEXT("${model}",key="model",size=0.85,halign="middle") => @PLACE(0,-9);
// };
// # @SELECT-INSTANCE(model="sar8p_clkbuf") => @SET-SYMBOL $S_sar8p_clkbuf;
// $S_sar8p_nand2 = @DEFINE-SYMBOL {
// (-7,1.7) @PIN(terminal=1,direction="left");
// @LINE {(-7,1.7) (-5,1.7)};
// (-7,-1.7) @PIN(terminal=2,direction="left");
// @LINE {(-7,-1.7) (-5,-1.7)};
// (7,0) @PIN(terminal=5,direction="right");
// @LINE {(5,0) (7,0)};
// (0,7) @PIN(terminal=3,direction="up");
// @LINE {(0,7) (0,5)};
// (0,-7) @PIN(terminal=4,direction="down");
// @LINE {(0,-7) (0,-5)};
// @LINE {(-5,5) (0,5) (3,4) (4.4,2) (5,0) (4.4,-2) (3,-4) (0,-5) (-5,-5) (-5,5)};
// (5.5,0) @CIRCLE(radius=0.5);
// ? @TEXT("${name}",key="name",size=1.6,halign="middle") => @PLACE(0,8.5);
// ? @TEXT("${model}",key="model",size=0.85,halign="middle") => @PLACE(0,-9);
// };
// # @SELECT-INSTANCE(model="sar8p_nand2") => @SET-SYMBOL $S_sar8p_nand2;
// $S_sar8p_and2 = @DEFINE-SYMBOL {
// (-7,1.7) @PIN(terminal=1,direction="left");
// @LINE {(-7,1.7) (-5,1.7)};
// (-7,-1.7) @PIN(terminal=2,direction="left");
// @LINE {(-7,-1.7) (-5,-1.7)};
// (7,0) @PIN(terminal=5,direction="right");
// @LINE {(5,0) (7,0)};
// (0,7) @PIN(terminal=3,direction="up");
// @LINE {(0,7) (0,5)};
// (0,-7) @PIN(terminal=4,direction="down");
// @LINE {(0,-7) (0,-5)};
// @LINE {(-5,5) (0,5) (3,4) (4.4,2) (5,0) (4.4,-2) (3,-4) (0,-5) (-5,-5) (-5,5)};
// ? @TEXT("${name}",key="name",size=1.6,halign="middle") => @PLACE(0,8.5);
// ? @TEXT("${model}",key="model",size=0.85,halign="middle") => @PLACE(0,-9);
// };
// # @SELECT-INSTANCE(model="sar8p_and2") => @SET-SYMBOL $S_sar8p_and2;
// $S_sar8p_buf = @DEFINE-SYMBOL {
// (-7,0) @PIN(terminal=1,direction="left");
// @LINE {(-7,0) (-5,0)};
// (7,0) @PIN(terminal=4,direction="right");
// @LINE {(5,0) (7,0)};
// (0,7) @PIN(terminal=2,direction="up");
// @LINE {(0,7) (0,5)};
// (0,-7) @PIN(terminal=3,direction="down");
// @LINE {(0,-7) (0,-5)};
// @LINE {(-5,5) (-5,-5) (4,0) (-5,5)};
// ? @TEXT("${name}",key="name",size=1.6,halign="middle") => @PLACE(0,8.5);
// ? @TEXT("${model}",key="model",size=0.85,halign="middle") => @PLACE(0,-9);
// };
// # @SELECT-INSTANCE(model="sar8p_buf") => @SET-SYMBOL $S_sar8p_buf;
// $S_sar8p_xor2 = @DEFINE-SYMBOL {
// (-7,1.7) @PIN(terminal=1,direction="left");
// @LINE {(-7,1.7) (-5,1.7)};
// (-7,-1.7) @PIN(terminal=2,direction="left");
// @LINE {(-7,-1.7) (-5,-1.7)};
// (7,0) @PIN(terminal=5,direction="right");
// @LINE {(5,0) (7,0)};
// (0,7) @PIN(terminal=3,direction="up");
// @LINE {(0,7) (0,5)};
// (0,-7) @PIN(terminal=4,direction="down");
// @LINE {(0,-7) (0,-5)};
// @LINE {(-5,5) (-1,4.6) (2,3) (5,0) (2,-3) (-1,-4.6) (-5,-5) (-3.8,-2) (-3.5,0) (-3.8,2) (-5,5)};
// @LINE {(-6,5) (-4.8,2) (-4.5,0) (-4.8,-2) (-6,-5)};
// ? @TEXT("${name}",key="name",size=1.6,halign="middle") => @PLACE(0,8.5);
// ? @TEXT("${model}",key="model",size=0.85,halign="middle") => @PLACE(0,-9);
// };
// # @SELECT-INSTANCE(model="sar8p_xor2") => @SET-SYMBOL $S_sar8p_xor2;
// $S_sar8p_or2 = @DEFINE-SYMBOL {
// (-7,1.7) @PIN(terminal=1,direction="left");
// @LINE {(-7,1.7) (-5,1.7)};
// (-7,-1.7) @PIN(terminal=2,direction="left");
// @LINE {(-7,-1.7) (-5,-1.7)};
// (7,0) @PIN(terminal=5,direction="right");
// @LINE {(5,0) (7,0)};
// (0,7) @PIN(terminal=3,direction="up");
// @LINE {(0,7) (0,5)};
// (0,-7) @PIN(terminal=4,direction="down");
// @LINE {(0,-7) (0,-5)};
// @LINE {(-5,5) (-1,4.6) (2,3) (5,0) (2,-3) (-1,-4.6) (-5,-5) (-3.8,-2) (-3.5,0) (-3.8,2) (-5,5)};
// ? @TEXT("${name}",key="name",size=1.6,halign="middle") => @PLACE(0,8.5);
// ? @TEXT("${model}",key="model",size=0.85,halign="middle") => @PLACE(0,-9);
// };
// # @SELECT-INSTANCE(model="sar8p_or2") => @SET-SYMBOL $S_sar8p_or2;
// $S_sar8p_sr = @DEFINE-SYMBOL {
// @LINE {(-11,6) (11,6) (11,-6) (-11,-6) (-11,6)};
// (-13,1.65) @PIN(terminal=2,direction="left");
// @LINE {(-13,1.65) (-11,1.65)};
// (-10.5,1.65) @TEXT("R",size=1.1,halign="start",valign="middle");
// (-13,-1.65) @PIN(terminal=3,direction="left");
// @LINE {(-13,-1.65) (-11,-1.65)};
// (-10.5,-1.65) @TEXT("S",size=1.1,halign="start",valign="middle");
// (13,0) @PIN(terminal=1,direction="right");
// @LINE {(13,0) (11,0)};
// (10.5,0) @TEXT("Q",size=1.1,halign="end",valign="middle");
// (0,8) @PIN(terminal=4,direction="up");
// @LINE {(0,8) (0,6)};
// (0,5.2) @TEXT("VDD",size=1.1,halign="middle",valign="middle");
// (0,-8) @PIN(terminal=5,direction="down");
// @LINE {(0,-8) (0,-6)};
// (0,-5.2) @TEXT("VSS",size=1.1,halign="middle",valign="middle");
// ? @TEXT("${name}",key="name",size=1.6,halign="middle") => @PLACE(0,9.5);
// ? @TEXT("${model}",key="model",size=0.85,halign="middle") => @PLACE(0,-10);
// };
// # @SELECT-INSTANCE(model="sar8p_sr") => @SET-SYMBOL $S_sar8p_sr;
// $S_sar8p_dffr = @DEFINE-SYMBOL {
// (-7,3.4) @PIN(terminal=1,direction="left");
// @LINE {(-7,3.4) (-5,3.4)};
// (-4.5,3.4) @TEXT("CK",size=0.7,halign="start",valign="middle");
// @LINE {(-5,4.1) (-3.8,3.4) (-5,2.7)};
// (-7,0) @PIN(terminal=2,direction="left");
// @LINE {(-7,0) (-5,0)};
// (-4.5,0) @TEXT("D",size=0.7,halign="start",valign="middle");
// (-7,-3.4) @PIN(terminal=4,direction="left");
// @LINE {(-7,-3.4) (-5,-3.4)};
// (-4.5,-3.4) @TEXT("RST",size=0.7,halign="start",valign="middle");
// (7,0) @PIN(terminal=3,direction="right");
// @LINE {(5,0) (7,0)};
// (0,7) @PIN(terminal=5,direction="up");
// @LINE {(0,7) (0,5)};
// (0,-7) @PIN(terminal=6,direction="down");
// @LINE {(0,-7) (0,-5)};
// @LINE {(-5,5) (5,5) (5,-5) (-5,-5) (-5,5)};
// (1,0) @TEXT("DFF",size=0.85,halign="middle",valign="middle");
// ? @TEXT("${name}",key="name",size=1.6,halign="middle") => @PLACE(0,8.5);
// ? @TEXT("${model}",key="model",size=0.85,halign="middle") => @PLACE(0,-9);
// };
// # @SELECT-INSTANCE(model="sar8p_dffr") => @SET-SYMBOL $S_sar8p_dffr;
// $S_sar8p_mux2 = @DEFINE-SYMBOL {
// (-7,3.4) @PIN(terminal=1,direction="left");
// @LINE {(-7,3.4) (-5,3.4)};
// (-4.5,3.4) @TEXT("D0",size=0.7,halign="start",valign="middle");
// (-7,0) @PIN(terminal=2,direction="left");
// @LINE {(-7,0) (-5,0)};
// (-4.5,0) @TEXT("D1",size=0.7,halign="start",valign="middle");
// (-7,-3.4) @PIN(terminal=3,direction="left");
// @LINE {(-7,-3.4) (-5,-3.4)};
// (-4.5,-3.4) @TEXT("SEL",size=0.7,halign="start",valign="middle");
// (7,0) @PIN(terminal=6,direction="right");
// @LINE {(5,0) (7,0)};
// (0,7) @PIN(terminal=4,direction="up");
// @LINE {(0,7) (0,5)};
// (0,-7) @PIN(terminal=5,direction="down");
// @LINE {(0,-7) (0,-5)};
// @LINE {(-5,5) (5,5) (5,-5) (-5,-5) (-5,5)};
// (1,0) @TEXT("MUX",size=0.85,halign="middle",valign="middle");
// ? @TEXT("${name}",key="name",size=1.6,halign="middle") => @PLACE(0,8.5);
// ? @TEXT("${model}",key="model",size=0.85,halign="middle") => @PLACE(0,-9);
// };
// # @SELECT-INSTANCE(model="sar8p_mux2") => @SET-SYMBOL $S_sar8p_mux2;
// $S_sar_strongarm_t28 = @DEFINE-SYMBOL {
// @LINE {(-11,6.6) (11,6.6) (11,-6.6) (-11,-6.6) (-11,6.6)};
// (-13,3.3) @PIN(terminal=1,direction="left");
// @LINE {(-13,3.3) (-11,3.3)};
// (-10.5,3.3) @TEXT("CLK",size=1.1,halign="start",valign="middle");
// (-13,0) @PIN(terminal=5,direction="left");
// @LINE {(-13,0) (-11,0)};
// (-10.5,0) @TEXT("VINN",size=1.1,halign="start",valign="middle");
// (-13,-3.3) @PIN(terminal=6,direction="left");
// @LINE {(-13,-3.3) (-11,-3.3)};
// (-10.5,-3.3) @TEXT("VINP",size=1.1,halign="start",valign="middle");
// (13,1.65) @PIN(terminal=2,direction="right");
// @LINE {(13,1.65) (11,1.65)};
// (10.5,1.65) @TEXT("OUTN",size=1.1,halign="end",valign="middle");
// (13,-1.65) @PIN(terminal=3,direction="right");
// @LINE {(13,-1.65) (11,-1.65)};
// (10.5,-1.65) @TEXT("OUTP",size=1.1,halign="end",valign="middle");
// (0,8.6) @PIN(terminal=4,direction="up");
// @LINE {(0,8.6) (0,6.6)};
// (0,5.8) @TEXT("VDD",size=1.1,halign="middle",valign="middle");
// (0,-8.6) @PIN(terminal=7,direction="down");
// @LINE {(0,-8.6) (0,-6.6)};
// (0,-5.8) @TEXT("VSS",size=1.1,halign="middle",valign="middle");
// ? @TEXT("${name}",key="name",size=1.6,halign="middle") => @PLACE(0,10.1);
// ? @TEXT("${model}",key="model",size=0.85,halign="middle") => @PLACE(0,-10.6);
// };
// # @SELECT-INSTANCE(model="sar_strongarm_t28") => @SET-SYMBOL $S_sar_strongarm_t28;
// $S_sar8p_nonoverlap = @DEFINE-SYMBOL {
// @LINE {(-11,6) (11,6) (11,-6) (-11,-6) (-11,6)};
// (-13,0) @PIN(terminal=1,direction="left");
// @LINE {(-13,0) (-11,0)};
// (-10.5,0) @TEXT("CODE",size=1.1,halign="start",valign="middle");
// (13,1.65) @PIN(terminal=2,direction="right");
// @LINE {(13,1.65) (11,1.65)};
// (10.5,1.65) @TEXT("H",size=1.1,halign="end",valign="middle");
// (13,-1.65) @PIN(terminal=3,direction="right");
// @LINE {(13,-1.65) (11,-1.65)};
// (10.5,-1.65) @TEXT("L",size=1.1,halign="end",valign="middle");
// (0,8) @PIN(terminal=4,direction="up");
// @LINE {(0,8) (0,6)};
// (0,5.2) @TEXT("VDD",size=1.1,halign="middle",valign="middle");
// (0,-8) @PIN(terminal=5,direction="down");
// @LINE {(0,-8) (0,-6)};
// (0,-5.2) @TEXT("VSS",size=1.1,halign="middle",valign="middle");
// ? @TEXT("${name}",key="name",size=1.6,halign="middle") => @PLACE(0,9.5);
// ? @TEXT("${model}",key="model",size=0.85,halign="middle") => @PLACE(0,-10);
// };
// # @SELECT-INSTANCE(model="sar8p_nonoverlap") => @SET-SYMBOL $S_sar8p_nonoverlap;
// $S_sar8p_refdrv_b0 = @DEFINE-SYMBOL {
// @LINE {(-11,11.55) (11,11.55) (11,-11.55) (-11,-11.55) (-11,11.55)};
// (13,8.25) @PIN(terminal=1,direction="right");
// @LINE {(13,8.25) (11,8.25)};
// (10.5,8.25) @TEXT("GNN",size=1.1,halign="end",valign="middle");
// (13,4.95) @PIN(terminal=2,direction="right");
// @LINE {(13,4.95) (11,4.95)};
// (10.5,4.95) @TEXT("GNP",size=1.1,halign="end",valign="middle");
// (13,1.65) @PIN(terminal=3,direction="right");
// @LINE {(13,1.65) (11,1.65)};
// (10.5,1.65) @TEXT("GPN",size=1.1,halign="end",valign="middle");
// (13,-1.65) @PIN(terminal=4,direction="right");
// @LINE {(13,-1.65) (11,-1.65)};
// (10.5,-1.65) @TEXT("GPP",size=1.1,halign="end",valign="middle");
// (13,-4.95) @PIN(terminal=5,direction="right");
// @LINE {(13,-4.95) (11,-4.95)};
// (10.5,-4.95) @TEXT("H",size=1.1,halign="end",valign="middle");
// (13,-8.25) @PIN(terminal=6,direction="right");
// @LINE {(13,-8.25) (11,-8.25)};
// (10.5,-8.25) @TEXT("L",size=1.1,halign="end",valign="middle");
// (0,13.55) @PIN(terminal=7,direction="up");
// @LINE {(0,13.55) (0,11.55)};
// (0,10.75) @TEXT("VDD",size=1.1,halign="middle",valign="middle");
// (0,-13.55) @PIN(terminal=8,direction="down");
// @LINE {(0,-13.55) (0,-11.55)};
// (0,-10.75) @TEXT("VSS",size=1.1,halign="middle",valign="middle");
// ? @TEXT("${name}",key="name",size=1.6,halign="middle") => @PLACE(0,15.05);
// ? @TEXT("${model}",key="model",size=0.85,halign="middle") => @PLACE(0,-15.55);
// };
// # @SELECT-INSTANCE(model="sar8p_refdrv_b0") => @SET-SYMBOL $S_sar8p_refdrv_b0;
// $S_sar8p_refdrv_b1 = @DEFINE-SYMBOL {
// @LINE {(-11,11.55) (11,11.55) (11,-11.55) (-11,-11.55) (-11,11.55)};
// (13,8.25) @PIN(terminal=1,direction="right");
// @LINE {(13,8.25) (11,8.25)};
// (10.5,8.25) @TEXT("GNN",size=1.1,halign="end",valign="middle");
// (13,4.95) @PIN(terminal=2,direction="right");
// @LINE {(13,4.95) (11,4.95)};
// (10.5,4.95) @TEXT("GNP",size=1.1,halign="end",valign="middle");
// (13,1.65) @PIN(terminal=3,direction="right");
// @LINE {(13,1.65) (11,1.65)};
// (10.5,1.65) @TEXT("GPN",size=1.1,halign="end",valign="middle");
// (13,-1.65) @PIN(terminal=4,direction="right");
// @LINE {(13,-1.65) (11,-1.65)};
// (10.5,-1.65) @TEXT("GPP",size=1.1,halign="end",valign="middle");
// (13,-4.95) @PIN(terminal=5,direction="right");
// @LINE {(13,-4.95) (11,-4.95)};
// (10.5,-4.95) @TEXT("H",size=1.1,halign="end",valign="middle");
// (13,-8.25) @PIN(terminal=6,direction="right");
// @LINE {(13,-8.25) (11,-8.25)};
// (10.5,-8.25) @TEXT("L",size=1.1,halign="end",valign="middle");
// (0,13.55) @PIN(terminal=7,direction="up");
// @LINE {(0,13.55) (0,11.55)};
// (0,10.75) @TEXT("VDD",size=1.1,halign="middle",valign="middle");
// (0,-13.55) @PIN(terminal=8,direction="down");
// @LINE {(0,-13.55) (0,-11.55)};
// (0,-10.75) @TEXT("VSS",size=1.1,halign="middle",valign="middle");
// ? @TEXT("${name}",key="name",size=1.6,halign="middle") => @PLACE(0,15.05);
// ? @TEXT("${model}",key="model",size=0.85,halign="middle") => @PLACE(0,-15.55);
// };
// # @SELECT-INSTANCE(model="sar8p_refdrv_b1") => @SET-SYMBOL $S_sar8p_refdrv_b1;
// $S_sar8p_refdrv_b2 = @DEFINE-SYMBOL {
// @LINE {(-11,11.55) (11,11.55) (11,-11.55) (-11,-11.55) (-11,11.55)};
// (13,8.25) @PIN(terminal=1,direction="right");
// @LINE {(13,8.25) (11,8.25)};
// (10.5,8.25) @TEXT("GNN",size=1.1,halign="end",valign="middle");
// (13,4.95) @PIN(terminal=2,direction="right");
// @LINE {(13,4.95) (11,4.95)};
// (10.5,4.95) @TEXT("GNP",size=1.1,halign="end",valign="middle");
// (13,1.65) @PIN(terminal=3,direction="right");
// @LINE {(13,1.65) (11,1.65)};
// (10.5,1.65) @TEXT("GPN",size=1.1,halign="end",valign="middle");
// (13,-1.65) @PIN(terminal=4,direction="right");
// @LINE {(13,-1.65) (11,-1.65)};
// (10.5,-1.65) @TEXT("GPP",size=1.1,halign="end",valign="middle");
// (13,-4.95) @PIN(terminal=5,direction="right");
// @LINE {(13,-4.95) (11,-4.95)};
// (10.5,-4.95) @TEXT("H",size=1.1,halign="end",valign="middle");
// (13,-8.25) @PIN(terminal=6,direction="right");
// @LINE {(13,-8.25) (11,-8.25)};
// (10.5,-8.25) @TEXT("L",size=1.1,halign="end",valign="middle");
// (0,13.55) @PIN(terminal=7,direction="up");
// @LINE {(0,13.55) (0,11.55)};
// (0,10.75) @TEXT("VDD",size=1.1,halign="middle",valign="middle");
// (0,-13.55) @PIN(terminal=8,direction="down");
// @LINE {(0,-13.55) (0,-11.55)};
// (0,-10.75) @TEXT("VSS",size=1.1,halign="middle",valign="middle");
// ? @TEXT("${name}",key="name",size=1.6,halign="middle") => @PLACE(0,15.05);
// ? @TEXT("${model}",key="model",size=0.85,halign="middle") => @PLACE(0,-15.55);
// };
// # @SELECT-INSTANCE(model="sar8p_refdrv_b2") => @SET-SYMBOL $S_sar8p_refdrv_b2;
// $S_sar8p_refdrv_b3 = @DEFINE-SYMBOL {
// @LINE {(-11,11.55) (11,11.55) (11,-11.55) (-11,-11.55) (-11,11.55)};
// (13,8.25) @PIN(terminal=1,direction="right");
// @LINE {(13,8.25) (11,8.25)};
// (10.5,8.25) @TEXT("GNN",size=1.1,halign="end",valign="middle");
// (13,4.95) @PIN(terminal=2,direction="right");
// @LINE {(13,4.95) (11,4.95)};
// (10.5,4.95) @TEXT("GNP",size=1.1,halign="end",valign="middle");
// (13,1.65) @PIN(terminal=3,direction="right");
// @LINE {(13,1.65) (11,1.65)};
// (10.5,1.65) @TEXT("GPN",size=1.1,halign="end",valign="middle");
// (13,-1.65) @PIN(terminal=4,direction="right");
// @LINE {(13,-1.65) (11,-1.65)};
// (10.5,-1.65) @TEXT("GPP",size=1.1,halign="end",valign="middle");
// (13,-4.95) @PIN(terminal=5,direction="right");
// @LINE {(13,-4.95) (11,-4.95)};
// (10.5,-4.95) @TEXT("H",size=1.1,halign="end",valign="middle");
// (13,-8.25) @PIN(terminal=6,direction="right");
// @LINE {(13,-8.25) (11,-8.25)};
// (10.5,-8.25) @TEXT("L",size=1.1,halign="end",valign="middle");
// (0,13.55) @PIN(terminal=7,direction="up");
// @LINE {(0,13.55) (0,11.55)};
// (0,10.75) @TEXT("VDD",size=1.1,halign="middle",valign="middle");
// (0,-13.55) @PIN(terminal=8,direction="down");
// @LINE {(0,-13.55) (0,-11.55)};
// (0,-10.75) @TEXT("VSS",size=1.1,halign="middle",valign="middle");
// ? @TEXT("${name}",key="name",size=1.6,halign="middle") => @PLACE(0,15.05);
// ? @TEXT("${model}",key="model",size=0.85,halign="middle") => @PLACE(0,-15.55);
// };
// # @SELECT-INSTANCE(model="sar8p_refdrv_b3") => @SET-SYMBOL $S_sar8p_refdrv_b3;
// $S_sar8p_refdrv_b4 = @DEFINE-SYMBOL {
// @LINE {(-11,11.55) (11,11.55) (11,-11.55) (-11,-11.55) (-11,11.55)};
// (13,8.25) @PIN(terminal=1,direction="right");
// @LINE {(13,8.25) (11,8.25)};
// (10.5,8.25) @TEXT("GNN",size=1.1,halign="end",valign="middle");
// (13,4.95) @PIN(terminal=2,direction="right");
// @LINE {(13,4.95) (11,4.95)};
// (10.5,4.95) @TEXT("GNP",size=1.1,halign="end",valign="middle");
// (13,1.65) @PIN(terminal=3,direction="right");
// @LINE {(13,1.65) (11,1.65)};
// (10.5,1.65) @TEXT("GPN",size=1.1,halign="end",valign="middle");
// (13,-1.65) @PIN(terminal=4,direction="right");
// @LINE {(13,-1.65) (11,-1.65)};
// (10.5,-1.65) @TEXT("GPP",size=1.1,halign="end",valign="middle");
// (13,-4.95) @PIN(terminal=5,direction="right");
// @LINE {(13,-4.95) (11,-4.95)};
// (10.5,-4.95) @TEXT("H",size=1.1,halign="end",valign="middle");
// (13,-8.25) @PIN(terminal=6,direction="right");
// @LINE {(13,-8.25) (11,-8.25)};
// (10.5,-8.25) @TEXT("L",size=1.1,halign="end",valign="middle");
// (0,13.55) @PIN(terminal=7,direction="up");
// @LINE {(0,13.55) (0,11.55)};
// (0,10.75) @TEXT("VDD",size=1.1,halign="middle",valign="middle");
// (0,-13.55) @PIN(terminal=8,direction="down");
// @LINE {(0,-13.55) (0,-11.55)};
// (0,-10.75) @TEXT("VSS",size=1.1,halign="middle",valign="middle");
// ? @TEXT("${name}",key="name",size=1.6,halign="middle") => @PLACE(0,15.05);
// ? @TEXT("${model}",key="model",size=0.85,halign="middle") => @PLACE(0,-15.55);
// };
// # @SELECT-INSTANCE(model="sar8p_refdrv_b4") => @SET-SYMBOL $S_sar8p_refdrv_b4;
// $S_sar8p_refdrv_b5 = @DEFINE-SYMBOL {
// @LINE {(-11,11.55) (11,11.55) (11,-11.55) (-11,-11.55) (-11,11.55)};
// (13,8.25) @PIN(terminal=1,direction="right");
// @LINE {(13,8.25) (11,8.25)};
// (10.5,8.25) @TEXT("GNN",size=1.1,halign="end",valign="middle");
// (13,4.95) @PIN(terminal=2,direction="right");
// @LINE {(13,4.95) (11,4.95)};
// (10.5,4.95) @TEXT("GNP",size=1.1,halign="end",valign="middle");
// (13,1.65) @PIN(terminal=3,direction="right");
// @LINE {(13,1.65) (11,1.65)};
// (10.5,1.65) @TEXT("GPN",size=1.1,halign="end",valign="middle");
// (13,-1.65) @PIN(terminal=4,direction="right");
// @LINE {(13,-1.65) (11,-1.65)};
// (10.5,-1.65) @TEXT("GPP",size=1.1,halign="end",valign="middle");
// (13,-4.95) @PIN(terminal=5,direction="right");
// @LINE {(13,-4.95) (11,-4.95)};
// (10.5,-4.95) @TEXT("H",size=1.1,halign="end",valign="middle");
// (13,-8.25) @PIN(terminal=6,direction="right");
// @LINE {(13,-8.25) (11,-8.25)};
// (10.5,-8.25) @TEXT("L",size=1.1,halign="end",valign="middle");
// (0,13.55) @PIN(terminal=7,direction="up");
// @LINE {(0,13.55) (0,11.55)};
// (0,10.75) @TEXT("VDD",size=1.1,halign="middle",valign="middle");
// (0,-13.55) @PIN(terminal=8,direction="down");
// @LINE {(0,-13.55) (0,-11.55)};
// (0,-10.75) @TEXT("VSS",size=1.1,halign="middle",valign="middle");
// ? @TEXT("${name}",key="name",size=1.6,halign="middle") => @PLACE(0,15.05);
// ? @TEXT("${model}",key="model",size=0.85,halign="middle") => @PLACE(0,-15.55);
// };
// # @SELECT-INSTANCE(model="sar8p_refdrv_b5") => @SET-SYMBOL $S_sar8p_refdrv_b5;
// $S_sar8p_refdrv_b6 = @DEFINE-SYMBOL {
// @LINE {(-11,11.55) (11,11.55) (11,-11.55) (-11,-11.55) (-11,11.55)};
// (13,8.25) @PIN(terminal=1,direction="right");
// @LINE {(13,8.25) (11,8.25)};
// (10.5,8.25) @TEXT("GNN",size=1.1,halign="end",valign="middle");
// (13,4.95) @PIN(terminal=2,direction="right");
// @LINE {(13,4.95) (11,4.95)};
// (10.5,4.95) @TEXT("GNP",size=1.1,halign="end",valign="middle");
// (13,1.65) @PIN(terminal=3,direction="right");
// @LINE {(13,1.65) (11,1.65)};
// (10.5,1.65) @TEXT("GPN",size=1.1,halign="end",valign="middle");
// (13,-1.65) @PIN(terminal=4,direction="right");
// @LINE {(13,-1.65) (11,-1.65)};
// (10.5,-1.65) @TEXT("GPP",size=1.1,halign="end",valign="middle");
// (13,-4.95) @PIN(terminal=5,direction="right");
// @LINE {(13,-4.95) (11,-4.95)};
// (10.5,-4.95) @TEXT("H",size=1.1,halign="end",valign="middle");
// (13,-8.25) @PIN(terminal=6,direction="right");
// @LINE {(13,-8.25) (11,-8.25)};
// (10.5,-8.25) @TEXT("L",size=1.1,halign="end",valign="middle");
// (0,13.55) @PIN(terminal=7,direction="up");
// @LINE {(0,13.55) (0,11.55)};
// (0,10.75) @TEXT("VDD",size=1.1,halign="middle",valign="middle");
// (0,-13.55) @PIN(terminal=8,direction="down");
// @LINE {(0,-13.55) (0,-11.55)};
// (0,-10.75) @TEXT("VSS",size=1.1,halign="middle",valign="middle");
// ? @TEXT("${name}",key="name",size=1.6,halign="middle") => @PLACE(0,15.05);
// ? @TEXT("${model}",key="model",size=0.85,halign="middle") => @PLACE(0,-15.55);
// };
// # @SELECT-INSTANCE(model="sar8p_refdrv_b6") => @SET-SYMBOL $S_sar8p_refdrv_b6;
// $S_sar8p_refdrv_b7 = @DEFINE-SYMBOL {
// @LINE {(-11,11.55) (11,11.55) (11,-11.55) (-11,-11.55) (-11,11.55)};
// (13,8.25) @PIN(terminal=1,direction="right");
// @LINE {(13,8.25) (11,8.25)};
// (10.5,8.25) @TEXT("GNN",size=1.1,halign="end",valign="middle");
// (13,4.95) @PIN(terminal=2,direction="right");
// @LINE {(13,4.95) (11,4.95)};
// (10.5,4.95) @TEXT("GNP",size=1.1,halign="end",valign="middle");
// (13,1.65) @PIN(terminal=3,direction="right");
// @LINE {(13,1.65) (11,1.65)};
// (10.5,1.65) @TEXT("GPN",size=1.1,halign="end",valign="middle");
// (13,-1.65) @PIN(terminal=4,direction="right");
// @LINE {(13,-1.65) (11,-1.65)};
// (10.5,-1.65) @TEXT("GPP",size=1.1,halign="end",valign="middle");
// (13,-4.95) @PIN(terminal=5,direction="right");
// @LINE {(13,-4.95) (11,-4.95)};
// (10.5,-4.95) @TEXT("H",size=1.1,halign="end",valign="middle");
// (13,-8.25) @PIN(terminal=6,direction="right");
// @LINE {(13,-8.25) (11,-8.25)};
// (10.5,-8.25) @TEXT("L",size=1.1,halign="end",valign="middle");
// (0,13.55) @PIN(terminal=7,direction="up");
// @LINE {(0,13.55) (0,11.55)};
// (0,10.75) @TEXT("VDD",size=1.1,halign="middle",valign="middle");
// (0,-13.55) @PIN(terminal=8,direction="down");
// @LINE {(0,-13.55) (0,-11.55)};
// (0,-10.75) @TEXT("VSS",size=1.1,halign="middle",valign="middle");
// ? @TEXT("${name}",key="name",size=1.6,halign="middle") => @PLACE(0,15.05);
// ? @TEXT("${model}",key="model",size=0.85,halign="middle") => @PLACE(0,-15.55);
// };
// # @SELECT-INSTANCE(model="sar8p_refdrv_b7") => @SET-SYMBOL $S_sar8p_refdrv_b7;
// $S_sar8p_refword = @DEFINE-SYMBOL {
// @LINE {(-11,8.25) (11,8.25) (11,-8.25) (-11,-8.25) (-11,8.25)};
// (-13,4.95) @PIN(terminal=[1, 2, 3, 4, 5, 6, 7, 8],direction="left");
// @LINE {(-13,4.95) (-11,4.95)};
// (-10.5,4.95) @TEXT("CODE[7:0]",size=1.1,halign="start",valign="middle");
// (-13,1.65) @PIN(terminal=[9, 10, 11, 12, 13, 14, 15, 16],direction="left");
// @LINE {(-13,1.65) (-11,1.65)};
// (-10.5,1.65) @TEXT("D[7:0]",size=1.1,halign="start",valign="middle");
// (-13,-1.65) @PIN(terminal=49,direction="left");
// @LINE {(-13,-1.65) (-11,-1.65)};
// (-10.5,-1.65) @TEXT("PHI_U",size=1.1,halign="start",valign="middle");
// (-13,-4.95) @PIN(terminal=50,direction="left");
// @LINE {(-13,-4.95) (-11,-4.95)};
// (-10.5,-4.95) @TEXT("SAMPLE",size=1.1,halign="start",valign="middle");
// (13,4.95) @PIN(terminal=[17, 18, 19, 20, 21, 22, 23, 24],direction="right");
// @LINE {(13,4.95) (11,4.95)};
// (10.5,4.95) @TEXT("GNN[7:0]",size=1.1,halign="end",valign="middle");
// (13,1.65) @PIN(terminal=[25, 26, 27, 28, 29, 30, 31, 32],direction="right");
// @LINE {(13,1.65) (11,1.65)};
// (10.5,1.65) @TEXT("GNP[7:0]",size=1.1,halign="end",valign="middle");
// (13,-1.65) @PIN(terminal=[33, 34, 35, 36, 37, 38, 39, 40],direction="right");
// @LINE {(13,-1.65) (11,-1.65)};
// (10.5,-1.65) @TEXT("GPN[7:0]",size=1.1,halign="end",valign="middle");
// (13,-4.95) @PIN(terminal=[41, 42, 43, 44, 45, 46, 47, 48],direction="right");
// @LINE {(13,-4.95) (11,-4.95)};
// (10.5,-4.95) @TEXT("GPP[7:0]",size=1.1,halign="end",valign="middle");
// (0,10.25) @PIN(terminal=51,direction="up");
// @LINE {(0,10.25) (0,8.25)};
// (0,7.45) @TEXT("VDD",size=1.1,halign="middle",valign="middle");
// (0,-10.25) @PIN(terminal=52,direction="down");
// @LINE {(0,-10.25) (0,-8.25)};
// (0,-7.45) @TEXT("VSS",size=1.1,halign="middle",valign="middle");
// ? @TEXT("${name}",key="name",size=1.6,halign="middle") => @PLACE(0,11.75);
// ? @TEXT("${model}",key="model",size=0.85,halign="middle") => @PLACE(0,-12.25);
// };
// # @SELECT-INSTANCE(model="sar8p_refword") => @SET-SYMBOL $S_sar8p_refword;
// $S_sar8s_refword = @DEFINE-SYMBOL {
// @LINE {(-11,9.9) (11,9.9) (11,-9.9) (-11,-9.9) (-11,9.9)};
// (-13,4.95) @PIN(terminal=[1, 2, 3, 4, 5, 6, 7, 8],direction="left");
// @LINE {(-13,4.95) (-11,4.95)};
// (-10.5,4.95) @TEXT("CODE[7:0]",size=1.1,halign="start",valign="middle");
// (-13,1.65) @PIN(terminal=[9, 10, 11, 12, 13, 14, 15, 16],direction="left");
// @LINE {(-13,1.65) (-11,1.65)};
// (-10.5,1.65) @TEXT("D[7:0]",size=1.1,halign="start",valign="middle");
// (-13,-1.65) @PIN(terminal=49,direction="left");
// @LINE {(-13,-1.65) (-11,-1.65)};
// (-10.5,-1.65) @TEXT("PHI_U",size=1.1,halign="start",valign="middle");
// (-13,-4.95) @PIN(terminal=50,direction="left");
// @LINE {(-13,-4.95) (-11,-4.95)};
// (-10.5,-4.95) @TEXT("SAMPLE",size=1.1,halign="start",valign="middle");
// (13,6.6) @PIN(terminal=[17, 18, 19, 20, 21, 22, 23, 24],direction="right");
// @LINE {(13,6.6) (11,6.6)};
// (10.5,6.6) @TEXT("GNN[7:0]",size=1.1,halign="end",valign="middle");
// (13,3.3) @PIN(terminal=[25, 26, 27, 28, 29, 30, 31, 32],direction="right");
// @LINE {(13,3.3) (11,3.3)};
// (10.5,3.3) @TEXT("GNP[7:0]",size=1.1,halign="end",valign="middle");
// (13,0) @PIN(terminal=[33, 34, 35, 36, 37, 38, 39, 40],direction="right");
// @LINE {(13,0) (11,0)};
// (10.5,0) @TEXT("GPN[7:0]",size=1.1,halign="end",valign="middle");
// (13,-3.3) @PIN(terminal=[41, 42, 43, 44, 45, 46, 47, 48],direction="right");
// @LINE {(13,-3.3) (11,-3.3)};
// (10.5,-3.3) @TEXT("GPP[7:0]",size=1.1,halign="end",valign="middle");
// (13,-6.6) @PIN(terminal=53,direction="right");
// @LINE {(13,-6.6) (11,-6.6)};
// (10.5,-6.6) @TEXT("RST_DONE",size=1.1,halign="end",valign="middle");
// (0,11.9) @PIN(terminal=51,direction="up");
// @LINE {(0,11.9) (0,9.9)};
// (0,9.1) @TEXT("VDD",size=1.1,halign="middle",valign="middle");
// (0,-11.9) @PIN(terminal=52,direction="down");
// @LINE {(0,-11.9) (0,-9.9)};
// (0,-9.1) @TEXT("VSS",size=1.1,halign="middle",valign="middle");
// ? @TEXT("${name}",key="name",size=1.6,halign="middle") => @PLACE(0,13.4);
// ? @TEXT("${model}",key="model",size=0.85,halign="middle") => @PLACE(0,-13.9);
// };
// # @SELECT-INSTANCE(model="sar8s_refword") => @SET-SYMBOL $S_sar8s_refword;
// $S_sar8i_refword = @DEFINE-SYMBOL {
// @LINE {(-11,11.55) (11,11.55) (11,-11.55) (-11,-11.55) (-11,11.55)};
// (-13,4.95) @PIN(terminal=[1, 2, 3, 4, 5, 6, 7, 8],direction="left");
// @LINE {(-13,4.95) (-11,4.95)};
// (-10.5,4.95) @TEXT("CODE[7:0]",size=1.1,halign="start",valign="middle");
// (-13,1.65) @PIN(terminal=[9, 10, 11, 12, 13, 14, 15, 16],direction="left");
// @LINE {(-13,1.65) (-11,1.65)};
// (-10.5,1.65) @TEXT("D[7:0]",size=1.1,halign="start",valign="middle");
// (-13,-1.65) @PIN(terminal=49,direction="left");
// @LINE {(-13,-1.65) (-11,-1.65)};
// (-10.5,-1.65) @TEXT("PHI_U",size=1.1,halign="start",valign="middle");
// (-13,-4.95) @PIN(terminal=50,direction="left");
// @LINE {(-13,-4.95) (-11,-4.95)};
// (-10.5,-4.95) @TEXT("SAMPLE",size=1.1,halign="start",valign="middle");
// (13,8.25) @PIN(terminal=[17, 18, 19, 20, 21, 22, 23, 24],direction="right");
// @LINE {(13,8.25) (11,8.25)};
// (10.5,8.25) @TEXT("GNN[7:0]",size=1.1,halign="end",valign="middle");
// (13,4.95) @PIN(terminal=[25, 26, 27, 28, 29, 30, 31, 32],direction="right");
// @LINE {(13,4.95) (11,4.95)};
// (10.5,4.95) @TEXT("GNP[7:0]",size=1.1,halign="end",valign="middle");
// (13,1.65) @PIN(terminal=[33, 34, 35, 36, 37, 38, 39, 40],direction="right");
// @LINE {(13,1.65) (11,1.65)};
// (10.5,1.65) @TEXT("GPN[7:0]",size=1.1,halign="end",valign="middle");
// (13,-1.65) @PIN(terminal=[41, 42, 43, 44, 45, 46, 47, 48],direction="right");
// @LINE {(13,-1.65) (11,-1.65)};
// (10.5,-1.65) @TEXT("GPP[7:0]",size=1.1,halign="end",valign="middle");
// (13,-4.95) @PIN(terminal=53,direction="right");
// @LINE {(13,-4.95) (11,-4.95)};
// (10.5,-4.95) @TEXT("RST_DONE",size=1.1,halign="end",valign="middle");
// (13,-8.25) @PIN(terminal=54,direction="right");
// @LINE {(13,-8.25) (11,-8.25)};
// (10.5,-8.25) @TEXT("PRESET",size=1.1,halign="end",valign="middle");
// (0,13.55) @PIN(terminal=51,direction="up");
// @LINE {(0,13.55) (0,11.55)};
// (0,10.75) @TEXT("VDD",size=1.1,halign="middle",valign="middle");
// (0,-13.55) @PIN(terminal=52,direction="down");
// @LINE {(0,-13.55) (0,-11.55)};
// (0,-10.75) @TEXT("VSS",size=1.1,halign="middle",valign="middle");
// ? @TEXT("${name}",key="name",size=1.6,halign="middle") => @PLACE(0,15.05);
// ? @TEXT("${model}",key="model",size=0.85,halign="middle") => @PLACE(0,-15.55);
// };
// # @SELECT-INSTANCE(model="sar8i_refword") => @SET-SYMBOL $S_sar8i_refword;
// $S_sar8i_idle = @DEFINE-SYMBOL {
// @LINE {(-11,6) (11,6) (11,-6) (-11,-6) (-11,6)};
// (-13,1.65) @PIN(terminal=1,direction="left");
// @LINE {(-13,1.65) (-11,1.65)};
// (-10.5,1.65) @TEXT("ACTIVE",size=1.1,halign="start",valign="middle");
// (-13,-1.65) @PIN(terminal=2,direction="left");
// @LINE {(-13,-1.65) (-11,-1.65)};
// (-10.5,-1.65) @TEXT("SAMPLE",size=1.1,halign="start",valign="middle");
// (13,1.65) @PIN(terminal=5,direction="right");
// @LINE {(13,1.65) (11,1.65)};
// (10.5,1.65) @TEXT("PRESET",size=1.1,halign="end",valign="middle");
// (13,-1.65) @PIN(terminal=6,direction="right");
// @LINE {(13,-1.65) (11,-1.65)};
// (10.5,-1.65) @TEXT("SAMPLE_MATCH",size=1.1,halign="end",valign="middle");
// (0,8) @PIN(terminal=3,direction="up");
// @LINE {(0,8) (0,6)};
// (0,5.2) @TEXT("VDD",size=1.1,halign="middle",valign="middle");
// (0,-8) @PIN(terminal=4,direction="down");
// @LINE {(0,-8) (0,-6)};
// (0,-5.2) @TEXT("VSS",size=1.1,halign="middle",valign="middle");
// ? @TEXT("${name}",key="name",size=1.6,halign="middle") => @PLACE(0,9.5);
// ? @TEXT("${model}",key="model",size=0.85,halign="middle") => @PLACE(0,-10);
// };
// # @SELECT-INSTANCE(model="sar8i_idle") => @SET-SYMBOL $S_sar8i_idle;
// $S_sar8p_timing = @DEFINE-SYMBOL {
// @LINE {(-11,8.25) (11,8.25) (11,-8.25) (-11,-8.25) (-11,8.25)};
// (-13,4.95) @PIN(terminal=1,direction="left");
// @LINE {(-13,4.95) (-11,4.95)};
// (-10.5,4.95) @TEXT("ACTIVE",size=1.1,halign="start",valign="middle");
// (-13,1.65) @PIN(terminal=3,direction="left");
// @LINE {(-13,1.65) (-11,1.65)};
// (-10.5,1.65) @TEXT("COMP_N",size=1.1,halign="start",valign="middle");
// (-13,-1.65) @PIN(terminal=4,direction="left");
// @LINE {(-13,-1.65) (-11,-1.65)};
// (-10.5,-1.65) @TEXT("COMP_P",size=1.1,halign="start",valign="middle");
// (-13,-4.95) @PIN(terminal=8,direction="left");
// @LINE {(-13,-4.95) (-11,-4.95)};
// (-10.5,-4.95) @TEXT("SAMPLE",size=1.1,halign="start",valign="middle");
// (13,4.95) @PIN(terminal=2,direction="right");
// @LINE {(13,4.95) (11,4.95)};
// (10.5,4.95) @TEXT("CMP_CLK",size=1.1,halign="end",valign="middle");
// (13,1.65) @PIN(terminal=5,direction="right");
// @LINE {(13,1.65) (11,1.65)};
// (10.5,1.65) @TEXT("DATA",size=1.1,halign="end",valign="middle");
// (13,-1.65) @PIN(terminal=6,direction="right");
// @LINE {(13,-1.65) (11,-1.65)};
// (10.5,-1.65) @TEXT("PHI_U",size=1.1,halign="end",valign="middle");
// (13,-4.95) @PIN(terminal=7,direction="right");
// @LINE {(13,-4.95) (11,-4.95)};
// (10.5,-4.95) @TEXT("PHI_W",size=1.1,halign="end",valign="middle");
// (0,10.25) @PIN(terminal=9,direction="up");
// @LINE {(0,10.25) (0,8.25)};
// (0,7.45) @TEXT("VDD",size=1.1,halign="middle",valign="middle");
// (0,-10.25) @PIN(terminal=10,direction="down");
// @LINE {(0,-10.25) (0,-8.25)};
// (0,-7.45) @TEXT("VSS",size=1.1,halign="middle",valign="middle");
// ? @TEXT("${name}",key="name",size=1.6,halign="middle") => @PLACE(0,11.75);
// ? @TEXT("${model}",key="model",size=0.85,halign="middle") => @PLACE(0,-12.25);
// };
// # @SELECT-INSTANCE(model="sar8p_timing") => @SET-SYMBOL $S_sar8p_timing;
// $S_sar8p_bitseq8 = @DEFINE-SYMBOL {
// @LINE {(-11,6) (11,6) (11,-6) (-11,-6) (-11,6)};
// (-13,1.65) @PIN(terminal=1,direction="left");
// @LINE {(-13,1.65) (-11,1.65)};
// (-10.5,1.65) @TEXT("PHI_U",size=1.1,halign="start",valign="middle");
// (-13,-1.65) @PIN(terminal=2,direction="left");
// @LINE {(-13,-1.65) (-11,-1.65)};
// (-10.5,-1.65) @TEXT("SAMPLE",size=1.1,halign="start",valign="middle");
// (13,0) @PIN(terminal=[3, 4, 5, 6, 7, 8, 9, 10],direction="right");
// @LINE {(13,0) (11,0)};
// (10.5,0) @TEXT("T[7:0]",size=1.1,halign="end",valign="middle");
// (0,8) @PIN(terminal=11,direction="up");
// @LINE {(0,8) (0,6)};
// (0,5.2) @TEXT("VDD",size=1.1,halign="middle",valign="middle");
// (0,-8) @PIN(terminal=12,direction="down");
// @LINE {(0,-8) (0,-6)};
// (0,-5.2) @TEXT("VSS",size=1.1,halign="middle",valign="middle");
// ? @TEXT("${name}",key="name",size=1.6,halign="middle") => @PLACE(0,9.5);
// ? @TEXT("${model}",key="model",size=0.85,halign="middle") => @PLACE(0,-10);
// };
// # @SELECT-INSTANCE(model="sar8p_bitseq8") => @SET-SYMBOL $S_sar8p_bitseq8;
// $S_sar8p_bit = @DEFINE-SYMBOL {
// @LINE {(-11,8.25) (11,8.25) (11,-8.25) (-11,-8.25) (-11,8.25)};
// (-13,4.95) @PIN(terminal=3,direction="left");
// @LINE {(-13,4.95) (-11,4.95)};
// (-10.5,4.95) @TEXT("DATA",size=1.1,halign="start",valign="middle");
// (-13,1.65) @PIN(terminal=4,direction="left");
// @LINE {(-13,1.65) (-11,1.65)};
// (-10.5,1.65) @TEXT("PHI_W",size=1.1,halign="start",valign="middle");
// (-13,-1.65) @PIN(terminal=5,direction="left");
// @LINE {(-13,-1.65) (-11,-1.65)};
// (-10.5,-1.65) @TEXT("SAMPLE",size=1.1,halign="start",valign="middle");
// (-13,-4.95) @PIN(terminal=6,direction="left");
// @LINE {(-13,-4.95) (-11,-4.95)};
// (-10.5,-4.95) @TEXT("TOKEN",size=1.1,halign="start",valign="middle");
// (13,1.65) @PIN(terminal=1,direction="right");
// @LINE {(13,1.65) (11,1.65)};
// (10.5,1.65) @TEXT("CODE",size=1.1,halign="end",valign="middle");
// (13,-1.65) @PIN(terminal=2,direction="right");
// @LINE {(13,-1.65) (11,-1.65)};
// (10.5,-1.65) @TEXT("D",size=1.1,halign="end",valign="middle");
// (0,10.25) @PIN(terminal=7,direction="up");
// @LINE {(0,10.25) (0,8.25)};
// (0,7.45) @TEXT("VDD",size=1.1,halign="middle",valign="middle");
// (0,-10.25) @PIN(terminal=8,direction="down");
// @LINE {(0,-10.25) (0,-8.25)};
// (0,-7.45) @TEXT("VSS",size=1.1,halign="middle",valign="middle");
// ? @TEXT("${name}",key="name",size=1.6,halign="middle") => @PLACE(0,11.75);
// ? @TEXT("${model}",key="model",size=0.85,halign="middle") => @PLACE(0,-12.25);
// };
// # @SELECT-INSTANCE(model="sar8p_bit") => @SET-SYMBOL $S_sar8p_bit;
// $S_sar_logic_8b_physical = @DEFINE-SYMBOL {
// @LINE {(-11,8.25) (11,8.25) (11,-8.25) (-11,-8.25) (-11,8.25)};
// (-13,3.3) @PIN(terminal=10,direction="left");
// @LINE {(-13,3.3) (-11,3.3)};
// (-10.5,3.3) @TEXT("COMP_N",size=1.1,halign="start",valign="middle");
// (-13,0) @PIN(terminal=11,direction="left");
// @LINE {(-13,0) (-11,0)};
// (-10.5,0) @TEXT("COMP_P",size=1.1,halign="start",valign="middle");
// (-13,-3.3) @PIN(terminal=21,direction="left");
// @LINE {(-13,-3.3) (-11,-3.3)};
// (-10.5,-3.3) @TEXT("SAMPLE",size=1.1,halign="start",valign="middle");
// (13,4.95) @PIN(terminal=1,direction="right");
// @LINE {(13,4.95) (11,4.95)};
// (10.5,4.95) @TEXT("CMP_CLK",size=1.1,halign="end",valign="middle");
// (13,1.65) @PIN(terminal=[2, 3, 4, 5, 6, 7, 8, 9],direction="right");
// @LINE {(13,1.65) (11,1.65)};
// (10.5,1.65) @TEXT("CODE[7:0]",size=1.1,halign="end",valign="middle");
// (13,-1.65) @PIN(terminal=[12, 13, 14, 15, 16, 17, 18, 19],direction="right");
// @LINE {(13,-1.65) (11,-1.65)};
// (10.5,-1.65) @TEXT("D[7:0]",size=1.1,halign="end",valign="middle");
// (13,-4.95) @PIN(terminal=20,direction="right");
// @LINE {(13,-4.95) (11,-4.95)};
// (10.5,-4.95) @TEXT("PHI_U",size=1.1,halign="end",valign="middle");
// (0,10.25) @PIN(terminal=22,direction="up");
// @LINE {(0,10.25) (0,8.25)};
// (0,7.45) @TEXT("VDD",size=1.1,halign="middle",valign="middle");
// (0,-10.25) @PIN(terminal=23,direction="down");
// @LINE {(0,-10.25) (0,-8.25)};
// (0,-7.45) @TEXT("VSS",size=1.1,halign="middle",valign="middle");
// ? @TEXT("${name}",key="name",size=1.6,halign="middle") => @PLACE(0,11.75);
// ? @TEXT("${model}",key="model",size=0.85,halign="middle") => @PLACE(0,-12.25);
// };
// # @SELECT-INSTANCE(model="sar_logic_8b_physical") => @SET-SYMBOL $S_sar_logic_8b_physical;
// $S_sar8i_ctrl = @DEFINE-SYMBOL {
// @LINE {(-11,9.9) (11,9.9) (11,-9.9) (-11,-9.9) (-11,9.9)};
// (-13,3.3) @PIN(terminal=10,direction="left");
// @LINE {(-13,3.3) (-11,3.3)};
// (-10.5,3.3) @TEXT("COMP_N",size=1.1,halign="start",valign="middle");
// (-13,0) @PIN(terminal=11,direction="left");
// @LINE {(-13,0) (-11,0)};
// (-10.5,0) @TEXT("COMP_P",size=1.1,halign="start",valign="middle");
// (-13,-3.3) @PIN(terminal=21,direction="left");
// @LINE {(-13,-3.3) (-11,-3.3)};
// (-10.5,-3.3) @TEXT("SAMPLE",size=1.1,halign="start",valign="middle");
// (13,6.6) @PIN(terminal=1,direction="right");
// @LINE {(13,6.6) (11,6.6)};
// (10.5,6.6) @TEXT("CMP_CLK",size=1.1,halign="end",valign="middle");
// (13,3.3) @PIN(terminal=[2, 3, 4, 5, 6, 7, 8, 9],direction="right");
// @LINE {(13,3.3) (11,3.3)};
// (10.5,3.3) @TEXT("CODE[7:0]",size=1.1,halign="end",valign="middle");
// (13,0) @PIN(terminal=[12, 13, 14, 15, 16, 17, 18, 19],direction="right");
// @LINE {(13,0) (11,0)};
// (10.5,0) @TEXT("D[7:0]",size=1.1,halign="end",valign="middle");
// (13,-3.3) @PIN(terminal=20,direction="right");
// @LINE {(13,-3.3) (11,-3.3)};
// (10.5,-3.3) @TEXT("PHI_U",size=1.1,halign="end",valign="middle");
// (13,-6.6) @PIN(terminal=24,direction="right");
// @LINE {(13,-6.6) (11,-6.6)};
// (10.5,-6.6) @TEXT("ACTIVE",size=1.1,halign="end",valign="middle");
// (0,11.9) @PIN(terminal=22,direction="up");
// @LINE {(0,11.9) (0,9.9)};
// (0,9.1) @TEXT("VDD",size=1.1,halign="middle",valign="middle");
// (0,-11.9) @PIN(terminal=23,direction="down");
// @LINE {(0,-11.9) (0,-9.9)};
// (0,-9.1) @TEXT("VSS",size=1.1,halign="middle",valign="middle");
// ? @TEXT("${name}",key="name",size=1.6,halign="middle") => @PLACE(0,13.4);
// ? @TEXT("${model}",key="model",size=0.85,halign="middle") => @PLACE(0,-13.9);
// };
// # @SELECT-INSTANCE(model="sar8i_ctrl") => @SET-SYMBOL $S_sar8i_ctrl;
// $S_tb_cdac = @DEFINE-SYMBOL {
// @LINE {(-11,6) (11,6) (11,-6) (-11,-6) (-11,6)};
// ? @TEXT("${name}",key="name",size=1.6,halign="middle") => @PLACE(0,9.5);
// ? @TEXT("${model}",key="model",size=0.85,halign="middle") => @PLACE(0,-10);
// };
// # @SELECT-INSTANCE(model="tb_cdac") => @SET-SYMBOL $S_tb_cdac;
// $S_tb_comparator = @DEFINE-SYMBOL {
// @LINE {(-11,6) (11,6) (11,-6) (-11,-6) (-11,6)};
// ? @TEXT("${name}",key="name",size=1.6,halign="middle") => @PLACE(0,9.5);
// ? @TEXT("${model}",key="model",size=0.85,halign="middle") => @PLACE(0,-10);
// };
// # @SELECT-INSTANCE(model="tb_comparator") => @SET-SYMBOL $S_tb_comparator;
// $S_tb_reference = @DEFINE-SYMBOL {
// @LINE {(-11,6) (11,6) (11,-6) (-11,-6) (-11,6)};
// ? @TEXT("${name}",key="name",size=1.6,halign="middle") => @PLACE(0,9.5);
// ? @TEXT("${model}",key="model",size=0.85,halign="middle") => @PLACE(0,-10);
// };
// # @SELECT-INSTANCE(model="tb_reference") => @SET-SYMBOL $S_tb_reference;
// $S_tb_sampler = @DEFINE-SYMBOL {
// @LINE {(-11,6) (11,6) (11,-6) (-11,-6) (-11,6)};
// ? @TEXT("${name}",key="name",size=1.6,halign="middle") => @PLACE(0,9.5);
// ? @TEXT("${model}",key="model",size=0.85,halign="middle") => @PLACE(0,-10);
// };
// # @SELECT-INSTANCE(model="tb_sampler") => @SET-SYMBOL $S_tb_sampler;
// $S_tb_sar = @DEFINE-SYMBOL {
// @LINE {(-11,6) (11,6) (11,-6) (-11,-6) (-11,6)};
// ? @TEXT("${name}",key="name",size=1.6,halign="middle") => @PLACE(0,9.5);
// ? @TEXT("${model}",key="model",size=0.85,halign="middle") => @PLACE(0,-10);
// };
// # @SELECT-INSTANCE(model="tb_sar") => @SET-SYMBOL $S_tb_sar;
// $S_tb_timing = @DEFINE-SYMBOL {
// @LINE {(-11,6) (11,6) (11,-6) (-11,-6) (-11,6)};
// ? @TEXT("${name}",key="name",size=1.6,halign="middle") => @PLACE(0,9.5);
// ? @TEXT("${model}",key="model",size=0.85,halign="middle") => @PLACE(0,-10);
// };
// # @SELECT-INSTANCE(model="tb_timing") => @SET-SYMBOL $S_tb_timing;
// $S_tb_sar_top = @DEFINE-SYMBOL {
// @LINE {(-11,9.9) (11,9.9) (11,-9.9) (-11,-9.9) (-11,9.9)};
// (-13,6.6) @PIN(terminal=9,direction="left");
// @LINE {(-13,6.6) (-11,6.6)};
// (-10.5,6.6) @TEXT("SAMPLE",size=1.1,halign="start",valign="middle");
// (-13,3.3) @PIN(terminal=11,direction="left");
// @LINE {(-13,3.3) (-11,3.3)};
// (-10.5,3.3) @TEXT("VINN",size=1.1,halign="start",valign="middle");
// (-13,0) @PIN(terminal=12,direction="left");
// @LINE {(-13,0) (-11,0)};
// (-10.5,0) @TEXT("VINP",size=1.1,halign="start",valign="middle");
// (-13,-3.3) @PIN(terminal=13,direction="left");
// @LINE {(-13,-3.3) (-11,-3.3)};
// (-10.5,-3.3) @TEXT("VREFN",size=1.1,halign="start",valign="middle");
// (-13,-6.6) @PIN(terminal=14,direction="left");
// @LINE {(-13,-6.6) (-11,-6.6)};
// (-10.5,-6.6) @TEXT("VREFP",size=1.1,halign="start",valign="middle");
// (13,0) @PIN(terminal=[1, 2, 3, 4, 5, 6, 7, 8],direction="right");
// @LINE {(13,0) (11,0)};
// (10.5,0) @TEXT("D[7:0]",size=1.1,halign="end",valign="middle");
// (0,11.9) @PIN(terminal=10,direction="up");
// @LINE {(0,11.9) (0,9.9)};
// (0,9.1) @TEXT("VDD!",size=1.1,halign="middle",valign="middle");
// (0,-11.9) @PIN(terminal=15,direction="down");
// @LINE {(0,-11.9) (0,-9.9)};
// (0,-9.1) @TEXT("0",size=1.1,halign="middle",valign="middle");
// ? @TEXT("${name}",key="name",size=1.6,halign="middle") => @PLACE(0,13.4);
// ? @TEXT("${model}",key="model",size=0.85,halign="middle") => @PLACE(0,-13.9);
// };
// # @SELECT-INSTANCE(model="tb_sar_top") => @SET-SYMBOL $S_tb_sar_top;
// $S_tb_sar_stalled_top = @DEFINE-SYMBOL {
// @LINE {(-11,9.9) (11,9.9) (11,-9.9) (-11,-9.9) (-11,9.9)};
// (-13,6.6) @PIN(terminal=9,direction="left");
// @LINE {(-13,6.6) (-11,6.6)};
// (-10.5,6.6) @TEXT("SAMPLE",size=1.1,halign="start",valign="middle");
// (-13,3.3) @PIN(terminal=11,direction="left");
// @LINE {(-13,3.3) (-11,3.3)};
// (-10.5,3.3) @TEXT("VINN",size=1.1,halign="start",valign="middle");
// (-13,0) @PIN(terminal=12,direction="left");
// @LINE {(-13,0) (-11,0)};
// (-10.5,0) @TEXT("VINP",size=1.1,halign="start",valign="middle");
// (-13,-3.3) @PIN(terminal=13,direction="left");
// @LINE {(-13,-3.3) (-11,-3.3)};
// (-10.5,-3.3) @TEXT("VREFN",size=1.1,halign="start",valign="middle");
// (-13,-6.6) @PIN(terminal=14,direction="left");
// @LINE {(-13,-6.6) (-11,-6.6)};
// (-10.5,-6.6) @TEXT("VREFP",size=1.1,halign="start",valign="middle");
// (13,0) @PIN(terminal=[1, 2, 3, 4, 5, 6, 7, 8],direction="right");
// @LINE {(13,0) (11,0)};
// (10.5,0) @TEXT("D[7:0]",size=1.1,halign="end",valign="middle");
// (0,11.9) @PIN(terminal=10,direction="up");
// @LINE {(0,11.9) (0,9.9)};
// (0,9.1) @TEXT("VDD!",size=1.1,halign="middle",valign="middle");
// (0,-11.9) @PIN(terminal=15,direction="down");
// @LINE {(0,-11.9) (0,-9.9)};
// (0,-9.1) @TEXT("0",size=1.1,halign="middle",valign="middle");
// ? @TEXT("${name}",key="name",size=1.6,halign="middle") => @PLACE(0,13.4);
// ? @TEXT("${model}",key="model",size=0.85,halign="middle") => @PLACE(0,-13.9);
// };
// # @SELECT-INSTANCE(model="tb_sar_stalled_top") => @SET-SYMBOL $S_tb_sar_stalled_top;
// $S_INVD1BWP12T30P140 = @DEFINE-SYMBOL {
// (-7,0) @PIN(terminal=1,direction="left");
// @LINE {(-7,0) (-5,0)};
// (7,0) @PIN(terminal=2,direction="right");
// @LINE {(5,0) (7,0)};
// (0,7) @PIN(terminal=3,direction="up");
// @LINE {(0,7) (0,5)};
// (0,-7) @PIN(terminal=4,direction="down");
// @LINE {(0,-7) (0,-5)};
// @LINE {(-5,5) (-5,-5) (4,0) (-5,5)};
// (4.5,0) @CIRCLE(radius=0.5);
// ? @TEXT("${name}",key="name",size=1.6,halign="middle") => @PLACE(0,8.5);
// ? @TEXT("${model}",key="model",size=0.85,halign="middle") => @PLACE(0,-9);
// };
// # @SELECT-INSTANCE(model="INVD1BWP12T30P140") => @SET-SYMBOL $S_INVD1BWP12T30P140;
// $S_ND2D1BWP12T30P140 = @DEFINE-SYMBOL {
// (-7,1.7) @PIN(terminal=1,direction="left");
// @LINE {(-7,1.7) (-5,1.7)};
// (-7,-1.7) @PIN(terminal=2,direction="left");
// @LINE {(-7,-1.7) (-5,-1.7)};
// (7,0) @PIN(terminal=3,direction="right");
// @LINE {(5,0) (7,0)};
// (0,7) @PIN(terminal=4,direction="up");
// @LINE {(0,7) (0,5)};
// (0,-7) @PIN(terminal=5,direction="down");
// @LINE {(0,-7) (0,-5)};
// @LINE {(-5,5) (0,5) (3,4) (4.4,2) (5,0) (4.4,-2) (3,-4) (0,-5) (-5,-5) (-5,5)};
// (5.5,0) @CIRCLE(radius=0.5);
// ? @TEXT("${name}",key="name",size=1.6,halign="middle") => @PLACE(0,8.5);
// ? @TEXT("${model}",key="model",size=0.85,halign="middle") => @PLACE(0,-9);
// };
// # @SELECT-INSTANCE(model="ND2D1BWP12T30P140") => @SET-SYMBOL $S_ND2D1BWP12T30P140;
// $S_DFCNQD1BWP12T30P140 = @DEFINE-SYMBOL {
// (-7,3.4) @PIN(terminal=1,direction="left");
// @LINE {(-7,3.4) (-5,3.4)};
// (-4.5,3.4) @TEXT("D",size=0.7,halign="start",valign="middle");
// (-7,0) @PIN(terminal=2,direction="left");
// @LINE {(-7,0) (-5,0)};
// (-4.5,0) @TEXT("CK",size=0.7,halign="start",valign="middle");
// @LINE {(-5,0.7) (-3.8,0) (-5,-0.7)};
// (-7,-3.4) @PIN(terminal=3,direction="left");
// @LINE {(-7,-3.4) (-5,-3.4)};
// (-4.5,-3.4) @TEXT("RN",size=0.7,halign="start",valign="middle");
// (-5.4,-3.4) @CIRCLE(radius=0.4);
// (7,0) @PIN(terminal=4,direction="right");
// @LINE {(5,0) (7,0)};
// (0,7) @PIN(terminal=5,direction="up");
// @LINE {(0,7) (0,5)};
// (0,-7) @PIN(terminal=6,direction="down");
// @LINE {(0,-7) (0,-5)};
// @LINE {(-5,5) (5,5) (5,-5) (-5,-5) (-5,5)};
// (1,0) @TEXT("DFF",size=0.85,halign="middle",valign="middle");
// ? @TEXT("${name}",key="name",size=1.6,halign="middle") => @PLACE(0,8.5);
// ? @TEXT("${model}",key="model",size=0.85,halign="middle") => @PLACE(0,-9);
// };
// # @SELECT-INSTANCE(model="DFCNQD1BWP12T30P140") => @SET-SYMBOL $S_DFCNQD1BWP12T30P140;
// $S_b_cdac = @DEFINE-SYMBOL {
// @LINE {(-11,11.55) (11,11.55) (11,-11.55) (-11,-11.55) (-11,11.55)};
// (-13,8.25) @PIN(terminal=[1, 2, 3, 4, 5, 6, 7, 8],direction="left");
// @LINE {(-13,8.25) (-11,8.25)};
// (-10.5,8.25) @TEXT("GNN[7:0]",size=1.1,halign="start",valign="middle");
// (-13,4.95) @PIN(terminal=[9, 10, 11, 12, 13, 14, 15, 16],direction="left");
// @LINE {(-13,4.95) (-11,4.95)};
// (-10.5,4.95) @TEXT("GNP[7:0]",size=1.1,halign="start",valign="middle");
// (-13,1.65) @PIN(terminal=[17, 18, 19, 20, 21, 22, 23, 24],direction="left");
// @LINE {(-13,1.65) (-11,1.65)};
// (-10.5,1.65) @TEXT("GPN[7:0]",size=1.1,halign="start",valign="middle");
// (-13,-1.65) @PIN(terminal=[25, 26, 27, 28, 29, 30, 31, 32],direction="left");
// @LINE {(-13,-1.65) (-11,-1.65)};
// (-10.5,-1.65) @TEXT("GPP[7:0]",size=1.1,halign="start",valign="middle");
// (-13,-4.95) @PIN(terminal=36,direction="left");
// @LINE {(-13,-4.95) (-11,-4.95)};
// (-10.5,-4.95) @TEXT("VREFN",size=1.1,halign="start",valign="middle");
// (-13,-8.25) @PIN(terminal=37,direction="left");
// @LINE {(-13,-8.25) (-11,-8.25)};
// (-10.5,-8.25) @TEXT("VREFP",size=1.1,halign="start",valign="middle");
// (13,1.65) @PIN(terminal=33,direction="right");
// @LINE {(13,1.65) (11,1.65)};
// (10.5,1.65) @TEXT("TOPN",size=1.1,halign="end",valign="middle");
// (13,-1.65) @PIN(terminal=34,direction="right");
// @LINE {(13,-1.65) (11,-1.65)};
// (10.5,-1.65) @TEXT("TOPP",size=1.1,halign="end",valign="middle");
// (0,13.55) @PIN(terminal=35,direction="up");
// @LINE {(0,13.55) (0,11.55)};
// (0,10.75) @TEXT("VDD",size=1.1,halign="middle",valign="middle");
// (0,-13.55) @PIN(terminal=38,direction="down");
// @LINE {(0,-13.55) (0,-11.55)};
// (0,-10.75) @TEXT("VSS",size=1.1,halign="middle",valign="middle");
// ? @TEXT("${name}",key="name",size=1.6,halign="middle") => @PLACE(0,15.05);
// ? @TEXT("${model}",key="model",size=0.85,halign="middle") => @PLACE(0,-15.55);
// };
// # @SELECT-INSTANCE(model="b_cdac") => @SET-SYMBOL $S_b_cdac;
// $S_b_cdac_bit = @DEFINE-SYMBOL {
// @LINE {(-11,11.55) (11,11.55) (11,-11.55) (-11,-11.55) (-11,11.55)};
// (-13,8.25) @PIN(terminal=1,direction="left");
// @LINE {(-13,8.25) (-11,8.25)};
// (-10.5,8.25) @TEXT("GNN",size=1.1,halign="start",valign="middle");
// (-13,4.95) @PIN(terminal=2,direction="left");
// @LINE {(-13,4.95) (-11,4.95)};
// (-10.5,4.95) @TEXT("GNP",size=1.1,halign="start",valign="middle");
// (-13,1.65) @PIN(terminal=3,direction="left");
// @LINE {(-13,1.65) (-11,1.65)};
// (-10.5,1.65) @TEXT("GPN",size=1.1,halign="start",valign="middle");
// (-13,-1.65) @PIN(terminal=4,direction="left");
// @LINE {(-13,-1.65) (-11,-1.65)};
// (-10.5,-1.65) @TEXT("GPP",size=1.1,halign="start",valign="middle");
// (-13,-4.95) @PIN(terminal=7,direction="left");
// @LINE {(-13,-4.95) (-11,-4.95)};
// (-10.5,-4.95) @TEXT("VREFN",size=1.1,halign="start",valign="middle");
// (-13,-8.25) @PIN(terminal=8,direction="left");
// @LINE {(-13,-8.25) (-11,-8.25)};
// (-10.5,-8.25) @TEXT("VREFP",size=1.1,halign="start",valign="middle");
// (13,1.65) @PIN(terminal=5,direction="right");
// @LINE {(13,1.65) (11,1.65)};
// (10.5,1.65) @TEXT("TOPN",size=1.1,halign="end",valign="middle");
// (13,-1.65) @PIN(terminal=6,direction="right");
// @LINE {(13,-1.65) (11,-1.65)};
// (10.5,-1.65) @TEXT("TOPP",size=1.1,halign="end",valign="middle");
// (0,13.55) @PIN(terminal=9,direction="up");
// @LINE {(0,13.55) (0,11.55)};
// (0,10.75) @TEXT("VDD",size=1.1,halign="middle",valign="middle");
// (0,-13.55) @PIN(terminal=10,direction="down");
// @LINE {(0,-13.55) (0,-11.55)};
// (0,-10.75) @TEXT("VSS",size=1.1,halign="middle",valign="middle");
// ? @TEXT("${name}",key="name",size=1.6,halign="middle") => @PLACE(0,15.05);
// ? @TEXT("${model}",key="model",size=0.85,halign="middle") => @PLACE(0,-15.55);
// };
// # @SELECT-INSTANCE(model="b_cdac_bit") => @SET-SYMBOL $S_b_cdac_bit;
// $S_b_comparator = @DEFINE-SYMBOL {
// @LINE {(-11,6.6) (11,6.6) (11,-6.6) (-11,-6.6) (-11,6.6)};
// (-13,3.3) @PIN(terminal=1,direction="left");
// @LINE {(-13,3.3) (-11,3.3)};
// (-10.5,3.3) @TEXT("CLK",size=1.1,halign="start",valign="middle");
// (-13,0) @PIN(terminal=5,direction="left");
// @LINE {(-13,0) (-11,0)};
// (-10.5,0) @TEXT("VINN",size=1.1,halign="start",valign="middle");
// (-13,-3.3) @PIN(terminal=6,direction="left");
// @LINE {(-13,-3.3) (-11,-3.3)};
// (-10.5,-3.3) @TEXT("VINP",size=1.1,halign="start",valign="middle");
// (13,1.65) @PIN(terminal=2,direction="right");
// @LINE {(13,1.65) (11,1.65)};
// (10.5,1.65) @TEXT("OUTN",size=1.1,halign="end",valign="middle");
// (13,-1.65) @PIN(terminal=3,direction="right");
// @LINE {(13,-1.65) (11,-1.65)};
// (10.5,-1.65) @TEXT("OUTP",size=1.1,halign="end",valign="middle");
// (0,8.6) @PIN(terminal=4,direction="up");
// @LINE {(0,8.6) (0,6.6)};
// (0,5.8) @TEXT("VDD",size=1.1,halign="middle",valign="middle");
// (0,-8.6) @PIN(terminal=7,direction="down");
// @LINE {(0,-8.6) (0,-6.6)};
// (0,-5.8) @TEXT("VSS",size=1.1,halign="middle",valign="middle");
// ? @TEXT("${name}",key="name",size=1.6,halign="middle") => @PLACE(0,10.1);
// ? @TEXT("${model}",key="model",size=0.85,halign="middle") => @PLACE(0,-10.6);
// };
// # @SELECT-INSTANCE(model="b_comparator") => @SET-SYMBOL $S_b_comparator;
// $S_b_reference = @DEFINE-SYMBOL {
// @LINE {(-11,11.55) (11,11.55) (11,-11.55) (-11,-11.55) (-11,11.55)};
// (-13,4.95) @PIN(terminal=[1, 2, 3, 4, 5, 6, 7, 8],direction="left");
// @LINE {(-13,4.95) (-11,4.95)};
// (-10.5,4.95) @TEXT("CODE[7:0]",size=1.1,halign="start",valign="middle");
// (-13,1.65) @PIN(terminal=[9, 10, 11, 12, 13, 14, 15, 16],direction="left");
// @LINE {(-13,1.65) (-11,1.65)};
// (-10.5,1.65) @TEXT("D[7:0]",size=1.1,halign="start",valign="middle");
// (-13,-1.65) @PIN(terminal=49,direction="left");
// @LINE {(-13,-1.65) (-11,-1.65)};
// (-10.5,-1.65) @TEXT("PHI_U",size=1.1,halign="start",valign="middle");
// (-13,-4.95) @PIN(terminal=50,direction="left");
// @LINE {(-13,-4.95) (-11,-4.95)};
// (-10.5,-4.95) @TEXT("SAMPLE",size=1.1,halign="start",valign="middle");
// (13,8.25) @PIN(terminal=[17, 18, 19, 20, 21, 22, 23, 24],direction="right");
// @LINE {(13,8.25) (11,8.25)};
// (10.5,8.25) @TEXT("GNN[7:0]",size=1.1,halign="end",valign="middle");
// (13,4.95) @PIN(terminal=[25, 26, 27, 28, 29, 30, 31, 32],direction="right");
// @LINE {(13,4.95) (11,4.95)};
// (10.5,4.95) @TEXT("GNP[7:0]",size=1.1,halign="end",valign="middle");
// (13,1.65) @PIN(terminal=[33, 34, 35, 36, 37, 38, 39, 40],direction="right");
// @LINE {(13,1.65) (11,1.65)};
// (10.5,1.65) @TEXT("GPN[7:0]",size=1.1,halign="end",valign="middle");
// (13,-1.65) @PIN(terminal=[41, 42, 43, 44, 45, 46, 47, 48],direction="right");
// @LINE {(13,-1.65) (11,-1.65)};
// (10.5,-1.65) @TEXT("GPP[7:0]",size=1.1,halign="end",valign="middle");
// (13,-4.95) @PIN(terminal=53,direction="right");
// @LINE {(13,-4.95) (11,-4.95)};
// (10.5,-4.95) @TEXT("RST_DONE",size=1.1,halign="end",valign="middle");
// (13,-8.25) @PIN(terminal=54,direction="right");
// @LINE {(13,-8.25) (11,-8.25)};
// (10.5,-8.25) @TEXT("PRESET",size=1.1,halign="end",valign="middle");
// (0,13.55) @PIN(terminal=51,direction="up");
// @LINE {(0,13.55) (0,11.55)};
// (0,10.75) @TEXT("VDD",size=1.1,halign="middle",valign="middle");
// (0,-13.55) @PIN(terminal=52,direction="down");
// @LINE {(0,-13.55) (0,-11.55)};
// (0,-10.75) @TEXT("VSS",size=1.1,halign="middle",valign="middle");
// ? @TEXT("${name}",key="name",size=1.6,halign="middle") => @PLACE(0,15.05);
// ? @TEXT("${model}",key="model",size=0.85,halign="middle") => @PLACE(0,-15.55);
// };
// # @SELECT-INSTANCE(model="b_reference") => @SET-SYMBOL $S_b_reference;
// $S_b_edge = @DEFINE-SYMBOL {
// @LINE {(-11,6) (11,6) (11,-6) (-11,-6) (-11,6)};
// (-13,0) @PIN(terminal=1,direction="left");
// @LINE {(-13,0) (-11,0)};
// (-10.5,0) @TEXT("A",size=1.1,halign="start",valign="middle");
// (13,0) @PIN(terminal=4,direction="right");
// @LINE {(13,0) (11,0)};
// (10.5,0) @TEXT("Y",size=1.1,halign="end",valign="middle");
// (0,8) @PIN(terminal=2,direction="up");
// @LINE {(0,8) (0,6)};
// (0,5.2) @TEXT("VDD",size=1.1,halign="middle",valign="middle");
// (0,-8) @PIN(terminal=3,direction="down");
// @LINE {(0,-8) (0,-6)};
// (0,-5.2) @TEXT("VSS",size=1.1,halign="middle",valign="middle");
// ? @TEXT("${name}",key="name",size=1.6,halign="middle") => @PLACE(0,9.5);
// ? @TEXT("${model}",key="model",size=0.85,halign="middle") => @PLACE(0,-10);
// };
// # @SELECT-INSTANCE(model="b_edge") => @SET-SYMBOL $S_b_edge;
// $S_b_idle = @DEFINE-SYMBOL {
// @LINE {(-11,6.6) (11,6.6) (11,-6.6) (-11,-6.6) (-11,6.6)};
// (-13,0) @PIN(terminal=2,direction="left");
// @LINE {(-13,0) (-11,0)};
// (-10.5,0) @TEXT("SAMPLE",size=1.1,halign="start",valign="middle");
// (13,3.3) @PIN(terminal=1,direction="right");
// @LINE {(13,3.3) (11,3.3)};
// (10.5,3.3) @TEXT("ACTIVE",size=1.1,halign="end",valign="middle");
// (13,0) @PIN(terminal=5,direction="right");
// @LINE {(13,0) (11,0)};
// (10.5,0) @TEXT("PRESET",size=1.1,halign="end",valign="middle");
// (13,-3.3) @PIN(terminal=6,direction="right");
// @LINE {(13,-3.3) (11,-3.3)};
// (10.5,-3.3) @TEXT("SAMPLE_MATCH",size=1.1,halign="end",valign="middle");
// (0,8.6) @PIN(terminal=3,direction="up");
// @LINE {(0,8.6) (0,6.6)};
// (0,5.8) @TEXT("VDD",size=1.1,halign="middle",valign="middle");
// (0,-8.6) @PIN(terminal=4,direction="down");
// @LINE {(0,-8.6) (0,-6.6)};
// (0,-5.8) @TEXT("VSS",size=1.1,halign="middle",valign="middle");
// ? @TEXT("${name}",key="name",size=1.6,halign="middle") => @PLACE(0,10.1);
// ? @TEXT("${model}",key="model",size=0.85,halign="middle") => @PLACE(0,-10.6);
// };
// # @SELECT-INSTANCE(model="b_idle") => @SET-SYMBOL $S_b_idle;
// $S_b_sampler = @DEFINE-SYMBOL {
// @LINE {(-11,6) (11,6) (11,-6) (-11,-6) (-11,6)};
// (-13,1.65) @PIN(terminal=1,direction="left");
// @LINE {(-13,1.65) (-11,1.65)};
// (-10.5,1.65) @TEXT("CLKS",size=1.1,halign="start",valign="middle");
// (-13,-1.65) @PIN(terminal=3,direction="left");
// @LINE {(-13,-1.65) (-11,-1.65)};
// (-10.5,-1.65) @TEXT("VIN",size=1.1,halign="start",valign="middle");
// (13,0) @PIN(terminal=2,direction="right");
// @LINE {(13,0) (11,0)};
// (10.5,0) @TEXT("VOUT",size=1.1,halign="end",valign="middle");
// (0,8) @PIN(terminal=4,direction="up");
// @LINE {(0,8) (0,6)};
// (0,5.2) @TEXT("VDD",size=1.1,halign="middle",valign="middle");
// (0,-8) @PIN(terminal=5,direction="down");
// @LINE {(0,-8) (0,-6)};
// (0,-5.2) @TEXT("VSS",size=1.1,halign="middle",valign="middle");
// ? @TEXT("${name}",key="name",size=1.6,halign="middle") => @PLACE(0,9.5);
// ? @TEXT("${model}",key="model",size=0.85,halign="middle") => @PLACE(0,-10);
// };
// # @SELECT-INSTANCE(model="b_sampler") => @SET-SYMBOL $S_b_sampler;
// $S_b_sar = @DEFINE-SYMBOL {
// @LINE {(-11,9.9) (11,9.9) (11,-9.9) (-11,-9.9) (-11,9.9)};
// (-13,3.3) @PIN(terminal=10,direction="left");
// @LINE {(-13,3.3) (-11,3.3)};
// (-10.5,3.3) @TEXT("COMP_N",size=1.1,halign="start",valign="middle");
// (-13,0) @PIN(terminal=11,direction="left");
// @LINE {(-13,0) (-11,0)};
// (-10.5,0) @TEXT("COMP_P",size=1.1,halign="start",valign="middle");
// (-13,-3.3) @PIN(terminal=21,direction="left");
// @LINE {(-13,-3.3) (-11,-3.3)};
// (-10.5,-3.3) @TEXT("SAMPLE",size=1.1,halign="start",valign="middle");
// (13,6.6) @PIN(terminal=1,direction="right");
// @LINE {(13,6.6) (11,6.6)};
// (10.5,6.6) @TEXT("CMP_CLK",size=1.1,halign="end",valign="middle");
// (13,3.3) @PIN(terminal=[2, 3, 4, 5, 6, 7, 8, 9],direction="right");
// @LINE {(13,3.3) (11,3.3)};
// (10.5,3.3) @TEXT("CODE[7:0]",size=1.1,halign="end",valign="middle");
// (13,0) @PIN(terminal=[12, 13, 14, 15, 16, 17, 18, 19],direction="right");
// @LINE {(13,0) (11,0)};
// (10.5,0) @TEXT("D[7:0]",size=1.1,halign="end",valign="middle");
// (13,-3.3) @PIN(terminal=20,direction="right");
// @LINE {(13,-3.3) (11,-3.3)};
// (10.5,-3.3) @TEXT("PHI_U",size=1.1,halign="end",valign="middle");
// (13,-6.6) @PIN(terminal=24,direction="right");
// @LINE {(13,-6.6) (11,-6.6)};
// (10.5,-6.6) @TEXT("ACTIVE",size=1.1,halign="end",valign="middle");
// (0,11.9) @PIN(terminal=22,direction="up");
// @LINE {(0,11.9) (0,9.9)};
// (0,9.1) @TEXT("VDD",size=1.1,halign="middle",valign="middle");
// (0,-11.9) @PIN(terminal=23,direction="down");
// @LINE {(0,-11.9) (0,-9.9)};
// (0,-9.1) @TEXT("VSS",size=1.1,halign="middle",valign="middle");
// ? @TEXT("${name}",key="name",size=1.6,halign="middle") => @PLACE(0,13.4);
// ? @TEXT("${model}",key="model",size=0.85,halign="middle") => @PLACE(0,-13.9);
// };
// # @SELECT-INSTANCE(model="b_sar") => @SET-SYMBOL $S_b_sar;
// $S_sar_adc_b = @DEFINE-SYMBOL {
// @LINE {(-11,9.9) (11,9.9) (11,-9.9) (-11,-9.9) (-11,9.9)};
// (-13,6.6) @PIN(terminal=9,direction="left");
// @LINE {(-13,6.6) (-11,6.6)};
// (-10.5,6.6) @TEXT("SAMPLE",size=1.1,halign="start",valign="middle");
// (-13,3.3) @PIN(terminal=11,direction="left");
// @LINE {(-13,3.3) (-11,3.3)};
// (-10.5,3.3) @TEXT("VINN",size=1.1,halign="start",valign="middle");
// (-13,0) @PIN(terminal=12,direction="left");
// @LINE {(-13,0) (-11,0)};
// (-10.5,0) @TEXT("VINP",size=1.1,halign="start",valign="middle");
// (-13,-3.3) @PIN(terminal=13,direction="left");
// @LINE {(-13,-3.3) (-11,-3.3)};
// (-10.5,-3.3) @TEXT("VREFN",size=1.1,halign="start",valign="middle");
// (-13,-6.6) @PIN(terminal=14,direction="left");
// @LINE {(-13,-6.6) (-11,-6.6)};
// (-10.5,-6.6) @TEXT("VREFP",size=1.1,halign="start",valign="middle");
// (13,0) @PIN(terminal=[1, 2, 3, 4, 5, 6, 7, 8],direction="right");
// @LINE {(13,0) (11,0)};
// (10.5,0) @TEXT("D[7:0]",size=1.1,halign="end",valign="middle");
// (0,11.9) @PIN(terminal=10,direction="up");
// @LINE {(0,11.9) (0,9.9)};
// (0,9.1) @TEXT("VDD",size=1.1,halign="middle",valign="middle");
// (0,-11.9) @PIN(terminal=15,direction="down");
// @LINE {(0,-11.9) (0,-9.9)};
// (0,-9.1) @TEXT("VSS",size=1.1,halign="middle",valign="middle");
// ? @TEXT("${name}",key="name",size=1.6,halign="middle") => @PLACE(0,13.4);
// ? @TEXT("${model}",key="model",size=0.85,halign="middle") => @PLACE(0,-13.9);
// };
// # @SELECT-INSTANCE(model="sar_adc_b") => @SET-SYMBOL $S_sar_adc_b;
// $S_b_delay = @DEFINE-SYMBOL {
// @LINE {(-11,6) (11,6) (11,-6) (-11,-6) (-11,6)};
// (-13,0) @PIN(terminal=1,direction="left");
// @LINE {(-13,0) (-11,0)};
// (-10.5,0) @TEXT("A",size=1.1,halign="start",valign="middle");
// (13,0) @PIN(terminal=4,direction="right");
// @LINE {(13,0) (11,0)};
// (10.5,0) @TEXT("Y",size=1.1,halign="end",valign="middle");
// (0,8) @PIN(terminal=2,direction="up");
// @LINE {(0,8) (0,6)};
// (0,5.2) @TEXT("VDD",size=1.1,halign="middle",valign="middle");
// (0,-8) @PIN(terminal=3,direction="down");
// @LINE {(0,-8) (0,-6)};
// (0,-5.2) @TEXT("VSS",size=1.1,halign="middle",valign="middle");
// ? @TEXT("${name}",key="name",size=1.6,halign="middle") => @PLACE(0,9.5);
// ? @TEXT("${model}",key="model",size=0.85,halign="middle") => @PLACE(0,-10);
// };
// # @SELECT-INSTANCE(model="b_delay") => @SET-SYMBOL $S_b_delay;
// $S_b_behavior_observer = @DEFINE-SYMBOL {
// @LINE {(-11,6) (11,6) (11,-6) (-11,-6) (-11,6)};
// (-13,0) @PIN(terminal=9,direction="left");
// @LINE {(-13,0) (-11,0)};
// (-10.5,0) @TEXT("SAMPLE",size=1.1,halign="start",valign="middle");
// (13,0) @PIN(terminal=[1, 2, 3, 4, 5, 6, 7, 8],direction="right");
// @LINE {(13,0) (11,0)};
// (10.5,0) @TEXT("D[7:0]",size=1.1,halign="end",valign="middle");
// (0,8) @PIN(terminal=10,direction="up");
// @LINE {(0,8) (0,6)};
// (0,5.2) @TEXT("VDD",size=1.1,halign="middle",valign="middle");
// (0,-8) @PIN(terminal=11,direction="down");
// @LINE {(0,-8) (0,-6)};
// (0,-5.2) @TEXT("VSS",size=1.1,halign="middle",valign="middle");
// ? @TEXT("${name}",key="name",size=1.6,halign="middle") => @PLACE(0,9.5);
// ? @TEXT("${model}",key="model",size=0.85,halign="middle") => @PLACE(0,-10);
// };
// # @SELECT-INSTANCE(model="b_behavior_observer") => @SET-SYMBOL $S_b_behavior_observer;
// $S_b_tb_switch = @DEFINE-SYMBOL {
// @LINE {(-11,6.6) (11,6.6) (11,-6.6) (-11,-6.6) (-11,6.6)};
// (-13,3.3) @PIN(terminal=1,direction="left");
// @LINE {(-13,3.3) (-11,3.3)};
// (-10.5,3.3) @TEXT("A",size=1.1,halign="start",valign="middle");
// (-13,0) @PIN(terminal=2,direction="left");
// @LINE {(-13,0) (-11,0)};
// (-10.5,0) @TEXT("B",size=1.1,halign="start",valign="middle");
// (-13,-3.3) @PIN(terminal=3,direction="left");
// @LINE {(-13,-3.3) (-11,-3.3)};
// (-10.5,-3.3) @TEXT("EN",size=1.1,halign="start",valign="middle");
// (0,8.6) @PIN(terminal=4,direction="up");
// @LINE {(0,8.6) (0,6.6)};
// (0,5.8) @TEXT("VDD",size=1.1,halign="middle",valign="middle");
// (0,-8.6) @PIN(terminal=5,direction="down");
// @LINE {(0,-8.6) (0,-6.6)};
// (0,-5.8) @TEXT("VSS",size=1.1,halign="middle",valign="middle");
// ? @TEXT("${name}",key="name",size=1.6,halign="middle") => @PLACE(0,10.1);
// ? @TEXT("${model}",key="model",size=0.85,halign="middle") => @PLACE(0,-10.6);
// };
// # @SELECT-INSTANCE(model="b_tb_switch") => @SET-SYMBOL $S_b_tb_switch;
// $S_b_sampler_bridge = @DEFINE-SYMBOL {
// @LINE {(-11,6) (11,6) (11,-6) (-11,-6) (-11,6)};
// (-13,1.65) @PIN(terminal=1,direction="left");
// @LINE {(-13,1.65) (-11,1.65)};
// (-10.5,1.65) @TEXT("CLKS",size=1.1,halign="start",valign="middle");
// (-13,-1.65) @PIN(terminal=3,direction="left");
// @LINE {(-13,-1.65) (-11,-1.65)};
// (-10.5,-1.65) @TEXT("Vin",size=1.1,halign="start",valign="middle");
// (13,0) @PIN(terminal=2,direction="right");
// @LINE {(13,0) (11,0)};
// (10.5,0) @TEXT("VOUT",size=1.1,halign="end",valign="middle");
// ? @TEXT("${name}",key="name",size=1.6,halign="middle") => @PLACE(0,9.5);
// ? @TEXT("${model}",key="model",size=0.85,halign="middle") => @PLACE(0,-10);
// };
// # @SELECT-INSTANCE(model="b_sampler_bridge") => @SET-SYMBOL $S_b_sampler_bridge;
// $S_b_sar8p_delay_valid = @DEFINE-SYMBOL {
// @LINE {(-11,6) (11,6) (11,-6) (-11,-6) (-11,6)};
// (-13,0) @PIN(terminal=1,direction="left");
// @LINE {(-13,0) (-11,0)};
// (-10.5,0) @TEXT("A",size=1.1,halign="start",valign="middle");
// (13,0) @PIN(terminal=4,direction="right");
// @LINE {(13,0) (11,0)};
// (10.5,0) @TEXT("Y",size=1.1,halign="end",valign="middle");
// (0,8) @PIN(terminal=2,direction="up");
// @LINE {(0,8) (0,6)};
// (0,5.2) @TEXT("VDD",size=1.1,halign="middle",valign="middle");
// (0,-8) @PIN(terminal=3,direction="down");
// @LINE {(0,-8) (0,-6)};
// (0,-5.2) @TEXT("VSS",size=1.1,halign="middle",valign="middle");
// ? @TEXT("${name}",key="name",size=1.6,halign="middle") => @PLACE(0,9.5);
// ? @TEXT("${model}",key="model",size=0.85,halign="middle") => @PLACE(0,-10);
// };
// # @SELECT-INSTANCE(model="b_sar8p_delay_valid") => @SET-SYMBOL $S_b_sar8p_delay_valid;
// $S_b_sar8p_delay_write = @DEFINE-SYMBOL {
// @LINE {(-11,6) (11,6) (11,-6) (-11,-6) (-11,6)};
// (-13,0) @PIN(terminal=1,direction="left");
// @LINE {(-13,0) (-11,0)};
// (-10.5,0) @TEXT("A",size=1.1,halign="start",valign="middle");
// (13,0) @PIN(terminal=4,direction="right");
// @LINE {(13,0) (11,0)};
// (10.5,0) @TEXT("Y",size=1.1,halign="end",valign="middle");
// (0,8) @PIN(terminal=2,direction="up");
// @LINE {(0,8) (0,6)};
// (0,5.2) @TEXT("VDD",size=1.1,halign="middle",valign="middle");
// (0,-8) @PIN(terminal=3,direction="down");
// @LINE {(0,-8) (0,-6)};
// (0,-5.2) @TEXT("VSS",size=1.1,halign="middle",valign="middle");
// ? @TEXT("${name}",key="name",size=1.6,halign="middle") => @PLACE(0,9.5);
// ? @TEXT("${model}",key="model",size=0.85,halign="middle") => @PLACE(0,-10);
// };
// # @SELECT-INSTANCE(model="b_sar8p_delay_write") => @SET-SYMBOL $S_b_sar8p_delay_write;
// $S_b_sar8p_delay_quiet = @DEFINE-SYMBOL {
// @LINE {(-11,6) (11,6) (11,-6) (-11,-6) (-11,6)};
// (-13,0) @PIN(terminal=1,direction="left");
// @LINE {(-13,0) (-11,0)};
// (-10.5,0) @TEXT("A",size=1.1,halign="start",valign="middle");
// (13,0) @PIN(terminal=4,direction="right");
// @LINE {(13,0) (11,0)};
// (10.5,0) @TEXT("Y",size=1.1,halign="end",valign="middle");
// (0,8) @PIN(terminal=2,direction="up");
// @LINE {(0,8) (0,6)};
// (0,5.2) @TEXT("VDD",size=1.1,halign="middle",valign="middle");
// (0,-8) @PIN(terminal=3,direction="down");
// @LINE {(0,-8) (0,-6)};
// (0,-5.2) @TEXT("VSS",size=1.1,halign="middle",valign="middle");
// ? @TEXT("${name}",key="name",size=1.6,halign="middle") => @PLACE(0,9.5);
// ? @TEXT("${model}",key="model",size=0.85,halign="middle") => @PLACE(0,-10);
// };
// # @SELECT-INSTANCE(model="b_sar8p_delay_quiet") => @SET-SYMBOL $S_b_sar8p_delay_quiet;
// $S_b_sar8p_delay_capture = @DEFINE-SYMBOL {
// @LINE {(-11,6) (11,6) (11,-6) (-11,-6) (-11,6)};
// (-13,0) @PIN(terminal=1,direction="left");
// @LINE {(-13,0) (-11,0)};
// (-10.5,0) @TEXT("A",size=1.1,halign="start",valign="middle");
// (13,0) @PIN(terminal=4,direction="right");
// @LINE {(13,0) (11,0)};
// (10.5,0) @TEXT("Y",size=1.1,halign="end",valign="middle");
// (0,8) @PIN(terminal=2,direction="up");
// @LINE {(0,8) (0,6)};
// (0,5.2) @TEXT("VDD",size=1.1,halign="middle",valign="middle");
// (0,-8) @PIN(terminal=3,direction="down");
// @LINE {(0,-8) (0,-6)};
// (0,-5.2) @TEXT("VSS",size=1.1,halign="middle",valign="middle");
// ? @TEXT("${name}",key="name",size=1.6,halign="middle") => @PLACE(0,9.5);
// ? @TEXT("${model}",key="model",size=0.85,halign="middle") => @PLACE(0,-10);
// };
// # @SELECT-INSTANCE(model="b_sar8p_delay_capture") => @SET-SYMBOL $S_b_sar8p_delay_capture;
// $S_b_sar8p_delay_bbm = @DEFINE-SYMBOL {
// @LINE {(-11,6) (11,6) (11,-6) (-11,-6) (-11,6)};
// (-13,0) @PIN(terminal=1,direction="left");
// @LINE {(-13,0) (-11,0)};
// (-10.5,0) @TEXT("A",size=1.1,halign="start",valign="middle");
// (13,0) @PIN(terminal=4,direction="right");
// @LINE {(13,0) (11,0)};
// (10.5,0) @TEXT("Y",size=1.1,halign="end",valign="middle");
// (0,8) @PIN(terminal=2,direction="up");
// @LINE {(0,8) (0,6)};
// (0,5.2) @TEXT("VDD",size=1.1,halign="middle",valign="middle");
// (0,-8) @PIN(terminal=3,direction="down");
// @LINE {(0,-8) (0,-6)};
// (0,-5.2) @TEXT("VSS",size=1.1,halign="middle",valign="middle");
// ? @TEXT("${name}",key="name",size=1.6,halign="middle") => @PLACE(0,9.5);
// ? @TEXT("${model}",key="model",size=0.85,halign="middle") => @PLACE(0,-10);
// };
// # @SELECT-INSTANCE(model="b_sar8p_delay_bbm") => @SET-SYMBOL $S_b_sar8p_delay_bbm;
// $S_b_sar8r_delay = @DEFINE-SYMBOL {
// @LINE {(-11,6) (11,6) (11,-6) (-11,-6) (-11,6)};
// (-13,0) @PIN(terminal=1,direction="left");
// @LINE {(-13,0) (-11,0)};
// (-10.5,0) @TEXT("A",size=1.1,halign="start",valign="middle");
// (13,0) @PIN(terminal=4,direction="right");
// @LINE {(13,0) (11,0)};
// (10.5,0) @TEXT("Y",size=1.1,halign="end",valign="middle");
// (0,8) @PIN(terminal=2,direction="up");
// @LINE {(0,8) (0,6)};
// (0,5.2) @TEXT("VDD",size=1.1,halign="middle",valign="middle");
// (0,-8) @PIN(terminal=3,direction="down");
// @LINE {(0,-8) (0,-6)};
// (0,-5.2) @TEXT("VSS",size=1.1,halign="middle",valign="middle");
// ? @TEXT("${name}",key="name",size=1.6,halign="middle") => @PLACE(0,9.5);
// ? @TEXT("${model}",key="model",size=0.85,halign="middle") => @PLACE(0,-10);
// };
// # @SELECT-INSTANCE(model="b_sar8r_delay") => @SET-SYMBOL $S_b_sar8r_delay;
// $S_b_sar8s_step = @DEFINE-SYMBOL {
// @LINE {(-11,6) (11,6) (11,-6) (-11,-6) (-11,6)};
// (-13,0) @PIN(terminal=1,direction="left");
// @LINE {(-13,0) (-11,0)};
// (-10.5,0) @TEXT("A",size=1.1,halign="start",valign="middle");
// (13,0) @PIN(terminal=4,direction="right");
// @LINE {(13,0) (11,0)};
// (10.5,0) @TEXT("Y",size=1.1,halign="end",valign="middle");
// (0,8) @PIN(terminal=2,direction="up");
// @LINE {(0,8) (0,6)};
// (0,5.2) @TEXT("VDD",size=1.1,halign="middle",valign="middle");
// (0,-8) @PIN(terminal=3,direction="down");
// @LINE {(0,-8) (0,-6)};
// (0,-5.2) @TEXT("VSS",size=1.1,halign="middle",valign="middle");
// ? @TEXT("${name}",key="name",size=1.6,halign="middle") => @PLACE(0,9.5);
// ? @TEXT("${model}",key="model",size=0.85,halign="middle") => @PLACE(0,-10);
// };
// # @SELECT-INSTANCE(model="b_sar8s_step") => @SET-SYMBOL $S_b_sar8s_step;
// $S_b_sar8i_guard = @DEFINE-SYMBOL {
// @LINE {(-11,6) (11,6) (11,-6) (-11,-6) (-11,6)};
// (-13,0) @PIN(terminal=1,direction="left");
// @LINE {(-13,0) (-11,0)};
// (-10.5,0) @TEXT("A",size=1.1,halign="start",valign="middle");
// (13,0) @PIN(terminal=4,direction="right");
// @LINE {(13,0) (11,0)};
// (10.5,0) @TEXT("Y",size=1.1,halign="end",valign="middle");
// (0,8) @PIN(terminal=2,direction="up");
// @LINE {(0,8) (0,6)};
// (0,5.2) @TEXT("VDD",size=1.1,halign="middle",valign="middle");
// (0,-8) @PIN(terminal=3,direction="down");
// @LINE {(0,-8) (0,-6)};
// (0,-5.2) @TEXT("VSS",size=1.1,halign="middle",valign="middle");
// ? @TEXT("${name}",key="name",size=1.6,halign="middle") => @PLACE(0,9.5);
// ? @TEXT("${model}",key="model",size=0.85,halign="middle") => @PLACE(0,-10);
// };
// # @SELECT-INSTANCE(model="b_sar8i_guard") => @SET-SYMBOL $S_b_sar8i_guard;
// $S_b_sar8r_edge = @DEFINE-SYMBOL {
// @LINE {(-11,6) (11,6) (11,-6) (-11,-6) (-11,6)};
// (-13,0) @PIN(terminal=1,direction="left");
// @LINE {(-13,0) (-11,0)};
// (-10.5,0) @TEXT("A",size=1.1,halign="start",valign="middle");
// (13,0) @PIN(terminal=4,direction="right");
// @LINE {(13,0) (11,0)};
// (10.5,0) @TEXT("Y",size=1.1,halign="end",valign="middle");
// (0,8) @PIN(terminal=2,direction="up");
// @LINE {(0,8) (0,6)};
// (0,5.2) @TEXT("VDD",size=1.1,halign="middle",valign="middle");
// (0,-8) @PIN(terminal=3,direction="down");
// @LINE {(0,-8) (0,-6)};
// (0,-5.2) @TEXT("VSS",size=1.1,halign="middle",valign="middle");
// ? @TEXT("${name}",key="name",size=1.6,halign="middle") => @PLACE(0,9.5);
// ? @TEXT("${model}",key="model",size=0.85,halign="middle") => @PLACE(0,-10);
// };
// # @SELECT-INSTANCE(model="b_sar8r_edge") => @SET-SYMBOL $S_b_sar8r_edge;
// $S_b_sar8p_clkbuf = @DEFINE-SYMBOL {
// @LINE {(-11,6) (11,6) (11,-6) (-11,-6) (-11,6)};
// (-13,0) @PIN(terminal=1,direction="left");
// @LINE {(-13,0) (-11,0)};
// (-10.5,0) @TEXT("A",size=1.1,halign="start",valign="middle");
// (13,0) @PIN(terminal=4,direction="right");
// @LINE {(13,0) (11,0)};
// (10.5,0) @TEXT("Y",size=1.1,halign="end",valign="middle");
// (0,8) @PIN(terminal=2,direction="up");
// @LINE {(0,8) (0,6)};
// (0,5.2) @TEXT("VDD",size=1.1,halign="middle",valign="middle");
// (0,-8) @PIN(terminal=3,direction="down");
// @LINE {(0,-8) (0,-6)};
// (0,-5.2) @TEXT("VSS",size=1.1,halign="middle",valign="middle");
// ? @TEXT("${name}",key="name",size=1.6,halign="middle") => @PLACE(0,9.5);
// ? @TEXT("${model}",key="model",size=0.85,halign="middle") => @PLACE(0,-10);
// };
// # @SELECT-INSTANCE(model="b_sar8p_clkbuf") => @SET-SYMBOL $S_b_sar8p_clkbuf;
// } }
// END SARADC RNL

simulator lang=spectre

subckt sar_adc8_join_r4 D0 D1 D2 D3 D4 D5 D6 D7 SAMPLE VDD! VINN VINP  VREFN VREFP 0
    XSEQ (SAMPLE_MATCH VDD! 0 SEQ_SAMPLE) sar8r_edge
    XIDLE (ACTIVE SAMPLE_INT VDD! 0 PRESET SAMPLE_MATCH) sar8i_idle
    XSAMPLE (SAMPLE VDD! 0 SAMPLE_INT) sar8p_clkbuf
    XBOOTN (SEQ_SAMPLE TOPN VINN) sar_bootstrap_flat_8b_p
    XBOOTP (SEQ_SAMPLE TOPP VINP) sar_bootstrap_flat_8b_p
    XCDAC (GNN0 GNN1 GNN2 GNN3 GNN4 GNN5 GNN6 GNN7 GNP0 GNP1 GNP2 GNP3  GNP4 GNP5 GNP6 GNP7 GPN0 GPN1 GPN2 GPN3 GPN4 GPN5 GPN6 GPN7 GPP0  GPP1 GPP2 GPP3 GPP4 GPP5 GPP6 GPP7 TOPN TOPP VDD! VREFN VREFP 0)  sar8j_r1_cdac
    XCTRL (CMP_CLK CODE0 CODE1 CODE2 CODE3 CODE4 CODE5 CODE6 CODE7 COMP_N  COMP_P D0 D1 D2 D3 D4 D5 D6 D7 PHI_U SAMPLE_INT VDD! 0 ACTIVE)  sar8i_ctrl
    XREF (CODE0 CODE1 CODE2 CODE3 CODE4 CODE5 CODE6 CODE7 D0 D1 D2 D3 D4  D5 D6 D7 GNN0 GNN1 GNN2 GNN3 GNN4 GNN5 GNN6 GNN7 GNP0 GNP1 GNP2  GNP3 GNP4 GNP5 GNP6 GNP7 GPN0 GPN1 GPN2 GPN3 GPN4 GPN5 GPN6 GPN7  GPP0 GPP1 GPP2 GPP3 GPP4 GPP5 GPP6 GPP7 PHI_U SAMPLE_INT VDD! 0 RST_DONE PRESET)  sar8i_refword
    XCOMP (CMP_CLK COMP_N COMP_P VDD! TOPN TOPP 0) sar_strongarm_t28
    CL_COMP_N (COMP_N 0) cfmom_2t nr=8 lr=2.5u w=50n s=50n stm=1 spm=3  multi=2 mismatchflag=1
    CL_COMP_P (COMP_P 0) cfmom_2t nr=8 lr=2.5u w=50n s=50n stm=1 spm=3  multi=2 mismatchflag=1
    CL_CMP_CLK (CMP_CLK 0) cfmom_2t nr=8 lr=2.5u w=50n s=50n stm=1 spm=3  multi=2 mismatchflag=1
// BEGIN SARADC RNL
// @RNL(author="saradc topology") {
// (-24,105) @TEXT("SAR8 / current transistor hierarchy",size=2,halign="start",textcolor="#223d52");
// (-24,97) @TEXT("VIN pair -> Bootstrap -> MOM CDAC -> StrongARM -> asynchronous SAR",size=1.15,halign="start",textcolor="#223d52");
// #XSAMPLE @SET-SYMBOL $S_sar8p_clkbuf;
// #XSAMPLE @PLACE(0,67) => @ORIENT("R0");
// #XIDLE @SET-SYMBOL $S_sar8i_idle;
// #XIDLE @PLACE(65,67) => @ORIENT("R0");
// #XSEQ @SET-SYMBOL $S_sar8r_edge;
// #XSEQ @PLACE(130,67) => @ORIENT("R0");
// #XBOOTN @SET-SYMBOL $S_sar_bootstrap_flat_8b_p;
// #XBOOTN @PLACE(0,12) => @ORIENT("R0");
// #XBOOTP @SET-SYMBOL $S_sar_bootstrap_flat_8b_p;
// #XBOOTP @PLACE(0,-25) => @ORIENT("R0");
// #XCDAC @SET-SYMBOL $S_sar8j_r1_cdac;
// #XCDAC @PLACE(72,-7) => @ORIENT("R0");
// #XCOMP @SET-SYMBOL $S_sar_strongarm_t28;
// #XCOMP @PLACE(137,-7) => @ORIENT("R0");
// #XCTRL @SET-SYMBOL $S_sar8i_ctrl;
// #XCTRL @PLACE(204,-7) => @ORIENT("R0");
// #XREF @SET-SYMBOL $S_sar8i_refword;
// #XREF @PLACE(72,-91) => @ORIENT("R0");
// #CL_COMP_N @SET-SYMBOL $CAPACITOR;
// #CL_COMP_N @PLACE(168,-45) => @ORIENT("R0");
// #CL_COMP_N @TEXT("CL_COMP_N",key="name",size=1.3,halign="start") => @PLACE(171,-42);
// #CL_COMP_N @TEXT("nr=8 lr=2.5u w=50n multi=2",key="value",size=0.9,halign="start") => @PLACE(171,-49);
// #CL_COMP_N @TEXT("",key="model");
// #CL_COMP_P @SET-SYMBOL $CAPACITOR;
// #CL_COMP_P @PLACE(184,-45) => @ORIENT("R0");
// #CL_COMP_P @TEXT("CL_COMP_P",key="name",size=1.3,halign="start") => @PLACE(187,-42);
// #CL_COMP_P @TEXT("nr=8 lr=2.5u w=50n multi=2",key="value",size=0.9,halign="start") => @PLACE(187,-49);
// #CL_COMP_P @TEXT("",key="model");
// #CL_CMP_CLK @SET-SYMBOL $CAPACITOR;
// #CL_CMP_CLK @PLACE(222,-45) => @ORIENT("R0");
// #CL_CMP_CLK @TEXT("CL_CMP_CLK",key="name",size=1.3,halign="start") => @PLACE(225,-42);
// #CL_CMP_CLK @TEXT("nr=8 lr=2.5u w=50n multi=2",key="value",size=0.9,halign="start") => @PLACE(225,-49);
// #CL_CMP_CLK @TEXT("",key="model");
// (-12,81) @TEXT("Sample buffer",size=2.4,halign="start",textcolor="#223d52");
// (53,82) @TEXT("Idle / preset",size=2.4,halign="start",textcolor="#223d52");
// (118,82) @TEXT("Sample edge",size=2.4,halign="start",textcolor="#223d52");
// (-12,27) @TEXT("Bootstrap -",size=2.4,halign="start",textcolor="#223d52");
// (-12,-10) @TEXT("Bootstrap +",size=2.4,halign="start",textcolor="#223d52");
// (60,13.55) @TEXT("MOM CDAC",size=2.4,halign="start",textcolor="#223d52");
// (125,8.6) @TEXT("StrongARM",size=2.4,halign="start",textcolor="#223d52");
// (192,11.9) @TEXT("Async SAR",size=2.4,halign="start",textcolor="#223d52");
// (60,-70.45) @TEXT("Reference word",size=2.4,halign="start",textcolor="#223d52");
// &"SAMPLE_INT" @WIRE(mode="straight",linecolor="#30485d",linewidth=0.16) {#XSAMPLE:4 (29.5,67) (29.5,65.35) #XIDLE:2};
// &"SAMPLE_MATCH" @WIRE(mode="straight",linecolor="#30485d",linewidth=0.16) {#XIDLE:6 (97.5,65.35) (97.5,67) #XSEQ:1};
// &"SEQ_SAMPLE" @WIRE(mode="straight",linecolor="#94601a",linewidth=0.16) {(-25,-23.35) (-25,13.65) (-25,67)};
// &"SEQ_SAMPLE" @WIRE(mode="straight",linecolor="#94601a",linewidth=0.16) {#XSEQ:4 (-25,67)};
// $JUNCTION @ATTACH (-25,67);
// &"SEQ_SAMPLE" @WIRE(mode="straight",linecolor="#94601a",linewidth=0.16) {#XBOOTN:1 (-25,13.65)};
// $JUNCTION @ATTACH (-25,13.65);
// &"SEQ_SAMPLE" @WIRE(mode="straight",linecolor="#94601a",linewidth=0.16) {#XBOOTP:1 (-25,-23.35)};
// $JUNCTION @ATTACH (-25,-23.35);
// &"TOPN" @WIRE(mode="straight",linecolor="#30485d",linewidth=0.16) {#XBOOTN:2 (32,12) (32,24) (98,24) (98,-5.35) #XCDAC:33};
// &"TOPP" @WIRE(mode="straight",linecolor="#30485d",linewidth=0.16) {#XBOOTP:2 (36,-25) (36,-31) (101,-31) (101,-8.65) #XCDAC:34};
// &"TOPN" @WIRE(mode="straight",linecolor="#30485d",linewidth=0.16) {#XCDAC:33 (104.5,-5.35) (104.5,-7) #XCOMP:5};
// &"TOPP" @WIRE(mode="straight",linecolor="#30485d",linewidth=0.16) {#XCDAC:34 (104.5,-8.65) (104.5,-10.3) #XCOMP:6};
// &"COMP_N" @WIRE(mode="straight",linecolor="#30485d",linewidth=0.16) {(168,-43) (168,-5.35) (168,-3.7)};
// &"COMP_N" @WIRE(mode="straight",linecolor="#30485d",linewidth=0.16) {#XCOMP:2 (168,-5.35)};
// $JUNCTION @ATTACH (168,-5.35);
// &"COMP_N" @WIRE(mode="straight",linecolor="#30485d",linewidth=0.16) {#XCTRL:10 (168,-3.7)};
// $JUNCTION @ATTACH (168,-3.7);
// &"COMP_N" @WIRE(mode="straight",linecolor="#30485d",linewidth=0.16) {#CL_COMP_N:1 (168,-43)};
// $JUNCTION @ATTACH (168,-43);
// &"COMP_P" @WIRE(mode="straight",linecolor="#30485d",linewidth=0.16) {(184,-43) (184,-8.65) (184,-7)};
// &"COMP_P" @WIRE(mode="straight",linecolor="#30485d",linewidth=0.16) {#XCOMP:3 (184,-8.65)};
// $JUNCTION @ATTACH (184,-8.65);
// &"COMP_P" @WIRE(mode="straight",linecolor="#30485d",linewidth=0.16) {#XCTRL:11 (184,-7)};
// $JUNCTION @ATTACH (184,-7);
// &"COMP_P" @WIRE(mode="straight",linecolor="#30485d",linewidth=0.16) {#CL_COMP_P:1 (184,-43)};
// $JUNCTION @ATTACH (184,-43);
// &"CMP_CLK" @WIRE(mode="straight",linecolor="#94601a",linewidth=0.16) {(124,34) (217,34) (222,34)};
// &"CMP_CLK" @WIRE(mode="straight",linecolor="#94601a",linewidth=0.16) {#XCTRL:1 (217,34)};
// $JUNCTION @ATTACH (217,34);
// &"CMP_CLK" @WIRE(mode="straight",linecolor="#94601a",linewidth=0.16) {#XCOMP:1 (124,34)};
// $JUNCTION @ATTACH (124,34);
// &"CMP_CLK" @WIRE(mode="straight",linecolor="#94601a",linewidth=0.16) {#CL_CMP_CLK:1 (222,34)};
// $JUNCTION @ATTACH (222,34);
// {&"GNN0" &"GNN1" &"GNN2" &"GNN3" &"GNN4" &"GNN5" &"GNN6" &"GNN7"} @WIRE(mode="straight",linewidth=0.3) {#XREF:17 (111,-82.75) (111,-60) (41,-60) (41,1.25) #XCDAC:1};
// {&"GNP0" &"GNP1" &"GNP2" &"GNP3" &"GNP4" &"GNP5" &"GNP6" &"GNP7"} @WIRE(mode="straight",linewidth=0.3) {#XREF:25 (115,-86.05) (115,-64) (37,-64) (37,-2.05) #XCDAC:9};
// {&"GPN0" &"GPN1" &"GPN2" &"GPN3" &"GPN4" &"GPN5" &"GPN6" &"GPN7"} @WIRE(mode="straight",linewidth=0.3) {#XREF:33 (119,-89.35) (119,-68) (33,-68) (33,-5.35) #XCDAC:17};
// {&"GPP0" &"GPP1" &"GPP2" &"GPP3" &"GPP4" &"GPP5" &"GPP6" &"GPP7"} @WIRE(mode="straight",linewidth=0.3) {#XREF:41 (123,-92.65) (123,-72) (29,-72) (29,-8.65) #XCDAC:25};
// {&"CODE0" &"CODE1" &"CODE2" &"CODE3" &"CODE4" &"CODE5" &"CODE6" &"CODE7"} @WIRE(mode="straight",linewidth=0.3) {#XCTRL:2 (244,-3.7) (244,-132) (43,-132) (43,-86.05) #XREF:1};
// {&"D0" &"D1" &"D2" &"D3" &"D4" &"D5" &"D6" &"D7"} @WIRE(mode="straight",linewidth=0.3) {#XCTRL:12 (248,-7) (248,-136) (39,-136) (39,-89.35) #XREF:9};
// (155,-128) @TEXT("CODE[7:0] / D[7:0] feedback",size=0.95,halign="start",textcolor="#223d52");
// (-24,-145) @TEXT("All three physical comparator/clock MOM loads are shown. VDD! / 0 are global rails.",size=0.95,halign="start",textcolor="#223d52");
// &"VDD!" @WIRE(mode="straight",linecolor="#30485d",linewidth=0.16) {#XSEQ:2 (130,78)};
// (130,78.4) @TEXT("VDD!",size=1.1,halign="middle",valign="bottom");
// &"0" @WIRE(mode="straight",linecolor="#30485d",linewidth=0.16) {#XSEQ:3 (130,56)};
// (130,55.6) @TEXT("0",size=1.1,halign="middle",valign="top");
// &"ACTIVE" @WIRE(mode="straight",linecolor="#30485d",linewidth=0.16) {#XIDLE:1 (49,68.65)};
// (48.6,68.65) @TEXT("ACTIVE",size=1.1,halign="end",valign="middle");
// &"VDD!" @WIRE(mode="straight",linecolor="#30485d",linewidth=0.16) {#XIDLE:3 (65,78)};
// (65,78.4) @TEXT("VDD!",size=1.1,halign="middle",valign="bottom");
// &"0" @WIRE(mode="straight",linecolor="#30485d",linewidth=0.16) {#XIDLE:4 (65,56)};
// (65,55.6) @TEXT("0",size=1.1,halign="middle",valign="top");
// &"PRESET" @WIRE(mode="straight",linecolor="#30485d",linewidth=0.16) {#XIDLE:5 (81,68.65)};
// (81.4,68.65) @TEXT("PRESET",size=1.1,halign="start",valign="middle");
// &"SAMPLE" @WIRE(mode="straight",linecolor="#30485d",linewidth=0.16) {#XSAMPLE:1 (-10,67)};
// (-10.4,67) @TEXT("SAMPLE",size=1.1,halign="end",valign="middle");
// &"VDD!" @WIRE(mode="straight",linecolor="#30485d",linewidth=0.16) {#XSAMPLE:2 (0,77)};
// (0,77.4) @TEXT("VDD!",size=1.1,halign="middle",valign="bottom");
// &"0" @WIRE(mode="straight",linecolor="#30485d",linewidth=0.16) {#XSAMPLE:3 (0,57)};
// (0,56.6) @TEXT("0",size=1.1,halign="middle",valign="top");
// &"VINN" @WIRE(mode="straight",linecolor="#30485d",linewidth=0.16) {#XBOOTN:3 (-16,10.35)};
// (-16.4,10.35) @TEXT("VINN",size=1.1,halign="end",valign="middle");
// &"VINP" @WIRE(mode="straight",linecolor="#30485d",linewidth=0.16) {#XBOOTP:3 (-16,-26.65)};
// (-16.4,-26.65) @TEXT("VINP",size=1.1,halign="end",valign="middle");
// &"VDD!" @WIRE(mode="straight",linecolor="#30485d",linewidth=0.16) {#XCDAC:35 (72,9.55)};
// (72,9.95) @TEXT("VDD!",size=1.1,halign="middle",valign="bottom");
// &"VREFN" @WIRE(mode="straight",linecolor="#30485d",linewidth=0.16) {#XCDAC:36 (56,-11.95)};
// (55.6,-11.95) @TEXT("VREFN",size=1.1,halign="end",valign="middle");
// &"VREFP" @WIRE(mode="straight",linecolor="#30485d",linewidth=0.16) {#XCDAC:37 (56,-15.25)};
// (55.6,-15.25) @TEXT("VREFP",size=1.1,halign="end",valign="middle");
// &"0" @WIRE(mode="straight",linecolor="#30485d",linewidth=0.16) {#XCDAC:38 (72,-23.55)};
// (72,-23.95) @TEXT("0",size=1.1,halign="middle",valign="top");
// &"PHI_U" @WIRE(mode="straight",linecolor="#30485d",linewidth=0.16) {#XCTRL:20 (220,-10.3)};
// (220.4,-10.3) @TEXT("PHI_U",size=1.1,halign="start",valign="middle");
// &"SAMPLE_INT" @WIRE(mode="straight",linecolor="#30485d",linewidth=0.16) {#XCTRL:21 (188,-10.3)};
// (187.6,-10.3) @TEXT("SAMPLE_INT",size=1.1,halign="end",valign="middle");
// &"VDD!" @WIRE(mode="straight",linecolor="#30485d",linewidth=0.16) {#XCTRL:22 (204,7.9)};
// (204,8.3) @TEXT("VDD!",size=1.1,halign="middle",valign="bottom");
// &"0" @WIRE(mode="straight",linecolor="#30485d",linewidth=0.16) {#XCTRL:23 (204,-21.9)};
// (204,-22.3) @TEXT("0",size=1.1,halign="middle",valign="top");
// &"ACTIVE" @WIRE(mode="straight",linecolor="#30485d",linewidth=0.16) {#XCTRL:24 (220,-13.6)};
// (220.4,-13.6) @TEXT("ACTIVE",size=1.1,halign="start",valign="middle");
// &"PHI_U" @WIRE(mode="straight",linecolor="#30485d",linewidth=0.16) {#XREF:49 (56,-92.65)};
// (55.6,-92.65) @TEXT("PHI_U",size=1.1,halign="end",valign="middle");
// &"SAMPLE_INT" @WIRE(mode="straight",linecolor="#30485d",linewidth=0.16) {#XREF:50 (56,-95.95)};
// (55.6,-95.95) @TEXT("SAMPLE_INT",size=1.1,halign="end",valign="middle");
// &"VDD!" @WIRE(mode="straight",linecolor="#30485d",linewidth=0.16) {#XREF:51 (72,-74.45)};
// (72,-74.05) @TEXT("VDD!",size=1.1,halign="middle",valign="bottom");
// &"0" @WIRE(mode="straight",linecolor="#30485d",linewidth=0.16) {#XREF:52 (72,-107.55)};
// (72,-107.95) @TEXT("0",size=1.1,halign="middle",valign="top");
// &"RST_DONE" @WIRE(mode="straight",linecolor="#30485d",linewidth=0.16) {#XREF:53 (88,-95.95)};
// (88.4,-95.95) @TEXT("RST_DONE",size=1.1,halign="start",valign="middle");
// &"PRESET" @WIRE(mode="straight",linecolor="#30485d",linewidth=0.16) {#XREF:54 (88,-99.25)};
// (88.4,-99.25) @TEXT("PRESET",size=1.1,halign="start",valign="middle");
// &"VDD!" @WIRE(mode="straight",linecolor="#30485d",linewidth=0.16) {#XCOMP:4 (137,4.6)};
// (137,5) @TEXT("VDD!",size=1.1,halign="middle",valign="bottom");
// &"0" @WIRE(mode="straight",linecolor="#30485d",linewidth=0.16) {#XCOMP:7 (137,-18.6)};
// (137,-19) @TEXT("0",size=1.1,halign="middle",valign="top");
// &"0" @WIRE(mode="straight",linecolor="#30485d",linewidth=0.16) {#CL_COMP_N:2 (168,-50)};
// (168,-50.4) @TEXT("0",size=1.1,halign="middle",valign="top");
// &"0" @WIRE(mode="straight",linecolor="#30485d",linewidth=0.16) {#CL_COMP_P:2 (184,-50)};
// (184,-50.4) @TEXT("0",size=1.1,halign="middle",valign="top");
// &"0" @WIRE(mode="straight",linecolor="#30485d",linewidth=0.16) {#CL_CMP_CLK:2 (222,-50)};
// (222,-50.4) @TEXT("0",size=1.1,halign="middle",valign="top");
// }
// END SARADC RNL
ends sar_adc8_join_r4

subckt sar_bootstrap_flat_8b_p CLKS VOUT Vin
    Mmain (VOUT G Vin 0) nch_18_mac l=150.0n w=1u multi=1 nf=1 sd=180.0n          ad=1.55e-13 as=1.55e-13 pd=2.31u ps=2.31u nrd=0 nrs=0 sa=155.00n          sb=155.00n sa1=155.00n sa2=155.00n sa3=155.00n sa4=155.00n          sb1=155.00n sb2=155.00n sb3=155.00n spa=180.0n spa1=180.0n          spa2=180.0n spa3=180.0n sap=172.362n sapb=242.67n spba=233.666n          spba1=239.844n spmt=1.11111e+15 spomt=0 spomt1=1.11111e+60          spmb=1.11111e+15 spomb=0 spomb1=1.11111e+60
    Mmain_U1 (VOUT G Vin 0) nch_18_mac l=150.0n w=1u multi=1 nf=1 sd=180.0n          ad=1.55e-13 as=1.55e-13 pd=2.31u ps=2.31u nrd=0 nrs=0 sa=155.00n          sb=155.00n sa1=155.00n sa2=155.00n sa3=155.00n sa4=155.00n          sb1=155.00n sb2=155.00n sb3=155.00n spa=180.0n spa1=180.0n          spa2=180.0n spa3=180.0n sap=172.362n sapb=242.67n spba=233.666n          spba1=239.844n spmt=1.11111e+15 spomt=0 spomt1=1.11111e+60          spmb=1.11111e+15 spomb=0 spomb1=1.11111e+60
    M4C (CTRL CLKS BBOT 0) nch_18_mac l=150.0n w=1u multi=1 nf=1 sd=180.0n          ad=1.55e-13 as=1.55e-13 pd=2.31u ps=2.31u nrd=0 nrs=0 sa=155.00n          sb=155.00n sa1=155.00n sa2=155.00n sa3=155.00n sa4=155.00n          sb1=155.00n sb2=155.00n sb3=155.00n spa=180.0n spa1=180.0n          spa2=180.0n spa3=180.0n sap=172.362n sapb=242.67n spba=233.666n          spba1=239.844n spmt=1.11111e+15 spomt=0 spomt1=1.11111e+60          spmb=1.11111e+15 spomb=0 spomb1=1.11111e+60
    Msin (BBOT G Vin 0) nch_18_mac l=150.0n w=1u multi=1 nf=1 sd=180.0n          ad=1.55e-13 as=1.55e-13 pd=2.31u ps=2.31u nrd=0 nrs=0 sa=155.00n          sb=155.00n sa1=155.00n sa2=155.00n sa3=155.00n sa4=155.00n          sb1=155.00n sb2=155.00n sb3=155.00n spa=180.0n spa1=180.0n          spa2=180.0n spa3=180.0n sap=172.362n sapb=242.67n spba=233.666n          spba1=239.844n spmt=1.11111e+15 spomt=0 spomt1=1.11111e+60          spmb=1.11111e+15 spomb=0 spomb1=1.11111e+60
    Maux (G VDD! GRESET 0) nch_18_mac l=150.0n w=1u multi=1 nf=1 sd=180.0n          ad=1.55e-13 as=1.55e-13 pd=2.31u ps=2.31u nrd=0 nrs=0 sa=155.00n          sb=155.00n sa1=155.00n sa2=155.00n sa3=155.00n sa4=155.00n          sb1=155.00n sb2=155.00n sb3=155.00n spa=180.0n spa1=180.0n          spa2=180.0n spa3=180.0n sap=172.362n sapb=242.67n spba=233.666n          spba1=239.844n spmt=1.11111e+15 spomt=0 spomt1=1.11111e+60          spmb=1.11111e+15 spomb=0 spomb1=1.11111e+60
    MRSTG (GRESET CLKSB 0 0) nch_18_mac l=150.0n w=1u multi=1 nf=1          sd=180.0n ad=1.55e-13 as=1.55e-13 pd=2.31u ps=2.31u nrd=0 nrs=0          sa=155.00n sb=155.00n sa1=155.00n sa2=155.00n sa3=155.00n          sa4=155.00n sb1=155.00n sb2=155.00n sb3=155.00n spa=180.0n          spa1=180.0n spa2=180.0n spa3=180.0n sap=172.362n sapb=242.67n          spba=233.666n spba1=239.844n spmt=1.11111e+15 spomt=0          spomt1=1.11111e+60 spmb=1.11111e+15 spomb=0 spomb1=1.11111e+60
    M4A (CTRL G BBOT 0) nch_18_mac l=150.0n w=1u multi=1 nf=1 sd=180.0n          ad=1.55e-13 as=1.55e-13 pd=2.31u ps=2.31u nrd=0 nrs=0 sa=155.00n          sb=155.00n sa1=155.00n sa2=155.00n sa3=155.00n sa4=155.00n          sb1=155.00n sb2=155.00n sb3=155.00n spa=180.0n spa1=180.0n          spa2=180.0n spa3=180.0n sap=172.362n sapb=242.67n spba=233.666n          spba1=239.844n spmt=1.11111e+15 spomt=0 spomt1=1.11111e+60          spmb=1.11111e+15 spomb=0 spomb1=1.11111e+60
    M8 (BBOT CLKSB 0 0) nch_18_mac l=150.0n w=1u multi=1 nf=1 sd=180.0n          ad=1.55e-13 as=1.55e-13 pd=2.31u ps=2.31u nrd=0 nrs=0 sa=155.00n          sb=155.00n sa1=155.00n sa2=155.00n sa3=155.00n sa4=155.00n          sb1=155.00n sb2=155.00n sb3=155.00n spa=180.0n spa1=180.0n          spa2=180.0n spa3=180.0n sap=172.362n sapb=242.67n spba=233.666n          spba1=239.844n spmt=1.11111e+15 spomt=0 spomt1=1.11111e+60          spmb=1.11111e+15 spomb=0 spomb1=1.11111e+60
    MNCLK (CLKSB CLKS 0 0) nch_18_mac l=150.0n w=1u multi=1 nf=1 sd=180.0n          ad=1.55e-13 as=1.55e-13 pd=2.31u ps=2.31u nrd=0 nrs=0 sa=155.00n          sb=155.00n sa1=155.00n sa2=155.00n sa3=155.00n sa4=155.00n          sb1=155.00n sb2=155.00n sb3=155.00n spa=180.0n spa1=180.0n          spa2=180.0n spa3=180.0n sap=172.362n sapb=242.67n spba=233.666n          spba1=239.844n spmt=1.11111e+15 spomt=0 spomt1=1.11111e+60          spmb=1.11111e+15 spomb=0 spomb1=1.11111e+60
    M2 (BTOP G VDD! BTOP) pch_18_mac l=150.0n w=1u multi=1 nf=1 sd=180.0n          ad=1.55e-13 as=1.55e-13 pd=2.31u ps=2.31u nrd=0 nrs=0 sa=155.00n          sb=155.00n sa1=155.00n sa2=155.00n sa3=155.00n sa4=155.00n          sb1=155.00n sb2=155.00n sb3=155.00n spa=180.0n spa1=180.0n          spa2=180.0n spa3=180.0n sap=172.362n sapb=242.67n spba=233.666n          spba1=239.844n spmt=1.11111e+15 spomt=0 spomt1=1.11111e+60          spmb=1.11111e+15 spomb=0 spomb1=1.11111e+60
    M4 (G CTRL BTOP BTOP) pch_18_mac l=150.0n w=1u multi=1 nf=1 sd=180.0n          ad=1.55e-13 as=1.55e-13 pd=2.31u ps=2.31u nrd=0 nrs=0 sa=155.00n          sb=155.00n sa1=155.00n sa2=155.00n sa3=155.00n sa4=155.00n          sb1=155.00n sb2=155.00n sb3=155.00n spa=180.0n spa1=180.0n          spa2=180.0n spa3=180.0n sap=172.362n sapb=242.67n spba=233.666n          spba1=239.844n spmt=1.11111e+15 spomt=0 spomt1=1.11111e+60          spmb=1.11111e+15 spomb=0 spomb1=1.11111e+60
    M4B (CTRL CLKS VDD! VDD!) pch_18_mac l=150.0n w=1u multi=1 nf=1          sd=180.0n ad=1.55e-13 as=1.55e-13 pd=2.31u ps=2.31u nrd=0 nrs=0          sa=155.00n sb=155.00n sa1=155.00n sa2=155.00n sa3=155.00n          sa4=155.00n sb1=155.00n sb2=155.00n sb3=155.00n spa=180.0n          spa1=180.0n spa2=180.0n spa3=180.0n sap=172.362n sapb=242.67n          spba=233.666n spba1=239.844n spmt=1.11111e+15 spomt=0          spomt1=1.11111e+60 spmb=1.11111e+15 spomb=0 spomb1=1.11111e+60
    MPCLK (CLKSB CLKS VDD! VDD!) pch_18_mac l=150.0n w=1u multi=1 nf=1          sd=180.0n ad=1.55e-13 as=1.55e-13 pd=2.31u ps=2.31u nrd=0 nrs=0          sa=155.00n sb=155.00n sa1=155.00n sa2=155.00n sa3=155.00n          sa4=155.00n sb1=155.00n sb2=155.00n sb3=155.00n spa=180.0n          spa1=180.0n spa2=180.0n spa3=180.0n sap=172.362n sapb=242.67n          spba=233.666n spba1=239.844n spmt=1.11111e+15 spomt=0          spomt1=1.11111e+60 spmb=1.11111e+15 spomb=0 spomb1=1.11111e+60
    Cboot (BTOP BBOT) cfmom_2t nr=8 lr=2.5u w=50n s=50n stm=1 spm=3          multi=200 mismatchflag=1
// BEGIN SARADC RNL
// @RNL(author="saradc topology") {
// (-13,70) @TEXT("Bootstrap / two parallel sampling switches / MOM bootstrap capacitor",size=1.5,halign="start",textcolor="#223d52");
// #MPCLK @SET-SYMBOL $PMOS_4TERM;
// #MPCLK @PLACE(0,35) => @ORIENT("R0");
// #MPCLK @TEXT("MPCLK",key="name",size=1.3,halign="start") => @PLACE(3,38);
// #MPCLK @TEXT("l=150.0n w=1u multi=1",key="value",size=0.9,halign="start") => @PLACE(3,31);
// #MPCLK @TEXT("",key="model");
// #MNCLK @SET-SYMBOL $NMOS_4TERM;
// #MNCLK @PLACE(0,5) => @ORIENT("R0");
// #MNCLK @TEXT("MNCLK",key="name",size=1.3,halign="start") => @PLACE(3,8);
// #MNCLK @TEXT("l=150.0n w=1u multi=1",key="value",size=0.9,halign="start") => @PLACE(3,1);
// #MNCLK @TEXT("",key="model");
// #M4B @SET-SYMBOL $PMOS_4TERM;
// #M4B @PLACE(38,35) => @ORIENT("R0");
// #M4B @TEXT("M4B",key="name",size=1.3,halign="start") => @PLACE(41,38);
// #M4B @TEXT("l=150.0n w=1u multi=1",key="value",size=0.9,halign="start") => @PLACE(41,31);
// #M4B @TEXT("",key="model");
// #M4C @SET-SYMBOL $NMOS_4TERM;
// #M4C @PLACE(38,5) => @ORIENT("R0");
// #M4C @TEXT("M4C",key="name",size=1.3,halign="start") => @PLACE(41,8);
// #M4C @TEXT("l=150.0n w=1u multi=1",key="value",size=0.9,halign="start") => @PLACE(41,1);
// #M4C @TEXT("",key="model");
// #M4A @SET-SYMBOL $NMOS_4TERM;
// #M4A @PLACE(56,5) => @ORIENT("R0");
// #M4A @TEXT("M4A",key="name",size=1.3,halign="start") => @PLACE(59,8);
// #M4A @TEXT("l=150.0n w=1u multi=1",key="value",size=0.9,halign="start") => @PLACE(59,1);
// #M4A @TEXT("",key="model");
// #Cboot @SET-SYMBOL $CAPACITOR;
// #Cboot @PLACE(80,21) => @ORIENT("R0");
// #Cboot @TEXT("Cboot",key="name",size=1.3,halign="start") => @PLACE(83,24);
// #Cboot @TEXT("nr=8 lr=2.5u w=50n multi=200",key="value",size=0.9,halign="start") => @PLACE(83,17);
// #Cboot @TEXT("",key="model");
// #M2 @SET-SYMBOL $PMOS_4TERM;
// #M2 @PLACE(80,48) => @ORIENT("R0");
// #M2 @TEXT("M2",key="name",size=1.3,halign="start") => @PLACE(83,51);
// #M2 @TEXT("l=150.0n w=1u multi=1",key="value",size=0.9,halign="start") => @PLACE(83,44);
// #M2 @TEXT("",key="model");
// #M8 @SET-SYMBOL $NMOS_4TERM;
// #M8 @PLACE(80,-9) => @ORIENT("R0");
// #M8 @TEXT("M8",key="name",size=1.3,halign="start") => @PLACE(83,-6);
// #M8 @TEXT("l=150.0n w=1u multi=1",key="value",size=0.9,halign="start") => @PLACE(83,-13);
// #M8 @TEXT("",key="model");
// #Msin @SET-SYMBOL $NMOS_4TERM;
// #Msin @PLACE(101,-9) => @ORIENT("R0");
// #Msin @TEXT("Msin",key="name",size=1.3,halign="start") => @PLACE(104,-6);
// #Msin @TEXT("l=150.0n w=1u multi=1",key="value",size=0.9,halign="start") => @PLACE(104,-13);
// #Msin @TEXT("",key="model");
// #M4 @SET-SYMBOL $PMOS_4TERM;
// #M4 @PLACE(116,43) => @ORIENT("R0");
// #M4 @TEXT("M4",key="name",size=1.3,halign="start") => @PLACE(119,46);
// #M4 @TEXT("l=150.0n w=1u multi=1",key="value",size=0.9,halign="start") => @PLACE(119,39);
// #M4 @TEXT("",key="model");
// #Maux @SET-SYMBOL $NMOS_4TERM;
// #Maux @PLACE(116,4) => @ORIENT("R0");
// #Maux @TEXT("Maux",key="name",size=1.3,halign="start") => @PLACE(119,7);
// #Maux @TEXT("l=150.0n w=1u multi=1",key="value",size=0.9,halign="start") => @PLACE(119,0);
// #Maux @TEXT("",key="model");
// #MRSTG @SET-SYMBOL $NMOS_4TERM;
// #MRSTG @PLACE(116,-22) => @ORIENT("R0");
// #MRSTG @TEXT("MRSTG",key="name",size=1.3,halign="start") => @PLACE(119,-19);
// #MRSTG @TEXT("l=150.0n w=1u multi=1",key="value",size=0.9,halign="start") => @PLACE(119,-26);
// #MRSTG @TEXT("",key="model");
// #Mmain @SET-SYMBOL $NMOS_4TERM;
// #Mmain @PLACE(158,17) => @ORIENT("R270");
// #Mmain @TEXT("Mmain",key="name",size=1.3,halign="start") => @PLACE(161,20);
// #Mmain @TEXT("l=150.0n w=1u multi=1",key="value",size=0.9,halign="start") => @PLACE(161,13);
// #Mmain @TEXT("",key="model");
// #Mmain_U1 @SET-SYMBOL $NMOS_4TERM;
// #Mmain_U1 @PLACE(158,-8) => @ORIENT("R270");
// #Mmain_U1 @TEXT("Mmain_U1",key="name",size=1.3,halign="start") => @PLACE(161,-5);
// #Mmain_U1 @TEXT("l=150.0n w=1u multi=1",key="value",size=0.9,halign="start") => @PLACE(161,-12);
// #Mmain_U1 @TEXT("",key="model");
// &"CLKSB" @WIRE(mode="straight",linecolor="#30485d",linewidth=0.16) {#MPCLK:1 (0,20)};
// $JUNCTION @ATTACH (0,20);
// &"CLKSB" @WIRE(mode="straight",linecolor="#30485d",linewidth=0.16) {#MNCLK:1 (0,20)};
// $JUNCTION @ATTACH (0,20);
// &"CTRL" @WIRE(mode="straight",linecolor="#30485d",linewidth=0.16) {(38,60) (56,60) (113,60)};
// &"CTRL" @WIRE(mode="straight",linecolor="#30485d",linewidth=0.16) {#M4B:1 (38,60)};
// $JUNCTION @ATTACH (38,60);
// &"CTRL" @WIRE(mode="straight",linecolor="#30485d",linewidth=0.16) {#M4C:1 (38,60)};
// $JUNCTION @ATTACH (38,60);
// &"CTRL" @WIRE(mode="straight",linecolor="#30485d",linewidth=0.16) {#M4A:1 (56,60)};
// $JUNCTION @ATTACH (56,60);
// &"CTRL" @WIRE(mode="straight",linecolor="#30485d",linewidth=0.16) {#M4:2 (113,60)};
// $JUNCTION @ATTACH (113,60);
// &"BTOP" @WIRE(mode="straight",linecolor="#226e85",linewidth=0.16) {(80,31) (116,31)};
// &"BTOP" @WIRE(mode="straight",linecolor="#226e85",linewidth=0.16) {#Cboot:1 (80,31)};
// $JUNCTION @ATTACH (80,31);
// &"BTOP" @WIRE(mode="straight",linecolor="#226e85",linewidth=0.16) {#M2:1 (80,31)};
// $JUNCTION @ATTACH (80,31);
// &"BTOP" @WIRE(mode="straight",linecolor="#226e85",linewidth=0.16) {#M4:3 (116,31)};
// $JUNCTION @ATTACH (116,31);
// &"BBOT" @WIRE(mode="straight",linecolor="#226e85",linewidth=0.16) {(38,-2) (56,-2) (80,-2) (101,-2)};
// &"BBOT" @WIRE(mode="straight",linecolor="#226e85",linewidth=0.16) {#Cboot:2 (80,-2)};
// $JUNCTION @ATTACH (80,-2);
// &"BBOT" @WIRE(mode="straight",linecolor="#226e85",linewidth=0.16) {#M4C:3 (38,-2)};
// $JUNCTION @ATTACH (38,-2);
// &"BBOT" @WIRE(mode="straight",linecolor="#226e85",linewidth=0.16) {#M4A:3 (56,-2)};
// $JUNCTION @ATTACH (56,-2);
// &"BBOT" @WIRE(mode="straight",linecolor="#226e85",linewidth=0.16) {#M8:1 (80,-2)};
// $JUNCTION @ATTACH (80,-2);
// &"BBOT" @WIRE(mode="straight",linecolor="#226e85",linewidth=0.16) {#Msin:1 (101,-2)};
// $JUNCTION @ATTACH (101,-2);
// &"G" @WIRE(mode="straight",linecolor="#226e85",linewidth=0.16) {(138,-5) (138,6) (138,20) (138,41)};
// &"G" @WIRE(mode="straight",linecolor="#226e85",linewidth=0.16) {#M4:1 (138,41)};
// $JUNCTION @ATTACH (138,41);
// &"G" @WIRE(mode="straight",linecolor="#226e85",linewidth=0.16) {#Maux:1 (138,6)};
// $JUNCTION @ATTACH (138,6);
// &"G" @WIRE(mode="straight",linecolor="#226e85",linewidth=0.16) {#Mmain:2 (138,20)};
// $JUNCTION @ATTACH (138,20);
// &"G" @WIRE(mode="straight",linecolor="#226e85",linewidth=0.16) {#Mmain_U1:2 (138,-5)};
// $JUNCTION @ATTACH (138,-5);
// &"GRESET" @WIRE(mode="straight",linecolor="#30485d",linewidth=0.16) {#Maux:3 (116,2) (116,-20) #MRSTG:1};
// &"Vin" @WIRE(mode="straight",linecolor="#226e85",linewidth=0.16) {(146,-11) (146,-8) (146,17)};
// &"Vin" @WIRE(mode="straight",linecolor="#226e85",linewidth=0.16) {#Msin:3 (146,-11)};
// $JUNCTION @ATTACH (146,-11);
// &"Vin" @WIRE(mode="straight",linecolor="#226e85",linewidth=0.16) {#Mmain:3 (146,17)};
// $JUNCTION @ATTACH (146,17);
// &"Vin" @WIRE(mode="straight",linecolor="#226e85",linewidth=0.16) {#Mmain_U1:3 (146,-8)};
// $JUNCTION @ATTACH (146,-8);
// &"VOUT" @WIRE(mode="straight",linecolor="#226e85",linewidth=0.16) {(177,-8) (177,17)};
// &"VOUT" @WIRE(mode="straight",linecolor="#226e85",linewidth=0.16) {#Mmain:1 (177,17)};
// $JUNCTION @ATTACH (177,17);
// &"VOUT" @WIRE(mode="straight",linecolor="#226e85",linewidth=0.16) {#Mmain_U1:1 (177,-8)};
// $JUNCTION @ATTACH (177,-8);
// (-13,-44) @TEXT("Clock inverter",size=1.1,halign="start",textcolor="#223d52");
// (33,-44) @TEXT("Precharge / boosted G and BTOP",size=1.1,halign="start",textcolor="#223d52");
// (144,-44) @TEXT("Vin -> VOUT",size=1.1,halign="start",textcolor="#223d52");
// (-13,-51) @TEXT("Bulk connections remain explicit: M2/M4 use BTOP; sampling MOS uses 0. No ideal replacement.",size=0.9,halign="start",textcolor="#223d52");
// &"0" @WIRE(mode="straight",linecolor="#30485d",linewidth=0.16) {#Mmain:4 (158,13)};
// (158,12.6) @TEXT("0",size=1.1,halign="middle",valign="top");
// &"0" @WIRE(mode="straight",linecolor="#30485d",linewidth=0.16) {#Mmain_U1:4 (158,-12)};
// (158,-12.4) @TEXT("0",size=1.1,halign="middle",valign="top");
// &"CLKS" @WIRE(mode="straight",linecolor="#30485d",linewidth=0.16) {#M4C:2 (32,5)};
// (31.6,5) @TEXT("CLKS",size=1.1,halign="end",valign="middle");
// &"0" @WIRE(mode="straight",linecolor="#30485d",linewidth=0.16) {#M4C:4 (42,5)};
// (42.4,5) @TEXT("0",size=1.1,halign="start",valign="middle");
// &"G" @WIRE(mode="straight",linecolor="#30485d",linewidth=0.16) {#Msin:2 (95,-9)};
// (94.6,-9) @TEXT("G",size=1.1,halign="end",valign="middle");
// &"0" @WIRE(mode="straight",linecolor="#30485d",linewidth=0.16) {#Msin:4 (105,-9)};
// (105.4,-9) @TEXT("0",size=1.1,halign="start",valign="middle");
// &"VDD!" @WIRE(mode="straight",linecolor="#30485d",linewidth=0.16) {#Maux:2 (110,4)};
// (109.6,4) @TEXT("VDD!",size=1.1,halign="end",valign="middle");
// &"0" @WIRE(mode="straight",linecolor="#30485d",linewidth=0.16) {#Maux:4 (120,4)};
// (120.4,4) @TEXT("0",size=1.1,halign="start",valign="middle");
// &"CLKSB" @WIRE(mode="straight",linecolor="#30485d",linewidth=0.16) {#MRSTG:2 (110,-22)};
// (109.6,-22) @TEXT("CLKSB",size=1.1,halign="end",valign="middle");
// &"0" @WIRE(mode="straight",linecolor="#30485d",linewidth=0.16) {#MRSTG:3 (116,-27)};
// (116,-27.4) @TEXT("0",size=1.1,halign="middle",valign="top");
// &"0" @WIRE(mode="straight",linecolor="#30485d",linewidth=0.16) {#MRSTG:4 (120,-22)};
// (120.4,-22) @TEXT("0",size=1.1,halign="start",valign="middle");
// &"G" @WIRE(mode="straight",linecolor="#30485d",linewidth=0.16) {#M4A:2 (50,5)};
// (49.6,5) @TEXT("G",size=1.1,halign="end",valign="middle");
// &"0" @WIRE(mode="straight",linecolor="#30485d",linewidth=0.16) {#M4A:4 (60,5)};
// (60.4,5) @TEXT("0",size=1.1,halign="start",valign="middle");
// &"CLKSB" @WIRE(mode="straight",linecolor="#30485d",linewidth=0.16) {#M8:2 (74,-9)};
// (73.6,-9) @TEXT("CLKSB",size=1.1,halign="end",valign="middle");
// &"0" @WIRE(mode="straight",linecolor="#30485d",linewidth=0.16) {#M8:3 (80,-14)};
// (80,-14.4) @TEXT("0",size=1.1,halign="middle",valign="top");
// &"0" @WIRE(mode="straight",linecolor="#30485d",linewidth=0.16) {#M8:4 (84,-9)};
// (84.4,-9) @TEXT("0",size=1.1,halign="start",valign="middle");
// &"CLKS" @WIRE(mode="straight",linecolor="#30485d",linewidth=0.16) {#MNCLK:2 (-6,5)};
// (-6.4,5) @TEXT("CLKS",size=1.1,halign="end",valign="middle");
// &"0" @WIRE(mode="straight",linecolor="#30485d",linewidth=0.16) {#MNCLK:3 (0,0)};
// (0,-0.4) @TEXT("0",size=1.1,halign="middle",valign="top");
// &"0" @WIRE(mode="straight",linecolor="#30485d",linewidth=0.16) {#MNCLK:4 (4,5)};
// (4.4,5) @TEXT("0",size=1.1,halign="start",valign="middle");
// &"G" @WIRE(mode="straight",linecolor="#30485d",linewidth=0.16) {#M2:2 (74,48)};
// (73.6,48) @TEXT("G",size=1.1,halign="end",valign="middle");
// &"VDD!" @WIRE(mode="straight",linecolor="#30485d",linewidth=0.16) {#M2:3 (80,53)};
// (80,53.4) @TEXT("VDD!",size=1.1,halign="middle",valign="bottom");
// &"BTOP" @WIRE(mode="straight",linecolor="#30485d",linewidth=0.16) {#M2:4 (84,48)};
// (84.4,48) @TEXT("BTOP",size=1.1,halign="start",valign="middle");
// &"BTOP" @WIRE(mode="straight",linecolor="#30485d",linewidth=0.16) {#M4:4 (120,43)};
// (120.4,43) @TEXT("BTOP",size=1.1,halign="start",valign="middle");
// &"CLKS" @WIRE(mode="straight",linecolor="#30485d",linewidth=0.16) {#M4B:2 (32,35)};
// (31.6,35) @TEXT("CLKS",size=1.1,halign="end",valign="middle");
// &"VDD!" @WIRE(mode="straight",linecolor="#30485d",linewidth=0.16) {#M4B:3 (38,40)};
// (38,40.4) @TEXT("VDD!",size=1.1,halign="middle",valign="bottom");
// &"VDD!" @WIRE(mode="straight",linecolor="#30485d",linewidth=0.16) {#M4B:4 (42,35)};
// (42.4,35) @TEXT("VDD!",size=1.1,halign="start",valign="middle");
// &"CLKS" @WIRE(mode="straight",linecolor="#30485d",linewidth=0.16) {#MPCLK:2 (-6,35)};
// (-6.4,35) @TEXT("CLKS",size=1.1,halign="end",valign="middle");
// &"VDD!" @WIRE(mode="straight",linecolor="#30485d",linewidth=0.16) {#MPCLK:3 (0,40)};
// (0,40.4) @TEXT("VDD!",size=1.1,halign="middle",valign="bottom");
// &"VDD!" @WIRE(mode="straight",linecolor="#30485d",linewidth=0.16) {#MPCLK:4 (4,35)};
// (4.4,35) @TEXT("VDD!",size=1.1,halign="start",valign="middle");
// }
// END SARADC RNL
ends sar_bootstrap_flat_8b_p

subckt sar8j_r1_sw_b0 BOT GN GP VDD VREFN VREFP VSS
    MP_HIGH (BOT GP VREFP VDD) pch_mac l=90n w=175.00n multi=3 nf=1          sd=100n ad=1.3125e-14 as=1.3125e-14 pd=500n ps=500n nrd=1.633331          nrs=1.633331 sa=75.0n sb=75.0n sa1=75.0n sa2=75.0n sa3=75.0n          sa4=75.0n sb1=75.0n sb2=75.0n sb3=75.0n spa=100n spa1=100n          spa2=100n spa3=100n sap=91.9776n sapb=114.444n spba=115.715n          spba1=117.043n dfm_flag=0 spmt=1.11111e+15 spomt=0          spomt1=1.11111e+60 spmb=1.11111e+15 spomb=0 spomb1=1.11111e+60
    MN_LOW (BOT GN VREFN VSS) nch_mac l=90n w=150.0n multi=3 nf=1 sd=100n          ad=1.125e-14 as=1.125e-14 pd=450.0n ps=450.0n nrd=2.702751          nrs=2.702751 sa=75.0n sb=75.0n sa1=75.0n sa2=75.0n sa3=75.0n          sa4=75.0n sb1=75.0n sb2=75.0n sb3=75.0n spa=100n spa1=100n          spa2=100n spa3=100n sap=91.9776n sapb=114.444n spba=115.715n          spba1=117.043n dfm_flag=0 spmt=1.11111e+15 spomt=0          spomt1=1.11111e+60 spmb=1.11111e+15 spomb=0 spomb1=1.11111e+60
// BEGIN SARADC RNL
// @RNL(author="saradc topology") {
// #MP_HIGH @SET-SYMBOL $PMOS_4TERM;
// #MP_HIGH @PLACE(0,20) => @ORIENT("R0");
// #MP_HIGH @TEXT("MP_HIGH",key="name",size=1.3,halign="start") => @PLACE(3,23);
// #MP_HIGH @TEXT("l=90n w=175.00n multi=3",key="value",size=0.9,halign="start") => @PLACE(3,16);
// #MP_HIGH @TEXT("",key="model");
// #MN_LOW @SET-SYMBOL $NMOS_4TERM;
// #MN_LOW @PLACE(0,-10) => @ORIENT("R0");
// #MN_LOW @TEXT("MN_LOW",key="name",size=1.3,halign="start") => @PLACE(3,-7);
// #MN_LOW @TEXT("l=90n w=150.0n multi=3",key="value",size=0.9,halign="start") => @PLACE(3,-14);
// #MN_LOW @TEXT("",key="model");
// &"BOT" @WIRE(mode="straight",linecolor="#226e85",linewidth=0.16) {#MP_HIGH:1 (0,5)};
// $JUNCTION @ATTACH (0,5);
// &"BOT" @WIRE(mode="straight",linecolor="#226e85",linewidth=0.16) {#MN_LOW:1 (0,5)};
// $JUNCTION @ATTACH (0,5);
// (-20,48) @TEXT("sar8j_r1_sw_b0 / real reference switches",size=1.3,halign="start",textcolor="#223d52");
// &"GP" @WIRE(mode="straight",linecolor="#30485d",linewidth=0.16) {#MP_HIGH:2 (-6,20)};
// (-6.4,20) @TEXT("GP",size=1.1,halign="end",valign="middle");
// &"VREFP" @WIRE(mode="straight",linecolor="#30485d",linewidth=0.16) {#MP_HIGH:3 (0,25)};
// (0,25.4) @TEXT("VREFP",size=1.1,halign="middle",valign="bottom");
// &"VDD" @WIRE(mode="straight",linecolor="#30485d",linewidth=0.16) {#MP_HIGH:4 (4,20)};
// (4.4,20) @TEXT("VDD",size=1.1,halign="start",valign="middle");
// &"GN" @WIRE(mode="straight",linecolor="#30485d",linewidth=0.16) {#MN_LOW:2 (-6,-10)};
// (-6.4,-10) @TEXT("GN",size=1.1,halign="end",valign="middle");
// &"VREFN" @WIRE(mode="straight",linecolor="#30485d",linewidth=0.16) {#MN_LOW:3 (0,-15)};
// (0,-15.4) @TEXT("VREFN",size=1.1,halign="middle",valign="top");
// &"VSS" @WIRE(mode="straight",linecolor="#30485d",linewidth=0.16) {#MN_LOW:4 (4,-10)};
// (4.4,-10) @TEXT("VSS",size=1.1,halign="start",valign="middle");
// }
// END SARADC RNL
ends sar8j_r1_sw_b0

subckt sar8j_r1_sw_b1 BOT GN GP VDD VREFN VREFP VSS
    MP_HIGH (BOT GP VREFP VDD) pch_mac l=90n w=175.00n multi=6 nf=1          sd=100n ad=1.3125e-14 as=1.3125e-14 pd=500n ps=500n nrd=1.633331          nrs=1.633331 sa=75.0n sb=75.0n sa1=75.0n sa2=75.0n sa3=75.0n          sa4=75.0n sb1=75.0n sb2=75.0n sb3=75.0n spa=100n spa1=100n          spa2=100n spa3=100n sap=91.9776n sapb=114.444n spba=115.715n          spba1=117.043n dfm_flag=0 spmt=1.11111e+15 spomt=0          spomt1=1.11111e+60 spmb=1.11111e+15 spomb=0 spomb1=1.11111e+60
    MN_LOW (BOT GN VREFN VSS) nch_mac l=90n w=150.0n multi=6 nf=1 sd=100n          ad=1.125e-14 as=1.125e-14 pd=450.0n ps=450.0n nrd=2.702751          nrs=2.702751 sa=75.0n sb=75.0n sa1=75.0n sa2=75.0n sa3=75.0n          sa4=75.0n sb1=75.0n sb2=75.0n sb3=75.0n spa=100n spa1=100n          spa2=100n spa3=100n sap=91.9776n sapb=114.444n spba=115.715n          spba1=117.043n dfm_flag=0 spmt=1.11111e+15 spomt=0          spomt1=1.11111e+60 spmb=1.11111e+15 spomb=0 spomb1=1.11111e+60
// BEGIN SARADC RNL
// @RNL(author="saradc topology") {
// #MP_HIGH @SET-SYMBOL $PMOS_4TERM;
// #MP_HIGH @PLACE(0,20) => @ORIENT("R0");
// #MP_HIGH @TEXT("MP_HIGH",key="name",size=1.3,halign="start") => @PLACE(3,23);
// #MP_HIGH @TEXT("l=90n w=175.00n multi=6",key="value",size=0.9,halign="start") => @PLACE(3,16);
// #MP_HIGH @TEXT("",key="model");
// #MN_LOW @SET-SYMBOL $NMOS_4TERM;
// #MN_LOW @PLACE(0,-10) => @ORIENT("R0");
// #MN_LOW @TEXT("MN_LOW",key="name",size=1.3,halign="start") => @PLACE(3,-7);
// #MN_LOW @TEXT("l=90n w=150.0n multi=6",key="value",size=0.9,halign="start") => @PLACE(3,-14);
// #MN_LOW @TEXT("",key="model");
// &"BOT" @WIRE(mode="straight",linecolor="#226e85",linewidth=0.16) {#MP_HIGH:1 (0,5)};
// $JUNCTION @ATTACH (0,5);
// &"BOT" @WIRE(mode="straight",linecolor="#226e85",linewidth=0.16) {#MN_LOW:1 (0,5)};
// $JUNCTION @ATTACH (0,5);
// (-20,48) @TEXT("sar8j_r1_sw_b1 / real reference switches",size=1.3,halign="start",textcolor="#223d52");
// &"GP" @WIRE(mode="straight",linecolor="#30485d",linewidth=0.16) {#MP_HIGH:2 (-6,20)};
// (-6.4,20) @TEXT("GP",size=1.1,halign="end",valign="middle");
// &"VREFP" @WIRE(mode="straight",linecolor="#30485d",linewidth=0.16) {#MP_HIGH:3 (0,25)};
// (0,25.4) @TEXT("VREFP",size=1.1,halign="middle",valign="bottom");
// &"VDD" @WIRE(mode="straight",linecolor="#30485d",linewidth=0.16) {#MP_HIGH:4 (4,20)};
// (4.4,20) @TEXT("VDD",size=1.1,halign="start",valign="middle");
// &"GN" @WIRE(mode="straight",linecolor="#30485d",linewidth=0.16) {#MN_LOW:2 (-6,-10)};
// (-6.4,-10) @TEXT("GN",size=1.1,halign="end",valign="middle");
// &"VREFN" @WIRE(mode="straight",linecolor="#30485d",linewidth=0.16) {#MN_LOW:3 (0,-15)};
// (0,-15.4) @TEXT("VREFN",size=1.1,halign="middle",valign="top");
// &"VSS" @WIRE(mode="straight",linecolor="#30485d",linewidth=0.16) {#MN_LOW:4 (4,-10)};
// (4.4,-10) @TEXT("VSS",size=1.1,halign="start",valign="middle");
// }
// END SARADC RNL
ends sar8j_r1_sw_b1

subckt sar8j_r1_sw_b2 BOT GN GP VDD VREFN VREFP VSS
    MP_HIGH (BOT GP VREFP VDD) pch_mac l=90n w=175.00n multi=12 nf=1          sd=100n ad=1.3125e-14 as=1.3125e-14 pd=500n ps=500n nrd=1.633331          nrs=1.633331 sa=75.0n sb=75.0n sa1=75.0n sa2=75.0n sa3=75.0n          sa4=75.0n sb1=75.0n sb2=75.0n sb3=75.0n spa=100n spa1=100n          spa2=100n spa3=100n sap=91.9776n sapb=114.444n spba=115.715n          spba1=117.043n dfm_flag=0 spmt=1.11111e+15 spomt=0          spomt1=1.11111e+60 spmb=1.11111e+15 spomb=0 spomb1=1.11111e+60
    MN_LOW (BOT GN VREFN VSS) nch_mac l=90n w=150.0n multi=12 nf=1 sd=100n          ad=1.125e-14 as=1.125e-14 pd=450.0n ps=450.0n nrd=2.702751          nrs=2.702751 sa=75.0n sb=75.0n sa1=75.0n sa2=75.0n sa3=75.0n          sa4=75.0n sb1=75.0n sb2=75.0n sb3=75.0n spa=100n spa1=100n          spa2=100n spa3=100n sap=91.9776n sapb=114.444n spba=115.715n          spba1=117.043n dfm_flag=0 spmt=1.11111e+15 spomt=0          spomt1=1.11111e+60 spmb=1.11111e+15 spomb=0 spomb1=1.11111e+60
// BEGIN SARADC RNL
// @RNL(author="saradc topology") {
// #MP_HIGH @SET-SYMBOL $PMOS_4TERM;
// #MP_HIGH @PLACE(0,20) => @ORIENT("R0");
// #MP_HIGH @TEXT("MP_HIGH",key="name",size=1.3,halign="start") => @PLACE(3,23);
// #MP_HIGH @TEXT("l=90n w=175.00n multi=12",key="value",size=0.9,halign="start") => @PLACE(3,16);
// #MP_HIGH @TEXT("",key="model");
// #MN_LOW @SET-SYMBOL $NMOS_4TERM;
// #MN_LOW @PLACE(0,-10) => @ORIENT("R0");
// #MN_LOW @TEXT("MN_LOW",key="name",size=1.3,halign="start") => @PLACE(3,-7);
// #MN_LOW @TEXT("l=90n w=150.0n multi=12",key="value",size=0.9,halign="start") => @PLACE(3,-14);
// #MN_LOW @TEXT("",key="model");
// &"BOT" @WIRE(mode="straight",linecolor="#226e85",linewidth=0.16) {#MP_HIGH:1 (0,5)};
// $JUNCTION @ATTACH (0,5);
// &"BOT" @WIRE(mode="straight",linecolor="#226e85",linewidth=0.16) {#MN_LOW:1 (0,5)};
// $JUNCTION @ATTACH (0,5);
// (-20,48) @TEXT("sar8j_r1_sw_b2 / real reference switches",size=1.3,halign="start",textcolor="#223d52");
// &"GP" @WIRE(mode="straight",linecolor="#30485d",linewidth=0.16) {#MP_HIGH:2 (-6,20)};
// (-6.4,20) @TEXT("GP",size=1.1,halign="end",valign="middle");
// &"VREFP" @WIRE(mode="straight",linecolor="#30485d",linewidth=0.16) {#MP_HIGH:3 (0,25)};
// (0,25.4) @TEXT("VREFP",size=1.1,halign="middle",valign="bottom");
// &"VDD" @WIRE(mode="straight",linecolor="#30485d",linewidth=0.16) {#MP_HIGH:4 (4,20)};
// (4.4,20) @TEXT("VDD",size=1.1,halign="start",valign="middle");
// &"GN" @WIRE(mode="straight",linecolor="#30485d",linewidth=0.16) {#MN_LOW:2 (-6,-10)};
// (-6.4,-10) @TEXT("GN",size=1.1,halign="end",valign="middle");
// &"VREFN" @WIRE(mode="straight",linecolor="#30485d",linewidth=0.16) {#MN_LOW:3 (0,-15)};
// (0,-15.4) @TEXT("VREFN",size=1.1,halign="middle",valign="top");
// &"VSS" @WIRE(mode="straight",linecolor="#30485d",linewidth=0.16) {#MN_LOW:4 (4,-10)};
// (4.4,-10) @TEXT("VSS",size=1.1,halign="start",valign="middle");
// }
// END SARADC RNL
ends sar8j_r1_sw_b2

subckt sar8j_r1_sw_b3 BOT GN GP VDD VREFN VREFP VSS
    MP_HIGH (BOT GP VREFP VDD) pch_mac l=90n w=175.00n multi=24 nf=1          sd=100n ad=1.3125e-14 as=1.3125e-14 pd=500n ps=500n nrd=1.633331          nrs=1.633331 sa=75.0n sb=75.0n sa1=75.0n sa2=75.0n sa3=75.0n          sa4=75.0n sb1=75.0n sb2=75.0n sb3=75.0n spa=100n spa1=100n          spa2=100n spa3=100n sap=91.9776n sapb=114.444n spba=115.715n          spba1=117.043n dfm_flag=0 spmt=1.11111e+15 spomt=0          spomt1=1.11111e+60 spmb=1.11111e+15 spomb=0 spomb1=1.11111e+60
    MN_LOW (BOT GN VREFN VSS) nch_mac l=90n w=150.0n multi=24 nf=1 sd=100n          ad=1.125e-14 as=1.125e-14 pd=450.0n ps=450.0n nrd=2.702751          nrs=2.702751 sa=75.0n sb=75.0n sa1=75.0n sa2=75.0n sa3=75.0n          sa4=75.0n sb1=75.0n sb2=75.0n sb3=75.0n spa=100n spa1=100n          spa2=100n spa3=100n sap=91.9776n sapb=114.444n spba=115.715n          spba1=117.043n dfm_flag=0 spmt=1.11111e+15 spomt=0          spomt1=1.11111e+60 spmb=1.11111e+15 spomb=0 spomb1=1.11111e+60
// BEGIN SARADC RNL
// @RNL(author="saradc topology") {
// #MP_HIGH @SET-SYMBOL $PMOS_4TERM;
// #MP_HIGH @PLACE(0,20) => @ORIENT("R0");
// #MP_HIGH @TEXT("MP_HIGH",key="name",size=1.3,halign="start") => @PLACE(3,23);
// #MP_HIGH @TEXT("l=90n w=175.00n multi=24",key="value",size=0.9,halign="start") => @PLACE(3,16);
// #MP_HIGH @TEXT("",key="model");
// #MN_LOW @SET-SYMBOL $NMOS_4TERM;
// #MN_LOW @PLACE(0,-10) => @ORIENT("R0");
// #MN_LOW @TEXT("MN_LOW",key="name",size=1.3,halign="start") => @PLACE(3,-7);
// #MN_LOW @TEXT("l=90n w=150.0n multi=24",key="value",size=0.9,halign="start") => @PLACE(3,-14);
// #MN_LOW @TEXT("",key="model");
// &"BOT" @WIRE(mode="straight",linecolor="#226e85",linewidth=0.16) {#MP_HIGH:1 (0,5)};
// $JUNCTION @ATTACH (0,5);
// &"BOT" @WIRE(mode="straight",linecolor="#226e85",linewidth=0.16) {#MN_LOW:1 (0,5)};
// $JUNCTION @ATTACH (0,5);
// (-20,48) @TEXT("sar8j_r1_sw_b3 / real reference switches",size=1.3,halign="start",textcolor="#223d52");
// &"GP" @WIRE(mode="straight",linecolor="#30485d",linewidth=0.16) {#MP_HIGH:2 (-6,20)};
// (-6.4,20) @TEXT("GP",size=1.1,halign="end",valign="middle");
// &"VREFP" @WIRE(mode="straight",linecolor="#30485d",linewidth=0.16) {#MP_HIGH:3 (0,25)};
// (0,25.4) @TEXT("VREFP",size=1.1,halign="middle",valign="bottom");
// &"VDD" @WIRE(mode="straight",linecolor="#30485d",linewidth=0.16) {#MP_HIGH:4 (4,20)};
// (4.4,20) @TEXT("VDD",size=1.1,halign="start",valign="middle");
// &"GN" @WIRE(mode="straight",linecolor="#30485d",linewidth=0.16) {#MN_LOW:2 (-6,-10)};
// (-6.4,-10) @TEXT("GN",size=1.1,halign="end",valign="middle");
// &"VREFN" @WIRE(mode="straight",linecolor="#30485d",linewidth=0.16) {#MN_LOW:3 (0,-15)};
// (0,-15.4) @TEXT("VREFN",size=1.1,halign="middle",valign="top");
// &"VSS" @WIRE(mode="straight",linecolor="#30485d",linewidth=0.16) {#MN_LOW:4 (4,-10)};
// (4.4,-10) @TEXT("VSS",size=1.1,halign="start",valign="middle");
// }
// END SARADC RNL
ends sar8j_r1_sw_b3

subckt sar8j_r1_sw_b4 BOT GN GP VDD VREFN VREFP VSS
    MP_HIGH (BOT GP VREFP VDD) pch_mac l=90n w=175.00n multi=48 nf=1          sd=100n ad=1.3125e-14 as=1.3125e-14 pd=500n ps=500n nrd=1.633331          nrs=1.633331 sa=75.0n sb=75.0n sa1=75.0n sa2=75.0n sa3=75.0n          sa4=75.0n sb1=75.0n sb2=75.0n sb3=75.0n spa=100n spa1=100n          spa2=100n spa3=100n sap=91.9776n sapb=114.444n spba=115.715n          spba1=117.043n dfm_flag=0 spmt=1.11111e+15 spomt=0          spomt1=1.11111e+60 spmb=1.11111e+15 spomb=0 spomb1=1.11111e+60
    MN_LOW (BOT GN VREFN VSS) nch_mac l=90n w=150.0n multi=48 nf=1 sd=100n          ad=1.125e-14 as=1.125e-14 pd=450.0n ps=450.0n nrd=2.702751          nrs=2.702751 sa=75.0n sb=75.0n sa1=75.0n sa2=75.0n sa3=75.0n          sa4=75.0n sb1=75.0n sb2=75.0n sb3=75.0n spa=100n spa1=100n          spa2=100n spa3=100n sap=91.9776n sapb=114.444n spba=115.715n          spba1=117.043n dfm_flag=0 spmt=1.11111e+15 spomt=0          spomt1=1.11111e+60 spmb=1.11111e+15 spomb=0 spomb1=1.11111e+60
// BEGIN SARADC RNL
// @RNL(author="saradc topology") {
// #MP_HIGH @SET-SYMBOL $PMOS_4TERM;
// #MP_HIGH @PLACE(0,20) => @ORIENT("R0");
// #MP_HIGH @TEXT("MP_HIGH",key="name",size=1.3,halign="start") => @PLACE(3,23);
// #MP_HIGH @TEXT("l=90n w=175.00n multi=48",key="value",size=0.9,halign="start") => @PLACE(3,16);
// #MP_HIGH @TEXT("",key="model");
// #MN_LOW @SET-SYMBOL $NMOS_4TERM;
// #MN_LOW @PLACE(0,-10) => @ORIENT("R0");
// #MN_LOW @TEXT("MN_LOW",key="name",size=1.3,halign="start") => @PLACE(3,-7);
// #MN_LOW @TEXT("l=90n w=150.0n multi=48",key="value",size=0.9,halign="start") => @PLACE(3,-14);
// #MN_LOW @TEXT("",key="model");
// &"BOT" @WIRE(mode="straight",linecolor="#226e85",linewidth=0.16) {#MP_HIGH:1 (0,5)};
// $JUNCTION @ATTACH (0,5);
// &"BOT" @WIRE(mode="straight",linecolor="#226e85",linewidth=0.16) {#MN_LOW:1 (0,5)};
// $JUNCTION @ATTACH (0,5);
// (-20,48) @TEXT("sar8j_r1_sw_b4 / real reference switches",size=1.3,halign="start",textcolor="#223d52");
// &"GP" @WIRE(mode="straight",linecolor="#30485d",linewidth=0.16) {#MP_HIGH:2 (-6,20)};
// (-6.4,20) @TEXT("GP",size=1.1,halign="end",valign="middle");
// &"VREFP" @WIRE(mode="straight",linecolor="#30485d",linewidth=0.16) {#MP_HIGH:3 (0,25)};
// (0,25.4) @TEXT("VREFP",size=1.1,halign="middle",valign="bottom");
// &"VDD" @WIRE(mode="straight",linecolor="#30485d",linewidth=0.16) {#MP_HIGH:4 (4,20)};
// (4.4,20) @TEXT("VDD",size=1.1,halign="start",valign="middle");
// &"GN" @WIRE(mode="straight",linecolor="#30485d",linewidth=0.16) {#MN_LOW:2 (-6,-10)};
// (-6.4,-10) @TEXT("GN",size=1.1,halign="end",valign="middle");
// &"VREFN" @WIRE(mode="straight",linecolor="#30485d",linewidth=0.16) {#MN_LOW:3 (0,-15)};
// (0,-15.4) @TEXT("VREFN",size=1.1,halign="middle",valign="top");
// &"VSS" @WIRE(mode="straight",linecolor="#30485d",linewidth=0.16) {#MN_LOW:4 (4,-10)};
// (4.4,-10) @TEXT("VSS",size=1.1,halign="start",valign="middle");
// }
// END SARADC RNL
ends sar8j_r1_sw_b4

subckt sar8j_r1_sw_b5 BOT GN GP VDD VREFN VREFP VSS
    MP_HIGH (BOT GP VREFP VDD) pch_mac l=90n w=175.00n multi=96 nf=1          sd=100n ad=1.3125e-14 as=1.3125e-14 pd=500n ps=500n nrd=1.633331          nrs=1.633331 sa=75.0n sb=75.0n sa1=75.0n sa2=75.0n sa3=75.0n          sa4=75.0n sb1=75.0n sb2=75.0n sb3=75.0n spa=100n spa1=100n          spa2=100n spa3=100n sap=91.9776n sapb=114.444n spba=115.715n          spba1=117.043n dfm_flag=0 spmt=1.11111e+15 spomt=0          spomt1=1.11111e+60 spmb=1.11111e+15 spomb=0 spomb1=1.11111e+60
    MN_LOW (BOT GN VREFN VSS) nch_mac l=90n w=150.0n multi=96 nf=1 sd=100n          ad=1.125e-14 as=1.125e-14 pd=450.0n ps=450.0n nrd=2.702751          nrs=2.702751 sa=75.0n sb=75.0n sa1=75.0n sa2=75.0n sa3=75.0n          sa4=75.0n sb1=75.0n sb2=75.0n sb3=75.0n spa=100n spa1=100n          spa2=100n spa3=100n sap=91.9776n sapb=114.444n spba=115.715n          spba1=117.043n dfm_flag=0 spmt=1.11111e+15 spomt=0          spomt1=1.11111e+60 spmb=1.11111e+15 spomb=0 spomb1=1.11111e+60
// BEGIN SARADC RNL
// @RNL(author="saradc topology") {
// #MP_HIGH @SET-SYMBOL $PMOS_4TERM;
// #MP_HIGH @PLACE(0,20) => @ORIENT("R0");
// #MP_HIGH @TEXT("MP_HIGH",key="name",size=1.3,halign="start") => @PLACE(3,23);
// #MP_HIGH @TEXT("l=90n w=175.00n multi=96",key="value",size=0.9,halign="start") => @PLACE(3,16);
// #MP_HIGH @TEXT("",key="model");
// #MN_LOW @SET-SYMBOL $NMOS_4TERM;
// #MN_LOW @PLACE(0,-10) => @ORIENT("R0");
// #MN_LOW @TEXT("MN_LOW",key="name",size=1.3,halign="start") => @PLACE(3,-7);
// #MN_LOW @TEXT("l=90n w=150.0n multi=96",key="value",size=0.9,halign="start") => @PLACE(3,-14);
// #MN_LOW @TEXT("",key="model");
// &"BOT" @WIRE(mode="straight",linecolor="#226e85",linewidth=0.16) {#MP_HIGH:1 (0,5)};
// $JUNCTION @ATTACH (0,5);
// &"BOT" @WIRE(mode="straight",linecolor="#226e85",linewidth=0.16) {#MN_LOW:1 (0,5)};
// $JUNCTION @ATTACH (0,5);
// (-20,48) @TEXT("sar8j_r1_sw_b5 / real reference switches",size=1.3,halign="start",textcolor="#223d52");
// &"GP" @WIRE(mode="straight",linecolor="#30485d",linewidth=0.16) {#MP_HIGH:2 (-6,20)};
// (-6.4,20) @TEXT("GP",size=1.1,halign="end",valign="middle");
// &"VREFP" @WIRE(mode="straight",linecolor="#30485d",linewidth=0.16) {#MP_HIGH:3 (0,25)};
// (0,25.4) @TEXT("VREFP",size=1.1,halign="middle",valign="bottom");
// &"VDD" @WIRE(mode="straight",linecolor="#30485d",linewidth=0.16) {#MP_HIGH:4 (4,20)};
// (4.4,20) @TEXT("VDD",size=1.1,halign="start",valign="middle");
// &"GN" @WIRE(mode="straight",linecolor="#30485d",linewidth=0.16) {#MN_LOW:2 (-6,-10)};
// (-6.4,-10) @TEXT("GN",size=1.1,halign="end",valign="middle");
// &"VREFN" @WIRE(mode="straight",linecolor="#30485d",linewidth=0.16) {#MN_LOW:3 (0,-15)};
// (0,-15.4) @TEXT("VREFN",size=1.1,halign="middle",valign="top");
// &"VSS" @WIRE(mode="straight",linecolor="#30485d",linewidth=0.16) {#MN_LOW:4 (4,-10)};
// (4.4,-10) @TEXT("VSS",size=1.1,halign="start",valign="middle");
// }
// END SARADC RNL
ends sar8j_r1_sw_b5

subckt sar8j_r1_sw_b6 BOT GN GP VDD VREFN VREFP VSS
    MP_HIGH (BOT GP VREFP VDD) pch_mac l=90n w=175.00n multi=192 nf=1          sd=100n ad=1.3125e-14 as=1.3125e-14 pd=500n ps=500n nrd=1.633331          nrs=1.633331 sa=75.0n sb=75.0n sa1=75.0n sa2=75.0n sa3=75.0n          sa4=75.0n sb1=75.0n sb2=75.0n sb3=75.0n spa=100n spa1=100n          spa2=100n spa3=100n sap=91.9776n sapb=114.444n spba=115.715n          spba1=117.043n dfm_flag=0 spmt=1.11111e+15 spomt=0          spomt1=1.11111e+60 spmb=1.11111e+15 spomb=0 spomb1=1.11111e+60
    MN_LOW (BOT GN VREFN VSS) nch_mac l=90n w=150.0n multi=192 nf=1          sd=100n ad=1.125e-14 as=1.125e-14 pd=450.0n ps=450.0n nrd=2.702751          nrs=2.702751 sa=75.0n sb=75.0n sa1=75.0n sa2=75.0n sa3=75.0n          sa4=75.0n sb1=75.0n sb2=75.0n sb3=75.0n spa=100n spa1=100n          spa2=100n spa3=100n sap=91.9776n sapb=114.444n spba=115.715n          spba1=117.043n dfm_flag=0 spmt=1.11111e+15 spomt=0          spomt1=1.11111e+60 spmb=1.11111e+15 spomb=0 spomb1=1.11111e+60
// BEGIN SARADC RNL
// @RNL(author="saradc topology") {
// #MP_HIGH @SET-SYMBOL $PMOS_4TERM;
// #MP_HIGH @PLACE(0,20) => @ORIENT("R0");
// #MP_HIGH @TEXT("MP_HIGH",key="name",size=1.3,halign="start") => @PLACE(3,23);
// #MP_HIGH @TEXT("l=90n w=175.00n multi=192",key="value",size=0.9,halign="start") => @PLACE(3,16);
// #MP_HIGH @TEXT("",key="model");
// #MN_LOW @SET-SYMBOL $NMOS_4TERM;
// #MN_LOW @PLACE(0,-10) => @ORIENT("R0");
// #MN_LOW @TEXT("MN_LOW",key="name",size=1.3,halign="start") => @PLACE(3,-7);
// #MN_LOW @TEXT("l=90n w=150.0n multi=192",key="value",size=0.9,halign="start") => @PLACE(3,-14);
// #MN_LOW @TEXT("",key="model");
// &"BOT" @WIRE(mode="straight",linecolor="#226e85",linewidth=0.16) {#MP_HIGH:1 (0,5)};
// $JUNCTION @ATTACH (0,5);
// &"BOT" @WIRE(mode="straight",linecolor="#226e85",linewidth=0.16) {#MN_LOW:1 (0,5)};
// $JUNCTION @ATTACH (0,5);
// (-20,48) @TEXT("sar8j_r1_sw_b6 / real reference switches",size=1.3,halign="start",textcolor="#223d52");
// &"GP" @WIRE(mode="straight",linecolor="#30485d",linewidth=0.16) {#MP_HIGH:2 (-6,20)};
// (-6.4,20) @TEXT("GP",size=1.1,halign="end",valign="middle");
// &"VREFP" @WIRE(mode="straight",linecolor="#30485d",linewidth=0.16) {#MP_HIGH:3 (0,25)};
// (0,25.4) @TEXT("VREFP",size=1.1,halign="middle",valign="bottom");
// &"VDD" @WIRE(mode="straight",linecolor="#30485d",linewidth=0.16) {#MP_HIGH:4 (4,20)};
// (4.4,20) @TEXT("VDD",size=1.1,halign="start",valign="middle");
// &"GN" @WIRE(mode="straight",linecolor="#30485d",linewidth=0.16) {#MN_LOW:2 (-6,-10)};
// (-6.4,-10) @TEXT("GN",size=1.1,halign="end",valign="middle");
// &"VREFN" @WIRE(mode="straight",linecolor="#30485d",linewidth=0.16) {#MN_LOW:3 (0,-15)};
// (0,-15.4) @TEXT("VREFN",size=1.1,halign="middle",valign="top");
// &"VSS" @WIRE(mode="straight",linecolor="#30485d",linewidth=0.16) {#MN_LOW:4 (4,-10)};
// (4.4,-10) @TEXT("VSS",size=1.1,halign="start",valign="middle");
// }
// END SARADC RNL
ends sar8j_r1_sw_b6

subckt sar8j_r1_sw_b7 BOT GN GP VDD VREFN VREFP VSS
    MP_HIGH (BOT GP VREFP VDD) pch_mac l=90n w=175.00n multi=384 nf=1          sd=100n ad=1.3125e-14 as=1.3125e-14 pd=500n ps=500n nrd=1.633331          nrs=1.633331 sa=75.0n sb=75.0n sa1=75.0n sa2=75.0n sa3=75.0n          sa4=75.0n sb1=75.0n sb2=75.0n sb3=75.0n spa=100n spa1=100n          spa2=100n spa3=100n sap=91.9776n sapb=114.444n spba=115.715n          spba1=117.043n dfm_flag=0 spmt=1.11111e+15 spomt=0          spomt1=1.11111e+60 spmb=1.11111e+15 spomb=0 spomb1=1.11111e+60
    MN_LOW (BOT GN VREFN VSS) nch_mac l=90n w=150.0n multi=384 nf=1          sd=100n ad=1.125e-14 as=1.125e-14 pd=450.0n ps=450.0n nrd=2.702751          nrs=2.702751 sa=75.0n sb=75.0n sa1=75.0n sa2=75.0n sa3=75.0n          sa4=75.0n sb1=75.0n sb2=75.0n sb3=75.0n spa=100n spa1=100n          spa2=100n spa3=100n sap=91.9776n sapb=114.444n spba=115.715n          spba1=117.043n dfm_flag=0 spmt=1.11111e+15 spomt=0          spomt1=1.11111e+60 spmb=1.11111e+15 spomb=0 spomb1=1.11111e+60
// BEGIN SARADC RNL
// @RNL(author="saradc topology") {
// #MP_HIGH @SET-SYMBOL $PMOS_4TERM;
// #MP_HIGH @PLACE(0,20) => @ORIENT("R0");
// #MP_HIGH @TEXT("MP_HIGH",key="name",size=1.3,halign="start") => @PLACE(3,23);
// #MP_HIGH @TEXT("l=90n w=175.00n multi=384",key="value",size=0.9,halign="start") => @PLACE(3,16);
// #MP_HIGH @TEXT("",key="model");
// #MN_LOW @SET-SYMBOL $NMOS_4TERM;
// #MN_LOW @PLACE(0,-10) => @ORIENT("R0");
// #MN_LOW @TEXT("MN_LOW",key="name",size=1.3,halign="start") => @PLACE(3,-7);
// #MN_LOW @TEXT("l=90n w=150.0n multi=384",key="value",size=0.9,halign="start") => @PLACE(3,-14);
// #MN_LOW @TEXT("",key="model");
// &"BOT" @WIRE(mode="straight",linecolor="#226e85",linewidth=0.16) {#MP_HIGH:1 (0,5)};
// $JUNCTION @ATTACH (0,5);
// &"BOT" @WIRE(mode="straight",linecolor="#226e85",linewidth=0.16) {#MN_LOW:1 (0,5)};
// $JUNCTION @ATTACH (0,5);
// (-20,48) @TEXT("sar8j_r1_sw_b7 / real reference switches",size=1.3,halign="start",textcolor="#223d52");
// &"GP" @WIRE(mode="straight",linecolor="#30485d",linewidth=0.16) {#MP_HIGH:2 (-6,20)};
// (-6.4,20) @TEXT("GP",size=1.1,halign="end",valign="middle");
// &"VREFP" @WIRE(mode="straight",linecolor="#30485d",linewidth=0.16) {#MP_HIGH:3 (0,25)};
// (0,25.4) @TEXT("VREFP",size=1.1,halign="middle",valign="bottom");
// &"VDD" @WIRE(mode="straight",linecolor="#30485d",linewidth=0.16) {#MP_HIGH:4 (4,20)};
// (4.4,20) @TEXT("VDD",size=1.1,halign="start",valign="middle");
// &"GN" @WIRE(mode="straight",linecolor="#30485d",linewidth=0.16) {#MN_LOW:2 (-6,-10)};
// (-6.4,-10) @TEXT("GN",size=1.1,halign="end",valign="middle");
// &"VREFN" @WIRE(mode="straight",linecolor="#30485d",linewidth=0.16) {#MN_LOW:3 (0,-15)};
// (0,-15.4) @TEXT("VREFN",size=1.1,halign="middle",valign="top");
// &"VSS" @WIRE(mode="straight",linecolor="#30485d",linewidth=0.16) {#MN_LOW:4 (4,-10)};
// (4.4,-10) @TEXT("VSS",size=1.1,halign="start",valign="middle");
// }
// END SARADC RNL
ends sar8j_r1_sw_b7

subckt sar8j_r1_cdac GNN0 GNN1 GNN2 GNN3 GNN4 GNN5 GNN6 GNN7 GNP0 GNP1          GNP2 GNP3 GNP4 GNP5 GNP6 GNP7 GPN0 GPN1 GPN2 GPN3 GPN4 GPN5 GPN6          GPN7 GPP0 GPP1 GPP2 GPP3 GPP4 GPP5 GPP6 GPP7 TOPN TOPP VDD VREFN          VREFP VSS
    CMOMN8 (TOPN VREFN) cfmom_2t nr=8 lr=2u w=50n s=50n stm=1 spm=3          multi=1 mismatchflag=1
    CMOMN7 (TOPN BN7) cfmom_2t nr=8 lr=2u w=50n s=50n stm=1 spm=3          multi=128 mismatchflag=1
    CMOMN6 (TOPN BN6) cfmom_2t nr=8 lr=2u w=50n s=50n stm=1 spm=3 multi=64          mismatchflag=1
    CMOMN5 (TOPN BN5) cfmom_2t nr=8 lr=2u w=50n s=50n stm=1 spm=3 multi=32          mismatchflag=1
    CMOMN4 (TOPN BN4) cfmom_2t nr=8 lr=2u w=50n s=50n stm=1 spm=3 multi=16          mismatchflag=1
    CMOMN3 (TOPN BN3) cfmom_2t nr=8 lr=2u w=50n s=50n stm=1 spm=3 multi=8          mismatchflag=1
    CMOMN2 (TOPN BN2) cfmom_2t nr=8 lr=2u w=50n s=50n stm=1 spm=3 multi=4          mismatchflag=1
    CMOMN1 (TOPN BN1) cfmom_2t nr=8 lr=2u w=50n s=50n stm=1 spm=3 multi=2          mismatchflag=1
    CMOMN0 (TOPN BN0) cfmom_2t nr=8 lr=2u w=50n s=50n stm=1 spm=3 multi=1          mismatchflag=1
    CMOMP8 (TOPP VREFP) cfmom_2t nr=8 lr=2u w=50n s=50n stm=1 spm=3          multi=1 mismatchflag=1
    CMOMP7 (TOPP BP7) cfmom_2t nr=8 lr=2u w=50n s=50n stm=1 spm=3          multi=128 mismatchflag=1
    CMOMP6 (TOPP BP6) cfmom_2t nr=8 lr=2u w=50n s=50n stm=1 spm=3 multi=64          mismatchflag=1
    CMOMP5 (TOPP BP5) cfmom_2t nr=8 lr=2u w=50n s=50n stm=1 spm=3 multi=32          mismatchflag=1
    CMOMP4 (TOPP BP4) cfmom_2t nr=8 lr=2u w=50n s=50n stm=1 spm=3 multi=16          mismatchflag=1
    CMOMP3 (TOPP BP3) cfmom_2t nr=8 lr=2u w=50n s=50n stm=1 spm=3 multi=8          mismatchflag=1
    CMOMP2 (TOPP BP2) cfmom_2t nr=8 lr=2u w=50n s=50n stm=1 spm=3 multi=4          mismatchflag=1
    CMOMP1 (TOPP BP1) cfmom_2t nr=8 lr=2u w=50n s=50n stm=1 spm=3 multi=2          mismatchflag=1
    CMOMP0 (TOPP BP0) cfmom_2t nr=8 lr=2u w=50n s=50n stm=1 spm=3 multi=1          mismatchflag=1
    XSN0 (BN0 GNN0 GNP0 VDD VREFN VREFP VSS) sar8j_r1_sw_b0
    XSP0 (BP0 GPN0 GPP0 VDD VREFN VREFP VSS) sar8j_r1_sw_b0
    XSN1 (BN1 GNN1 GNP1 VDD VREFN VREFP VSS) sar8j_r1_sw_b1
    XSP1 (BP1 GPN1 GPP1 VDD VREFN VREFP VSS) sar8j_r1_sw_b1
    XSN2 (BN2 GNN2 GNP2 VDD VREFN VREFP VSS) sar8j_r1_sw_b2
    XSP2 (BP2 GPN2 GPP2 VDD VREFN VREFP VSS) sar8j_r1_sw_b2
    XSN3 (BN3 GNN3 GNP3 VDD VREFN VREFP VSS) sar8j_r1_sw_b3
    XSP3 (BP3 GPN3 GPP3 VDD VREFN VREFP VSS) sar8j_r1_sw_b3
    XSN4 (BN4 GNN4 GNP4 VDD VREFN VREFP VSS) sar8j_r1_sw_b4
    XSP4 (BP4 GPN4 GPP4 VDD VREFN VREFP VSS) sar8j_r1_sw_b4
    XSN5 (BN5 GNN5 GNP5 VDD VREFN VREFP VSS) sar8j_r1_sw_b5
    XSP5 (BP5 GPN5 GPP5 VDD VREFN VREFP VSS) sar8j_r1_sw_b5
    XSN6 (BN6 GNN6 GNP6 VDD VREFN VREFP VSS) sar8j_r1_sw_b6
    XSP6 (BP6 GPN6 GPP6 VDD VREFN VREFP VSS) sar8j_r1_sw_b6
    XSN7 (BN7 GNN7 GNP7 VDD VREFN VREFP VSS) sar8j_r1_sw_b7
    XSP7 (BP7 GPN7 GPP7 VDD VREFN VREFP VSS) sar8j_r1_sw_b7
// BEGIN SARADC RNL
// @RNL(author="saradc topology") {
// (-17,85) @TEXT("Differential binary MOM CDAC / 1, 2, 4, ..., 128 units + 1 dummy per side",size=1.5,halign="start",textcolor="#223d52");
// #CMOMN0 @SET-SYMBOL $CAPACITOR;
// #CMOMN0 @PLACE(0,40) => @ORIENT("R0");
// #CMOMN0 @TEXT("CMOMN0",key="name",size=1.3,halign="start") => @PLACE(3,43);
// #CMOMN0 @TEXT("nr=8 lr=2u w=50n multi=1",key="value",size=0.9,halign="start") => @PLACE(3,36);
// #CMOMN0 @TEXT("",key="model");
// #XSN0 @SET-SYMBOL $S_sar8j_r1_sw_b0;
// #XSN0 @PLACE(0,16) => @ORIENT("R0");
// &"BN0" @WIRE(mode="straight",linecolor="#30485d",linewidth=0.16) {#CMOMN0:2 (0,38) (0,28) #XSN0:1};
// #CMOMN1 @SET-SYMBOL $CAPACITOR;
// #CMOMN1 @PLACE(43,40) => @ORIENT("R0");
// #CMOMN1 @TEXT("CMOMN1",key="name",size=1.3,halign="start") => @PLACE(46,43);
// #CMOMN1 @TEXT("nr=8 lr=2u w=50n multi=2",key="value",size=0.9,halign="start") => @PLACE(46,36);
// #CMOMN1 @TEXT("",key="model");
// #XSN1 @SET-SYMBOL $S_sar8j_r1_sw_b1;
// #XSN1 @PLACE(43,16) => @ORIENT("R0");
// &"BN1" @WIRE(mode="straight",linecolor="#30485d",linewidth=0.16) {#CMOMN1:2 (43,38) (43,28) #XSN1:1};
// #CMOMN2 @SET-SYMBOL $CAPACITOR;
// #CMOMN2 @PLACE(86,40) => @ORIENT("R0");
// #CMOMN2 @TEXT("CMOMN2",key="name",size=1.3,halign="start") => @PLACE(89,43);
// #CMOMN2 @TEXT("nr=8 lr=2u w=50n multi=4",key="value",size=0.9,halign="start") => @PLACE(89,36);
// #CMOMN2 @TEXT("",key="model");
// #XSN2 @SET-SYMBOL $S_sar8j_r1_sw_b2;
// #XSN2 @PLACE(86,16) => @ORIENT("R0");
// &"BN2" @WIRE(mode="straight",linecolor="#30485d",linewidth=0.16) {#CMOMN2:2 (86,38) (86,28) #XSN2:1};
// #CMOMN3 @SET-SYMBOL $CAPACITOR;
// #CMOMN3 @PLACE(129,40) => @ORIENT("R0");
// #CMOMN3 @TEXT("CMOMN3",key="name",size=1.3,halign="start") => @PLACE(132,43);
// #CMOMN3 @TEXT("nr=8 lr=2u w=50n multi=8",key="value",size=0.9,halign="start") => @PLACE(132,36);
// #CMOMN3 @TEXT("",key="model");
// #XSN3 @SET-SYMBOL $S_sar8j_r1_sw_b3;
// #XSN3 @PLACE(129,16) => @ORIENT("R0");
// &"BN3" @WIRE(mode="straight",linecolor="#30485d",linewidth=0.16) {#CMOMN3:2 (129,38) (129,28) #XSN3:1};
// #CMOMN4 @SET-SYMBOL $CAPACITOR;
// #CMOMN4 @PLACE(172,40) => @ORIENT("R0");
// #CMOMN4 @TEXT("CMOMN4",key="name",size=1.3,halign="start") => @PLACE(175,43);
// #CMOMN4 @TEXT("nr=8 lr=2u w=50n multi=16",key="value",size=0.9,halign="start") => @PLACE(175,36);
// #CMOMN4 @TEXT("",key="model");
// #XSN4 @SET-SYMBOL $S_sar8j_r1_sw_b4;
// #XSN4 @PLACE(172,16) => @ORIENT("R0");
// &"BN4" @WIRE(mode="straight",linecolor="#30485d",linewidth=0.16) {#CMOMN4:2 (172,38) (172,28) #XSN4:1};
// #CMOMN5 @SET-SYMBOL $CAPACITOR;
// #CMOMN5 @PLACE(215,40) => @ORIENT("R0");
// #CMOMN5 @TEXT("CMOMN5",key="name",size=1.3,halign="start") => @PLACE(218,43);
// #CMOMN5 @TEXT("nr=8 lr=2u w=50n multi=32",key="value",size=0.9,halign="start") => @PLACE(218,36);
// #CMOMN5 @TEXT("",key="model");
// #XSN5 @SET-SYMBOL $S_sar8j_r1_sw_b5;
// #XSN5 @PLACE(215,16) => @ORIENT("R0");
// &"BN5" @WIRE(mode="straight",linecolor="#30485d",linewidth=0.16) {#CMOMN5:2 (215,38) (215,28) #XSN5:1};
// #CMOMN6 @SET-SYMBOL $CAPACITOR;
// #CMOMN6 @PLACE(258,40) => @ORIENT("R0");
// #CMOMN6 @TEXT("CMOMN6",key="name",size=1.3,halign="start") => @PLACE(261,43);
// #CMOMN6 @TEXT("nr=8 lr=2u w=50n multi=64",key="value",size=0.9,halign="start") => @PLACE(261,36);
// #CMOMN6 @TEXT("",key="model");
// #XSN6 @SET-SYMBOL $S_sar8j_r1_sw_b6;
// #XSN6 @PLACE(258,16) => @ORIENT("R0");
// &"BN6" @WIRE(mode="straight",linecolor="#30485d",linewidth=0.16) {#CMOMN6:2 (258,38) (258,28) #XSN6:1};
// #CMOMN7 @SET-SYMBOL $CAPACITOR;
// #CMOMN7 @PLACE(301,40) => @ORIENT("R0");
// #CMOMN7 @TEXT("CMOMN7",key="name",size=1.3,halign="start") => @PLACE(304,43);
// #CMOMN7 @TEXT("nr=8 lr=2u w=50n multi=128",key="value",size=0.9,halign="start") => @PLACE(304,36);
// #CMOMN7 @TEXT("",key="model");
// #XSN7 @SET-SYMBOL $S_sar8j_r1_sw_b7;
// #XSN7 @PLACE(301,16) => @ORIENT("R0");
// &"BN7" @WIRE(mode="straight",linecolor="#30485d",linewidth=0.16) {#CMOMN7:2 (301,38) (301,28) #XSN7:1};
// #CMOMN8 @SET-SYMBOL $CAPACITOR;
// #CMOMN8 @PLACE(344,40) => @ORIENT("R0");
// #CMOMN8 @TEXT("CMOMN8",key="name",size=1.3,halign="start") => @PLACE(347,43);
// #CMOMN8 @TEXT("nr=8 lr=2u w=50n multi=1",key="value",size=0.9,halign="start") => @PLACE(347,36);
// #CMOMN8 @TEXT("",key="model");
// &"TOPN" @WIRE(mode="straight",linecolor="#226e85",linewidth=0.16) {(0,55) (43,55) (86,55) (129,55) (172,55) (215,55) (258,55) (301,55) (344,55)};
// &"TOPN" @WIRE(mode="straight",linecolor="#226e85",linewidth=0.16) {#CMOMN0:1 (0,55)};
// $JUNCTION @ATTACH (0,55);
// &"TOPN" @WIRE(mode="straight",linecolor="#226e85",linewidth=0.16) {#CMOMN1:1 (43,55)};
// $JUNCTION @ATTACH (43,55);
// &"TOPN" @WIRE(mode="straight",linecolor="#226e85",linewidth=0.16) {#CMOMN2:1 (86,55)};
// $JUNCTION @ATTACH (86,55);
// &"TOPN" @WIRE(mode="straight",linecolor="#226e85",linewidth=0.16) {#CMOMN3:1 (129,55)};
// $JUNCTION @ATTACH (129,55);
// &"TOPN" @WIRE(mode="straight",linecolor="#226e85",linewidth=0.16) {#CMOMN4:1 (172,55)};
// $JUNCTION @ATTACH (172,55);
// &"TOPN" @WIRE(mode="straight",linecolor="#226e85",linewidth=0.16) {#CMOMN5:1 (215,55)};
// $JUNCTION @ATTACH (215,55);
// &"TOPN" @WIRE(mode="straight",linecolor="#226e85",linewidth=0.16) {#CMOMN6:1 (258,55)};
// $JUNCTION @ATTACH (258,55);
// &"TOPN" @WIRE(mode="straight",linecolor="#226e85",linewidth=0.16) {#CMOMN7:1 (301,55)};
// $JUNCTION @ATTACH (301,55);
// &"TOPN" @WIRE(mode="straight",linecolor="#226e85",linewidth=0.16) {#CMOMN8:1 (344,55)};
// $JUNCTION @ATTACH (344,55);
// (-17,65) @TEXT("TOPN / negative bank",size=1.2,halign="start",textcolor="#223d52");
// (340,16) @TEXT("dummy -> VREFN",size=0.9,halign="start",textcolor="#223d52");
// #CMOMP0 @SET-SYMBOL $CAPACITOR;
// #CMOMP0 @PLACE(0,-40) => @ORIENT("R0");
// #CMOMP0 @TEXT("CMOMP0",key="name",size=1.3,halign="start") => @PLACE(3,-37);
// #CMOMP0 @TEXT("nr=8 lr=2u w=50n multi=1",key="value",size=0.9,halign="start") => @PLACE(3,-44);
// #CMOMP0 @TEXT("",key="model");
// #XSP0 @SET-SYMBOL $S_sar8j_r1_sw_b0;
// #XSP0 @PLACE(0,-64) => @ORIENT("R0");
// &"BP0" @WIRE(mode="straight",linecolor="#30485d",linewidth=0.16) {#CMOMP0:2 (0,-42) (0,-52) #XSP0:1};
// #CMOMP1 @SET-SYMBOL $CAPACITOR;
// #CMOMP1 @PLACE(43,-40) => @ORIENT("R0");
// #CMOMP1 @TEXT("CMOMP1",key="name",size=1.3,halign="start") => @PLACE(46,-37);
// #CMOMP1 @TEXT("nr=8 lr=2u w=50n multi=2",key="value",size=0.9,halign="start") => @PLACE(46,-44);
// #CMOMP1 @TEXT("",key="model");
// #XSP1 @SET-SYMBOL $S_sar8j_r1_sw_b1;
// #XSP1 @PLACE(43,-64) => @ORIENT("R0");
// &"BP1" @WIRE(mode="straight",linecolor="#30485d",linewidth=0.16) {#CMOMP1:2 (43,-42) (43,-52) #XSP1:1};
// #CMOMP2 @SET-SYMBOL $CAPACITOR;
// #CMOMP2 @PLACE(86,-40) => @ORIENT("R0");
// #CMOMP2 @TEXT("CMOMP2",key="name",size=1.3,halign="start") => @PLACE(89,-37);
// #CMOMP2 @TEXT("nr=8 lr=2u w=50n multi=4",key="value",size=0.9,halign="start") => @PLACE(89,-44);
// #CMOMP2 @TEXT("",key="model");
// #XSP2 @SET-SYMBOL $S_sar8j_r1_sw_b2;
// #XSP2 @PLACE(86,-64) => @ORIENT("R0");
// &"BP2" @WIRE(mode="straight",linecolor="#30485d",linewidth=0.16) {#CMOMP2:2 (86,-42) (86,-52) #XSP2:1};
// #CMOMP3 @SET-SYMBOL $CAPACITOR;
// #CMOMP3 @PLACE(129,-40) => @ORIENT("R0");
// #CMOMP3 @TEXT("CMOMP3",key="name",size=1.3,halign="start") => @PLACE(132,-37);
// #CMOMP3 @TEXT("nr=8 lr=2u w=50n multi=8",key="value",size=0.9,halign="start") => @PLACE(132,-44);
// #CMOMP3 @TEXT("",key="model");
// #XSP3 @SET-SYMBOL $S_sar8j_r1_sw_b3;
// #XSP3 @PLACE(129,-64) => @ORIENT("R0");
// &"BP3" @WIRE(mode="straight",linecolor="#30485d",linewidth=0.16) {#CMOMP3:2 (129,-42) (129,-52) #XSP3:1};
// #CMOMP4 @SET-SYMBOL $CAPACITOR;
// #CMOMP4 @PLACE(172,-40) => @ORIENT("R0");
// #CMOMP4 @TEXT("CMOMP4",key="name",size=1.3,halign="start") => @PLACE(175,-37);
// #CMOMP4 @TEXT("nr=8 lr=2u w=50n multi=16",key="value",size=0.9,halign="start") => @PLACE(175,-44);
// #CMOMP4 @TEXT("",key="model");
// #XSP4 @SET-SYMBOL $S_sar8j_r1_sw_b4;
// #XSP4 @PLACE(172,-64) => @ORIENT("R0");
// &"BP4" @WIRE(mode="straight",linecolor="#30485d",linewidth=0.16) {#CMOMP4:2 (172,-42) (172,-52) #XSP4:1};
// #CMOMP5 @SET-SYMBOL $CAPACITOR;
// #CMOMP5 @PLACE(215,-40) => @ORIENT("R0");
// #CMOMP5 @TEXT("CMOMP5",key="name",size=1.3,halign="start") => @PLACE(218,-37);
// #CMOMP5 @TEXT("nr=8 lr=2u w=50n multi=32",key="value",size=0.9,halign="start") => @PLACE(218,-44);
// #CMOMP5 @TEXT("",key="model");
// #XSP5 @SET-SYMBOL $S_sar8j_r1_sw_b5;
// #XSP5 @PLACE(215,-64) => @ORIENT("R0");
// &"BP5" @WIRE(mode="straight",linecolor="#30485d",linewidth=0.16) {#CMOMP5:2 (215,-42) (215,-52) #XSP5:1};
// #CMOMP6 @SET-SYMBOL $CAPACITOR;
// #CMOMP6 @PLACE(258,-40) => @ORIENT("R0");
// #CMOMP6 @TEXT("CMOMP6",key="name",size=1.3,halign="start") => @PLACE(261,-37);
// #CMOMP6 @TEXT("nr=8 lr=2u w=50n multi=64",key="value",size=0.9,halign="start") => @PLACE(261,-44);
// #CMOMP6 @TEXT("",key="model");
// #XSP6 @SET-SYMBOL $S_sar8j_r1_sw_b6;
// #XSP6 @PLACE(258,-64) => @ORIENT("R0");
// &"BP6" @WIRE(mode="straight",linecolor="#30485d",linewidth=0.16) {#CMOMP6:2 (258,-42) (258,-52) #XSP6:1};
// #CMOMP7 @SET-SYMBOL $CAPACITOR;
// #CMOMP7 @PLACE(301,-40) => @ORIENT("R0");
// #CMOMP7 @TEXT("CMOMP7",key="name",size=1.3,halign="start") => @PLACE(304,-37);
// #CMOMP7 @TEXT("nr=8 lr=2u w=50n multi=128",key="value",size=0.9,halign="start") => @PLACE(304,-44);
// #CMOMP7 @TEXT("",key="model");
// #XSP7 @SET-SYMBOL $S_sar8j_r1_sw_b7;
// #XSP7 @PLACE(301,-64) => @ORIENT("R0");
// &"BP7" @WIRE(mode="straight",linecolor="#30485d",linewidth=0.16) {#CMOMP7:2 (301,-42) (301,-52) #XSP7:1};
// #CMOMP8 @SET-SYMBOL $CAPACITOR;
// #CMOMP8 @PLACE(344,-40) => @ORIENT("R0");
// #CMOMP8 @TEXT("CMOMP8",key="name",size=1.3,halign="start") => @PLACE(347,-37);
// #CMOMP8 @TEXT("nr=8 lr=2u w=50n multi=1",key="value",size=0.9,halign="start") => @PLACE(347,-44);
// #CMOMP8 @TEXT("",key="model");
// &"TOPP" @WIRE(mode="straight",linecolor="#226e85",linewidth=0.16) {(0,-25) (43,-25) (86,-25) (129,-25) (172,-25) (215,-25) (258,-25) (301,-25) (344,-25)};
// &"TOPP" @WIRE(mode="straight",linecolor="#226e85",linewidth=0.16) {#CMOMP0:1 (0,-25)};
// $JUNCTION @ATTACH (0,-25);
// &"TOPP" @WIRE(mode="straight",linecolor="#226e85",linewidth=0.16) {#CMOMP1:1 (43,-25)};
// $JUNCTION @ATTACH (43,-25);
// &"TOPP" @WIRE(mode="straight",linecolor="#226e85",linewidth=0.16) {#CMOMP2:1 (86,-25)};
// $JUNCTION @ATTACH (86,-25);
// &"TOPP" @WIRE(mode="straight",linecolor="#226e85",linewidth=0.16) {#CMOMP3:1 (129,-25)};
// $JUNCTION @ATTACH (129,-25);
// &"TOPP" @WIRE(mode="straight",linecolor="#226e85",linewidth=0.16) {#CMOMP4:1 (172,-25)};
// $JUNCTION @ATTACH (172,-25);
// &"TOPP" @WIRE(mode="straight",linecolor="#226e85",linewidth=0.16) {#CMOMP5:1 (215,-25)};
// $JUNCTION @ATTACH (215,-25);
// &"TOPP" @WIRE(mode="straight",linecolor="#226e85",linewidth=0.16) {#CMOMP6:1 (258,-25)};
// $JUNCTION @ATTACH (258,-25);
// &"TOPP" @WIRE(mode="straight",linecolor="#226e85",linewidth=0.16) {#CMOMP7:1 (301,-25)};
// $JUNCTION @ATTACH (301,-25);
// &"TOPP" @WIRE(mode="straight",linecolor="#226e85",linewidth=0.16) {#CMOMP8:1 (344,-25)};
// $JUNCTION @ATTACH (344,-25);
// (-17,-15) @TEXT("TOPP / positive bank",size=1.2,halign="start",textcolor="#223d52");
// (340,-64) @TEXT("dummy -> VREFP",size=0.9,halign="start",textcolor="#223d52");
// (-17,-100) @TEXT("Each switch expands to the real PMOS/NMOS pair. GP/GN are physical gates, not ideal switch controls.",size=1,halign="start",textcolor="#223d52");
// &"VREFN" @WIRE(mode="straight",linecolor="#30485d",linewidth=0.16) {#CMOMN8:2 (344,35)};
// (344,34.6) @TEXT("VREFN",size=1.1,halign="middle",valign="top");
// &"VREFP" @WIRE(mode="straight",linecolor="#30485d",linewidth=0.16) {#CMOMP8:2 (344,-45)};
// (344,-45.4) @TEXT("VREFP",size=1.1,halign="middle",valign="top");
// &"GNN0" @WIRE(mode="straight",linecolor="#30485d",linewidth=0.16) {#XSN0:2 (-5,1)};
// (-5,0.6) @TEXT("GNN0",size=1.1,halign="middle",valign="top");
// &"GNP0" @WIRE(mode="straight",linecolor="#30485d",linewidth=0.16) {#XSN0:3 (5,1)};
// (5,0.6) @TEXT("GNP0",size=1.1,halign="middle",valign="top");
// &"VDD" @WIRE(mode="straight",linecolor="#30485d",linewidth=0.16) {#XSN0:4 (16,20)};
// (16.4,20) @TEXT("VDD",size=1.1,halign="start",valign="middle");
// &"VREFN" @WIRE(mode="straight",linecolor="#30485d",linewidth=0.16) {#XSN0:5 (-16,12)};
// (-16.4,12) @TEXT("VREFN",size=1.1,halign="end",valign="middle");
// &"VREFP" @WIRE(mode="straight",linecolor="#30485d",linewidth=0.16) {#XSN0:6 (-16,20)};
// (-16.4,20) @TEXT("VREFP",size=1.1,halign="end",valign="middle");
// &"VSS" @WIRE(mode="straight",linecolor="#30485d",linewidth=0.16) {#XSN0:7 (16,12)};
// (16.4,12) @TEXT("VSS",size=1.1,halign="start",valign="middle");
// &"GPN0" @WIRE(mode="straight",linecolor="#30485d",linewidth=0.16) {#XSP0:2 (-5,-79)};
// (-5,-79.4) @TEXT("GPN0",size=1.1,halign="middle",valign="top");
// &"GPP0" @WIRE(mode="straight",linecolor="#30485d",linewidth=0.16) {#XSP0:3 (5,-79)};
// (5,-79.4) @TEXT("GPP0",size=1.1,halign="middle",valign="top");
// &"VDD" @WIRE(mode="straight",linecolor="#30485d",linewidth=0.16) {#XSP0:4 (16,-60)};
// (16.4,-60) @TEXT("VDD",size=1.1,halign="start",valign="middle");
// &"VREFN" @WIRE(mode="straight",linecolor="#30485d",linewidth=0.16) {#XSP0:5 (-16,-68)};
// (-16.4,-68) @TEXT("VREFN",size=1.1,halign="end",valign="middle");
// &"VREFP" @WIRE(mode="straight",linecolor="#30485d",linewidth=0.16) {#XSP0:6 (-16,-60)};
// (-16.4,-60) @TEXT("VREFP",size=1.1,halign="end",valign="middle");
// &"VSS" @WIRE(mode="straight",linecolor="#30485d",linewidth=0.16) {#XSP0:7 (16,-68)};
// (16.4,-68) @TEXT("VSS",size=1.1,halign="start",valign="middle");
// &"GNN1" @WIRE(mode="straight",linecolor="#30485d",linewidth=0.16) {#XSN1:2 (38,1)};
// (38,0.6) @TEXT("GNN1",size=1.1,halign="middle",valign="top");
// &"GNP1" @WIRE(mode="straight",linecolor="#30485d",linewidth=0.16) {#XSN1:3 (48,1)};
// (48,0.6) @TEXT("GNP1",size=1.1,halign="middle",valign="top");
// &"VDD" @WIRE(mode="straight",linecolor="#30485d",linewidth=0.16) {#XSN1:4 (59,20)};
// (59.4,20) @TEXT("VDD",size=1.1,halign="start",valign="middle");
// &"VREFN" @WIRE(mode="straight",linecolor="#30485d",linewidth=0.16) {#XSN1:5 (27,12)};
// (26.6,12) @TEXT("VREFN",size=1.1,halign="end",valign="middle");
// &"VREFP" @WIRE(mode="straight",linecolor="#30485d",linewidth=0.16) {#XSN1:6 (27,20)};
// (26.6,20) @TEXT("VREFP",size=1.1,halign="end",valign="middle");
// &"VSS" @WIRE(mode="straight",linecolor="#30485d",linewidth=0.16) {#XSN1:7 (59,12)};
// (59.4,12) @TEXT("VSS",size=1.1,halign="start",valign="middle");
// &"GPN1" @WIRE(mode="straight",linecolor="#30485d",linewidth=0.16) {#XSP1:2 (38,-79)};
// (38,-79.4) @TEXT("GPN1",size=1.1,halign="middle",valign="top");
// &"GPP1" @WIRE(mode="straight",linecolor="#30485d",linewidth=0.16) {#XSP1:3 (48,-79)};
// (48,-79.4) @TEXT("GPP1",size=1.1,halign="middle",valign="top");
// &"VDD" @WIRE(mode="straight",linecolor="#30485d",linewidth=0.16) {#XSP1:4 (59,-60)};
// (59.4,-60) @TEXT("VDD",size=1.1,halign="start",valign="middle");
// &"VREFN" @WIRE(mode="straight",linecolor="#30485d",linewidth=0.16) {#XSP1:5 (27,-68)};
// (26.6,-68) @TEXT("VREFN",size=1.1,halign="end",valign="middle");
// &"VREFP" @WIRE(mode="straight",linecolor="#30485d",linewidth=0.16) {#XSP1:6 (27,-60)};
// (26.6,-60) @TEXT("VREFP",size=1.1,halign="end",valign="middle");
// &"VSS" @WIRE(mode="straight",linecolor="#30485d",linewidth=0.16) {#XSP1:7 (59,-68)};
// (59.4,-68) @TEXT("VSS",size=1.1,halign="start",valign="middle");
// &"GNN2" @WIRE(mode="straight",linecolor="#30485d",linewidth=0.16) {#XSN2:2 (81,1)};
// (81,0.6) @TEXT("GNN2",size=1.1,halign="middle",valign="top");
// &"GNP2" @WIRE(mode="straight",linecolor="#30485d",linewidth=0.16) {#XSN2:3 (91,1)};
// (91,0.6) @TEXT("GNP2",size=1.1,halign="middle",valign="top");
// &"VDD" @WIRE(mode="straight",linecolor="#30485d",linewidth=0.16) {#XSN2:4 (102,20)};
// (102.4,20) @TEXT("VDD",size=1.1,halign="start",valign="middle");
// &"VREFN" @WIRE(mode="straight",linecolor="#30485d",linewidth=0.16) {#XSN2:5 (70,12)};
// (69.6,12) @TEXT("VREFN",size=1.1,halign="end",valign="middle");
// &"VREFP" @WIRE(mode="straight",linecolor="#30485d",linewidth=0.16) {#XSN2:6 (70,20)};
// (69.6,20) @TEXT("VREFP",size=1.1,halign="end",valign="middle");
// &"VSS" @WIRE(mode="straight",linecolor="#30485d",linewidth=0.16) {#XSN2:7 (102,12)};
// (102.4,12) @TEXT("VSS",size=1.1,halign="start",valign="middle");
// &"GPN2" @WIRE(mode="straight",linecolor="#30485d",linewidth=0.16) {#XSP2:2 (81,-79)};
// (81,-79.4) @TEXT("GPN2",size=1.1,halign="middle",valign="top");
// &"GPP2" @WIRE(mode="straight",linecolor="#30485d",linewidth=0.16) {#XSP2:3 (91,-79)};
// (91,-79.4) @TEXT("GPP2",size=1.1,halign="middle",valign="top");
// &"VDD" @WIRE(mode="straight",linecolor="#30485d",linewidth=0.16) {#XSP2:4 (102,-60)};
// (102.4,-60) @TEXT("VDD",size=1.1,halign="start",valign="middle");
// &"VREFN" @WIRE(mode="straight",linecolor="#30485d",linewidth=0.16) {#XSP2:5 (70,-68)};
// (69.6,-68) @TEXT("VREFN",size=1.1,halign="end",valign="middle");
// &"VREFP" @WIRE(mode="straight",linecolor="#30485d",linewidth=0.16) {#XSP2:6 (70,-60)};
// (69.6,-60) @TEXT("VREFP",size=1.1,halign="end",valign="middle");
// &"VSS" @WIRE(mode="straight",linecolor="#30485d",linewidth=0.16) {#XSP2:7 (102,-68)};
// (102.4,-68) @TEXT("VSS",size=1.1,halign="start",valign="middle");
// &"GNN3" @WIRE(mode="straight",linecolor="#30485d",linewidth=0.16) {#XSN3:2 (124,1)};
// (124,0.6) @TEXT("GNN3",size=1.1,halign="middle",valign="top");
// &"GNP3" @WIRE(mode="straight",linecolor="#30485d",linewidth=0.16) {#XSN3:3 (134,1)};
// (134,0.6) @TEXT("GNP3",size=1.1,halign="middle",valign="top");
// &"VDD" @WIRE(mode="straight",linecolor="#30485d",linewidth=0.16) {#XSN3:4 (145,20)};
// (145.4,20) @TEXT("VDD",size=1.1,halign="start",valign="middle");
// &"VREFN" @WIRE(mode="straight",linecolor="#30485d",linewidth=0.16) {#XSN3:5 (113,12)};
// (112.6,12) @TEXT("VREFN",size=1.1,halign="end",valign="middle");
// &"VREFP" @WIRE(mode="straight",linecolor="#30485d",linewidth=0.16) {#XSN3:6 (113,20)};
// (112.6,20) @TEXT("VREFP",size=1.1,halign="end",valign="middle");
// &"VSS" @WIRE(mode="straight",linecolor="#30485d",linewidth=0.16) {#XSN3:7 (145,12)};
// (145.4,12) @TEXT("VSS",size=1.1,halign="start",valign="middle");
// &"GPN3" @WIRE(mode="straight",linecolor="#30485d",linewidth=0.16) {#XSP3:2 (124,-79)};
// (124,-79.4) @TEXT("GPN3",size=1.1,halign="middle",valign="top");
// &"GPP3" @WIRE(mode="straight",linecolor="#30485d",linewidth=0.16) {#XSP3:3 (134,-79)};
// (134,-79.4) @TEXT("GPP3",size=1.1,halign="middle",valign="top");
// &"VDD" @WIRE(mode="straight",linecolor="#30485d",linewidth=0.16) {#XSP3:4 (145,-60)};
// (145.4,-60) @TEXT("VDD",size=1.1,halign="start",valign="middle");
// &"VREFN" @WIRE(mode="straight",linecolor="#30485d",linewidth=0.16) {#XSP3:5 (113,-68)};
// (112.6,-68) @TEXT("VREFN",size=1.1,halign="end",valign="middle");
// &"VREFP" @WIRE(mode="straight",linecolor="#30485d",linewidth=0.16) {#XSP3:6 (113,-60)};
// (112.6,-60) @TEXT("VREFP",size=1.1,halign="end",valign="middle");
// &"VSS" @WIRE(mode="straight",linecolor="#30485d",linewidth=0.16) {#XSP3:7 (145,-68)};
// (145.4,-68) @TEXT("VSS",size=1.1,halign="start",valign="middle");
// &"GNN4" @WIRE(mode="straight",linecolor="#30485d",linewidth=0.16) {#XSN4:2 (167,1)};
// (167,0.6) @TEXT("GNN4",size=1.1,halign="middle",valign="top");
// &"GNP4" @WIRE(mode="straight",linecolor="#30485d",linewidth=0.16) {#XSN4:3 (177,1)};
// (177,0.6) @TEXT("GNP4",size=1.1,halign="middle",valign="top");
// &"VDD" @WIRE(mode="straight",linecolor="#30485d",linewidth=0.16) {#XSN4:4 (188,20)};
// (188.4,20) @TEXT("VDD",size=1.1,halign="start",valign="middle");
// &"VREFN" @WIRE(mode="straight",linecolor="#30485d",linewidth=0.16) {#XSN4:5 (156,12)};
// (155.6,12) @TEXT("VREFN",size=1.1,halign="end",valign="middle");
// &"VREFP" @WIRE(mode="straight",linecolor="#30485d",linewidth=0.16) {#XSN4:6 (156,20)};
// (155.6,20) @TEXT("VREFP",size=1.1,halign="end",valign="middle");
// &"VSS" @WIRE(mode="straight",linecolor="#30485d",linewidth=0.16) {#XSN4:7 (188,12)};
// (188.4,12) @TEXT("VSS",size=1.1,halign="start",valign="middle");
// &"GPN4" @WIRE(mode="straight",linecolor="#30485d",linewidth=0.16) {#XSP4:2 (167,-79)};
// (167,-79.4) @TEXT("GPN4",size=1.1,halign="middle",valign="top");
// &"GPP4" @WIRE(mode="straight",linecolor="#30485d",linewidth=0.16) {#XSP4:3 (177,-79)};
// (177,-79.4) @TEXT("GPP4",size=1.1,halign="middle",valign="top");
// &"VDD" @WIRE(mode="straight",linecolor="#30485d",linewidth=0.16) {#XSP4:4 (188,-60)};
// (188.4,-60) @TEXT("VDD",size=1.1,halign="start",valign="middle");
// &"VREFN" @WIRE(mode="straight",linecolor="#30485d",linewidth=0.16) {#XSP4:5 (156,-68)};
// (155.6,-68) @TEXT("VREFN",size=1.1,halign="end",valign="middle");
// &"VREFP" @WIRE(mode="straight",linecolor="#30485d",linewidth=0.16) {#XSP4:6 (156,-60)};
// (155.6,-60) @TEXT("VREFP",size=1.1,halign="end",valign="middle");
// &"VSS" @WIRE(mode="straight",linecolor="#30485d",linewidth=0.16) {#XSP4:7 (188,-68)};
// (188.4,-68) @TEXT("VSS",size=1.1,halign="start",valign="middle");
// &"GNN5" @WIRE(mode="straight",linecolor="#30485d",linewidth=0.16) {#XSN5:2 (210,1)};
// (210,0.6) @TEXT("GNN5",size=1.1,halign="middle",valign="top");
// &"GNP5" @WIRE(mode="straight",linecolor="#30485d",linewidth=0.16) {#XSN5:3 (220,1)};
// (220,0.6) @TEXT("GNP5",size=1.1,halign="middle",valign="top");
// &"VDD" @WIRE(mode="straight",linecolor="#30485d",linewidth=0.16) {#XSN5:4 (231,20)};
// (231.4,20) @TEXT("VDD",size=1.1,halign="start",valign="middle");
// &"VREFN" @WIRE(mode="straight",linecolor="#30485d",linewidth=0.16) {#XSN5:5 (199,12)};
// (198.6,12) @TEXT("VREFN",size=1.1,halign="end",valign="middle");
// &"VREFP" @WIRE(mode="straight",linecolor="#30485d",linewidth=0.16) {#XSN5:6 (199,20)};
// (198.6,20) @TEXT("VREFP",size=1.1,halign="end",valign="middle");
// &"VSS" @WIRE(mode="straight",linecolor="#30485d",linewidth=0.16) {#XSN5:7 (231,12)};
// (231.4,12) @TEXT("VSS",size=1.1,halign="start",valign="middle");
// &"GPN5" @WIRE(mode="straight",linecolor="#30485d",linewidth=0.16) {#XSP5:2 (210,-79)};
// (210,-79.4) @TEXT("GPN5",size=1.1,halign="middle",valign="top");
// &"GPP5" @WIRE(mode="straight",linecolor="#30485d",linewidth=0.16) {#XSP5:3 (220,-79)};
// (220,-79.4) @TEXT("GPP5",size=1.1,halign="middle",valign="top");
// &"VDD" @WIRE(mode="straight",linecolor="#30485d",linewidth=0.16) {#XSP5:4 (231,-60)};
// (231.4,-60) @TEXT("VDD",size=1.1,halign="start",valign="middle");
// &"VREFN" @WIRE(mode="straight",linecolor="#30485d",linewidth=0.16) {#XSP5:5 (199,-68)};
// (198.6,-68) @TEXT("VREFN",size=1.1,halign="end",valign="middle");
// &"VREFP" @WIRE(mode="straight",linecolor="#30485d",linewidth=0.16) {#XSP5:6 (199,-60)};
// (198.6,-60) @TEXT("VREFP",size=1.1,halign="end",valign="middle");
// &"VSS" @WIRE(mode="straight",linecolor="#30485d",linewidth=0.16) {#XSP5:7 (231,-68)};
// (231.4,-68) @TEXT("VSS",size=1.1,halign="start",valign="middle");
// &"GNN6" @WIRE(mode="straight",linecolor="#30485d",linewidth=0.16) {#XSN6:2 (253,1)};
// (253,0.6) @TEXT("GNN6",size=1.1,halign="middle",valign="top");
// &"GNP6" @WIRE(mode="straight",linecolor="#30485d",linewidth=0.16) {#XSN6:3 (263,1)};
// (263,0.6) @TEXT("GNP6",size=1.1,halign="middle",valign="top");
// &"VDD" @WIRE(mode="straight",linecolor="#30485d",linewidth=0.16) {#XSN6:4 (274,20)};
// (274.4,20) @TEXT("VDD",size=1.1,halign="start",valign="middle");
// &"VREFN" @WIRE(mode="straight",linecolor="#30485d",linewidth=0.16) {#XSN6:5 (242,12)};
// (241.6,12) @TEXT("VREFN",size=1.1,halign="end",valign="middle");
// &"VREFP" @WIRE(mode="straight",linecolor="#30485d",linewidth=0.16) {#XSN6:6 (242,20)};
// (241.6,20) @TEXT("VREFP",size=1.1,halign="end",valign="middle");
// &"VSS" @WIRE(mode="straight",linecolor="#30485d",linewidth=0.16) {#XSN6:7 (274,12)};
// (274.4,12) @TEXT("VSS",size=1.1,halign="start",valign="middle");
// &"GPN6" @WIRE(mode="straight",linecolor="#30485d",linewidth=0.16) {#XSP6:2 (253,-79)};
// (253,-79.4) @TEXT("GPN6",size=1.1,halign="middle",valign="top");
// &"GPP6" @WIRE(mode="straight",linecolor="#30485d",linewidth=0.16) {#XSP6:3 (263,-79)};
// (263,-79.4) @TEXT("GPP6",size=1.1,halign="middle",valign="top");
// &"VDD" @WIRE(mode="straight",linecolor="#30485d",linewidth=0.16) {#XSP6:4 (274,-60)};
// (274.4,-60) @TEXT("VDD",size=1.1,halign="start",valign="middle");
// &"VREFN" @WIRE(mode="straight",linecolor="#30485d",linewidth=0.16) {#XSP6:5 (242,-68)};
// (241.6,-68) @TEXT("VREFN",size=1.1,halign="end",valign="middle");
// &"VREFP" @WIRE(mode="straight",linecolor="#30485d",linewidth=0.16) {#XSP6:6 (242,-60)};
// (241.6,-60) @TEXT("VREFP",size=1.1,halign="end",valign="middle");
// &"VSS" @WIRE(mode="straight",linecolor="#30485d",linewidth=0.16) {#XSP6:7 (274,-68)};
// (274.4,-68) @TEXT("VSS",size=1.1,halign="start",valign="middle");
// &"GNN7" @WIRE(mode="straight",linecolor="#30485d",linewidth=0.16) {#XSN7:2 (296,1)};
// (296,0.6) @TEXT("GNN7",size=1.1,halign="middle",valign="top");
// &"GNP7" @WIRE(mode="straight",linecolor="#30485d",linewidth=0.16) {#XSN7:3 (306,1)};
// (306,0.6) @TEXT("GNP7",size=1.1,halign="middle",valign="top");
// &"VDD" @WIRE(mode="straight",linecolor="#30485d",linewidth=0.16) {#XSN7:4 (317,20)};
// (317.4,20) @TEXT("VDD",size=1.1,halign="start",valign="middle");
// &"VREFN" @WIRE(mode="straight",linecolor="#30485d",linewidth=0.16) {#XSN7:5 (285,12)};
// (284.6,12) @TEXT("VREFN",size=1.1,halign="end",valign="middle");
// &"VREFP" @WIRE(mode="straight",linecolor="#30485d",linewidth=0.16) {#XSN7:6 (285,20)};
// (284.6,20) @TEXT("VREFP",size=1.1,halign="end",valign="middle");
// &"VSS" @WIRE(mode="straight",linecolor="#30485d",linewidth=0.16) {#XSN7:7 (317,12)};
// (317.4,12) @TEXT("VSS",size=1.1,halign="start",valign="middle");
// &"GPN7" @WIRE(mode="straight",linecolor="#30485d",linewidth=0.16) {#XSP7:2 (296,-79)};
// (296,-79.4) @TEXT("GPN7",size=1.1,halign="middle",valign="top");
// &"GPP7" @WIRE(mode="straight",linecolor="#30485d",linewidth=0.16) {#XSP7:3 (306,-79)};
// (306,-79.4) @TEXT("GPP7",size=1.1,halign="middle",valign="top");
// &"VDD" @WIRE(mode="straight",linecolor="#30485d",linewidth=0.16) {#XSP7:4 (317,-60)};
// (317.4,-60) @TEXT("VDD",size=1.1,halign="start",valign="middle");
// &"VREFN" @WIRE(mode="straight",linecolor="#30485d",linewidth=0.16) {#XSP7:5 (285,-68)};
// (284.6,-68) @TEXT("VREFN",size=1.1,halign="end",valign="middle");
// &"VREFP" @WIRE(mode="straight",linecolor="#30485d",linewidth=0.16) {#XSP7:6 (285,-60)};
// (284.6,-60) @TEXT("VREFP",size=1.1,halign="end",valign="middle");
// &"VSS" @WIRE(mode="straight",linecolor="#30485d",linewidth=0.16) {#XSP7:7 (317,-68)};
// (317.4,-68) @TEXT("VSS",size=1.1,halign="start",valign="middle");
// }
// END SARADC RNL
ends sar8j_r1_cdac

subckt sar8p_delay_valid A VDD VSS Y
R1 (B RC1 ) rupolym l=17.13u w=1u m=1 multi=(1)

R0 (A RC0 ) rupolym l=17.13u w=1u m=1 multi=(1)

    C1 (RC1 VSS) cfmom_2t nr=8 lr=2.5u w=50n s=50n stm=1 spm=3 multi=1          mismatchflag=1
    C0 (RC0 VSS) cfmom_2t nr=8 lr=2.5u w=50n s=50n stm=1 spm=3 multi=1          mismatchflag=1
    X006 (A VDD VSS AB) sar8p_inv
    X005 (RC1 VDD VSS Y) sar8p_inv
    X002 (RC0 VDD VSS B) sar8p_inv
    MN_CLEAR (RC0 AB VSS VSS) nch_mac l=30n w=2u multi=1 nf=1 sd=100n          ad=1.5e-13 as=1.5e-13 pd=4.15u ps=4.15u nrd=0.144730 nrs=0.144730          sa=75.0n sb=75.0n sa1=75.0n sa2=75.0n sa3=75.0n sa4=75.0n          sb1=75.0n sb2=75.0n sb3=75.0n spa=100n spa1=100n spa2=100n          spa3=100n sap=91.9776n sapb=114.444n spba=115.715n spba1=117.043n          dfm_flag=0 spmt=1.11111e+15 spomt=0 spomt1=1.11111e+60          spmb=1.11111e+15 spomb=0 spomb1=1.11111e+60
    MP_CLEAR (RC1 A VDD VDD) pch_mac l=30n w=3u multi=1 nf=1 sd=100n          ad=2.25e-13 as=2.25e-13 pd=6.15u ps=6.15u nrd=0.055246          nrs=0.055246 sa=75.0n sb=75.0n sa1=75.0n sa2=75.0n sa3=75.0n          sa4=75.0n sb1=75.0n sb2=75.0n sb3=75.0n spa=100n spa1=100n          spa2=100n spa3=100n sap=91.9776n sapb=114.444n spba=115.715n          spba1=117.043n dfm_flag=0 spmt=1.11111e+15 spomt=0          spomt1=1.11111e+60 spmb=1.11111e+15 spomb=0 spomb1=1.11111e+60
// BEGIN SARADC RNL
// @RNL(author="saradc topology") {
// (-18,47) @TEXT("sar8p_delay_valid / two RC stages with active clear",size=1.4,halign="start",textcolor="#223d52");
// #R0 @SET-SYMBOL $RESISTOR;
// #R0 @PLACE(12,15) => @ORIENT("R90");
// #R0 @TEXT("R0",key="name",size=1.3,halign="start") => @PLACE(15,18);
// #R0 @TEXT("l=17.13u w=1u multi=(1)",key="value",size=0.9,halign="start") => @PLACE(15,11);
// #R0 @TEXT("",key="model");
// #X002 @SET-SYMBOL $S_sar8p_inv;
// #X002 @PLACE(42,15) => @ORIENT("R0");
// #R1 @SET-SYMBOL $RESISTOR;
// #R1 @PLACE(70,15) => @ORIENT("R90");
// #R1 @TEXT("R1",key="name",size=1.3,halign="start") => @PLACE(73,18);
// #R1 @TEXT("l=17.13u w=1u multi=(1)",key="value",size=0.9,halign="start") => @PLACE(73,11);
// #R1 @TEXT("",key="model");
// #X005 @SET-SYMBOL $S_sar8p_inv;
// #X005 @PLACE(104,15) => @ORIENT("R0");
// #C0 @SET-SYMBOL $CAPACITOR;
// #C0 @PLACE(28,-4) => @ORIENT("R0");
// #C0 @TEXT("C0",key="name",size=1.3,halign="start") => @PLACE(31,-1);
// #C0 @TEXT("nr=8 lr=2.5u w=50n multi=1",key="value",size=0.9,halign="start") => @PLACE(31,-8);
// #C0 @TEXT("",key="model");
// #C1 @SET-SYMBOL $CAPACITOR;
// #C1 @PLACE(86,-4) => @ORIENT("R0");
// #C1 @TEXT("C1",key="name",size=1.3,halign="start") => @PLACE(89,-1);
// #C1 @TEXT("nr=8 lr=2.5u w=50n multi=1",key="value",size=0.9,halign="start") => @PLACE(89,-8);
// #C1 @TEXT("",key="model");
// #MN_CLEAR @SET-SYMBOL $NMOS_4TERM;
// #MN_CLEAR @PLACE(17,-23) => @ORIENT("R0");
// #MN_CLEAR @TEXT("MN_CLEAR",key="name",size=1.3,halign="start") => @PLACE(20,-20);
// #MN_CLEAR @TEXT("l=30n w=2u multi=1",key="value",size=0.9,halign="start") => @PLACE(20,-27);
// #MN_CLEAR @TEXT("",key="model");
// #MP_CLEAR @SET-SYMBOL $PMOS_4TERM;
// #MP_CLEAR @PLACE(76,39) => @ORIENT("R0");
// #MP_CLEAR @TEXT("MP_CLEAR",key="name",size=1.3,halign="start") => @PLACE(79,42);
// #MP_CLEAR @TEXT("l=30n w=3u multi=1",key="value",size=0.9,halign="start") => @PLACE(79,35);
// #MP_CLEAR @TEXT("",key="model");
// #X006 @SET-SYMBOL $S_sar8p_inv;
// #X006 @PLACE(-14,-23) => @ORIENT("R0");
// &"RC0" @WIRE(mode="straight",linecolor="#30485d",linewidth=0.16) {(28,-21) (28,-2) (28,15)};
// &"RC0" @WIRE(mode="straight",linecolor="#30485d",linewidth=0.16) {#R0:2 (28,15)};
// $JUNCTION @ATTACH (28,15);
// &"RC0" @WIRE(mode="straight",linecolor="#30485d",linewidth=0.16) {#C0:1 (28,-2)};
// $JUNCTION @ATTACH (28,-2);
// &"RC0" @WIRE(mode="straight",linecolor="#30485d",linewidth=0.16) {#X002:1 (28,15)};
// $JUNCTION @ATTACH (28,15);
// &"RC0" @WIRE(mode="straight",linecolor="#30485d",linewidth=0.16) {#MN_CLEAR:1 (28,-21)};
// $JUNCTION @ATTACH (28,-21);
// &"RC1" @WIRE(mode="straight",linecolor="#30485d",linewidth=0.16) {(86,-2) (86,15) (86,37)};
// &"RC1" @WIRE(mode="straight",linecolor="#30485d",linewidth=0.16) {#R1:2 (86,15)};
// $JUNCTION @ATTACH (86,15);
// &"RC1" @WIRE(mode="straight",linecolor="#30485d",linewidth=0.16) {#C1:1 (86,-2)};
// $JUNCTION @ATTACH (86,-2);
// &"RC1" @WIRE(mode="straight",linecolor="#30485d",linewidth=0.16) {#X005:1 (86,15)};
// $JUNCTION @ATTACH (86,15);
// &"RC1" @WIRE(mode="straight",linecolor="#30485d",linewidth=0.16) {#MP_CLEAR:1 (86,37)};
// $JUNCTION @ATTACH (86,37);
// &"B" @WIRE(mode="straight",linecolor="#30485d",linewidth=0.16) {#X002:4 (58.5,15) (58.5,15) #R1:1};
// &"AB" @WIRE(mode="straight",linecolor="#30485d",linewidth=0.16) {#X006:4 (3.5,-23) (3.5,-23) #MN_CLEAR:2};
// (-18,-44) @TEXT("R/C values and multiplicities are read from the netlist; clear transistors are retained.",size=0.9,halign="start",textcolor="#223d52");
// &"A" @WIRE(mode="straight",linecolor="#30485d",linewidth=0.16) {#R0:1 (7,15)};
// (6.6,15) @TEXT("A",size=1.1,halign="end",valign="middle");
// &"VSS" @WIRE(mode="straight",linecolor="#30485d",linewidth=0.16) {#C1:2 (86,-9)};
// (86,-9.4) @TEXT("VSS",size=1.1,halign="middle",valign="top");
// &"VSS" @WIRE(mode="straight",linecolor="#30485d",linewidth=0.16) {#C0:2 (28,-9)};
// (28,-9.4) @TEXT("VSS",size=1.1,halign="middle",valign="top");
// &"A" @WIRE(mode="straight",linecolor="#30485d",linewidth=0.16) {#X006:1 (-24,-23)};
// (-24.4,-23) @TEXT("A",size=1.1,halign="end",valign="middle");
// &"VDD" @WIRE(mode="straight",linecolor="#30485d",linewidth=0.16) {#X006:2 (-14,-13)};
// (-14,-12.6) @TEXT("VDD",size=1.1,halign="middle",valign="bottom");
// &"VSS" @WIRE(mode="straight",linecolor="#30485d",linewidth=0.16) {#X006:3 (-14,-33)};
// (-14,-33.4) @TEXT("VSS",size=1.1,halign="middle",valign="top");
// &"VDD" @WIRE(mode="straight",linecolor="#30485d",linewidth=0.16) {#X005:2 (104,25)};
// (104,25.4) @TEXT("VDD",size=1.1,halign="middle",valign="bottom");
// &"VSS" @WIRE(mode="straight",linecolor="#30485d",linewidth=0.16) {#X005:3 (104,5)};
// (104,4.6) @TEXT("VSS",size=1.1,halign="middle",valign="top");
// &"Y" @WIRE(mode="straight",linecolor="#30485d",linewidth=0.16) {#X005:4 (114,15)};
// (114.4,15) @TEXT("Y",size=1.1,halign="start",valign="middle");
// &"VDD" @WIRE(mode="straight",linecolor="#30485d",linewidth=0.16) {#X002:2 (42,25)};
// (42,25.4) @TEXT("VDD",size=1.1,halign="middle",valign="bottom");
// &"VSS" @WIRE(mode="straight",linecolor="#30485d",linewidth=0.16) {#X002:3 (42,5)};
// (42,4.6) @TEXT("VSS",size=1.1,halign="middle",valign="top");
// &"VSS" @WIRE(mode="straight",linecolor="#30485d",linewidth=0.16) {#MN_CLEAR:3 (17,-28)};
// (17,-28.4) @TEXT("VSS",size=1.1,halign="middle",valign="top");
// &"VSS" @WIRE(mode="straight",linecolor="#30485d",linewidth=0.16) {#MN_CLEAR:4 (21,-23)};
// (21.4,-23) @TEXT("VSS",size=1.1,halign="start",valign="middle");
// &"A" @WIRE(mode="straight",linecolor="#30485d",linewidth=0.16) {#MP_CLEAR:2 (70,39)};
// (69.6,39) @TEXT("A",size=1.1,halign="end",valign="middle");
// &"VDD" @WIRE(mode="straight",linecolor="#30485d",linewidth=0.16) {#MP_CLEAR:3 (76,44)};
// (76,44.4) @TEXT("VDD",size=1.1,halign="middle",valign="bottom");
// &"VDD" @WIRE(mode="straight",linecolor="#30485d",linewidth=0.16) {#MP_CLEAR:4 (80,39)};
// (80.4,39) @TEXT("VDD",size=1.1,halign="start",valign="middle");
// }
// END SARADC RNL
ends sar8p_delay_valid

subckt sar8p_delay_write A VDD VSS Y
R1 (B RC1 ) rupolym l=17.13u w=1u m=1 multi=(1)

R0 (A RC0 ) rupolym l=17.13u w=1u m=1 multi=(1)

    C1 (RC1 VSS) cfmom_2t nr=8 lr=2.5u w=50n s=50n stm=1 spm=3 multi=4          mismatchflag=1
    C0 (RC0 VSS) cfmom_2t nr=8 lr=2.5u w=50n s=50n stm=1 spm=3 multi=4          mismatchflag=1
    X006 (A VDD VSS AB) sar8p_inv
    X005 (RC1 VDD VSS Y) sar8p_inv
    X002 (RC0 VDD VSS B) sar8p_inv
    MN_CLEAR (RC0 AB VSS VSS) nch_mac l=30n w=2u multi=1 nf=1 sd=100n          ad=1.5e-13 as=1.5e-13 pd=4.15u ps=4.15u nrd=0.144730 nrs=0.144730          sa=75.0n sb=75.0n sa1=75.0n sa2=75.0n sa3=75.0n sa4=75.0n          sb1=75.0n sb2=75.0n sb3=75.0n spa=100n spa1=100n spa2=100n          spa3=100n sap=91.9776n sapb=114.444n spba=115.715n spba1=117.043n          dfm_flag=0 spmt=1.11111e+15 spomt=0 spomt1=1.11111e+60          spmb=1.11111e+15 spomb=0 spomb1=1.11111e+60
    MP_CLEAR (RC1 A VDD VDD) pch_mac l=30n w=3u multi=1 nf=1 sd=100n          ad=2.25e-13 as=2.25e-13 pd=6.15u ps=6.15u nrd=0.055246          nrs=0.055246 sa=75.0n sb=75.0n sa1=75.0n sa2=75.0n sa3=75.0n          sa4=75.0n sb1=75.0n sb2=75.0n sb3=75.0n spa=100n spa1=100n          spa2=100n spa3=100n sap=91.9776n sapb=114.444n spba=115.715n          spba1=117.043n dfm_flag=0 spmt=1.11111e+15 spomt=0          spomt1=1.11111e+60 spmb=1.11111e+15 spomb=0 spomb1=1.11111e+60
// BEGIN SARADC RNL
// @RNL(author="saradc topology") {
// (-18,47) @TEXT("sar8p_delay_write / two RC stages with active clear",size=1.4,halign="start",textcolor="#223d52");
// #R0 @SET-SYMBOL $RESISTOR;
// #R0 @PLACE(12,15) => @ORIENT("R90");
// #R0 @TEXT("R0",key="name",size=1.3,halign="start") => @PLACE(15,18);
// #R0 @TEXT("l=17.13u w=1u multi=(1)",key="value",size=0.9,halign="start") => @PLACE(15,11);
// #R0 @TEXT("",key="model");
// #X002 @SET-SYMBOL $S_sar8p_inv;
// #X002 @PLACE(42,15) => @ORIENT("R0");
// #R1 @SET-SYMBOL $RESISTOR;
// #R1 @PLACE(70,15) => @ORIENT("R90");
// #R1 @TEXT("R1",key="name",size=1.3,halign="start") => @PLACE(73,18);
// #R1 @TEXT("l=17.13u w=1u multi=(1)",key="value",size=0.9,halign="start") => @PLACE(73,11);
// #R1 @TEXT("",key="model");
// #X005 @SET-SYMBOL $S_sar8p_inv;
// #X005 @PLACE(104,15) => @ORIENT("R0");
// #C0 @SET-SYMBOL $CAPACITOR;
// #C0 @PLACE(28,-4) => @ORIENT("R0");
// #C0 @TEXT("C0",key="name",size=1.3,halign="start") => @PLACE(31,-1);
// #C0 @TEXT("nr=8 lr=2.5u w=50n multi=4",key="value",size=0.9,halign="start") => @PLACE(31,-8);
// #C0 @TEXT("",key="model");
// #C1 @SET-SYMBOL $CAPACITOR;
// #C1 @PLACE(86,-4) => @ORIENT("R0");
// #C1 @TEXT("C1",key="name",size=1.3,halign="start") => @PLACE(89,-1);
// #C1 @TEXT("nr=8 lr=2.5u w=50n multi=4",key="value",size=0.9,halign="start") => @PLACE(89,-8);
// #C1 @TEXT("",key="model");
// #MN_CLEAR @SET-SYMBOL $NMOS_4TERM;
// #MN_CLEAR @PLACE(17,-23) => @ORIENT("R0");
// #MN_CLEAR @TEXT("MN_CLEAR",key="name",size=1.3,halign="start") => @PLACE(20,-20);
// #MN_CLEAR @TEXT("l=30n w=2u multi=1",key="value",size=0.9,halign="start") => @PLACE(20,-27);
// #MN_CLEAR @TEXT("",key="model");
// #MP_CLEAR @SET-SYMBOL $PMOS_4TERM;
// #MP_CLEAR @PLACE(76,39) => @ORIENT("R0");
// #MP_CLEAR @TEXT("MP_CLEAR",key="name",size=1.3,halign="start") => @PLACE(79,42);
// #MP_CLEAR @TEXT("l=30n w=3u multi=1",key="value",size=0.9,halign="start") => @PLACE(79,35);
// #MP_CLEAR @TEXT("",key="model");
// #X006 @SET-SYMBOL $S_sar8p_inv;
// #X006 @PLACE(-14,-23) => @ORIENT("R0");
// &"RC0" @WIRE(mode="straight",linecolor="#30485d",linewidth=0.16) {(28,-21) (28,-2) (28,15)};
// &"RC0" @WIRE(mode="straight",linecolor="#30485d",linewidth=0.16) {#R0:2 (28,15)};
// $JUNCTION @ATTACH (28,15);
// &"RC0" @WIRE(mode="straight",linecolor="#30485d",linewidth=0.16) {#C0:1 (28,-2)};
// $JUNCTION @ATTACH (28,-2);
// &"RC0" @WIRE(mode="straight",linecolor="#30485d",linewidth=0.16) {#X002:1 (28,15)};
// $JUNCTION @ATTACH (28,15);
// &"RC0" @WIRE(mode="straight",linecolor="#30485d",linewidth=0.16) {#MN_CLEAR:1 (28,-21)};
// $JUNCTION @ATTACH (28,-21);
// &"RC1" @WIRE(mode="straight",linecolor="#30485d",linewidth=0.16) {(86,-2) (86,15) (86,37)};
// &"RC1" @WIRE(mode="straight",linecolor="#30485d",linewidth=0.16) {#R1:2 (86,15)};
// $JUNCTION @ATTACH (86,15);
// &"RC1" @WIRE(mode="straight",linecolor="#30485d",linewidth=0.16) {#C1:1 (86,-2)};
// $JUNCTION @ATTACH (86,-2);
// &"RC1" @WIRE(mode="straight",linecolor="#30485d",linewidth=0.16) {#X005:1 (86,15)};
// $JUNCTION @ATTACH (86,15);
// &"RC1" @WIRE(mode="straight",linecolor="#30485d",linewidth=0.16) {#MP_CLEAR:1 (86,37)};
// $JUNCTION @ATTACH (86,37);
// &"B" @WIRE(mode="straight",linecolor="#30485d",linewidth=0.16) {#X002:4 (58.5,15) (58.5,15) #R1:1};
// &"AB" @WIRE(mode="straight",linecolor="#30485d",linewidth=0.16) {#X006:4 (3.5,-23) (3.5,-23) #MN_CLEAR:2};
// (-18,-44) @TEXT("R/C values and multiplicities are read from the netlist; clear transistors are retained.",size=0.9,halign="start",textcolor="#223d52");
// &"A" @WIRE(mode="straight",linecolor="#30485d",linewidth=0.16) {#R0:1 (7,15)};
// (6.6,15) @TEXT("A",size=1.1,halign="end",valign="middle");
// &"VSS" @WIRE(mode="straight",linecolor="#30485d",linewidth=0.16) {#C1:2 (86,-9)};
// (86,-9.4) @TEXT("VSS",size=1.1,halign="middle",valign="top");
// &"VSS" @WIRE(mode="straight",linecolor="#30485d",linewidth=0.16) {#C0:2 (28,-9)};
// (28,-9.4) @TEXT("VSS",size=1.1,halign="middle",valign="top");
// &"A" @WIRE(mode="straight",linecolor="#30485d",linewidth=0.16) {#X006:1 (-24,-23)};
// (-24.4,-23) @TEXT("A",size=1.1,halign="end",valign="middle");
// &"VDD" @WIRE(mode="straight",linecolor="#30485d",linewidth=0.16) {#X006:2 (-14,-13)};
// (-14,-12.6) @TEXT("VDD",size=1.1,halign="middle",valign="bottom");
// &"VSS" @WIRE(mode="straight",linecolor="#30485d",linewidth=0.16) {#X006:3 (-14,-33)};
// (-14,-33.4) @TEXT("VSS",size=1.1,halign="middle",valign="top");
// &"VDD" @WIRE(mode="straight",linecolor="#30485d",linewidth=0.16) {#X005:2 (104,25)};
// (104,25.4) @TEXT("VDD",size=1.1,halign="middle",valign="bottom");
// &"VSS" @WIRE(mode="straight",linecolor="#30485d",linewidth=0.16) {#X005:3 (104,5)};
// (104,4.6) @TEXT("VSS",size=1.1,halign="middle",valign="top");
// &"Y" @WIRE(mode="straight",linecolor="#30485d",linewidth=0.16) {#X005:4 (114,15)};
// (114.4,15) @TEXT("Y",size=1.1,halign="start",valign="middle");
// &"VDD" @WIRE(mode="straight",linecolor="#30485d",linewidth=0.16) {#X002:2 (42,25)};
// (42,25.4) @TEXT("VDD",size=1.1,halign="middle",valign="bottom");
// &"VSS" @WIRE(mode="straight",linecolor="#30485d",linewidth=0.16) {#X002:3 (42,5)};
// (42,4.6) @TEXT("VSS",size=1.1,halign="middle",valign="top");
// &"VSS" @WIRE(mode="straight",linecolor="#30485d",linewidth=0.16) {#MN_CLEAR:3 (17,-28)};
// (17,-28.4) @TEXT("VSS",size=1.1,halign="middle",valign="top");
// &"VSS" @WIRE(mode="straight",linecolor="#30485d",linewidth=0.16) {#MN_CLEAR:4 (21,-23)};
// (21.4,-23) @TEXT("VSS",size=1.1,halign="start",valign="middle");
// &"A" @WIRE(mode="straight",linecolor="#30485d",linewidth=0.16) {#MP_CLEAR:2 (70,39)};
// (69.6,39) @TEXT("A",size=1.1,halign="end",valign="middle");
// &"VDD" @WIRE(mode="straight",linecolor="#30485d",linewidth=0.16) {#MP_CLEAR:3 (76,44)};
// (76,44.4) @TEXT("VDD",size=1.1,halign="middle",valign="bottom");
// &"VDD" @WIRE(mode="straight",linecolor="#30485d",linewidth=0.16) {#MP_CLEAR:4 (80,39)};
// (80.4,39) @TEXT("VDD",size=1.1,halign="start",valign="middle");
// }
// END SARADC RNL
ends sar8p_delay_write

subckt sar8p_delay_quiet A VDD VSS Y
R1 (B RC1 ) rupolym l=17.13u w=1u m=1 multi=(1)

R0 (A RC0 ) rupolym l=17.13u w=1u m=1 multi=(1)

    C1 (RC1 VSS) cfmom_2t nr=8 lr=2.5u w=50n s=50n stm=1 spm=3 multi=30          mismatchflag=1
    C0 (RC0 VSS) cfmom_2t nr=8 lr=2.5u w=50n s=50n stm=1 spm=3 multi=30          mismatchflag=1
    X006 (A VDD VSS AB) sar8p_inv
    X005 (RC1 VDD VSS Y) sar8p_inv
    X002 (RC0 VDD VSS B) sar8p_inv
    MN_CLEAR (RC0 AB VSS VSS) nch_mac l=30n w=2u multi=1 nf=1 sd=100n          ad=1.5e-13 as=1.5e-13 pd=4.15u ps=4.15u nrd=0.144730 nrs=0.144730          sa=75.0n sb=75.0n sa1=75.0n sa2=75.0n sa3=75.0n sa4=75.0n          sb1=75.0n sb2=75.0n sb3=75.0n spa=100n spa1=100n spa2=100n          spa3=100n sap=91.9776n sapb=114.444n spba=115.715n spba1=117.043n          dfm_flag=0 spmt=1.11111e+15 spomt=0 spomt1=1.11111e+60          spmb=1.11111e+15 spomb=0 spomb1=1.11111e+60
    MP_CLEAR (RC1 A VDD VDD) pch_mac l=30n w=3u multi=1 nf=1 sd=100n          ad=2.25e-13 as=2.25e-13 pd=6.15u ps=6.15u nrd=0.055246          nrs=0.055246 sa=75.0n sb=75.0n sa1=75.0n sa2=75.0n sa3=75.0n          sa4=75.0n sb1=75.0n sb2=75.0n sb3=75.0n spa=100n spa1=100n          spa2=100n spa3=100n sap=91.9776n sapb=114.444n spba=115.715n          spba1=117.043n dfm_flag=0 spmt=1.11111e+15 spomt=0          spomt1=1.11111e+60 spmb=1.11111e+15 spomb=0 spomb1=1.11111e+60
// BEGIN SARADC RNL
// @RNL(author="saradc topology") {
// (-18,47) @TEXT("sar8p_delay_quiet / two RC stages with active clear",size=1.4,halign="start",textcolor="#223d52");
// #R0 @SET-SYMBOL $RESISTOR;
// #R0 @PLACE(12,15) => @ORIENT("R90");
// #R0 @TEXT("R0",key="name",size=1.3,halign="start") => @PLACE(15,18);
// #R0 @TEXT("l=17.13u w=1u multi=(1)",key="value",size=0.9,halign="start") => @PLACE(15,11);
// #R0 @TEXT("",key="model");
// #X002 @SET-SYMBOL $S_sar8p_inv;
// #X002 @PLACE(42,15) => @ORIENT("R0");
// #R1 @SET-SYMBOL $RESISTOR;
// #R1 @PLACE(70,15) => @ORIENT("R90");
// #R1 @TEXT("R1",key="name",size=1.3,halign="start") => @PLACE(73,18);
// #R1 @TEXT("l=17.13u w=1u multi=(1)",key="value",size=0.9,halign="start") => @PLACE(73,11);
// #R1 @TEXT("",key="model");
// #X005 @SET-SYMBOL $S_sar8p_inv;
// #X005 @PLACE(104,15) => @ORIENT("R0");
// #C0 @SET-SYMBOL $CAPACITOR;
// #C0 @PLACE(28,-4) => @ORIENT("R0");
// #C0 @TEXT("C0",key="name",size=1.3,halign="start") => @PLACE(31,-1);
// #C0 @TEXT("nr=8 lr=2.5u w=50n multi=30",key="value",size=0.9,halign="start") => @PLACE(31,-8);
// #C0 @TEXT("",key="model");
// #C1 @SET-SYMBOL $CAPACITOR;
// #C1 @PLACE(86,-4) => @ORIENT("R0");
// #C1 @TEXT("C1",key="name",size=1.3,halign="start") => @PLACE(89,-1);
// #C1 @TEXT("nr=8 lr=2.5u w=50n multi=30",key="value",size=0.9,halign="start") => @PLACE(89,-8);
// #C1 @TEXT("",key="model");
// #MN_CLEAR @SET-SYMBOL $NMOS_4TERM;
// #MN_CLEAR @PLACE(17,-23) => @ORIENT("R0");
// #MN_CLEAR @TEXT("MN_CLEAR",key="name",size=1.3,halign="start") => @PLACE(20,-20);
// #MN_CLEAR @TEXT("l=30n w=2u multi=1",key="value",size=0.9,halign="start") => @PLACE(20,-27);
// #MN_CLEAR @TEXT("",key="model");
// #MP_CLEAR @SET-SYMBOL $PMOS_4TERM;
// #MP_CLEAR @PLACE(76,39) => @ORIENT("R0");
// #MP_CLEAR @TEXT("MP_CLEAR",key="name",size=1.3,halign="start") => @PLACE(79,42);
// #MP_CLEAR @TEXT("l=30n w=3u multi=1",key="value",size=0.9,halign="start") => @PLACE(79,35);
// #MP_CLEAR @TEXT("",key="model");
// #X006 @SET-SYMBOL $S_sar8p_inv;
// #X006 @PLACE(-14,-23) => @ORIENT("R0");
// &"RC0" @WIRE(mode="straight",linecolor="#30485d",linewidth=0.16) {(28,-21) (28,-2) (28,15)};
// &"RC0" @WIRE(mode="straight",linecolor="#30485d",linewidth=0.16) {#R0:2 (28,15)};
// $JUNCTION @ATTACH (28,15);
// &"RC0" @WIRE(mode="straight",linecolor="#30485d",linewidth=0.16) {#C0:1 (28,-2)};
// $JUNCTION @ATTACH (28,-2);
// &"RC0" @WIRE(mode="straight",linecolor="#30485d",linewidth=0.16) {#X002:1 (28,15)};
// $JUNCTION @ATTACH (28,15);
// &"RC0" @WIRE(mode="straight",linecolor="#30485d",linewidth=0.16) {#MN_CLEAR:1 (28,-21)};
// $JUNCTION @ATTACH (28,-21);
// &"RC1" @WIRE(mode="straight",linecolor="#30485d",linewidth=0.16) {(86,-2) (86,15) (86,37)};
// &"RC1" @WIRE(mode="straight",linecolor="#30485d",linewidth=0.16) {#R1:2 (86,15)};
// $JUNCTION @ATTACH (86,15);
// &"RC1" @WIRE(mode="straight",linecolor="#30485d",linewidth=0.16) {#C1:1 (86,-2)};
// $JUNCTION @ATTACH (86,-2);
// &"RC1" @WIRE(mode="straight",linecolor="#30485d",linewidth=0.16) {#X005:1 (86,15)};
// $JUNCTION @ATTACH (86,15);
// &"RC1" @WIRE(mode="straight",linecolor="#30485d",linewidth=0.16) {#MP_CLEAR:1 (86,37)};
// $JUNCTION @ATTACH (86,37);
// &"B" @WIRE(mode="straight",linecolor="#30485d",linewidth=0.16) {#X002:4 (58.5,15) (58.5,15) #R1:1};
// &"AB" @WIRE(mode="straight",linecolor="#30485d",linewidth=0.16) {#X006:4 (3.5,-23) (3.5,-23) #MN_CLEAR:2};
// (-18,-44) @TEXT("R/C values and multiplicities are read from the netlist; clear transistors are retained.",size=0.9,halign="start",textcolor="#223d52");
// &"A" @WIRE(mode="straight",linecolor="#30485d",linewidth=0.16) {#R0:1 (7,15)};
// (6.6,15) @TEXT("A",size=1.1,halign="end",valign="middle");
// &"VSS" @WIRE(mode="straight",linecolor="#30485d",linewidth=0.16) {#C1:2 (86,-9)};
// (86,-9.4) @TEXT("VSS",size=1.1,halign="middle",valign="top");
// &"VSS" @WIRE(mode="straight",linecolor="#30485d",linewidth=0.16) {#C0:2 (28,-9)};
// (28,-9.4) @TEXT("VSS",size=1.1,halign="middle",valign="top");
// &"A" @WIRE(mode="straight",linecolor="#30485d",linewidth=0.16) {#X006:1 (-24,-23)};
// (-24.4,-23) @TEXT("A",size=1.1,halign="end",valign="middle");
// &"VDD" @WIRE(mode="straight",linecolor="#30485d",linewidth=0.16) {#X006:2 (-14,-13)};
// (-14,-12.6) @TEXT("VDD",size=1.1,halign="middle",valign="bottom");
// &"VSS" @WIRE(mode="straight",linecolor="#30485d",linewidth=0.16) {#X006:3 (-14,-33)};
// (-14,-33.4) @TEXT("VSS",size=1.1,halign="middle",valign="top");
// &"VDD" @WIRE(mode="straight",linecolor="#30485d",linewidth=0.16) {#X005:2 (104,25)};
// (104,25.4) @TEXT("VDD",size=1.1,halign="middle",valign="bottom");
// &"VSS" @WIRE(mode="straight",linecolor="#30485d",linewidth=0.16) {#X005:3 (104,5)};
// (104,4.6) @TEXT("VSS",size=1.1,halign="middle",valign="top");
// &"Y" @WIRE(mode="straight",linecolor="#30485d",linewidth=0.16) {#X005:4 (114,15)};
// (114.4,15) @TEXT("Y",size=1.1,halign="start",valign="middle");
// &"VDD" @WIRE(mode="straight",linecolor="#30485d",linewidth=0.16) {#X002:2 (42,25)};
// (42,25.4) @TEXT("VDD",size=1.1,halign="middle",valign="bottom");
// &"VSS" @WIRE(mode="straight",linecolor="#30485d",linewidth=0.16) {#X002:3 (42,5)};
// (42,4.6) @TEXT("VSS",size=1.1,halign="middle",valign="top");
// &"VSS" @WIRE(mode="straight",linecolor="#30485d",linewidth=0.16) {#MN_CLEAR:3 (17,-28)};
// (17,-28.4) @TEXT("VSS",size=1.1,halign="middle",valign="top");
// &"VSS" @WIRE(mode="straight",linecolor="#30485d",linewidth=0.16) {#MN_CLEAR:4 (21,-23)};
// (21.4,-23) @TEXT("VSS",size=1.1,halign="start",valign="middle");
// &"A" @WIRE(mode="straight",linecolor="#30485d",linewidth=0.16) {#MP_CLEAR:2 (70,39)};
// (69.6,39) @TEXT("A",size=1.1,halign="end",valign="middle");
// &"VDD" @WIRE(mode="straight",linecolor="#30485d",linewidth=0.16) {#MP_CLEAR:3 (76,44)};
// (76,44.4) @TEXT("VDD",size=1.1,halign="middle",valign="bottom");
// &"VDD" @WIRE(mode="straight",linecolor="#30485d",linewidth=0.16) {#MP_CLEAR:4 (80,39)};
// (80.4,39) @TEXT("VDD",size=1.1,halign="start",valign="middle");
// }
// END SARADC RNL
ends sar8p_delay_quiet

subckt sar8p_delay_capture A VDD VSS Y
R1 (B RC1 ) rupolym l=17.13u w=1u m=1 multi=(1)

R0 (A RC0 ) rupolym l=17.13u w=1u m=1 multi=(1)

    C1 (RC1 VSS) cfmom_2t nr=8 lr=2.5u w=50n s=50n stm=1 spm=3 multi=10          mismatchflag=1
    C0 (RC0 VSS) cfmom_2t nr=8 lr=2.5u w=50n s=50n stm=1 spm=3 multi=10          mismatchflag=1
    X006 (A VDD VSS AB) sar8p_inv
    X005 (RC1 VDD VSS Y) sar8p_inv
    X002 (RC0 VDD VSS B) sar8p_inv
    MN_CLEAR (RC0 AB VSS VSS) nch_mac l=30n w=2u multi=1 nf=1 sd=100n          ad=1.5e-13 as=1.5e-13 pd=4.15u ps=4.15u nrd=0.144730 nrs=0.144730          sa=75.0n sb=75.0n sa1=75.0n sa2=75.0n sa3=75.0n sa4=75.0n          sb1=75.0n sb2=75.0n sb3=75.0n spa=100n spa1=100n spa2=100n          spa3=100n sap=91.9776n sapb=114.444n spba=115.715n spba1=117.043n          dfm_flag=0 spmt=1.11111e+15 spomt=0 spomt1=1.11111e+60          spmb=1.11111e+15 spomb=0 spomb1=1.11111e+60
    MP_CLEAR (RC1 A VDD VDD) pch_mac l=30n w=3u multi=1 nf=1 sd=100n          ad=2.25e-13 as=2.25e-13 pd=6.15u ps=6.15u nrd=0.055246          nrs=0.055246 sa=75.0n sb=75.0n sa1=75.0n sa2=75.0n sa3=75.0n          sa4=75.0n sb1=75.0n sb2=75.0n sb3=75.0n spa=100n spa1=100n          spa2=100n spa3=100n sap=91.9776n sapb=114.444n spba=115.715n          spba1=117.043n dfm_flag=0 spmt=1.11111e+15 spomt=0          spomt1=1.11111e+60 spmb=1.11111e+15 spomb=0 spomb1=1.11111e+60
// BEGIN SARADC RNL
// @RNL(author="saradc topology") {
// (-18,47) @TEXT("sar8p_delay_capture / two RC stages with active clear",size=1.4,halign="start",textcolor="#223d52");
// #R0 @SET-SYMBOL $RESISTOR;
// #R0 @PLACE(12,15) => @ORIENT("R90");
// #R0 @TEXT("R0",key="name",size=1.3,halign="start") => @PLACE(15,18);
// #R0 @TEXT("l=17.13u w=1u multi=(1)",key="value",size=0.9,halign="start") => @PLACE(15,11);
// #R0 @TEXT("",key="model");
// #X002 @SET-SYMBOL $S_sar8p_inv;
// #X002 @PLACE(42,15) => @ORIENT("R0");
// #R1 @SET-SYMBOL $RESISTOR;
// #R1 @PLACE(70,15) => @ORIENT("R90");
// #R1 @TEXT("R1",key="name",size=1.3,halign="start") => @PLACE(73,18);
// #R1 @TEXT("l=17.13u w=1u multi=(1)",key="value",size=0.9,halign="start") => @PLACE(73,11);
// #R1 @TEXT("",key="model");
// #X005 @SET-SYMBOL $S_sar8p_inv;
// #X005 @PLACE(104,15) => @ORIENT("R0");
// #C0 @SET-SYMBOL $CAPACITOR;
// #C0 @PLACE(28,-4) => @ORIENT("R0");
// #C0 @TEXT("C0",key="name",size=1.3,halign="start") => @PLACE(31,-1);
// #C0 @TEXT("nr=8 lr=2.5u w=50n multi=10",key="value",size=0.9,halign="start") => @PLACE(31,-8);
// #C0 @TEXT("",key="model");
// #C1 @SET-SYMBOL $CAPACITOR;
// #C1 @PLACE(86,-4) => @ORIENT("R0");
// #C1 @TEXT("C1",key="name",size=1.3,halign="start") => @PLACE(89,-1);
// #C1 @TEXT("nr=8 lr=2.5u w=50n multi=10",key="value",size=0.9,halign="start") => @PLACE(89,-8);
// #C1 @TEXT("",key="model");
// #MN_CLEAR @SET-SYMBOL $NMOS_4TERM;
// #MN_CLEAR @PLACE(17,-23) => @ORIENT("R0");
// #MN_CLEAR @TEXT("MN_CLEAR",key="name",size=1.3,halign="start") => @PLACE(20,-20);
// #MN_CLEAR @TEXT("l=30n w=2u multi=1",key="value",size=0.9,halign="start") => @PLACE(20,-27);
// #MN_CLEAR @TEXT("",key="model");
// #MP_CLEAR @SET-SYMBOL $PMOS_4TERM;
// #MP_CLEAR @PLACE(76,39) => @ORIENT("R0");
// #MP_CLEAR @TEXT("MP_CLEAR",key="name",size=1.3,halign="start") => @PLACE(79,42);
// #MP_CLEAR @TEXT("l=30n w=3u multi=1",key="value",size=0.9,halign="start") => @PLACE(79,35);
// #MP_CLEAR @TEXT("",key="model");
// #X006 @SET-SYMBOL $S_sar8p_inv;
// #X006 @PLACE(-14,-23) => @ORIENT("R0");
// &"RC0" @WIRE(mode="straight",linecolor="#30485d",linewidth=0.16) {(28,-21) (28,-2) (28,15)};
// &"RC0" @WIRE(mode="straight",linecolor="#30485d",linewidth=0.16) {#R0:2 (28,15)};
// $JUNCTION @ATTACH (28,15);
// &"RC0" @WIRE(mode="straight",linecolor="#30485d",linewidth=0.16) {#C0:1 (28,-2)};
// $JUNCTION @ATTACH (28,-2);
// &"RC0" @WIRE(mode="straight",linecolor="#30485d",linewidth=0.16) {#X002:1 (28,15)};
// $JUNCTION @ATTACH (28,15);
// &"RC0" @WIRE(mode="straight",linecolor="#30485d",linewidth=0.16) {#MN_CLEAR:1 (28,-21)};
// $JUNCTION @ATTACH (28,-21);
// &"RC1" @WIRE(mode="straight",linecolor="#30485d",linewidth=0.16) {(86,-2) (86,15) (86,37)};
// &"RC1" @WIRE(mode="straight",linecolor="#30485d",linewidth=0.16) {#R1:2 (86,15)};
// $JUNCTION @ATTACH (86,15);
// &"RC1" @WIRE(mode="straight",linecolor="#30485d",linewidth=0.16) {#C1:1 (86,-2)};
// $JUNCTION @ATTACH (86,-2);
// &"RC1" @WIRE(mode="straight",linecolor="#30485d",linewidth=0.16) {#X005:1 (86,15)};
// $JUNCTION @ATTACH (86,15);
// &"RC1" @WIRE(mode="straight",linecolor="#30485d",linewidth=0.16) {#MP_CLEAR:1 (86,37)};
// $JUNCTION @ATTACH (86,37);
// &"B" @WIRE(mode="straight",linecolor="#30485d",linewidth=0.16) {#X002:4 (58.5,15) (58.5,15) #R1:1};
// &"AB" @WIRE(mode="straight",linecolor="#30485d",linewidth=0.16) {#X006:4 (3.5,-23) (3.5,-23) #MN_CLEAR:2};
// (-18,-44) @TEXT("R/C values and multiplicities are read from the netlist; clear transistors are retained.",size=0.9,halign="start",textcolor="#223d52");
// &"A" @WIRE(mode="straight",linecolor="#30485d",linewidth=0.16) {#R0:1 (7,15)};
// (6.6,15) @TEXT("A",size=1.1,halign="end",valign="middle");
// &"VSS" @WIRE(mode="straight",linecolor="#30485d",linewidth=0.16) {#C1:2 (86,-9)};
// (86,-9.4) @TEXT("VSS",size=1.1,halign="middle",valign="top");
// &"VSS" @WIRE(mode="straight",linecolor="#30485d",linewidth=0.16) {#C0:2 (28,-9)};
// (28,-9.4) @TEXT("VSS",size=1.1,halign="middle",valign="top");
// &"A" @WIRE(mode="straight",linecolor="#30485d",linewidth=0.16) {#X006:1 (-24,-23)};
// (-24.4,-23) @TEXT("A",size=1.1,halign="end",valign="middle");
// &"VDD" @WIRE(mode="straight",linecolor="#30485d",linewidth=0.16) {#X006:2 (-14,-13)};
// (-14,-12.6) @TEXT("VDD",size=1.1,halign="middle",valign="bottom");
// &"VSS" @WIRE(mode="straight",linecolor="#30485d",linewidth=0.16) {#X006:3 (-14,-33)};
// (-14,-33.4) @TEXT("VSS",size=1.1,halign="middle",valign="top");
// &"VDD" @WIRE(mode="straight",linecolor="#30485d",linewidth=0.16) {#X005:2 (104,25)};
// (104,25.4) @TEXT("VDD",size=1.1,halign="middle",valign="bottom");
// &"VSS" @WIRE(mode="straight",linecolor="#30485d",linewidth=0.16) {#X005:3 (104,5)};
// (104,4.6) @TEXT("VSS",size=1.1,halign="middle",valign="top");
// &"Y" @WIRE(mode="straight",linecolor="#30485d",linewidth=0.16) {#X005:4 (114,15)};
// (114.4,15) @TEXT("Y",size=1.1,halign="start",valign="middle");
// &"VDD" @WIRE(mode="straight",linecolor="#30485d",linewidth=0.16) {#X002:2 (42,25)};
// (42,25.4) @TEXT("VDD",size=1.1,halign="middle",valign="bottom");
// &"VSS" @WIRE(mode="straight",linecolor="#30485d",linewidth=0.16) {#X002:3 (42,5)};
// (42,4.6) @TEXT("VSS",size=1.1,halign="middle",valign="top");
// &"VSS" @WIRE(mode="straight",linecolor="#30485d",linewidth=0.16) {#MN_CLEAR:3 (17,-28)};
// (17,-28.4) @TEXT("VSS",size=1.1,halign="middle",valign="top");
// &"VSS" @WIRE(mode="straight",linecolor="#30485d",linewidth=0.16) {#MN_CLEAR:4 (21,-23)};
// (21.4,-23) @TEXT("VSS",size=1.1,halign="start",valign="middle");
// &"A" @WIRE(mode="straight",linecolor="#30485d",linewidth=0.16) {#MP_CLEAR:2 (70,39)};
// (69.6,39) @TEXT("A",size=1.1,halign="end",valign="middle");
// &"VDD" @WIRE(mode="straight",linecolor="#30485d",linewidth=0.16) {#MP_CLEAR:3 (76,44)};
// (76,44.4) @TEXT("VDD",size=1.1,halign="middle",valign="bottom");
// &"VDD" @WIRE(mode="straight",linecolor="#30485d",linewidth=0.16) {#MP_CLEAR:4 (80,39)};
// (80.4,39) @TEXT("VDD",size=1.1,halign="start",valign="middle");
// }
// END SARADC RNL
ends sar8p_delay_capture

subckt sar8p_delay_bbm A VDD VSS Y
R1 (B RC1 ) rupolym l=17.13u w=1u m=1 multi=(1)

R0 (A RC0 ) rupolym l=17.13u w=1u m=1 multi=(1)

    C1 (RC1 VSS) cfmom_2t nr=8 lr=2.5u w=50n s=50n stm=1 spm=3 multi=1          mismatchflag=1
    C0 (RC0 VSS) cfmom_2t nr=8 lr=2.5u w=50n s=50n stm=1 spm=3 multi=1          mismatchflag=1
    X006 (A VDD VSS AB) sar8p_inv
    X005 (RC1 VDD VSS Y) sar8p_inv
    X002 (RC0 VDD VSS B) sar8p_inv
    MN_CLEAR (RC0 AB VSS VSS) nch_mac l=30n w=2u multi=1 nf=1 sd=100n          ad=1.5e-13 as=1.5e-13 pd=4.15u ps=4.15u nrd=0.144730 nrs=0.144730          sa=75.0n sb=75.0n sa1=75.0n sa2=75.0n sa3=75.0n sa4=75.0n          sb1=75.0n sb2=75.0n sb3=75.0n spa=100n spa1=100n spa2=100n          spa3=100n sap=91.9776n sapb=114.444n spba=115.715n spba1=117.043n          dfm_flag=0 spmt=1.11111e+15 spomt=0 spomt1=1.11111e+60          spmb=1.11111e+15 spomb=0 spomb1=1.11111e+60
    MP_CLEAR (RC1 A VDD VDD) pch_mac l=30n w=3u multi=1 nf=1 sd=100n          ad=2.25e-13 as=2.25e-13 pd=6.15u ps=6.15u nrd=0.055246          nrs=0.055246 sa=75.0n sb=75.0n sa1=75.0n sa2=75.0n sa3=75.0n          sa4=75.0n sb1=75.0n sb2=75.0n sb3=75.0n spa=100n spa1=100n          spa2=100n spa3=100n sap=91.9776n sapb=114.444n spba=115.715n          spba1=117.043n dfm_flag=0 spmt=1.11111e+15 spomt=0          spomt1=1.11111e+60 spmb=1.11111e+15 spomb=0 spomb1=1.11111e+60
// BEGIN SARADC RNL
// @RNL(author="saradc topology") {
// (-18,47) @TEXT("sar8p_delay_bbm / two RC stages with active clear",size=1.4,halign="start",textcolor="#223d52");
// #R0 @SET-SYMBOL $RESISTOR;
// #R0 @PLACE(12,15) => @ORIENT("R90");
// #R0 @TEXT("R0",key="name",size=1.3,halign="start") => @PLACE(15,18);
// #R0 @TEXT("l=17.13u w=1u multi=(1)",key="value",size=0.9,halign="start") => @PLACE(15,11);
// #R0 @TEXT("",key="model");
// #X002 @SET-SYMBOL $S_sar8p_inv;
// #X002 @PLACE(42,15) => @ORIENT("R0");
// #R1 @SET-SYMBOL $RESISTOR;
// #R1 @PLACE(70,15) => @ORIENT("R90");
// #R1 @TEXT("R1",key="name",size=1.3,halign="start") => @PLACE(73,18);
// #R1 @TEXT("l=17.13u w=1u multi=(1)",key="value",size=0.9,halign="start") => @PLACE(73,11);
// #R1 @TEXT("",key="model");
// #X005 @SET-SYMBOL $S_sar8p_inv;
// #X005 @PLACE(104,15) => @ORIENT("R0");
// #C0 @SET-SYMBOL $CAPACITOR;
// #C0 @PLACE(28,-4) => @ORIENT("R0");
// #C0 @TEXT("C0",key="name",size=1.3,halign="start") => @PLACE(31,-1);
// #C0 @TEXT("nr=8 lr=2.5u w=50n multi=1",key="value",size=0.9,halign="start") => @PLACE(31,-8);
// #C0 @TEXT("",key="model");
// #C1 @SET-SYMBOL $CAPACITOR;
// #C1 @PLACE(86,-4) => @ORIENT("R0");
// #C1 @TEXT("C1",key="name",size=1.3,halign="start") => @PLACE(89,-1);
// #C1 @TEXT("nr=8 lr=2.5u w=50n multi=1",key="value",size=0.9,halign="start") => @PLACE(89,-8);
// #C1 @TEXT("",key="model");
// #MN_CLEAR @SET-SYMBOL $NMOS_4TERM;
// #MN_CLEAR @PLACE(17,-23) => @ORIENT("R0");
// #MN_CLEAR @TEXT("MN_CLEAR",key="name",size=1.3,halign="start") => @PLACE(20,-20);
// #MN_CLEAR @TEXT("l=30n w=2u multi=1",key="value",size=0.9,halign="start") => @PLACE(20,-27);
// #MN_CLEAR @TEXT("",key="model");
// #MP_CLEAR @SET-SYMBOL $PMOS_4TERM;
// #MP_CLEAR @PLACE(76,39) => @ORIENT("R0");
// #MP_CLEAR @TEXT("MP_CLEAR",key="name",size=1.3,halign="start") => @PLACE(79,42);
// #MP_CLEAR @TEXT("l=30n w=3u multi=1",key="value",size=0.9,halign="start") => @PLACE(79,35);
// #MP_CLEAR @TEXT("",key="model");
// #X006 @SET-SYMBOL $S_sar8p_inv;
// #X006 @PLACE(-14,-23) => @ORIENT("R0");
// &"RC0" @WIRE(mode="straight",linecolor="#30485d",linewidth=0.16) {(28,-21) (28,-2) (28,15)};
// &"RC0" @WIRE(mode="straight",linecolor="#30485d",linewidth=0.16) {#R0:2 (28,15)};
// $JUNCTION @ATTACH (28,15);
// &"RC0" @WIRE(mode="straight",linecolor="#30485d",linewidth=0.16) {#C0:1 (28,-2)};
// $JUNCTION @ATTACH (28,-2);
// &"RC0" @WIRE(mode="straight",linecolor="#30485d",linewidth=0.16) {#X002:1 (28,15)};
// $JUNCTION @ATTACH (28,15);
// &"RC0" @WIRE(mode="straight",linecolor="#30485d",linewidth=0.16) {#MN_CLEAR:1 (28,-21)};
// $JUNCTION @ATTACH (28,-21);
// &"RC1" @WIRE(mode="straight",linecolor="#30485d",linewidth=0.16) {(86,-2) (86,15) (86,37)};
// &"RC1" @WIRE(mode="straight",linecolor="#30485d",linewidth=0.16) {#R1:2 (86,15)};
// $JUNCTION @ATTACH (86,15);
// &"RC1" @WIRE(mode="straight",linecolor="#30485d",linewidth=0.16) {#C1:1 (86,-2)};
// $JUNCTION @ATTACH (86,-2);
// &"RC1" @WIRE(mode="straight",linecolor="#30485d",linewidth=0.16) {#X005:1 (86,15)};
// $JUNCTION @ATTACH (86,15);
// &"RC1" @WIRE(mode="straight",linecolor="#30485d",linewidth=0.16) {#MP_CLEAR:1 (86,37)};
// $JUNCTION @ATTACH (86,37);
// &"B" @WIRE(mode="straight",linecolor="#30485d",linewidth=0.16) {#X002:4 (58.5,15) (58.5,15) #R1:1};
// &"AB" @WIRE(mode="straight",linecolor="#30485d",linewidth=0.16) {#X006:4 (3.5,-23) (3.5,-23) #MN_CLEAR:2};
// (-18,-44) @TEXT("R/C values and multiplicities are read from the netlist; clear transistors are retained.",size=0.9,halign="start",textcolor="#223d52");
// &"A" @WIRE(mode="straight",linecolor="#30485d",linewidth=0.16) {#R0:1 (7,15)};
// (6.6,15) @TEXT("A",size=1.1,halign="end",valign="middle");
// &"VSS" @WIRE(mode="straight",linecolor="#30485d",linewidth=0.16) {#C1:2 (86,-9)};
// (86,-9.4) @TEXT("VSS",size=1.1,halign="middle",valign="top");
// &"VSS" @WIRE(mode="straight",linecolor="#30485d",linewidth=0.16) {#C0:2 (28,-9)};
// (28,-9.4) @TEXT("VSS",size=1.1,halign="middle",valign="top");
// &"A" @WIRE(mode="straight",linecolor="#30485d",linewidth=0.16) {#X006:1 (-24,-23)};
// (-24.4,-23) @TEXT("A",size=1.1,halign="end",valign="middle");
// &"VDD" @WIRE(mode="straight",linecolor="#30485d",linewidth=0.16) {#X006:2 (-14,-13)};
// (-14,-12.6) @TEXT("VDD",size=1.1,halign="middle",valign="bottom");
// &"VSS" @WIRE(mode="straight",linecolor="#30485d",linewidth=0.16) {#X006:3 (-14,-33)};
// (-14,-33.4) @TEXT("VSS",size=1.1,halign="middle",valign="top");
// &"VDD" @WIRE(mode="straight",linecolor="#30485d",linewidth=0.16) {#X005:2 (104,25)};
// (104,25.4) @TEXT("VDD",size=1.1,halign="middle",valign="bottom");
// &"VSS" @WIRE(mode="straight",linecolor="#30485d",linewidth=0.16) {#X005:3 (104,5)};
// (104,4.6) @TEXT("VSS",size=1.1,halign="middle",valign="top");
// &"Y" @WIRE(mode="straight",linecolor="#30485d",linewidth=0.16) {#X005:4 (114,15)};
// (114.4,15) @TEXT("Y",size=1.1,halign="start",valign="middle");
// &"VDD" @WIRE(mode="straight",linecolor="#30485d",linewidth=0.16) {#X002:2 (42,25)};
// (42,25.4) @TEXT("VDD",size=1.1,halign="middle",valign="bottom");
// &"VSS" @WIRE(mode="straight",linecolor="#30485d",linewidth=0.16) {#X002:3 (42,5)};
// (42,4.6) @TEXT("VSS",size=1.1,halign="middle",valign="top");
// &"VSS" @WIRE(mode="straight",linecolor="#30485d",linewidth=0.16) {#MN_CLEAR:3 (17,-28)};
// (17,-28.4) @TEXT("VSS",size=1.1,halign="middle",valign="top");
// &"VSS" @WIRE(mode="straight",linecolor="#30485d",linewidth=0.16) {#MN_CLEAR:4 (21,-23)};
// (21.4,-23) @TEXT("VSS",size=1.1,halign="start",valign="middle");
// &"A" @WIRE(mode="straight",linecolor="#30485d",linewidth=0.16) {#MP_CLEAR:2 (70,39)};
// (69.6,39) @TEXT("A",size=1.1,halign="end",valign="middle");
// &"VDD" @WIRE(mode="straight",linecolor="#30485d",linewidth=0.16) {#MP_CLEAR:3 (76,44)};
// (76,44.4) @TEXT("VDD",size=1.1,halign="middle",valign="bottom");
// &"VDD" @WIRE(mode="straight",linecolor="#30485d",linewidth=0.16) {#MP_CLEAR:4 (80,39)};
// (80.4,39) @TEXT("VDD",size=1.1,halign="start",valign="middle");
// }
// END SARADC RNL
ends sar8p_delay_bbm

subckt sar8r_delay A VDD VSS Y
R1 (B RC1 ) rupolym l=17.13u w=1u m=1 multi=(1)

R0 (A RC0 ) rupolym l=17.13u w=1u m=1 multi=(1)

    C1 (RC1 VSS) cfmom_2t nr=8 lr=2.5u w=50n s=50n stm=1 spm=3 multi=20  mismatchflag=1
    C0 (RC0 VSS) cfmom_2t nr=8 lr=2.5u w=50n s=50n stm=1 spm=3 multi=20  mismatchflag=1
    X006 (A VDD VSS AB) sar8p_inv
    X005 (RC1 VDD VSS Y) sar8p_inv
    X002 (RC0 VDD VSS B) sar8p_inv
    MN_CLEAR (RC0 AB VSS VSS) nch_mac l=30n w=2u multi=1 nf=1 sd=100n  ad=1.5e-13 as=1.5e-13 pd=4.15u ps=4.15u nrd=0.144730 nrs=0.144730  sa=75.0n sb=75.0n sa1=75.0n sa2=75.0n sa3=75.0n sa4=75.0n  sb1=75.0n sb2=75.0n sb3=75.0n spa=100n spa1=100n spa2=100n  spa3=100n sap=91.9776n sapb=114.444n spba=115.715n spba1=117.043n  dfm_flag=0 spmt=1.11111e+15 spomt=0 spomt1=1.11111e+60  spmb=1.11111e+15 spomb=0 spomb1=1.11111e+60
    MP_CLEAR (RC1 A VDD VDD) pch_mac l=30n w=3u multi=1 nf=1 sd=100n  ad=2.25e-13 as=2.25e-13 pd=6.15u ps=6.15u nrd=0.055246  nrs=0.055246 sa=75.0n sb=75.0n sa1=75.0n sa2=75.0n sa3=75.0n  sa4=75.0n sb1=75.0n sb2=75.0n sb3=75.0n spa=100n spa1=100n  spa2=100n spa3=100n sap=91.9776n sapb=114.444n spba=115.715n  spba1=117.043n dfm_flag=0 spmt=1.11111e+15 spomt=0  spomt1=1.11111e+60 spmb=1.11111e+15 spomb=0 spomb1=1.11111e+60
// BEGIN SARADC RNL
// @RNL(author="saradc topology") {
// (-18,47) @TEXT("sar8r_delay / two RC stages with active clear",size=1.4,halign="start",textcolor="#223d52");
// #R0 @SET-SYMBOL $RESISTOR;
// #R0 @PLACE(12,15) => @ORIENT("R90");
// #R0 @TEXT("R0",key="name",size=1.3,halign="start") => @PLACE(15,18);
// #R0 @TEXT("l=17.13u w=1u multi=(1)",key="value",size=0.9,halign="start") => @PLACE(15,11);
// #R0 @TEXT("",key="model");
// #X002 @SET-SYMBOL $S_sar8p_inv;
// #X002 @PLACE(42,15) => @ORIENT("R0");
// #R1 @SET-SYMBOL $RESISTOR;
// #R1 @PLACE(70,15) => @ORIENT("R90");
// #R1 @TEXT("R1",key="name",size=1.3,halign="start") => @PLACE(73,18);
// #R1 @TEXT("l=17.13u w=1u multi=(1)",key="value",size=0.9,halign="start") => @PLACE(73,11);
// #R1 @TEXT("",key="model");
// #X005 @SET-SYMBOL $S_sar8p_inv;
// #X005 @PLACE(104,15) => @ORIENT("R0");
// #C0 @SET-SYMBOL $CAPACITOR;
// #C0 @PLACE(28,-4) => @ORIENT("R0");
// #C0 @TEXT("C0",key="name",size=1.3,halign="start") => @PLACE(31,-1);
// #C0 @TEXT("nr=8 lr=2.5u w=50n multi=20",key="value",size=0.9,halign="start") => @PLACE(31,-8);
// #C0 @TEXT("",key="model");
// #C1 @SET-SYMBOL $CAPACITOR;
// #C1 @PLACE(86,-4) => @ORIENT("R0");
// #C1 @TEXT("C1",key="name",size=1.3,halign="start") => @PLACE(89,-1);
// #C1 @TEXT("nr=8 lr=2.5u w=50n multi=20",key="value",size=0.9,halign="start") => @PLACE(89,-8);
// #C1 @TEXT("",key="model");
// #MN_CLEAR @SET-SYMBOL $NMOS_4TERM;
// #MN_CLEAR @PLACE(17,-23) => @ORIENT("R0");
// #MN_CLEAR @TEXT("MN_CLEAR",key="name",size=1.3,halign="start") => @PLACE(20,-20);
// #MN_CLEAR @TEXT("l=30n w=2u multi=1",key="value",size=0.9,halign="start") => @PLACE(20,-27);
// #MN_CLEAR @TEXT("",key="model");
// #MP_CLEAR @SET-SYMBOL $PMOS_4TERM;
// #MP_CLEAR @PLACE(76,39) => @ORIENT("R0");
// #MP_CLEAR @TEXT("MP_CLEAR",key="name",size=1.3,halign="start") => @PLACE(79,42);
// #MP_CLEAR @TEXT("l=30n w=3u multi=1",key="value",size=0.9,halign="start") => @PLACE(79,35);
// #MP_CLEAR @TEXT("",key="model");
// #X006 @SET-SYMBOL $S_sar8p_inv;
// #X006 @PLACE(-14,-23) => @ORIENT("R0");
// &"RC0" @WIRE(mode="straight",linecolor="#30485d",linewidth=0.16) {(28,-21) (28,-2) (28,15)};
// &"RC0" @WIRE(mode="straight",linecolor="#30485d",linewidth=0.16) {#R0:2 (28,15)};
// $JUNCTION @ATTACH (28,15);
// &"RC0" @WIRE(mode="straight",linecolor="#30485d",linewidth=0.16) {#C0:1 (28,-2)};
// $JUNCTION @ATTACH (28,-2);
// &"RC0" @WIRE(mode="straight",linecolor="#30485d",linewidth=0.16) {#X002:1 (28,15)};
// $JUNCTION @ATTACH (28,15);
// &"RC0" @WIRE(mode="straight",linecolor="#30485d",linewidth=0.16) {#MN_CLEAR:1 (28,-21)};
// $JUNCTION @ATTACH (28,-21);
// &"RC1" @WIRE(mode="straight",linecolor="#30485d",linewidth=0.16) {(86,-2) (86,15) (86,37)};
// &"RC1" @WIRE(mode="straight",linecolor="#30485d",linewidth=0.16) {#R1:2 (86,15)};
// $JUNCTION @ATTACH (86,15);
// &"RC1" @WIRE(mode="straight",linecolor="#30485d",linewidth=0.16) {#C1:1 (86,-2)};
// $JUNCTION @ATTACH (86,-2);
// &"RC1" @WIRE(mode="straight",linecolor="#30485d",linewidth=0.16) {#X005:1 (86,15)};
// $JUNCTION @ATTACH (86,15);
// &"RC1" @WIRE(mode="straight",linecolor="#30485d",linewidth=0.16) {#MP_CLEAR:1 (86,37)};
// $JUNCTION @ATTACH (86,37);
// &"B" @WIRE(mode="straight",linecolor="#30485d",linewidth=0.16) {#X002:4 (58.5,15) (58.5,15) #R1:1};
// &"AB" @WIRE(mode="straight",linecolor="#30485d",linewidth=0.16) {#X006:4 (3.5,-23) (3.5,-23) #MN_CLEAR:2};
// (-18,-44) @TEXT("R/C values and multiplicities are read from the netlist; clear transistors are retained.",size=0.9,halign="start",textcolor="#223d52");
// &"A" @WIRE(mode="straight",linecolor="#30485d",linewidth=0.16) {#R0:1 (7,15)};
// (6.6,15) @TEXT("A",size=1.1,halign="end",valign="middle");
// &"VSS" @WIRE(mode="straight",linecolor="#30485d",linewidth=0.16) {#C1:2 (86,-9)};
// (86,-9.4) @TEXT("VSS",size=1.1,halign="middle",valign="top");
// &"VSS" @WIRE(mode="straight",linecolor="#30485d",linewidth=0.16) {#C0:2 (28,-9)};
// (28,-9.4) @TEXT("VSS",size=1.1,halign="middle",valign="top");
// &"A" @WIRE(mode="straight",linecolor="#30485d",linewidth=0.16) {#X006:1 (-24,-23)};
// (-24.4,-23) @TEXT("A",size=1.1,halign="end",valign="middle");
// &"VDD" @WIRE(mode="straight",linecolor="#30485d",linewidth=0.16) {#X006:2 (-14,-13)};
// (-14,-12.6) @TEXT("VDD",size=1.1,halign="middle",valign="bottom");
// &"VSS" @WIRE(mode="straight",linecolor="#30485d",linewidth=0.16) {#X006:3 (-14,-33)};
// (-14,-33.4) @TEXT("VSS",size=1.1,halign="middle",valign="top");
// &"VDD" @WIRE(mode="straight",linecolor="#30485d",linewidth=0.16) {#X005:2 (104,25)};
// (104,25.4) @TEXT("VDD",size=1.1,halign="middle",valign="bottom");
// &"VSS" @WIRE(mode="straight",linecolor="#30485d",linewidth=0.16) {#X005:3 (104,5)};
// (104,4.6) @TEXT("VSS",size=1.1,halign="middle",valign="top");
// &"Y" @WIRE(mode="straight",linecolor="#30485d",linewidth=0.16) {#X005:4 (114,15)};
// (114.4,15) @TEXT("Y",size=1.1,halign="start",valign="middle");
// &"VDD" @WIRE(mode="straight",linecolor="#30485d",linewidth=0.16) {#X002:2 (42,25)};
// (42,25.4) @TEXT("VDD",size=1.1,halign="middle",valign="bottom");
// &"VSS" @WIRE(mode="straight",linecolor="#30485d",linewidth=0.16) {#X002:3 (42,5)};
// (42,4.6) @TEXT("VSS",size=1.1,halign="middle",valign="top");
// &"VSS" @WIRE(mode="straight",linecolor="#30485d",linewidth=0.16) {#MN_CLEAR:3 (17,-28)};
// (17,-28.4) @TEXT("VSS",size=1.1,halign="middle",valign="top");
// &"VSS" @WIRE(mode="straight",linecolor="#30485d",linewidth=0.16) {#MN_CLEAR:4 (21,-23)};
// (21.4,-23) @TEXT("VSS",size=1.1,halign="start",valign="middle");
// &"A" @WIRE(mode="straight",linecolor="#30485d",linewidth=0.16) {#MP_CLEAR:2 (70,39)};
// (69.6,39) @TEXT("A",size=1.1,halign="end",valign="middle");
// &"VDD" @WIRE(mode="straight",linecolor="#30485d",linewidth=0.16) {#MP_CLEAR:3 (76,44)};
// (76,44.4) @TEXT("VDD",size=1.1,halign="middle",valign="bottom");
// &"VDD" @WIRE(mode="straight",linecolor="#30485d",linewidth=0.16) {#MP_CLEAR:4 (80,39)};
// (80.4,39) @TEXT("VDD",size=1.1,halign="start",valign="middle");
// }
// END SARADC RNL
ends sar8r_delay

subckt sar8r_edge A VDD VSS Y
    XD (A VDD VSS AD) sar8r_delay
    XA (A AD VDD VSS QUAL) sar8p_and2
    XB (QUAL VDD VSS Y) sar8p_clkbuf
// BEGIN SARADC RNL
// @RNL(author="saradc topology") {
// #XD @SET-SYMBOL $S_sar8r_delay;
// #XD @PLACE(0,-20) => @ORIENT("R0");
// #XA @SET-SYMBOL $S_sar8p_and2;
// #XA @PLACE(43,0) => @ORIENT("R0");
// #XB @SET-SYMBOL $S_sar8p_clkbuf;
// #XB @PLACE(80,0) => @ORIENT("R0");
// &"A" @WIRE(mode="straight",linecolor="#30485d",linewidth=0.16) {#XD:1 (11.5,-20) (11.5,1.7) #XA:1};
// &"AD" @WIRE(mode="straight",linecolor="#30485d",linewidth=0.16) {#XD:4 (24.5,-20) (24.5,-1.7) #XA:2};
// &"QUAL" @WIRE(mode="straight",linecolor="#30485d",linewidth=0.16) {#XA:5 (61.5,0) (61.5,0) #XB:1};
// (-16,46) @TEXT("sar8r_edge / native standard-cell composition",size=1.3,halign="start",textcolor="#223d52");
// &"VDD" @WIRE(mode="straight",linecolor="#30485d",linewidth=0.16) {#XD:2 (0,-9)};
// (0,-8.6) @TEXT("VDD",size=1.1,halign="middle",valign="bottom");
// &"VSS" @WIRE(mode="straight",linecolor="#30485d",linewidth=0.16) {#XD:3 (0,-31)};
// (0,-31.4) @TEXT("VSS",size=1.1,halign="middle",valign="top");
// &"VDD" @WIRE(mode="straight",linecolor="#30485d",linewidth=0.16) {#XA:3 (43,10)};
// (43,10.4) @TEXT("VDD",size=1.1,halign="middle",valign="bottom");
// &"VSS" @WIRE(mode="straight",linecolor="#30485d",linewidth=0.16) {#XA:4 (43,-10)};
// (43,-10.4) @TEXT("VSS",size=1.1,halign="middle",valign="top");
// &"VDD" @WIRE(mode="straight",linecolor="#30485d",linewidth=0.16) {#XB:2 (80,10)};
// (80,10.4) @TEXT("VDD",size=1.1,halign="middle",valign="bottom");
// &"VSS" @WIRE(mode="straight",linecolor="#30485d",linewidth=0.16) {#XB:3 (80,-10)};
// (80,-10.4) @TEXT("VSS",size=1.1,halign="middle",valign="top");
// &"Y" @WIRE(mode="straight",linecolor="#30485d",linewidth=0.16) {#XB:4 (90,0)};
// (90.4,0) @TEXT("Y",size=1.1,halign="start",valign="middle");
// }
// END SARADC RNL
ends sar8r_edge

subckt sar8s_step A VDD VSS Y
R1 (B RC1 ) rupolym l=17.13u w=1u m=1 multi=(1)

R0 (A RC0 ) rupolym l=17.13u w=1u m=1 multi=(1)

    C1 (RC1 VSS) cfmom_2t nr=8 lr=2.5u w=50n s=50n stm=1 spm=3 multi=6  mismatchflag=1
    C0 (RC0 VSS) cfmom_2t nr=8 lr=2.5u w=50n s=50n stm=1 spm=3 multi=6  mismatchflag=1
    X006 (A VDD VSS AB) sar8p_inv
    X005 (RC1 VDD VSS Y) sar8p_inv
    X002 (RC0 VDD VSS B) sar8p_inv
    MN_CLEAR (RC0 AB VSS VSS) nch_mac l=30n w=2u multi=1 nf=1 sd=100n  ad=1.5e-13 as=1.5e-13 pd=4.15u ps=4.15u nrd=0.144730 nrs=0.144730  sa=75.0n sb=75.0n sa1=75.0n sa2=75.0n sa3=75.0n sa4=75.0n  sb1=75.0n sb2=75.0n sb3=75.0n spa=100n spa1=100n spa2=100n  spa3=100n sap=91.9776n sapb=114.444n spba=115.715n spba1=117.043n  dfm_flag=0 spmt=1.11111e+15 spomt=0 spomt1=1.11111e+60  spmb=1.11111e+15 spomb=0 spomb1=1.11111e+60
    MP_CLEAR (RC1 A VDD VDD) pch_mac l=30n w=3u multi=1 nf=1 sd=100n  ad=2.25e-13 as=2.25e-13 pd=6.15u ps=6.15u nrd=0.055246  nrs=0.055246 sa=75.0n sb=75.0n sa1=75.0n sa2=75.0n sa3=75.0n  sa4=75.0n sb1=75.0n sb2=75.0n sb3=75.0n spa=100n spa1=100n  spa2=100n spa3=100n sap=91.9776n sapb=114.444n spba=115.715n  spba1=117.043n dfm_flag=0 spmt=1.11111e+15 spomt=0  spomt1=1.11111e+60 spmb=1.11111e+15 spomb=0 spomb1=1.11111e+60
// BEGIN SARADC RNL
// @RNL(author="saradc topology") {
// (-18,47) @TEXT("sar8s_step / two RC stages with active clear",size=1.4,halign="start",textcolor="#223d52");
// #R0 @SET-SYMBOL $RESISTOR;
// #R0 @PLACE(12,15) => @ORIENT("R90");
// #R0 @TEXT("R0",key="name",size=1.3,halign="start") => @PLACE(15,18);
// #R0 @TEXT("l=17.13u w=1u multi=(1)",key="value",size=0.9,halign="start") => @PLACE(15,11);
// #R0 @TEXT("",key="model");
// #X002 @SET-SYMBOL $S_sar8p_inv;
// #X002 @PLACE(42,15) => @ORIENT("R0");
// #R1 @SET-SYMBOL $RESISTOR;
// #R1 @PLACE(70,15) => @ORIENT("R90");
// #R1 @TEXT("R1",key="name",size=1.3,halign="start") => @PLACE(73,18);
// #R1 @TEXT("l=17.13u w=1u multi=(1)",key="value",size=0.9,halign="start") => @PLACE(73,11);
// #R1 @TEXT("",key="model");
// #X005 @SET-SYMBOL $S_sar8p_inv;
// #X005 @PLACE(104,15) => @ORIENT("R0");
// #C0 @SET-SYMBOL $CAPACITOR;
// #C0 @PLACE(28,-4) => @ORIENT("R0");
// #C0 @TEXT("C0",key="name",size=1.3,halign="start") => @PLACE(31,-1);
// #C0 @TEXT("nr=8 lr=2.5u w=50n multi=6",key="value",size=0.9,halign="start") => @PLACE(31,-8);
// #C0 @TEXT("",key="model");
// #C1 @SET-SYMBOL $CAPACITOR;
// #C1 @PLACE(86,-4) => @ORIENT("R0");
// #C1 @TEXT("C1",key="name",size=1.3,halign="start") => @PLACE(89,-1);
// #C1 @TEXT("nr=8 lr=2.5u w=50n multi=6",key="value",size=0.9,halign="start") => @PLACE(89,-8);
// #C1 @TEXT("",key="model");
// #MN_CLEAR @SET-SYMBOL $NMOS_4TERM;
// #MN_CLEAR @PLACE(17,-23) => @ORIENT("R0");
// #MN_CLEAR @TEXT("MN_CLEAR",key="name",size=1.3,halign="start") => @PLACE(20,-20);
// #MN_CLEAR @TEXT("l=30n w=2u multi=1",key="value",size=0.9,halign="start") => @PLACE(20,-27);
// #MN_CLEAR @TEXT("",key="model");
// #MP_CLEAR @SET-SYMBOL $PMOS_4TERM;
// #MP_CLEAR @PLACE(76,39) => @ORIENT("R0");
// #MP_CLEAR @TEXT("MP_CLEAR",key="name",size=1.3,halign="start") => @PLACE(79,42);
// #MP_CLEAR @TEXT("l=30n w=3u multi=1",key="value",size=0.9,halign="start") => @PLACE(79,35);
// #MP_CLEAR @TEXT("",key="model");
// #X006 @SET-SYMBOL $S_sar8p_inv;
// #X006 @PLACE(-14,-23) => @ORIENT("R0");
// &"RC0" @WIRE(mode="straight",linecolor="#30485d",linewidth=0.16) {(28,-21) (28,-2) (28,15)};
// &"RC0" @WIRE(mode="straight",linecolor="#30485d",linewidth=0.16) {#R0:2 (28,15)};
// $JUNCTION @ATTACH (28,15);
// &"RC0" @WIRE(mode="straight",linecolor="#30485d",linewidth=0.16) {#C0:1 (28,-2)};
// $JUNCTION @ATTACH (28,-2);
// &"RC0" @WIRE(mode="straight",linecolor="#30485d",linewidth=0.16) {#X002:1 (28,15)};
// $JUNCTION @ATTACH (28,15);
// &"RC0" @WIRE(mode="straight",linecolor="#30485d",linewidth=0.16) {#MN_CLEAR:1 (28,-21)};
// $JUNCTION @ATTACH (28,-21);
// &"RC1" @WIRE(mode="straight",linecolor="#30485d",linewidth=0.16) {(86,-2) (86,15) (86,37)};
// &"RC1" @WIRE(mode="straight",linecolor="#30485d",linewidth=0.16) {#R1:2 (86,15)};
// $JUNCTION @ATTACH (86,15);
// &"RC1" @WIRE(mode="straight",linecolor="#30485d",linewidth=0.16) {#C1:1 (86,-2)};
// $JUNCTION @ATTACH (86,-2);
// &"RC1" @WIRE(mode="straight",linecolor="#30485d",linewidth=0.16) {#X005:1 (86,15)};
// $JUNCTION @ATTACH (86,15);
// &"RC1" @WIRE(mode="straight",linecolor="#30485d",linewidth=0.16) {#MP_CLEAR:1 (86,37)};
// $JUNCTION @ATTACH (86,37);
// &"B" @WIRE(mode="straight",linecolor="#30485d",linewidth=0.16) {#X002:4 (58.5,15) (58.5,15) #R1:1};
// &"AB" @WIRE(mode="straight",linecolor="#30485d",linewidth=0.16) {#X006:4 (3.5,-23) (3.5,-23) #MN_CLEAR:2};
// (-18,-44) @TEXT("R/C values and multiplicities are read from the netlist; clear transistors are retained.",size=0.9,halign="start",textcolor="#223d52");
// &"A" @WIRE(mode="straight",linecolor="#30485d",linewidth=0.16) {#R0:1 (7,15)};
// (6.6,15) @TEXT("A",size=1.1,halign="end",valign="middle");
// &"VSS" @WIRE(mode="straight",linecolor="#30485d",linewidth=0.16) {#C1:2 (86,-9)};
// (86,-9.4) @TEXT("VSS",size=1.1,halign="middle",valign="top");
// &"VSS" @WIRE(mode="straight",linecolor="#30485d",linewidth=0.16) {#C0:2 (28,-9)};
// (28,-9.4) @TEXT("VSS",size=1.1,halign="middle",valign="top");
// &"A" @WIRE(mode="straight",linecolor="#30485d",linewidth=0.16) {#X006:1 (-24,-23)};
// (-24.4,-23) @TEXT("A",size=1.1,halign="end",valign="middle");
// &"VDD" @WIRE(mode="straight",linecolor="#30485d",linewidth=0.16) {#X006:2 (-14,-13)};
// (-14,-12.6) @TEXT("VDD",size=1.1,halign="middle",valign="bottom");
// &"VSS" @WIRE(mode="straight",linecolor="#30485d",linewidth=0.16) {#X006:3 (-14,-33)};
// (-14,-33.4) @TEXT("VSS",size=1.1,halign="middle",valign="top");
// &"VDD" @WIRE(mode="straight",linecolor="#30485d",linewidth=0.16) {#X005:2 (104,25)};
// (104,25.4) @TEXT("VDD",size=1.1,halign="middle",valign="bottom");
// &"VSS" @WIRE(mode="straight",linecolor="#30485d",linewidth=0.16) {#X005:3 (104,5)};
// (104,4.6) @TEXT("VSS",size=1.1,halign="middle",valign="top");
// &"Y" @WIRE(mode="straight",linecolor="#30485d",linewidth=0.16) {#X005:4 (114,15)};
// (114.4,15) @TEXT("Y",size=1.1,halign="start",valign="middle");
// &"VDD" @WIRE(mode="straight",linecolor="#30485d",linewidth=0.16) {#X002:2 (42,25)};
// (42,25.4) @TEXT("VDD",size=1.1,halign="middle",valign="bottom");
// &"VSS" @WIRE(mode="straight",linecolor="#30485d",linewidth=0.16) {#X002:3 (42,5)};
// (42,4.6) @TEXT("VSS",size=1.1,halign="middle",valign="top");
// &"VSS" @WIRE(mode="straight",linecolor="#30485d",linewidth=0.16) {#MN_CLEAR:3 (17,-28)};
// (17,-28.4) @TEXT("VSS",size=1.1,halign="middle",valign="top");
// &"VSS" @WIRE(mode="straight",linecolor="#30485d",linewidth=0.16) {#MN_CLEAR:4 (21,-23)};
// (21.4,-23) @TEXT("VSS",size=1.1,halign="start",valign="middle");
// &"A" @WIRE(mode="straight",linecolor="#30485d",linewidth=0.16) {#MP_CLEAR:2 (70,39)};
// (69.6,39) @TEXT("A",size=1.1,halign="end",valign="middle");
// &"VDD" @WIRE(mode="straight",linecolor="#30485d",linewidth=0.16) {#MP_CLEAR:3 (76,44)};
// (76,44.4) @TEXT("VDD",size=1.1,halign="middle",valign="bottom");
// &"VDD" @WIRE(mode="straight",linecolor="#30485d",linewidth=0.16) {#MP_CLEAR:4 (80,39)};
// (80.4,39) @TEXT("VDD",size=1.1,halign="start",valign="middle");
// }
// END SARADC RNL
ends sar8s_step

subckt sar8i_guard A VDD VSS Y
R1 (B RC1 ) rupolym l=17.13u w=1u m=1 multi=(1)

R0 (A RC0 ) rupolym l=17.13u w=1u m=1 multi=(1)

    C1 (RC1 VSS) cfmom_2t nr=8 lr=2.5u w=50n s=50n stm=1 spm=3 multi=60  mismatchflag=1
    C0 (RC0 VSS) cfmom_2t nr=8 lr=2.5u w=50n s=50n stm=1 spm=3 multi=60  mismatchflag=1
    X006 (A VDD VSS AB) sar8p_inv
    X005 (RC1 VDD VSS Y) sar8p_inv
    X002 (RC0 VDD VSS B) sar8p_inv
    MN_CLEAR (RC0 AB VSS VSS) nch_mac l=30n w=2u multi=1 nf=1 sd=100n  ad=1.5e-13 as=1.5e-13 pd=4.15u ps=4.15u nrd=0.144730 nrs=0.144730  sa=75.0n sb=75.0n sa1=75.0n sa2=75.0n sa3=75.0n sa4=75.0n  sb1=75.0n sb2=75.0n sb3=75.0n spa=100n spa1=100n spa2=100n  spa3=100n sap=91.9776n sapb=114.444n spba=115.715n spba1=117.043n  dfm_flag=0 spmt=1.11111e+15 spomt=0 spomt1=1.11111e+60  spmb=1.11111e+15 spomb=0 spomb1=1.11111e+60
    MP_CLEAR (RC1 A VDD VDD) pch_mac l=30n w=3u multi=1 nf=1 sd=100n  ad=2.25e-13 as=2.25e-13 pd=6.15u ps=6.15u nrd=0.055246  nrs=0.055246 sa=75.0n sb=75.0n sa1=75.0n sa2=75.0n sa3=75.0n  sa4=75.0n sb1=75.0n sb2=75.0n sb3=75.0n spa=100n spa1=100n  spa2=100n spa3=100n sap=91.9776n sapb=114.444n spba=115.715n  spba1=117.043n dfm_flag=0 spmt=1.11111e+15 spomt=0  spomt1=1.11111e+60 spmb=1.11111e+15 spomb=0 spomb1=1.11111e+60
// BEGIN SARADC RNL
// @RNL(author="saradc topology") {
// (-18,47) @TEXT("sar8i_guard / two RC stages with active clear",size=1.4,halign="start",textcolor="#223d52");
// #R0 @SET-SYMBOL $RESISTOR;
// #R0 @PLACE(12,15) => @ORIENT("R90");
// #R0 @TEXT("R0",key="name",size=1.3,halign="start") => @PLACE(15,18);
// #R0 @TEXT("l=17.13u w=1u multi=(1)",key="value",size=0.9,halign="start") => @PLACE(15,11);
// #R0 @TEXT("",key="model");
// #X002 @SET-SYMBOL $S_sar8p_inv;
// #X002 @PLACE(42,15) => @ORIENT("R0");
// #R1 @SET-SYMBOL $RESISTOR;
// #R1 @PLACE(70,15) => @ORIENT("R90");
// #R1 @TEXT("R1",key="name",size=1.3,halign="start") => @PLACE(73,18);
// #R1 @TEXT("l=17.13u w=1u multi=(1)",key="value",size=0.9,halign="start") => @PLACE(73,11);
// #R1 @TEXT("",key="model");
// #X005 @SET-SYMBOL $S_sar8p_inv;
// #X005 @PLACE(104,15) => @ORIENT("R0");
// #C0 @SET-SYMBOL $CAPACITOR;
// #C0 @PLACE(28,-4) => @ORIENT("R0");
// #C0 @TEXT("C0",key="name",size=1.3,halign="start") => @PLACE(31,-1);
// #C0 @TEXT("nr=8 lr=2.5u w=50n multi=60",key="value",size=0.9,halign="start") => @PLACE(31,-8);
// #C0 @TEXT("",key="model");
// #C1 @SET-SYMBOL $CAPACITOR;
// #C1 @PLACE(86,-4) => @ORIENT("R0");
// #C1 @TEXT("C1",key="name",size=1.3,halign="start") => @PLACE(89,-1);
// #C1 @TEXT("nr=8 lr=2.5u w=50n multi=60",key="value",size=0.9,halign="start") => @PLACE(89,-8);
// #C1 @TEXT("",key="model");
// #MN_CLEAR @SET-SYMBOL $NMOS_4TERM;
// #MN_CLEAR @PLACE(17,-23) => @ORIENT("R0");
// #MN_CLEAR @TEXT("MN_CLEAR",key="name",size=1.3,halign="start") => @PLACE(20,-20);
// #MN_CLEAR @TEXT("l=30n w=2u multi=1",key="value",size=0.9,halign="start") => @PLACE(20,-27);
// #MN_CLEAR @TEXT("",key="model");
// #MP_CLEAR @SET-SYMBOL $PMOS_4TERM;
// #MP_CLEAR @PLACE(76,39) => @ORIENT("R0");
// #MP_CLEAR @TEXT("MP_CLEAR",key="name",size=1.3,halign="start") => @PLACE(79,42);
// #MP_CLEAR @TEXT("l=30n w=3u multi=1",key="value",size=0.9,halign="start") => @PLACE(79,35);
// #MP_CLEAR @TEXT("",key="model");
// #X006 @SET-SYMBOL $S_sar8p_inv;
// #X006 @PLACE(-14,-23) => @ORIENT("R0");
// &"RC0" @WIRE(mode="straight",linecolor="#30485d",linewidth=0.16) {(28,-21) (28,-2) (28,15)};
// &"RC0" @WIRE(mode="straight",linecolor="#30485d",linewidth=0.16) {#R0:2 (28,15)};
// $JUNCTION @ATTACH (28,15);
// &"RC0" @WIRE(mode="straight",linecolor="#30485d",linewidth=0.16) {#C0:1 (28,-2)};
// $JUNCTION @ATTACH (28,-2);
// &"RC0" @WIRE(mode="straight",linecolor="#30485d",linewidth=0.16) {#X002:1 (28,15)};
// $JUNCTION @ATTACH (28,15);
// &"RC0" @WIRE(mode="straight",linecolor="#30485d",linewidth=0.16) {#MN_CLEAR:1 (28,-21)};
// $JUNCTION @ATTACH (28,-21);
// &"RC1" @WIRE(mode="straight",linecolor="#30485d",linewidth=0.16) {(86,-2) (86,15) (86,37)};
// &"RC1" @WIRE(mode="straight",linecolor="#30485d",linewidth=0.16) {#R1:2 (86,15)};
// $JUNCTION @ATTACH (86,15);
// &"RC1" @WIRE(mode="straight",linecolor="#30485d",linewidth=0.16) {#C1:1 (86,-2)};
// $JUNCTION @ATTACH (86,-2);
// &"RC1" @WIRE(mode="straight",linecolor="#30485d",linewidth=0.16) {#X005:1 (86,15)};
// $JUNCTION @ATTACH (86,15);
// &"RC1" @WIRE(mode="straight",linecolor="#30485d",linewidth=0.16) {#MP_CLEAR:1 (86,37)};
// $JUNCTION @ATTACH (86,37);
// &"B" @WIRE(mode="straight",linecolor="#30485d",linewidth=0.16) {#X002:4 (58.5,15) (58.5,15) #R1:1};
// &"AB" @WIRE(mode="straight",linecolor="#30485d",linewidth=0.16) {#X006:4 (3.5,-23) (3.5,-23) #MN_CLEAR:2};
// (-18,-44) @TEXT("R/C values and multiplicities are read from the netlist; clear transistors are retained.",size=0.9,halign="start",textcolor="#223d52");
// &"A" @WIRE(mode="straight",linecolor="#30485d",linewidth=0.16) {#R0:1 (7,15)};
// (6.6,15) @TEXT("A",size=1.1,halign="end",valign="middle");
// &"VSS" @WIRE(mode="straight",linecolor="#30485d",linewidth=0.16) {#C1:2 (86,-9)};
// (86,-9.4) @TEXT("VSS",size=1.1,halign="middle",valign="top");
// &"VSS" @WIRE(mode="straight",linecolor="#30485d",linewidth=0.16) {#C0:2 (28,-9)};
// (28,-9.4) @TEXT("VSS",size=1.1,halign="middle",valign="top");
// &"A" @WIRE(mode="straight",linecolor="#30485d",linewidth=0.16) {#X006:1 (-24,-23)};
// (-24.4,-23) @TEXT("A",size=1.1,halign="end",valign="middle");
// &"VDD" @WIRE(mode="straight",linecolor="#30485d",linewidth=0.16) {#X006:2 (-14,-13)};
// (-14,-12.6) @TEXT("VDD",size=1.1,halign="middle",valign="bottom");
// &"VSS" @WIRE(mode="straight",linecolor="#30485d",linewidth=0.16) {#X006:3 (-14,-33)};
// (-14,-33.4) @TEXT("VSS",size=1.1,halign="middle",valign="top");
// &"VDD" @WIRE(mode="straight",linecolor="#30485d",linewidth=0.16) {#X005:2 (104,25)};
// (104,25.4) @TEXT("VDD",size=1.1,halign="middle",valign="bottom");
// &"VSS" @WIRE(mode="straight",linecolor="#30485d",linewidth=0.16) {#X005:3 (104,5)};
// (104,4.6) @TEXT("VSS",size=1.1,halign="middle",valign="top");
// &"Y" @WIRE(mode="straight",linecolor="#30485d",linewidth=0.16) {#X005:4 (114,15)};
// (114.4,15) @TEXT("Y",size=1.1,halign="start",valign="middle");
// &"VDD" @WIRE(mode="straight",linecolor="#30485d",linewidth=0.16) {#X002:2 (42,25)};
// (42,25.4) @TEXT("VDD",size=1.1,halign="middle",valign="bottom");
// &"VSS" @WIRE(mode="straight",linecolor="#30485d",linewidth=0.16) {#X002:3 (42,5)};
// (42,4.6) @TEXT("VSS",size=1.1,halign="middle",valign="top");
// &"VSS" @WIRE(mode="straight",linecolor="#30485d",linewidth=0.16) {#MN_CLEAR:3 (17,-28)};
// (17,-28.4) @TEXT("VSS",size=1.1,halign="middle",valign="top");
// &"VSS" @WIRE(mode="straight",linecolor="#30485d",linewidth=0.16) {#MN_CLEAR:4 (21,-23)};
// (21.4,-23) @TEXT("VSS",size=1.1,halign="start",valign="middle");
// &"A" @WIRE(mode="straight",linecolor="#30485d",linewidth=0.16) {#MP_CLEAR:2 (70,39)};
// (69.6,39) @TEXT("A",size=1.1,halign="end",valign="middle");
// &"VDD" @WIRE(mode="straight",linecolor="#30485d",linewidth=0.16) {#MP_CLEAR:3 (76,44)};
// (76,44.4) @TEXT("VDD",size=1.1,halign="middle",valign="bottom");
// &"VDD" @WIRE(mode="straight",linecolor="#30485d",linewidth=0.16) {#MP_CLEAR:4 (80,39)};
// (80.4,39) @TEXT("VDD",size=1.1,halign="start",valign="middle");
// }
// END SARADC RNL
ends sar8i_guard

subckt sar8p_inv A VDD VSS Y
    XLIB (A Y VDD VSS) INVD1BWP12T30P140
// BEGIN SARADC RNL
// @RNL(author="saradc topology") {
// #XLIB @SET-SYMBOL $S_INVD1BWP12T30P140;
// #XLIB @PLACE(0,0) => @ORIENT("R0");
// (-16,46) @TEXT("sar8p_inv / native standard-cell composition",size=1.3,halign="start",textcolor="#223d52");
// &"A" @WIRE(mode="straight",linecolor="#30485d",linewidth=0.16) {#XLIB:1 (-10,0)};
// (-10.4,0) @TEXT("A",size=1.1,halign="end",valign="middle");
// &"Y" @WIRE(mode="straight",linecolor="#30485d",linewidth=0.16) {#XLIB:2 (10,0)};
// (10.4,0) @TEXT("Y",size=1.1,halign="start",valign="middle");
// &"VDD" @WIRE(mode="straight",linecolor="#30485d",linewidth=0.16) {#XLIB:3 (0,10)};
// (0,10.4) @TEXT("VDD",size=1.1,halign="middle",valign="bottom");
// &"VSS" @WIRE(mode="straight",linecolor="#30485d",linewidth=0.16) {#XLIB:4 (0,-10)};
// (0,-10.4) @TEXT("VSS",size=1.1,halign="middle",valign="top");
// }
// END SARADC RNL
ends sar8p_inv

subckt sar8p_clkbuf A VDD VSS Y
    X000 (A VDD VSS AB) sar8p_inv
    XFINAL (AB VDD VSS Y) sar8p_inv
// BEGIN SARADC RNL
// @RNL(author="saradc topology") {
// #X000 @SET-SYMBOL $S_sar8p_inv;
// #X000 @PLACE(0,0) => @ORIENT("R0");
// #XFINAL @SET-SYMBOL $S_sar8p_inv;
// #XFINAL @PLACE(34,0) => @ORIENT("R0");
// &"AB" @WIRE(mode="straight",linecolor="#30485d",linewidth=0.16) {#X000:4 (17,0) (17,0) #XFINAL:1};
// (-16,46) @TEXT("sar8p_clkbuf / native standard-cell composition",size=1.3,halign="start",textcolor="#223d52");
// &"A" @WIRE(mode="straight",linecolor="#30485d",linewidth=0.16) {#X000:1 (-10,0)};
// (-10.4,0) @TEXT("A",size=1.1,halign="end",valign="middle");
// &"VDD" @WIRE(mode="straight",linecolor="#30485d",linewidth=0.16) {#X000:2 (0,10)};
// (0,10.4) @TEXT("VDD",size=1.1,halign="middle",valign="bottom");
// &"VSS" @WIRE(mode="straight",linecolor="#30485d",linewidth=0.16) {#X000:3 (0,-10)};
// (0,-10.4) @TEXT("VSS",size=1.1,halign="middle",valign="top");
// &"VDD" @WIRE(mode="straight",linecolor="#30485d",linewidth=0.16) {#XFINAL:2 (34,10)};
// (34,10.4) @TEXT("VDD",size=1.1,halign="middle",valign="bottom");
// &"VSS" @WIRE(mode="straight",linecolor="#30485d",linewidth=0.16) {#XFINAL:3 (34,-10)};
// (34,-10.4) @TEXT("VSS",size=1.1,halign="middle",valign="top");
// &"Y" @WIRE(mode="straight",linecolor="#30485d",linewidth=0.16) {#XFINAL:4 (44,0)};
// (44.4,0) @TEXT("Y",size=1.1,halign="start",valign="middle");
// }
// END SARADC RNL
ends sar8p_clkbuf

subckt sar8p_nand2 A B VDD VSS Y
    XLIB (A B Y VDD VSS) ND2D1BWP12T30P140
// BEGIN SARADC RNL
// @RNL(author="saradc topology") {
// #XLIB @SET-SYMBOL $S_ND2D1BWP12T30P140;
// #XLIB @PLACE(0,0) => @ORIENT("R0");
// (-16,46) @TEXT("sar8p_nand2 / native standard-cell composition",size=1.3,halign="start",textcolor="#223d52");
// &"A" @WIRE(mode="straight",linecolor="#30485d",linewidth=0.16) {#XLIB:1 (-10,1.7)};
// (-10.4,1.7) @TEXT("A",size=1.1,halign="end",valign="middle");
// &"B" @WIRE(mode="straight",linecolor="#30485d",linewidth=0.16) {#XLIB:2 (-10,-1.7)};
// (-10.4,-1.7) @TEXT("B",size=1.1,halign="end",valign="middle");
// &"Y" @WIRE(mode="straight",linecolor="#30485d",linewidth=0.16) {#XLIB:3 (10,0)};
// (10.4,0) @TEXT("Y",size=1.1,halign="start",valign="middle");
// &"VDD" @WIRE(mode="straight",linecolor="#30485d",linewidth=0.16) {#XLIB:4 (0,10)};
// (0,10.4) @TEXT("VDD",size=1.1,halign="middle",valign="bottom");
// &"VSS" @WIRE(mode="straight",linecolor="#30485d",linewidth=0.16) {#XLIB:5 (0,-10)};
// (0,-10.4) @TEXT("VSS",size=1.1,halign="middle",valign="top");
// }
// END SARADC RNL
ends sar8p_nand2

subckt sar8p_and2 A B VDD VSS Y
    X000 (A B VDD VSS N) sar8p_nand2
    X001 (N VDD VSS Y) sar8p_inv
// BEGIN SARADC RNL
// @RNL(author="saradc topology") {
// #X000 @SET-SYMBOL $S_sar8p_nand2;
// #X000 @PLACE(0,0) => @ORIENT("R0");
// #X001 @SET-SYMBOL $S_sar8p_inv;
// #X001 @PLACE(34,0) => @ORIENT("R0");
// &"N" @WIRE(mode="straight",linecolor="#30485d",linewidth=0.16) {#X000:5 (17,0) (17,0) #X001:1};
// (-16,46) @TEXT("sar8p_and2 / native standard-cell composition",size=1.3,halign="start",textcolor="#223d52");
// &"A" @WIRE(mode="straight",linecolor="#30485d",linewidth=0.16) {#X000:1 (-10,1.7)};
// (-10.4,1.7) @TEXT("A",size=1.1,halign="end",valign="middle");
// &"B" @WIRE(mode="straight",linecolor="#30485d",linewidth=0.16) {#X000:2 (-10,-1.7)};
// (-10.4,-1.7) @TEXT("B",size=1.1,halign="end",valign="middle");
// &"VDD" @WIRE(mode="straight",linecolor="#30485d",linewidth=0.16) {#X000:3 (0,10)};
// (0,10.4) @TEXT("VDD",size=1.1,halign="middle",valign="bottom");
// &"VSS" @WIRE(mode="straight",linecolor="#30485d",linewidth=0.16) {#X000:4 (0,-10)};
// (0,-10.4) @TEXT("VSS",size=1.1,halign="middle",valign="top");
// &"VDD" @WIRE(mode="straight",linecolor="#30485d",linewidth=0.16) {#X001:2 (34,10)};
// (34,10.4) @TEXT("VDD",size=1.1,halign="middle",valign="bottom");
// &"VSS" @WIRE(mode="straight",linecolor="#30485d",linewidth=0.16) {#X001:3 (34,-10)};
// (34,-10.4) @TEXT("VSS",size=1.1,halign="middle",valign="top");
// &"Y" @WIRE(mode="straight",linecolor="#30485d",linewidth=0.16) {#X001:4 (44,0)};
// (44.4,0) @TEXT("Y",size=1.1,halign="start",valign="middle");
// }
// END SARADC RNL
ends sar8p_and2

subckt sar8p_buf A VDD VSS Y
    X001 (N VDD VSS Y) sar8p_inv
    X000 (A VDD VSS N) sar8p_inv
// BEGIN SARADC RNL
// @RNL(author="saradc topology") {
// #X000 @SET-SYMBOL $S_sar8p_inv;
// #X000 @PLACE(0,0) => @ORIENT("R0");
// #X001 @SET-SYMBOL $S_sar8p_inv;
// #X001 @PLACE(34,0) => @ORIENT("R0");
// &"N" @WIRE(mode="straight",linecolor="#30485d",linewidth=0.16) {#X001:1 (17,0) (17,0) #X000:4};
// (-16,46) @TEXT("sar8p_buf / native standard-cell composition",size=1.3,halign="start",textcolor="#223d52");
// &"VDD" @WIRE(mode="straight",linecolor="#30485d",linewidth=0.16) {#X001:2 (34,10)};
// (34,10.4) @TEXT("VDD",size=1.1,halign="middle",valign="bottom");
// &"VSS" @WIRE(mode="straight",linecolor="#30485d",linewidth=0.16) {#X001:3 (34,-10)};
// (34,-10.4) @TEXT("VSS",size=1.1,halign="middle",valign="top");
// &"Y" @WIRE(mode="straight",linecolor="#30485d",linewidth=0.16) {#X001:4 (44,0)};
// (44.4,0) @TEXT("Y",size=1.1,halign="start",valign="middle");
// &"A" @WIRE(mode="straight",linecolor="#30485d",linewidth=0.16) {#X000:1 (-10,0)};
// (-10.4,0) @TEXT("A",size=1.1,halign="end",valign="middle");
// &"VDD" @WIRE(mode="straight",linecolor="#30485d",linewidth=0.16) {#X000:2 (0,10)};
// (0,10.4) @TEXT("VDD",size=1.1,halign="middle",valign="bottom");
// &"VSS" @WIRE(mode="straight",linecolor="#30485d",linewidth=0.16) {#X000:3 (0,-10)};
// (0,-10.4) @TEXT("VSS",size=1.1,halign="middle",valign="top");
// }
// END SARADC RNL
ends sar8p_buf

subckt sar8p_xor2 A B VDD VSS Y
    X003 (NA NB VDD VSS Y) sar8p_nand2
    X002 (B N VDD VSS NB) sar8p_nand2
    X001 (A N VDD VSS NA) sar8p_nand2
    X000 (A B VDD VSS N) sar8p_nand2
// BEGIN SARADC RNL
// @RNL(author="saradc topology") {
// #X000 @SET-SYMBOL $S_sar8p_nand2;
// #X000 @PLACE(0,0) => @ORIENT("R0");
// #X001 @SET-SYMBOL $S_sar8p_nand2;
// #X001 @PLACE(40,20) => @ORIENT("R0");
// #X002 @SET-SYMBOL $S_sar8p_nand2;
// #X002 @PLACE(40,-20) => @ORIENT("R0");
// #X003 @SET-SYMBOL $S_sar8p_nand2;
// #X003 @PLACE(80,0) => @ORIENT("R0");
// &"NA" @WIRE(mode="straight",linecolor="#30485d",linewidth=0.16) {#X003:1 (60,1.7) (60,20) #X001:5};
// &"NB" @WIRE(mode="straight",linecolor="#30485d",linewidth=0.16) {#X003:2 (60,-1.7) (60,-20) #X002:5};
// &"B" @WIRE(mode="straight",linecolor="#30485d",linewidth=0.16) {#X002:1 (13,-18.3) (13,-1.7) #X000:2};
// &"A" @WIRE(mode="straight",linecolor="#30485d",linewidth=0.16) {#X001:1 (13,21.7) (13,1.7) #X000:1};
// &"N" @WIRE(mode="straight",linecolor="#30485d",linewidth=0.16) {(2,-21.7) (2,0) (2,18.3)};
// &"N" @WIRE(mode="straight",linecolor="#30485d",linewidth=0.16) {#X002:2 (2,-21.7)};
// $JUNCTION @ATTACH (2,-21.7);
// &"N" @WIRE(mode="straight",linecolor="#30485d",linewidth=0.16) {#X001:2 (2,18.3)};
// $JUNCTION @ATTACH (2,18.3);
// &"N" @WIRE(mode="straight",linecolor="#30485d",linewidth=0.16) {#X000:5 (2,0)};
// $JUNCTION @ATTACH (2,0);
// (-16,46) @TEXT("sar8p_xor2 / native standard-cell composition",size=1.3,halign="start",textcolor="#223d52");
// &"VDD" @WIRE(mode="straight",linecolor="#30485d",linewidth=0.16) {#X003:3 (80,10)};
// (80,10.4) @TEXT("VDD",size=1.1,halign="middle",valign="bottom");
// &"VSS" @WIRE(mode="straight",linecolor="#30485d",linewidth=0.16) {#X003:4 (80,-10)};
// (80,-10.4) @TEXT("VSS",size=1.1,halign="middle",valign="top");
// &"Y" @WIRE(mode="straight",linecolor="#30485d",linewidth=0.16) {#X003:5 (90,0)};
// (90.4,0) @TEXT("Y",size=1.1,halign="start",valign="middle");
// &"VDD" @WIRE(mode="straight",linecolor="#30485d",linewidth=0.16) {#X002:3 (40,-10)};
// (40,-9.6) @TEXT("VDD",size=1.1,halign="middle",valign="bottom");
// &"VSS" @WIRE(mode="straight",linecolor="#30485d",linewidth=0.16) {#X002:4 (40,-30)};
// (40,-30.4) @TEXT("VSS",size=1.1,halign="middle",valign="top");
// &"VDD" @WIRE(mode="straight",linecolor="#30485d",linewidth=0.16) {#X001:3 (40,30)};
// (40,30.4) @TEXT("VDD",size=1.1,halign="middle",valign="bottom");
// &"VSS" @WIRE(mode="straight",linecolor="#30485d",linewidth=0.16) {#X001:4 (40,10)};
// (40,9.6) @TEXT("VSS",size=1.1,halign="middle",valign="top");
// &"VDD" @WIRE(mode="straight",linecolor="#30485d",linewidth=0.16) {#X000:3 (0,10)};
// (0,10.4) @TEXT("VDD",size=1.1,halign="middle",valign="bottom");
// &"VSS" @WIRE(mode="straight",linecolor="#30485d",linewidth=0.16) {#X000:4 (0,-10)};
// (0,-10.4) @TEXT("VSS",size=1.1,halign="middle",valign="top");
// }
// END SARADC RNL
ends sar8p_xor2

subckt sar8p_or2 A B VDD VSS Y
    X001 (B VDD VSS BB) sar8p_inv
    X000 (A VDD VSS AB) sar8p_inv
    X002 (AB BB VDD VSS Y) sar8p_nand2
// BEGIN SARADC RNL
// @RNL(author="saradc topology") {
// #X000 @SET-SYMBOL $S_sar8p_inv;
// #X000 @PLACE(0,16) => @ORIENT("R0");
// #X001 @SET-SYMBOL $S_sar8p_inv;
// #X001 @PLACE(0,-16) => @ORIENT("R0");
// #X002 @SET-SYMBOL $S_sar8p_nand2;
// #X002 @PLACE(40,0) => @ORIENT("R0");
// &"BB" @WIRE(mode="straight",linecolor="#30485d",linewidth=0.16) {#X001:4 (20,-16) (20,-1.7) #X002:2};
// &"AB" @WIRE(mode="straight",linecolor="#30485d",linewidth=0.16) {#X000:4 (20,16) (20,1.7) #X002:1};
// (-16,46) @TEXT("sar8p_or2 / native standard-cell composition",size=1.3,halign="start",textcolor="#223d52");
// &"B" @WIRE(mode="straight",linecolor="#30485d",linewidth=0.16) {#X001:1 (-10,-16)};
// (-10.4,-16) @TEXT("B",size=1.1,halign="end",valign="middle");
// &"VDD" @WIRE(mode="straight",linecolor="#30485d",linewidth=0.16) {#X001:2 (0,-6)};
// (0,-5.6) @TEXT("VDD",size=1.1,halign="middle",valign="bottom");
// &"VSS" @WIRE(mode="straight",linecolor="#30485d",linewidth=0.16) {#X001:3 (0,-26)};
// (0,-26.4) @TEXT("VSS",size=1.1,halign="middle",valign="top");
// &"A" @WIRE(mode="straight",linecolor="#30485d",linewidth=0.16) {#X000:1 (-10,16)};
// (-10.4,16) @TEXT("A",size=1.1,halign="end",valign="middle");
// &"VDD" @WIRE(mode="straight",linecolor="#30485d",linewidth=0.16) {#X000:2 (0,26)};
// (0,26.4) @TEXT("VDD",size=1.1,halign="middle",valign="bottom");
// &"VSS" @WIRE(mode="straight",linecolor="#30485d",linewidth=0.16) {#X000:3 (0,6)};
// (0,5.6) @TEXT("VSS",size=1.1,halign="middle",valign="top");
// &"VDD" @WIRE(mode="straight",linecolor="#30485d",linewidth=0.16) {#X002:3 (40,10)};
// (40,10.4) @TEXT("VDD",size=1.1,halign="middle",valign="bottom");
// &"VSS" @WIRE(mode="straight",linecolor="#30485d",linewidth=0.16) {#X002:4 (40,-10)};
// (40,-10.4) @TEXT("VSS",size=1.1,halign="middle",valign="top");
// &"Y" @WIRE(mode="straight",linecolor="#30485d",linewidth=0.16) {#X002:5 (50,0)};
// (50.4,0) @TEXT("Y",size=1.1,halign="start",valign="middle");
// }
// END SARADC RNL
ends sar8p_or2

subckt sar8p_sr Q R S VDD VSS
    X000 (R VDD VSS RB) sar8p_inv
    X003 (RB Q VDD VSS QB) sar8p_nand2
    X002 (SN QB VDD VSS Q) sar8p_nand2
    X001 (S RB VDD VSS SN) sar8p_nand2
    CQB (QB VSS) cfmom_2t nr=8 lr=2.5u w=50n s=50n stm=1 spm=3 multi=1          mismatchflag=1
// BEGIN SARADC RNL
// @RNL(author="saradc topology") {
// #X000 @SET-SYMBOL $S_sar8p_inv;
// #X000 @PLACE(0,-24) => @ORIENT("R0");
// #X001 @SET-SYMBOL $S_sar8p_nand2;
// #X001 @PLACE(38,20) => @ORIENT("R0");
// #X002 @SET-SYMBOL $S_sar8p_nand2;
// #X002 @PLACE(76,20) => @ORIENT("R0");
// #X003 @SET-SYMBOL $S_sar8p_nand2;
// #X003 @PLACE(76,-24) => @ORIENT("R0");
// #CQB @SET-SYMBOL $CAPACITOR;
// #CQB @PLACE(108,-37) => @ORIENT("R0");
// #CQB @TEXT("CQB",key="name",size=1.3,halign="start") => @PLACE(111,-34);
// #CQB @TEXT("nr=8 lr=2.5u w=50n multi=1",key="value",size=0.9,halign="start") => @PLACE(111,-41);
// #CQB @TEXT("",key="model");
// &"Q" @WIRE(mode="straight",linecolor="#30485d",linewidth=0.16) {#X003:2 (76,-25.7) (76,20) #X002:5};
// &"SN" @WIRE(mode="straight",linecolor="#30485d",linewidth=0.16) {#X002:1 (57,21.7) (57,20) #X001:5};
// &"RB" @WIRE(mode="straight",linecolor="#30485d",linewidth=0.16) {(2,-24) (2,-22.3) (2,18.3)};
// &"RB" @WIRE(mode="straight",linecolor="#30485d",linewidth=0.16) {#X000:4 (2,-24)};
// $JUNCTION @ATTACH (2,-24);
// &"RB" @WIRE(mode="straight",linecolor="#30485d",linewidth=0.16) {#X003:1 (2,-22.3)};
// $JUNCTION @ATTACH (2,-22.3);
// &"RB" @WIRE(mode="straight",linecolor="#30485d",linewidth=0.16) {#X001:2 (2,18.3)};
// $JUNCTION @ATTACH (2,18.3);
// &"QB" @WIRE(mode="straight",linecolor="#30485d",linewidth=0.16) {(64,-35) (64,-24) (64,18.3)};
// &"QB" @WIRE(mode="straight",linecolor="#30485d",linewidth=0.16) {#X003:5 (64,-24)};
// $JUNCTION @ATTACH (64,-24);
// &"QB" @WIRE(mode="straight",linecolor="#30485d",linewidth=0.16) {#X002:2 (64,18.3)};
// $JUNCTION @ATTACH (64,18.3);
// &"QB" @WIRE(mode="straight",linecolor="#30485d",linewidth=0.16) {#CQB:1 (64,-35)};
// $JUNCTION @ATTACH (64,-35);
// (-16,46) @TEXT("sar8p_sr / native standard-cell composition",size=1.3,halign="start",textcolor="#223d52");
// &"R" @WIRE(mode="straight",linecolor="#30485d",linewidth=0.16) {#X000:1 (-10,-24)};
// (-10.4,-24) @TEXT("R",size=1.1,halign="end",valign="middle");
// &"VDD" @WIRE(mode="straight",linecolor="#30485d",linewidth=0.16) {#X000:2 (0,-14)};
// (0,-13.6) @TEXT("VDD",size=1.1,halign="middle",valign="bottom");
// &"VSS" @WIRE(mode="straight",linecolor="#30485d",linewidth=0.16) {#X000:3 (0,-34)};
// (0,-34.4) @TEXT("VSS",size=1.1,halign="middle",valign="top");
// &"VDD" @WIRE(mode="straight",linecolor="#30485d",linewidth=0.16) {#X003:3 (76,-14)};
// (76,-13.6) @TEXT("VDD",size=1.1,halign="middle",valign="bottom");
// &"VSS" @WIRE(mode="straight",linecolor="#30485d",linewidth=0.16) {#X003:4 (76,-34)};
// (76,-34.4) @TEXT("VSS",size=1.1,halign="middle",valign="top");
// &"VDD" @WIRE(mode="straight",linecolor="#30485d",linewidth=0.16) {#X002:3 (76,30)};
// (76,30.4) @TEXT("VDD",size=1.1,halign="middle",valign="bottom");
// &"VSS" @WIRE(mode="straight",linecolor="#30485d",linewidth=0.16) {#X002:4 (76,10)};
// (76,9.6) @TEXT("VSS",size=1.1,halign="middle",valign="top");
// &"S" @WIRE(mode="straight",linecolor="#30485d",linewidth=0.16) {#X001:1 (28,21.7)};
// (27.6,21.7) @TEXT("S",size=1.1,halign="end",valign="middle");
// &"VDD" @WIRE(mode="straight",linecolor="#30485d",linewidth=0.16) {#X001:3 (38,30)};
// (38,30.4) @TEXT("VDD",size=1.1,halign="middle",valign="bottom");
// &"VSS" @WIRE(mode="straight",linecolor="#30485d",linewidth=0.16) {#X001:4 (38,10)};
// (38,9.6) @TEXT("VSS",size=1.1,halign="middle",valign="top");
// &"VSS" @WIRE(mode="straight",linecolor="#30485d",linewidth=0.16) {#CQB:2 (108,-42)};
// (108,-42.4) @TEXT("VSS",size=1.1,halign="middle",valign="top");
// }
// END SARADC RNL
ends sar8p_sr

subckt sar8p_dffr CK D Q RST VDD VSS
    XRESET (RST RN VDD VSS) INVD1BWP12T30P140
    XFF (D CK RN Q VDD VSS) DFCNQD1BWP12T30P140
// BEGIN SARADC RNL
// @RNL(author="saradc topology") {
// #XRESET @SET-SYMBOL $S_INVD1BWP12T30P140;
// #XRESET @PLACE(0,-20) => @ORIENT("R0");
// #XFF @SET-SYMBOL $S_DFCNQD1BWP12T30P140;
// #XFF @PLACE(43,0) => @ORIENT("R0");
// &"RN" @WIRE(mode="straight",linecolor="#30485d",linewidth=0.16) {#XRESET:2 (21.5,-20) (21.5,-3.4) #XFF:3};
// (-16,46) @TEXT("sar8p_dffr / native standard-cell composition",size=1.3,halign="start",textcolor="#223d52");
// &"RST" @WIRE(mode="straight",linecolor="#30485d",linewidth=0.16) {#XRESET:1 (-10,-20)};
// (-10.4,-20) @TEXT("RST",size=1.1,halign="end",valign="middle");
// &"VDD" @WIRE(mode="straight",linecolor="#30485d",linewidth=0.16) {#XRESET:3 (0,-10)};
// (0,-9.6) @TEXT("VDD",size=1.1,halign="middle",valign="bottom");
// &"VSS" @WIRE(mode="straight",linecolor="#30485d",linewidth=0.16) {#XRESET:4 (0,-30)};
// (0,-30.4) @TEXT("VSS",size=1.1,halign="middle",valign="top");
// &"D" @WIRE(mode="straight",linecolor="#30485d",linewidth=0.16) {#XFF:1 (33,3.4)};
// (32.6,3.4) @TEXT("D",size=1.1,halign="end",valign="middle");
// &"CK" @WIRE(mode="straight",linecolor="#30485d",linewidth=0.16) {#XFF:2 (33,0)};
// (32.6,0) @TEXT("CK",size=1.1,halign="end",valign="middle");
// &"Q" @WIRE(mode="straight",linecolor="#30485d",linewidth=0.16) {#XFF:4 (53,0)};
// (53.4,0) @TEXT("Q",size=1.1,halign="start",valign="middle");
// &"VDD" @WIRE(mode="straight",linecolor="#30485d",linewidth=0.16) {#XFF:5 (43,10)};
// (43,10.4) @TEXT("VDD",size=1.1,halign="middle",valign="bottom");
// &"VSS" @WIRE(mode="straight",linecolor="#30485d",linewidth=0.16) {#XFF:6 (43,-10)};
// (43,-10.4) @TEXT("VSS",size=1.1,halign="middle",valign="top");
// }
// END SARADC RNL
ends sar8p_dffr

subckt sar8p_mux2 D0 D1 SEL VDD VSS Y
    X000 (SEL VDD VSS SB) sar8p_inv
    X003 (N0 N1 VDD VSS Y) sar8p_nand2
    X002 (D1 SEL VDD VSS N1) sar8p_nand2
    X001 (D0 SB VDD VSS N0) sar8p_nand2
// BEGIN SARADC RNL
// @RNL(author="saradc topology") {
// #X000 @SET-SYMBOL $S_sar8p_inv;
// #X000 @PLACE(0,-26) => @ORIENT("R0");
// #X001 @SET-SYMBOL $S_sar8p_nand2;
// #X001 @PLACE(42,15) => @ORIENT("R0");
// #X002 @SET-SYMBOL $S_sar8p_nand2;
// #X002 @PLACE(42,-15) => @ORIENT("R0");
// #X003 @SET-SYMBOL $S_sar8p_nand2;
// #X003 @PLACE(84,0) => @ORIENT("R0");
// &"SEL" @WIRE(mode="straight",linecolor="#30485d",linewidth=0.16) {#X000:1 (14,-26) (14,-16.7) #X002:2};
// &"SB" @WIRE(mode="straight",linecolor="#30485d",linewidth=0.16) {#X000:4 (21,-26) (21,13.3) #X001:2};
// &"N0" @WIRE(mode="straight",linecolor="#30485d",linewidth=0.16) {#X003:1 (63,1.7) (63,15) #X001:5};
// &"N1" @WIRE(mode="straight",linecolor="#30485d",linewidth=0.16) {#X003:2 (63,-1.7) (63,-15) #X002:5};
// (-16,46) @TEXT("sar8p_mux2 / native standard-cell composition",size=1.3,halign="start",textcolor="#223d52");
// &"VDD" @WIRE(mode="straight",linecolor="#30485d",linewidth=0.16) {#X000:2 (0,-16)};
// (0,-15.6) @TEXT("VDD",size=1.1,halign="middle",valign="bottom");
// &"VSS" @WIRE(mode="straight",linecolor="#30485d",linewidth=0.16) {#X000:3 (0,-36)};
// (0,-36.4) @TEXT("VSS",size=1.1,halign="middle",valign="top");
// &"VDD" @WIRE(mode="straight",linecolor="#30485d",linewidth=0.16) {#X003:3 (84,10)};
// (84,10.4) @TEXT("VDD",size=1.1,halign="middle",valign="bottom");
// &"VSS" @WIRE(mode="straight",linecolor="#30485d",linewidth=0.16) {#X003:4 (84,-10)};
// (84,-10.4) @TEXT("VSS",size=1.1,halign="middle",valign="top");
// &"Y" @WIRE(mode="straight",linecolor="#30485d",linewidth=0.16) {#X003:5 (94,0)};
// (94.4,0) @TEXT("Y",size=1.1,halign="start",valign="middle");
// &"D1" @WIRE(mode="straight",linecolor="#30485d",linewidth=0.16) {#X002:1 (32,-13.3)};
// (31.6,-13.3) @TEXT("D1",size=1.1,halign="end",valign="middle");
// &"VDD" @WIRE(mode="straight",linecolor="#30485d",linewidth=0.16) {#X002:3 (42,-5)};
// (42,-4.6) @TEXT("VDD",size=1.1,halign="middle",valign="bottom");
// &"VSS" @WIRE(mode="straight",linecolor="#30485d",linewidth=0.16) {#X002:4 (42,-25)};
// (42,-25.4) @TEXT("VSS",size=1.1,halign="middle",valign="top");
// &"D0" @WIRE(mode="straight",linecolor="#30485d",linewidth=0.16) {#X001:1 (32,16.7)};
// (31.6,16.7) @TEXT("D0",size=1.1,halign="end",valign="middle");
// &"VDD" @WIRE(mode="straight",linecolor="#30485d",linewidth=0.16) {#X001:3 (42,25)};
// (42,25.4) @TEXT("VDD",size=1.1,halign="middle",valign="bottom");
// &"VSS" @WIRE(mode="straight",linecolor="#30485d",linewidth=0.16) {#X001:4 (42,5)};
// (42,4.6) @TEXT("VSS",size=1.1,halign="middle",valign="top");
// }
// END SARADC RNL
ends sar8p_mux2

subckt sar_strongarm_t28 CLK OUTN OUTP VDD VINN VINP VSS
    MNLATN (OUTN OUTP Y VSS) nch_mac l=30n w=500n multi=1 nf=1 sd=100n          ad=3.75e-14 as=3.75e-14 pd=1.15u ps=1.15u nrd=0.662935          nrs=0.662935 sa=75.0n sb=75.0n sa1=75.0n sa2=75.0n sa3=75.0n          sa4=75.0n sb1=75.0n sb2=75.0n sb3=75.0n spa=100n spa1=100n          spa2=100n spa3=100n sap=91.9776n sapb=114.444n spba=115.715n          spba1=117.043n dfm_flag=0 spmt=1.11111e+15 spomt=0          spomt1=1.11111e+60 spmb=1.11111e+15 spomb=0 spomb1=1.11111e+60
    MNLATP (OUTP OUTN X VSS) nch_mac l=30n w=500n multi=1 nf=1 sd=100n          ad=3.75e-14 as=3.75e-14 pd=1.15u ps=1.15u nrd=0.662935          nrs=0.662935 sa=75.0n sb=75.0n sa1=75.0n sa2=75.0n sa3=75.0n          sa4=75.0n sb1=75.0n sb2=75.0n sb3=75.0n spa=100n spa1=100n          spa2=100n spa3=100n sap=91.9776n sapb=114.444n spba=115.715n          spba1=117.043n dfm_flag=0 spmt=1.11111e+15 spomt=0          spomt1=1.11111e+60 spmb=1.11111e+15 spomb=0 spomb1=1.11111e+60
    MNINN (X VINN TAIL VSS) nch_mac l=30n w=1u multi=1 nf=1 sd=100n          ad=7.5e-14 as=7.5e-14 pd=2.15u ps=2.15u nrd=0.289519 nrs=0.289519          sa=75.0n sb=75.0n sa1=75.0n sa2=75.0n sa3=75.0n sa4=75.0n          sb1=75.0n sb2=75.0n sb3=75.0n spa=100n spa1=100n spa2=100n          spa3=100n sap=91.9776n sapb=114.444n spba=115.715n spba1=117.043n          dfm_flag=0 spmt=1.11111e+15 spomt=0 spomt1=1.11111e+60          spmb=1.11111e+15 spomb=0 spomb1=1.11111e+60
    MNINP (Y VINP TAIL VSS) nch_mac l=30n w=1u multi=1 nf=1 sd=100n          ad=7.5e-14 as=7.5e-14 pd=2.15u ps=2.15u nrd=0.289519 nrs=0.289519          sa=75.0n sb=75.0n sa1=75.0n sa2=75.0n sa3=75.0n sa4=75.0n          sb1=75.0n sb2=75.0n sb3=75.0n spa=100n spa1=100n spa2=100n          spa3=100n sap=91.9776n sapb=114.444n spba=115.715n spba1=117.043n          dfm_flag=0 spmt=1.11111e+15 spomt=0 spomt1=1.11111e+60          spmb=1.11111e+15 spomb=0 spomb1=1.11111e+60
    MNTAIL (TAIL CLK VSS VSS) nch_mac l=30n w=1u multi=1 nf=1 sd=100n          ad=7.5e-14 as=7.5e-14 pd=2.15u ps=2.15u nrd=0.289519 nrs=0.289519          sa=75.0n sb=75.0n sa1=75.0n sa2=75.0n sa3=75.0n sa4=75.0n          sb1=75.0n sb2=75.0n sb3=75.0n spa=100n spa1=100n spa2=100n          spa3=100n sap=91.9776n sapb=114.444n spba=115.715n spba1=117.043n          dfm_flag=0 spmt=1.11111e+15 spomt=0 spomt1=1.11111e+60          spmb=1.11111e+15 spomb=0 spomb1=1.11111e+60
    MPRSTN (OUTN CLK VDD VDD) pch_mac l=30n w=500n multi=1 nf=1 sd=100n          ad=3.75e-14 as=3.75e-14 pd=1.15u ps=1.15u nrd=0.383209          nrs=0.383209 sa=75.0n sb=75.0n sa1=75.0n sa2=75.0n sa3=75.0n          sa4=75.0n sb1=75.0n sb2=75.0n sb3=75.0n spa=100n spa1=100n          spa2=100n spa3=100n sap=91.9776n sapb=114.444n spba=115.715n          spba1=117.043n dfm_flag=0 spmt=1.11111e+15 spomt=0          spomt1=1.11111e+60 spmb=1.11111e+15 spomb=0 spomb1=1.11111e+60
    MPRSTP (OUTP CLK VDD VDD) pch_mac l=30n w=500n multi=1 nf=1 sd=100n          ad=3.75e-14 as=3.75e-14 pd=1.15u ps=1.15u nrd=0.383209          nrs=0.383209 sa=75.0n sb=75.0n sa1=75.0n sa2=75.0n sa3=75.0n          sa4=75.0n sb1=75.0n sb2=75.0n sb3=75.0n spa=100n spa1=100n          spa2=100n spa3=100n sap=91.9776n sapb=114.444n spba=115.715n          spba1=117.043n dfm_flag=0 spmt=1.11111e+15 spomt=0          spomt1=1.11111e+60 spmb=1.11111e+15 spomb=0 spomb1=1.11111e+60
    MPRSTY (Y CLK VDD VDD) pch_mac l=30n w=500n multi=1 nf=1 sd=100n          ad=3.75e-14 as=3.75e-14 pd=1.15u ps=1.15u nrd=0.383209          nrs=0.383209 sa=75.0n sb=75.0n sa1=75.0n sa2=75.0n sa3=75.0n          sa4=75.0n sb1=75.0n sb2=75.0n sb3=75.0n spa=100n spa1=100n          spa2=100n spa3=100n sap=91.9776n sapb=114.444n spba=115.715n          spba1=117.043n dfm_flag=0 spmt=1.11111e+15 spomt=0          spomt1=1.11111e+60 spmb=1.11111e+15 spomb=0 spomb1=1.11111e+60
    MPRSTX (X CLK VDD VDD) pch_mac l=30n w=500n multi=1 nf=1 sd=100n          ad=3.75e-14 as=3.75e-14 pd=1.15u ps=1.15u nrd=0.383209          nrs=0.383209 sa=75.0n sb=75.0n sa1=75.0n sa2=75.0n sa3=75.0n          sa4=75.0n sb1=75.0n sb2=75.0n sb3=75.0n spa=100n spa1=100n          spa2=100n spa3=100n sap=91.9776n sapb=114.444n spba=115.715n          spba1=117.043n dfm_flag=0 spmt=1.11111e+15 spomt=0          spomt1=1.11111e+60 spmb=1.11111e+15 spomb=0 spomb1=1.11111e+60
    MPLATN (OUTN OUTP VDD VDD) pch_mac l=30n w=500n multi=1 nf=1 sd=100n          ad=3.75e-14 as=3.75e-14 pd=1.15u ps=1.15u nrd=0.383209          nrs=0.383209 sa=75.0n sb=75.0n sa1=75.0n sa2=75.0n sa3=75.0n          sa4=75.0n sb1=75.0n sb2=75.0n sb3=75.0n spa=100n spa1=100n          spa2=100n spa3=100n sap=91.9776n sapb=114.444n spba=115.715n          spba1=117.043n dfm_flag=0 spmt=1.11111e+15 spomt=0          spomt1=1.11111e+60 spmb=1.11111e+15 spomb=0 spomb1=1.11111e+60
    MPLATP (OUTP OUTN VDD VDD) pch_mac l=30n w=500n multi=1 nf=1 sd=100n          ad=3.75e-14 as=3.75e-14 pd=1.15u ps=1.15u nrd=0.383209          nrs=0.383209 sa=75.0n sb=75.0n sa1=75.0n sa2=75.0n sa3=75.0n          sa4=75.0n sb1=75.0n sb2=75.0n sb3=75.0n spa=100n spa1=100n          spa2=100n spa3=100n sap=91.9776n sapb=114.444n spba=115.715n          spba1=117.043n dfm_flag=0 spmt=1.11111e+15 spomt=0          spomt1=1.11111e+60 spmb=1.11111e+15 spomb=0 spomb1=1.11111e+60
// BEGIN SARADC RNL
// @RNL(author="saradc topology") {
// (-47,72) @TEXT("StrongARM / 11 MOS / symmetric latch and input pair",size=1.5,halign="start",textcolor="#223d52");
// #MPLATN @SET-SYMBOL $PMOS_4TERM;
// #MPLATN @PLACE(-20,42) => @ORIENT("MY");
// #MPLATN @TEXT("MPLATN",key="name",size=1.3,halign="start") => @PLACE(-17,45);
// #MPLATN @TEXT("l=30n w=500n multi=1",key="value",size=0.9,halign="start") => @PLACE(-17,38);
// #MPLATN @TEXT("",key="model");
// #MPLATP @SET-SYMBOL $PMOS_4TERM;
// #MPLATP @PLACE(20,42) => @ORIENT("R0");
// #MPLATP @TEXT("MPLATP",key="name",size=1.3,halign="start") => @PLACE(23,45);
// #MPLATP @TEXT("l=30n w=500n multi=1",key="value",size=0.9,halign="start") => @PLACE(23,38);
// #MPLATP @TEXT("",key="model");
// #MNLATN @SET-SYMBOL $NMOS_4TERM;
// #MNLATN @PLACE(-20,20) => @ORIENT("MY");
// #MNLATN @TEXT("MNLATN",key="name",size=1.3,halign="start") => @PLACE(-17,23);
// #MNLATN @TEXT("l=30n w=500n multi=1",key="value",size=0.9,halign="start") => @PLACE(-17,16);
// #MNLATN @TEXT("",key="model");
// #MNLATP @SET-SYMBOL $NMOS_4TERM;
// #MNLATP @PLACE(20,20) => @ORIENT("R0");
// #MNLATP @TEXT("MNLATP",key="name",size=1.3,halign="start") => @PLACE(23,23);
// #MNLATP @TEXT("l=30n w=500n multi=1",key="value",size=0.9,halign="start") => @PLACE(23,16);
// #MNLATP @TEXT("",key="model");
// #MNINP @SET-SYMBOL $NMOS_4TERM;
// #MNINP @PLACE(-20,-5) => @ORIENT("R0");
// #MNINP @TEXT("MNINP",key="name",size=1.3,halign="start") => @PLACE(-17,-2);
// #MNINP @TEXT("l=30n w=1u multi=1",key="value",size=0.9,halign="start") => @PLACE(-17,-9);
// #MNINP @TEXT("",key="model");
// #MNINN @SET-SYMBOL $NMOS_4TERM;
// #MNINN @PLACE(20,-5) => @ORIENT("MY");
// #MNINN @TEXT("MNINN",key="name",size=1.3,halign="start") => @PLACE(23,-2);
// #MNINN @TEXT("l=30n w=1u multi=1",key="value",size=0.9,halign="start") => @PLACE(23,-9);
// #MNINN @TEXT("",key="model");
// #MNTAIL @SET-SYMBOL $NMOS_4TERM;
// #MNTAIL @PLACE(0,-30) => @ORIENT("R0");
// #MNTAIL @TEXT("MNTAIL",key="name",size=1.3,halign="start") => @PLACE(3,-27);
// #MNTAIL @TEXT("l=30n w=1u multi=1",key="value",size=0.9,halign="start") => @PLACE(3,-34);
// #MNTAIL @TEXT("",key="model");
// #MPRSTN @SET-SYMBOL $PMOS_4TERM;
// #MPRSTN @PLACE(-42,42) => @ORIENT("R0");
// #MPRSTN @TEXT("MPRSTN",key="name",size=1.3,halign="start") => @PLACE(-39,45);
// #MPRSTN @TEXT("l=30n w=500n multi=1",key="value",size=0.9,halign="start") => @PLACE(-39,38);
// #MPRSTN @TEXT("",key="model");
// #MPRSTP @SET-SYMBOL $PMOS_4TERM;
// #MPRSTP @PLACE(42,42) => @ORIENT("MY");
// #MPRSTP @TEXT("MPRSTP",key="name",size=1.3,halign="start") => @PLACE(45,45);
// #MPRSTP @TEXT("l=30n w=500n multi=1",key="value",size=0.9,halign="start") => @PLACE(45,38);
// #MPRSTP @TEXT("",key="model");
// #MPRSTY @SET-SYMBOL $PMOS_4TERM;
// #MPRSTY @PLACE(-42,10) => @ORIENT("R0");
// #MPRSTY @TEXT("MPRSTY",key="name",size=1.3,halign="start") => @PLACE(-39,13);
// #MPRSTY @TEXT("l=30n w=500n multi=1",key="value",size=0.9,halign="start") => @PLACE(-39,6);
// #MPRSTY @TEXT("",key="model");
// #MPRSTX @SET-SYMBOL $PMOS_4TERM;
// #MPRSTX @PLACE(42,10) => @ORIENT("MY");
// #MPRSTX @TEXT("MPRSTX",key="name",size=1.3,halign="start") => @PLACE(45,13);
// #MPRSTX @TEXT("l=30n w=500n multi=1",key="value",size=0.9,halign="start") => @PLACE(45,6);
// #MPRSTX @TEXT("",key="model");
// &"VDD" @WIRE(mode="straight",linecolor="#647584",linewidth=0.16) {(-42,61) (-20,61) (20,61) (42,61)};
// &"VDD" @WIRE(mode="straight",linecolor="#647584",linewidth=0.16) {#MPLATN:3 (-20,61)};
// $JUNCTION @ATTACH (-20,61);
// &"VDD" @WIRE(mode="straight",linecolor="#647584",linewidth=0.16) {#MPLATP:3 (20,61)};
// $JUNCTION @ATTACH (20,61);
// &"VDD" @WIRE(mode="straight",linecolor="#647584",linewidth=0.16) {#MPRSTN:3 (-42,61)};
// $JUNCTION @ATTACH (-42,61);
// &"VDD" @WIRE(mode="straight",linecolor="#647584",linewidth=0.16) {#MPRSTP:3 (42,61)};
// $JUNCTION @ATTACH (42,61);
// &"VDD" @WIRE(mode="straight",linecolor="#647584",linewidth=0.16) {#MPRSTY:3 (-42,61)};
// $JUNCTION @ATTACH (-42,61);
// &"VDD" @WIRE(mode="straight",linecolor="#647584",linewidth=0.16) {#MPRSTX:3 (42,61)};
// $JUNCTION @ATTACH (42,61);
// &"OUTN" @WIRE(mode="straight",linecolor="#226e85",linewidth=0.16) {(-42,31) (-20,31)};
// &"OUTN" @WIRE(mode="straight",linecolor="#226e85",linewidth=0.16) {#MPLATN:1 (-20,31)};
// $JUNCTION @ATTACH (-20,31);
// &"OUTN" @WIRE(mode="straight",linecolor="#226e85",linewidth=0.16) {#MNLATN:1 (-20,31)};
// $JUNCTION @ATTACH (-20,31);
// &"OUTN" @WIRE(mode="straight",linecolor="#226e85",linewidth=0.16) {#MPRSTN:1 (-42,31)};
// $JUNCTION @ATTACH (-42,31);
// &"OUTP" @WIRE(mode="straight",linecolor="#226e85",linewidth=0.16) {(20,33) (42,33)};
// &"OUTP" @WIRE(mode="straight",linecolor="#226e85",linewidth=0.16) {#MPLATP:1 (20,33)};
// $JUNCTION @ATTACH (20,33);
// &"OUTP" @WIRE(mode="straight",linecolor="#226e85",linewidth=0.16) {#MNLATP:1 (20,33)};
// $JUNCTION @ATTACH (20,33);
// &"OUTP" @WIRE(mode="straight",linecolor="#226e85",linewidth=0.16) {#MPRSTP:1 (42,33)};
// $JUNCTION @ATTACH (42,33);
// &"OUTN" @WIRE(mode="straight",linecolor="#226e85",linewidth=0.16) {#MPLATN:1 (-20,36) (8,36) (8,42) #MPLATP:2};
// &"OUTN" @WIRE(mode="straight",linecolor="#226e85",linewidth=0.16) {(8,36) (8,20) #MNLATP:2};
// $JUNCTION @ATTACH (8,36);
// &"OUTP" @WIRE(mode="straight",linecolor="#226e85",linewidth=0.16) {#MPLATP:1 (20,28) (-8,28) (-8,42) #MPLATN:2};
// &"OUTP" @WIRE(mode="straight",linecolor="#226e85",linewidth=0.16) {(-8,28) (-8,20) #MNLATN:2};
// $JUNCTION @ATTACH (-8,28);
// &"Y" @WIRE(mode="straight",linecolor="#226e85",linewidth=0.16) {(-42,4) (-20,4)};
// &"Y" @WIRE(mode="straight",linecolor="#226e85",linewidth=0.16) {#MNLATN:3 (-20,4)};
// $JUNCTION @ATTACH (-20,4);
// &"Y" @WIRE(mode="straight",linecolor="#226e85",linewidth=0.16) {#MNINP:1 (-20,4)};
// $JUNCTION @ATTACH (-20,4);
// &"Y" @WIRE(mode="straight",linecolor="#226e85",linewidth=0.16) {#MPRSTY:1 (-42,4)};
// $JUNCTION @ATTACH (-42,4);
// &"X" @WIRE(mode="straight",linecolor="#226e85",linewidth=0.16) {(20,4) (42,4)};
// &"X" @WIRE(mode="straight",linecolor="#226e85",linewidth=0.16) {#MNLATP:3 (20,4)};
// $JUNCTION @ATTACH (20,4);
// &"X" @WIRE(mode="straight",linecolor="#226e85",linewidth=0.16) {#MNINN:1 (20,4)};
// $JUNCTION @ATTACH (20,4);
// &"X" @WIRE(mode="straight",linecolor="#226e85",linewidth=0.16) {#MPRSTX:1 (42,4)};
// $JUNCTION @ATTACH (42,4);
// &"TAIL" @WIRE(mode="straight",linecolor="#226e85",linewidth=0.16) {(-20,-18) (0,-18) (20,-18)};
// &"TAIL" @WIRE(mode="straight",linecolor="#226e85",linewidth=0.16) {#MNINP:3 (-20,-18)};
// $JUNCTION @ATTACH (-20,-18);
// &"TAIL" @WIRE(mode="straight",linecolor="#226e85",linewidth=0.16) {#MNINN:3 (20,-18)};
// $JUNCTION @ATTACH (20,-18);
// &"TAIL" @WIRE(mode="straight",linecolor="#226e85",linewidth=0.16) {#MNTAIL:1 (0,-18)};
// $JUNCTION @ATTACH (0,-18);
// (-46,-48) @TEXT("VINP -> Y -> OUTN; VINN -> X -> OUTP. CLK resets PMOS and enables tail NMOS.",size=0.95,halign="start",textcolor="#223d52");
// &"VSS" @WIRE(mode="straight",linecolor="#30485d",linewidth=0.16) {#MNLATN:4 (-24,20)};
// (-24.4,20) @TEXT("VSS",size=1.1,halign="end",valign="middle");
// &"VSS" @WIRE(mode="straight",linecolor="#30485d",linewidth=0.16) {#MNLATP:4 (24,20)};
// (24.4,20) @TEXT("VSS",size=1.1,halign="start",valign="middle");
// &"VINN" @WIRE(mode="straight",linecolor="#30485d",linewidth=0.16) {#MNINN:2 (26,-5)};
// (26.4,-5) @TEXT("VINN",size=1.1,halign="start",valign="middle");
// &"VSS" @WIRE(mode="straight",linecolor="#30485d",linewidth=0.16) {#MNINN:4 (16,-5)};
// (15.6,-5) @TEXT("VSS",size=1.1,halign="end",valign="middle");
// &"VINP" @WIRE(mode="straight",linecolor="#30485d",linewidth=0.16) {#MNINP:2 (-26,-5)};
// (-26.4,-5) @TEXT("VINP",size=1.1,halign="end",valign="middle");
// &"VSS" @WIRE(mode="straight",linecolor="#30485d",linewidth=0.16) {#MNINP:4 (-16,-5)};
// (-15.6,-5) @TEXT("VSS",size=1.1,halign="start",valign="middle");
// &"CLK" @WIRE(mode="straight",linecolor="#30485d",linewidth=0.16) {#MNTAIL:2 (-6,-30)};
// (-6.4,-30) @TEXT("CLK",size=1.1,halign="end",valign="middle");
// &"VSS" @WIRE(mode="straight",linecolor="#30485d",linewidth=0.16) {#MNTAIL:3 (0,-35)};
// (0,-35.4) @TEXT("VSS",size=1.1,halign="middle",valign="top");
// &"VSS" @WIRE(mode="straight",linecolor="#30485d",linewidth=0.16) {#MNTAIL:4 (4,-30)};
// (4.4,-30) @TEXT("VSS",size=1.1,halign="start",valign="middle");
// &"CLK" @WIRE(mode="straight",linecolor="#30485d",linewidth=0.16) {#MPRSTN:2 (-48,42)};
// (-48.4,42) @TEXT("CLK",size=1.1,halign="end",valign="middle");
// &"VDD" @WIRE(mode="straight",linecolor="#30485d",linewidth=0.16) {#MPRSTN:4 (-38,42)};
// (-37.6,42) @TEXT("VDD",size=1.1,halign="start",valign="middle");
// &"CLK" @WIRE(mode="straight",linecolor="#30485d",linewidth=0.16) {#MPRSTP:2 (48,42)};
// (48.4,42) @TEXT("CLK",size=1.1,halign="start",valign="middle");
// &"VDD" @WIRE(mode="straight",linecolor="#30485d",linewidth=0.16) {#MPRSTP:4 (38,42)};
// (37.6,42) @TEXT("VDD",size=1.1,halign="end",valign="middle");
// &"CLK" @WIRE(mode="straight",linecolor="#30485d",linewidth=0.16) {#MPRSTY:2 (-48,10)};
// (-48.4,10) @TEXT("CLK",size=1.1,halign="end",valign="middle");
// &"VDD" @WIRE(mode="straight",linecolor="#30485d",linewidth=0.16) {#MPRSTY:4 (-38,10)};
// (-37.6,10) @TEXT("VDD",size=1.1,halign="start",valign="middle");
// &"CLK" @WIRE(mode="straight",linecolor="#30485d",linewidth=0.16) {#MPRSTX:2 (48,10)};
// (48.4,10) @TEXT("CLK",size=1.1,halign="start",valign="middle");
// &"VDD" @WIRE(mode="straight",linecolor="#30485d",linewidth=0.16) {#MPRSTX:4 (38,10)};
// (37.6,10) @TEXT("VDD",size=1.1,halign="end",valign="middle");
// &"VDD" @WIRE(mode="straight",linecolor="#30485d",linewidth=0.16) {#MPLATN:4 (-24,42)};
// (-24.4,42) @TEXT("VDD",size=1.1,halign="end",valign="middle");
// &"VDD" @WIRE(mode="straight",linecolor="#30485d",linewidth=0.16) {#MPLATP:4 (24,42)};
// (24.4,42) @TEXT("VDD",size=1.1,halign="start",valign="middle");
// }
// END SARADC RNL
ends sar_strongarm_t28

subckt sar8p_nonoverlap CODE H L VDD VSS
    X000 (CODE VDD VSS CB) sar8p_inv
    XD_LD (CB VDD VSS LD) sar8p_delay_bbm
    XD_HD (CODE VDD VSS HD) sar8p_delay_bbm
    X004 (CB LD VDD VSS L) sar8p_and2
    X002 (CODE HD VDD VSS H) sar8p_and2
// BEGIN SARADC RNL
// @RNL(author="saradc topology") {
// #X000 @SET-SYMBOL $S_sar8p_inv;
// #X000 @PLACE(0,18) => @ORIENT("R0");
// #XD_LD @SET-SYMBOL $S_sar8p_delay_bbm;
// #XD_LD @PLACE(36,18) => @ORIENT("R0");
// #XD_HD @SET-SYMBOL $S_sar8p_delay_bbm;
// #XD_HD @PLACE(36,-18) => @ORIENT("R0");
// #X004 @SET-SYMBOL $S_sar8p_and2;
// #X004 @PLACE(76,18) => @ORIENT("R0");
// #X002 @SET-SYMBOL $S_sar8p_and2;
// #X002 @PLACE(76,-18) => @ORIENT("R0");
// &"LD" @WIRE(mode="straight",linecolor="#30485d",linewidth=0.16) {#XD_LD:4 (59,18) (59,16.3) #X004:2};
// &"HD" @WIRE(mode="straight",linecolor="#30485d",linewidth=0.16) {#XD_HD:4 (59,-18) (59,-19.7) #X002:2};
// &"CODE" @WIRE(mode="straight",linecolor="#30485d",linewidth=0.16) {(-12,-18) (-12,-16.3) (-12,18)};
// &"CODE" @WIRE(mode="straight",linecolor="#30485d",linewidth=0.16) {#X000:1 (-12,18)};
// $JUNCTION @ATTACH (-12,18);
// &"CODE" @WIRE(mode="straight",linecolor="#30485d",linewidth=0.16) {#XD_HD:1 (-12,-18)};
// $JUNCTION @ATTACH (-12,-18);
// &"CODE" @WIRE(mode="straight",linecolor="#30485d",linewidth=0.16) {#X002:1 (-12,-16.3)};
// $JUNCTION @ATTACH (-12,-16.3);
// &"CB" @WIRE(mode="straight",linecolor="#30485d",linewidth=0.16) {(2,18) (2,19.7)};
// &"CB" @WIRE(mode="straight",linecolor="#30485d",linewidth=0.16) {#X000:4 (2,18)};
// $JUNCTION @ATTACH (2,18);
// &"CB" @WIRE(mode="straight",linecolor="#30485d",linewidth=0.16) {#XD_LD:1 (2,18)};
// $JUNCTION @ATTACH (2,18);
// &"CB" @WIRE(mode="straight",linecolor="#30485d",linewidth=0.16) {#X004:1 (2,19.7)};
// $JUNCTION @ATTACH (2,19.7);
// (-16,46) @TEXT("sar8p_nonoverlap / native standard-cell composition",size=1.3,halign="start",textcolor="#223d52");
// &"VDD" @WIRE(mode="straight",linecolor="#30485d",linewidth=0.16) {#X000:2 (0,28)};
// (0,28.4) @TEXT("VDD",size=1.1,halign="middle",valign="bottom");
// &"VSS" @WIRE(mode="straight",linecolor="#30485d",linewidth=0.16) {#X000:3 (0,8)};
// (0,7.6) @TEXT("VSS",size=1.1,halign="middle",valign="top");
// &"VDD" @WIRE(mode="straight",linecolor="#30485d",linewidth=0.16) {#XD_LD:2 (36,29)};
// (36,29.4) @TEXT("VDD",size=1.1,halign="middle",valign="bottom");
// &"VSS" @WIRE(mode="straight",linecolor="#30485d",linewidth=0.16) {#XD_LD:3 (36,7)};
// (36,6.6) @TEXT("VSS",size=1.1,halign="middle",valign="top");
// &"VDD" @WIRE(mode="straight",linecolor="#30485d",linewidth=0.16) {#XD_HD:2 (36,-7)};
// (36,-6.6) @TEXT("VDD",size=1.1,halign="middle",valign="bottom");
// &"VSS" @WIRE(mode="straight",linecolor="#30485d",linewidth=0.16) {#XD_HD:3 (36,-29)};
// (36,-29.4) @TEXT("VSS",size=1.1,halign="middle",valign="top");
// &"VDD" @WIRE(mode="straight",linecolor="#30485d",linewidth=0.16) {#X004:3 (76,28)};
// (76,28.4) @TEXT("VDD",size=1.1,halign="middle",valign="bottom");
// &"VSS" @WIRE(mode="straight",linecolor="#30485d",linewidth=0.16) {#X004:4 (76,8)};
// (76,7.6) @TEXT("VSS",size=1.1,halign="middle",valign="top");
// &"L" @WIRE(mode="straight",linecolor="#30485d",linewidth=0.16) {#X004:5 (86,18)};
// (86.4,18) @TEXT("L",size=1.1,halign="start",valign="middle");
// &"VDD" @WIRE(mode="straight",linecolor="#30485d",linewidth=0.16) {#X002:3 (76,-8)};
// (76,-7.6) @TEXT("VDD",size=1.1,halign="middle",valign="bottom");
// &"VSS" @WIRE(mode="straight",linecolor="#30485d",linewidth=0.16) {#X002:4 (76,-28)};
// (76,-28.4) @TEXT("VSS",size=1.1,halign="middle",valign="top");
// &"H" @WIRE(mode="straight",linecolor="#30485d",linewidth=0.16) {#X002:5 (86,-18)};
// (86.4,-18) @TEXT("H",size=1.1,halign="start",valign="middle");
// }
// END SARADC RNL
ends sar8p_nonoverlap

subckt sar8p_refdrv_b0 GNN GNP GPN GPP H L VDD VSS
    XSTD_GNNCN (GNNB GNNDRV VDD VSS) INVD1BWP12T30P140
    XSTD_GNNBN (GNNA GNNB VDD VSS) INVD1BWP12T30P140
    XSTD_GNNAN (GNNPRE GNNA VDD VSS) INVD1BWP12T30P140
    XSTD_GNPCN (GNPB GNPDRV VDD VSS) INVD1BWP12T30P140
    XSTD_GNPBN (GNPA GNPB VDD VSS) INVD1BWP12T30P140
    XSTD_GNPAN (H GNPA VDD VSS) INVD1BWP12T30P140
    XSTD_GPNCN (GPNB GPNDRV VDD VSS) INVD1BWP12T30P140
    XSTD_GPNBN (GPNA GPNB VDD VSS) INVD1BWP12T30P140
    XSTD_GPNAN (GPNPRE GPNA VDD VSS) INVD1BWP12T30P140
    XSTD_GPPCN (GPPB GPPDRV VDD VSS) INVD1BWP12T30P140
    XSTD_GPPBN (GPPA GPPB VDD VSS) INVD1BWP12T30P140
    XSTD_GPPAN (L GPPA VDD VSS) INVD1BWP12T30P140
//Series configuration of RGNN1
RGNN1  (GNNRG RGNN1_1__dmy0 ) rupolym l=17.13u w=1u m=1 multi=(1)
RGNN1_2__dmy0  (RGNN1_1__dmy0 RGNN1_2__dmy0 ) rupolym l=17.13u w=1u m=1          multi=(1)
RGNN1_3__dmy0  (RGNN1_2__dmy0 RGNN1_3__dmy0 ) rupolym l=17.13u w=1u m=1          multi=(1)
RGNN1_4__dmy0  (RGNN1_3__dmy0 RGNN1_4__dmy0 ) rupolym l=17.13u w=1u m=1          multi=(1)
RGNN1_5__dmy0  (RGNN1_4__dmy0 GNN ) rupolym l=17.13u w=1u m=1 multi=(1)
//End of RGNN1

//Series configuration of RGNN0
RGNN0  (GNNDRV RGNN0_1__dmy0 ) rupolym l=17.13u w=1u m=1 multi=(1)
RGNN0_2__dmy0  (RGNN0_1__dmy0 RGNN0_2__dmy0 ) rupolym l=17.13u w=1u m=1          multi=(1)
RGNN0_3__dmy0  (RGNN0_2__dmy0 RGNN0_3__dmy0 ) rupolym l=17.13u w=1u m=1          multi=(1)
RGNN0_4__dmy0  (RGNN0_3__dmy0 RGNN0_4__dmy0 ) rupolym l=17.13u w=1u m=1          multi=(1)
RGNN0_5__dmy0  (RGNN0_4__dmy0 GNNRG ) rupolym l=17.13u w=1u m=1 multi=(1)
//End of RGNN0

//Series configuration of RGNP1
RGNP1  (GNPRG RGNP1_1__dmy0 ) rupolym l=17.13u w=1u m=1 multi=(1)
RGNP1_2__dmy0  (RGNP1_1__dmy0 RGNP1_2__dmy0 ) rupolym l=17.13u w=1u m=1          multi=(1)
RGNP1_3__dmy0  (RGNP1_2__dmy0 RGNP1_3__dmy0 ) rupolym l=17.13u w=1u m=1          multi=(1)
RGNP1_4__dmy0  (RGNP1_3__dmy0 RGNP1_4__dmy0 ) rupolym l=17.13u w=1u m=1          multi=(1)
RGNP1_5__dmy0  (RGNP1_4__dmy0 GNP ) rupolym l=17.13u w=1u m=1 multi=(1)
//End of RGNP1

//Series configuration of RGNP0
RGNP0  (GNPDRV RGNP0_1__dmy0 ) rupolym l=17.13u w=1u m=1 multi=(1)
RGNP0_2__dmy0  (RGNP0_1__dmy0 RGNP0_2__dmy0 ) rupolym l=17.13u w=1u m=1          multi=(1)
RGNP0_3__dmy0  (RGNP0_2__dmy0 RGNP0_3__dmy0 ) rupolym l=17.13u w=1u m=1          multi=(1)
RGNP0_4__dmy0  (RGNP0_3__dmy0 RGNP0_4__dmy0 ) rupolym l=17.13u w=1u m=1          multi=(1)
RGNP0_5__dmy0  (RGNP0_4__dmy0 GNPRG ) rupolym l=17.13u w=1u m=1 multi=(1)
//End of RGNP0

//Series configuration of RGPN1
RGPN1  (GPNRG RGPN1_1__dmy0 ) rupolym l=17.13u w=1u m=1 multi=(1)
RGPN1_2__dmy0  (RGPN1_1__dmy0 RGPN1_2__dmy0 ) rupolym l=17.13u w=1u m=1          multi=(1)
RGPN1_3__dmy0  (RGPN1_2__dmy0 RGPN1_3__dmy0 ) rupolym l=17.13u w=1u m=1          multi=(1)
RGPN1_4__dmy0  (RGPN1_3__dmy0 RGPN1_4__dmy0 ) rupolym l=17.13u w=1u m=1          multi=(1)
RGPN1_5__dmy0  (RGPN1_4__dmy0 GPN ) rupolym l=17.13u w=1u m=1 multi=(1)
//End of RGPN1

//Series configuration of RGPN0
RGPN0  (GPNDRV RGPN0_1__dmy0 ) rupolym l=17.13u w=1u m=1 multi=(1)
RGPN0_2__dmy0  (RGPN0_1__dmy0 RGPN0_2__dmy0 ) rupolym l=17.13u w=1u m=1          multi=(1)
RGPN0_3__dmy0  (RGPN0_2__dmy0 RGPN0_3__dmy0 ) rupolym l=17.13u w=1u m=1          multi=(1)
RGPN0_4__dmy0  (RGPN0_3__dmy0 RGPN0_4__dmy0 ) rupolym l=17.13u w=1u m=1          multi=(1)
RGPN0_5__dmy0  (RGPN0_4__dmy0 GPNRG ) rupolym l=17.13u w=1u m=1 multi=(1)
//End of RGPN0

//Series configuration of RGPP1
RGPP1  (GPPRG RGPP1_1__dmy0 ) rupolym l=17.13u w=1u m=1 multi=(1)
RGPP1_2__dmy0  (RGPP1_1__dmy0 RGPP1_2__dmy0 ) rupolym l=17.13u w=1u m=1          multi=(1)
RGPP1_3__dmy0  (RGPP1_2__dmy0 RGPP1_3__dmy0 ) rupolym l=17.13u w=1u m=1          multi=(1)
RGPP1_4__dmy0  (RGPP1_3__dmy0 RGPP1_4__dmy0 ) rupolym l=17.13u w=1u m=1          multi=(1)
RGPP1_5__dmy0  (RGPP1_4__dmy0 GPP ) rupolym l=17.13u w=1u m=1 multi=(1)
//End of RGPP1

//Series configuration of RGPP0
RGPP0  (GPPDRV RGPP0_1__dmy0 ) rupolym l=17.13u w=1u m=1 multi=(1)
RGPP0_2__dmy0  (RGPP0_1__dmy0 RGPP0_2__dmy0 ) rupolym l=17.13u w=1u m=1          multi=(1)
RGPP0_3__dmy0  (RGPP0_2__dmy0 RGPP0_3__dmy0 ) rupolym l=17.13u w=1u m=1          multi=(1)
RGPP0_4__dmy0  (RGPP0_3__dmy0 RGPP0_4__dmy0 ) rupolym l=17.13u w=1u m=1          multi=(1)
RGPP0_5__dmy0  (RGPP0_4__dmy0 GPPRG ) rupolym l=17.13u w=1u m=1 multi=(1)
//End of RGPP0

    X025 (L VDD VSS GNNPRE) sar8p_inv
    X008 (H VDD VSS GPNPRE) sar8p_inv
// BEGIN SARADC RNL
// @RNL(author="saradc topology") {
// (-28,27) @TEXT("sar8p_refdrv_b0 / four physical gate-driver chains",size=1.5,halign="start",textcolor="#223d52");
// #X025 @SET-SYMBOL $S_sar8p_inv;
// #X025 @PLACE(-17,0) => @ORIENT("R0");
// #XSTD_GNNAN @SET-SYMBOL $S_INVD1BWP12T30P140;
// #XSTD_GNNAN @PLACE(18,0) => @ORIENT("R0");
// #XSTD_GNNBN @SET-SYMBOL $S_INVD1BWP12T30P140;
// #XSTD_GNNBN @PLACE(47,0) => @ORIENT("R0");
// #XSTD_GNNCN @SET-SYMBOL $S_INVD1BWP12T30P140;
// #XSTD_GNNCN @PLACE(76,0) => @ORIENT("R0");
// #RGNN0 @SET-SYMBOL $RESISTOR;
// #RGNN0 @PLACE(110,0) => @ORIENT("R90");
// #RGNN0 @TEXT("RGNN0",key="name",size=1.3,halign="start") => @PLACE(113,3);
// #RGNN0 @TEXT("l=17.13u w=1u multi=(1)",key="value",size=0.9,halign="start") => @PLACE(113,-4);
// #RGNN0 @TEXT("",key="model");
// #RGNN0_2__dmy0 @SET-SYMBOL $RESISTOR;
// #RGNN0_2__dmy0 @PLACE(135,0) => @ORIENT("R90");
// #RGNN0_2__dmy0 @TEXT("RGNN0_2__dmy0",key="name",size=1.3,halign="start") => @PLACE(138,3);
// #RGNN0_2__dmy0 @TEXT("l=17.13u w=1u multi=(1)",key="value",size=0.9,halign="start") => @PLACE(138,-4);
// #RGNN0_2__dmy0 @TEXT("",key="model");
// #RGNN0_3__dmy0 @SET-SYMBOL $RESISTOR;
// #RGNN0_3__dmy0 @PLACE(160,0) => @ORIENT("R90");
// #RGNN0_3__dmy0 @TEXT("RGNN0_3__dmy0",key="name",size=1.3,halign="start") => @PLACE(163,3);
// #RGNN0_3__dmy0 @TEXT("l=17.13u w=1u multi=(1)",key="value",size=0.9,halign="start") => @PLACE(163,-4);
// #RGNN0_3__dmy0 @TEXT("",key="model");
// #RGNN0_4__dmy0 @SET-SYMBOL $RESISTOR;
// #RGNN0_4__dmy0 @PLACE(185,0) => @ORIENT("R90");
// #RGNN0_4__dmy0 @TEXT("RGNN0_4__dmy0",key="name",size=1.3,halign="start") => @PLACE(188,3);
// #RGNN0_4__dmy0 @TEXT("l=17.13u w=1u multi=(1)",key="value",size=0.9,halign="start") => @PLACE(188,-4);
// #RGNN0_4__dmy0 @TEXT("",key="model");
// #RGNN0_5__dmy0 @SET-SYMBOL $RESISTOR;
// #RGNN0_5__dmy0 @PLACE(210,0) => @ORIENT("R90");
// #RGNN0_5__dmy0 @TEXT("RGNN0_5__dmy0",key="name",size=1.3,halign="start") => @PLACE(213,3);
// #RGNN0_5__dmy0 @TEXT("l=17.13u w=1u multi=(1)",key="value",size=0.9,halign="start") => @PLACE(213,-4);
// #RGNN0_5__dmy0 @TEXT("",key="model");
// #RGNN1 @SET-SYMBOL $RESISTOR;
// #RGNN1 @PLACE(235,0) => @ORIENT("R90");
// #RGNN1 @TEXT("RGNN1",key="name",size=1.3,halign="start") => @PLACE(238,3);
// #RGNN1 @TEXT("l=17.13u w=1u multi=(1)",key="value",size=0.9,halign="start") => @PLACE(238,-4);
// #RGNN1 @TEXT("",key="model");
// #RGNN1_2__dmy0 @SET-SYMBOL $RESISTOR;
// #RGNN1_2__dmy0 @PLACE(260,0) => @ORIENT("R90");
// #RGNN1_2__dmy0 @TEXT("RGNN1_2__dmy0",key="name",size=1.3,halign="start") => @PLACE(263,3);
// #RGNN1_2__dmy0 @TEXT("l=17.13u w=1u multi=(1)",key="value",size=0.9,halign="start") => @PLACE(263,-4);
// #RGNN1_2__dmy0 @TEXT("",key="model");
// #RGNN1_3__dmy0 @SET-SYMBOL $RESISTOR;
// #RGNN1_3__dmy0 @PLACE(285,0) => @ORIENT("R90");
// #RGNN1_3__dmy0 @TEXT("RGNN1_3__dmy0",key="name",size=1.3,halign="start") => @PLACE(288,3);
// #RGNN1_3__dmy0 @TEXT("l=17.13u w=1u multi=(1)",key="value",size=0.9,halign="start") => @PLACE(288,-4);
// #RGNN1_3__dmy0 @TEXT("",key="model");
// #RGNN1_4__dmy0 @SET-SYMBOL $RESISTOR;
// #RGNN1_4__dmy0 @PLACE(310,0) => @ORIENT("R90");
// #RGNN1_4__dmy0 @TEXT("RGNN1_4__dmy0",key="name",size=1.3,halign="start") => @PLACE(313,3);
// #RGNN1_4__dmy0 @TEXT("l=17.13u w=1u multi=(1)",key="value",size=0.9,halign="start") => @PLACE(313,-4);
// #RGNN1_4__dmy0 @TEXT("",key="model");
// #RGNN1_5__dmy0 @SET-SYMBOL $RESISTOR;
// #RGNN1_5__dmy0 @PLACE(335,0) => @ORIENT("R90");
// #RGNN1_5__dmy0 @TEXT("RGNN1_5__dmy0",key="name",size=1.3,halign="start") => @PLACE(338,3);
// #RGNN1_5__dmy0 @TEXT("l=17.13u w=1u multi=(1)",key="value",size=0.9,halign="start") => @PLACE(338,-4);
// #RGNN1_5__dmy0 @TEXT("",key="model");
// (104,15) @TEXT("GNN / 10 series poly sections",size=0.95,halign="start",textcolor="#223d52");
// #XSTD_GNPAN @SET-SYMBOL $S_INVD1BWP12T30P140;
// #XSTD_GNPAN @PLACE(18,-38) => @ORIENT("R0");
// #XSTD_GNPBN @SET-SYMBOL $S_INVD1BWP12T30P140;
// #XSTD_GNPBN @PLACE(47,-38) => @ORIENT("R0");
// #XSTD_GNPCN @SET-SYMBOL $S_INVD1BWP12T30P140;
// #XSTD_GNPCN @PLACE(76,-38) => @ORIENT("R0");
// #RGNP0 @SET-SYMBOL $RESISTOR;
// #RGNP0 @PLACE(110,-38) => @ORIENT("R90");
// #RGNP0 @TEXT("RGNP0",key="name",size=1.3,halign="start") => @PLACE(113,-35);
// #RGNP0 @TEXT("l=17.13u w=1u multi=(1)",key="value",size=0.9,halign="start") => @PLACE(113,-42);
// #RGNP0 @TEXT("",key="model");
// #RGNP0_2__dmy0 @SET-SYMBOL $RESISTOR;
// #RGNP0_2__dmy0 @PLACE(135,-38) => @ORIENT("R90");
// #RGNP0_2__dmy0 @TEXT("RGNP0_2__dmy0",key="name",size=1.3,halign="start") => @PLACE(138,-35);
// #RGNP0_2__dmy0 @TEXT("l=17.13u w=1u multi=(1)",key="value",size=0.9,halign="start") => @PLACE(138,-42);
// #RGNP0_2__dmy0 @TEXT("",key="model");
// #RGNP0_3__dmy0 @SET-SYMBOL $RESISTOR;
// #RGNP0_3__dmy0 @PLACE(160,-38) => @ORIENT("R90");
// #RGNP0_3__dmy0 @TEXT("RGNP0_3__dmy0",key="name",size=1.3,halign="start") => @PLACE(163,-35);
// #RGNP0_3__dmy0 @TEXT("l=17.13u w=1u multi=(1)",key="value",size=0.9,halign="start") => @PLACE(163,-42);
// #RGNP0_3__dmy0 @TEXT("",key="model");
// #RGNP0_4__dmy0 @SET-SYMBOL $RESISTOR;
// #RGNP0_4__dmy0 @PLACE(185,-38) => @ORIENT("R90");
// #RGNP0_4__dmy0 @TEXT("RGNP0_4__dmy0",key="name",size=1.3,halign="start") => @PLACE(188,-35);
// #RGNP0_4__dmy0 @TEXT("l=17.13u w=1u multi=(1)",key="value",size=0.9,halign="start") => @PLACE(188,-42);
// #RGNP0_4__dmy0 @TEXT("",key="model");
// #RGNP0_5__dmy0 @SET-SYMBOL $RESISTOR;
// #RGNP0_5__dmy0 @PLACE(210,-38) => @ORIENT("R90");
// #RGNP0_5__dmy0 @TEXT("RGNP0_5__dmy0",key="name",size=1.3,halign="start") => @PLACE(213,-35);
// #RGNP0_5__dmy0 @TEXT("l=17.13u w=1u multi=(1)",key="value",size=0.9,halign="start") => @PLACE(213,-42);
// #RGNP0_5__dmy0 @TEXT("",key="model");
// #RGNP1 @SET-SYMBOL $RESISTOR;
// #RGNP1 @PLACE(235,-38) => @ORIENT("R90");
// #RGNP1 @TEXT("RGNP1",key="name",size=1.3,halign="start") => @PLACE(238,-35);
// #RGNP1 @TEXT("l=17.13u w=1u multi=(1)",key="value",size=0.9,halign="start") => @PLACE(238,-42);
// #RGNP1 @TEXT("",key="model");
// #RGNP1_2__dmy0 @SET-SYMBOL $RESISTOR;
// #RGNP1_2__dmy0 @PLACE(260,-38) => @ORIENT("R90");
// #RGNP1_2__dmy0 @TEXT("RGNP1_2__dmy0",key="name",size=1.3,halign="start") => @PLACE(263,-35);
// #RGNP1_2__dmy0 @TEXT("l=17.13u w=1u multi=(1)",key="value",size=0.9,halign="start") => @PLACE(263,-42);
// #RGNP1_2__dmy0 @TEXT("",key="model");
// #RGNP1_3__dmy0 @SET-SYMBOL $RESISTOR;
// #RGNP1_3__dmy0 @PLACE(285,-38) => @ORIENT("R90");
// #RGNP1_3__dmy0 @TEXT("RGNP1_3__dmy0",key="name",size=1.3,halign="start") => @PLACE(288,-35);
// #RGNP1_3__dmy0 @TEXT("l=17.13u w=1u multi=(1)",key="value",size=0.9,halign="start") => @PLACE(288,-42);
// #RGNP1_3__dmy0 @TEXT("",key="model");
// #RGNP1_4__dmy0 @SET-SYMBOL $RESISTOR;
// #RGNP1_4__dmy0 @PLACE(310,-38) => @ORIENT("R90");
// #RGNP1_4__dmy0 @TEXT("RGNP1_4__dmy0",key="name",size=1.3,halign="start") => @PLACE(313,-35);
// #RGNP1_4__dmy0 @TEXT("l=17.13u w=1u multi=(1)",key="value",size=0.9,halign="start") => @PLACE(313,-42);
// #RGNP1_4__dmy0 @TEXT("",key="model");
// #RGNP1_5__dmy0 @SET-SYMBOL $RESISTOR;
// #RGNP1_5__dmy0 @PLACE(335,-38) => @ORIENT("R90");
// #RGNP1_5__dmy0 @TEXT("RGNP1_5__dmy0",key="name",size=1.3,halign="start") => @PLACE(338,-35);
// #RGNP1_5__dmy0 @TEXT("l=17.13u w=1u multi=(1)",key="value",size=0.9,halign="start") => @PLACE(338,-42);
// #RGNP1_5__dmy0 @TEXT("",key="model");
// (104,-23) @TEXT("GNP / 10 series poly sections",size=0.95,halign="start",textcolor="#223d52");
// #X008 @SET-SYMBOL $S_sar8p_inv;
// #X008 @PLACE(-17,-76) => @ORIENT("R0");
// #XSTD_GPNAN @SET-SYMBOL $S_INVD1BWP12T30P140;
// #XSTD_GPNAN @PLACE(18,-76) => @ORIENT("R0");
// #XSTD_GPNBN @SET-SYMBOL $S_INVD1BWP12T30P140;
// #XSTD_GPNBN @PLACE(47,-76) => @ORIENT("R0");
// #XSTD_GPNCN @SET-SYMBOL $S_INVD1BWP12T30P140;
// #XSTD_GPNCN @PLACE(76,-76) => @ORIENT("R0");
// #RGPN0 @SET-SYMBOL $RESISTOR;
// #RGPN0 @PLACE(110,-76) => @ORIENT("R90");
// #RGPN0 @TEXT("RGPN0",key="name",size=1.3,halign="start") => @PLACE(113,-73);
// #RGPN0 @TEXT("l=17.13u w=1u multi=(1)",key="value",size=0.9,halign="start") => @PLACE(113,-80);
// #RGPN0 @TEXT("",key="model");
// #RGPN0_2__dmy0 @SET-SYMBOL $RESISTOR;
// #RGPN0_2__dmy0 @PLACE(135,-76) => @ORIENT("R90");
// #RGPN0_2__dmy0 @TEXT("RGPN0_2__dmy0",key="name",size=1.3,halign="start") => @PLACE(138,-73);
// #RGPN0_2__dmy0 @TEXT("l=17.13u w=1u multi=(1)",key="value",size=0.9,halign="start") => @PLACE(138,-80);
// #RGPN0_2__dmy0 @TEXT("",key="model");
// #RGPN0_3__dmy0 @SET-SYMBOL $RESISTOR;
// #RGPN0_3__dmy0 @PLACE(160,-76) => @ORIENT("R90");
// #RGPN0_3__dmy0 @TEXT("RGPN0_3__dmy0",key="name",size=1.3,halign="start") => @PLACE(163,-73);
// #RGPN0_3__dmy0 @TEXT("l=17.13u w=1u multi=(1)",key="value",size=0.9,halign="start") => @PLACE(163,-80);
// #RGPN0_3__dmy0 @TEXT("",key="model");
// #RGPN0_4__dmy0 @SET-SYMBOL $RESISTOR;
// #RGPN0_4__dmy0 @PLACE(185,-76) => @ORIENT("R90");
// #RGPN0_4__dmy0 @TEXT("RGPN0_4__dmy0",key="name",size=1.3,halign="start") => @PLACE(188,-73);
// #RGPN0_4__dmy0 @TEXT("l=17.13u w=1u multi=(1)",key="value",size=0.9,halign="start") => @PLACE(188,-80);
// #RGPN0_4__dmy0 @TEXT("",key="model");
// #RGPN0_5__dmy0 @SET-SYMBOL $RESISTOR;
// #RGPN0_5__dmy0 @PLACE(210,-76) => @ORIENT("R90");
// #RGPN0_5__dmy0 @TEXT("RGPN0_5__dmy0",key="name",size=1.3,halign="start") => @PLACE(213,-73);
// #RGPN0_5__dmy0 @TEXT("l=17.13u w=1u multi=(1)",key="value",size=0.9,halign="start") => @PLACE(213,-80);
// #RGPN0_5__dmy0 @TEXT("",key="model");
// #RGPN1 @SET-SYMBOL $RESISTOR;
// #RGPN1 @PLACE(235,-76) => @ORIENT("R90");
// #RGPN1 @TEXT("RGPN1",key="name",size=1.3,halign="start") => @PLACE(238,-73);
// #RGPN1 @TEXT("l=17.13u w=1u multi=(1)",key="value",size=0.9,halign="start") => @PLACE(238,-80);
// #RGPN1 @TEXT("",key="model");
// #RGPN1_2__dmy0 @SET-SYMBOL $RESISTOR;
// #RGPN1_2__dmy0 @PLACE(260,-76) => @ORIENT("R90");
// #RGPN1_2__dmy0 @TEXT("RGPN1_2__dmy0",key="name",size=1.3,halign="start") => @PLACE(263,-73);
// #RGPN1_2__dmy0 @TEXT("l=17.13u w=1u multi=(1)",key="value",size=0.9,halign="start") => @PLACE(263,-80);
// #RGPN1_2__dmy0 @TEXT("",key="model");
// #RGPN1_3__dmy0 @SET-SYMBOL $RESISTOR;
// #RGPN1_3__dmy0 @PLACE(285,-76) => @ORIENT("R90");
// #RGPN1_3__dmy0 @TEXT("RGPN1_3__dmy0",key="name",size=1.3,halign="start") => @PLACE(288,-73);
// #RGPN1_3__dmy0 @TEXT("l=17.13u w=1u multi=(1)",key="value",size=0.9,halign="start") => @PLACE(288,-80);
// #RGPN1_3__dmy0 @TEXT("",key="model");
// #RGPN1_4__dmy0 @SET-SYMBOL $RESISTOR;
// #RGPN1_4__dmy0 @PLACE(310,-76) => @ORIENT("R90");
// #RGPN1_4__dmy0 @TEXT("RGPN1_4__dmy0",key="name",size=1.3,halign="start") => @PLACE(313,-73);
// #RGPN1_4__dmy0 @TEXT("l=17.13u w=1u multi=(1)",key="value",size=0.9,halign="start") => @PLACE(313,-80);
// #RGPN1_4__dmy0 @TEXT("",key="model");
// #RGPN1_5__dmy0 @SET-SYMBOL $RESISTOR;
// #RGPN1_5__dmy0 @PLACE(335,-76) => @ORIENT("R90");
// #RGPN1_5__dmy0 @TEXT("RGPN1_5__dmy0",key="name",size=1.3,halign="start") => @PLACE(338,-73);
// #RGPN1_5__dmy0 @TEXT("l=17.13u w=1u multi=(1)",key="value",size=0.9,halign="start") => @PLACE(338,-80);
// #RGPN1_5__dmy0 @TEXT("",key="model");
// (104,-61) @TEXT("GPN / 10 series poly sections",size=0.95,halign="start",textcolor="#223d52");
// #XSTD_GPPAN @SET-SYMBOL $S_INVD1BWP12T30P140;
// #XSTD_GPPAN @PLACE(18,-114) => @ORIENT("R0");
// #XSTD_GPPBN @SET-SYMBOL $S_INVD1BWP12T30P140;
// #XSTD_GPPBN @PLACE(47,-114) => @ORIENT("R0");
// #XSTD_GPPCN @SET-SYMBOL $S_INVD1BWP12T30P140;
// #XSTD_GPPCN @PLACE(76,-114) => @ORIENT("R0");
// #RGPP0 @SET-SYMBOL $RESISTOR;
// #RGPP0 @PLACE(110,-114) => @ORIENT("R90");
// #RGPP0 @TEXT("RGPP0",key="name",size=1.3,halign="start") => @PLACE(113,-111);
// #RGPP0 @TEXT("l=17.13u w=1u multi=(1)",key="value",size=0.9,halign="start") => @PLACE(113,-118);
// #RGPP0 @TEXT("",key="model");
// #RGPP0_2__dmy0 @SET-SYMBOL $RESISTOR;
// #RGPP0_2__dmy0 @PLACE(135,-114) => @ORIENT("R90");
// #RGPP0_2__dmy0 @TEXT("RGPP0_2__dmy0",key="name",size=1.3,halign="start") => @PLACE(138,-111);
// #RGPP0_2__dmy0 @TEXT("l=17.13u w=1u multi=(1)",key="value",size=0.9,halign="start") => @PLACE(138,-118);
// #RGPP0_2__dmy0 @TEXT("",key="model");
// #RGPP0_3__dmy0 @SET-SYMBOL $RESISTOR;
// #RGPP0_3__dmy0 @PLACE(160,-114) => @ORIENT("R90");
// #RGPP0_3__dmy0 @TEXT("RGPP0_3__dmy0",key="name",size=1.3,halign="start") => @PLACE(163,-111);
// #RGPP0_3__dmy0 @TEXT("l=17.13u w=1u multi=(1)",key="value",size=0.9,halign="start") => @PLACE(163,-118);
// #RGPP0_3__dmy0 @TEXT("",key="model");
// #RGPP0_4__dmy0 @SET-SYMBOL $RESISTOR;
// #RGPP0_4__dmy0 @PLACE(185,-114) => @ORIENT("R90");
// #RGPP0_4__dmy0 @TEXT("RGPP0_4__dmy0",key="name",size=1.3,halign="start") => @PLACE(188,-111);
// #RGPP0_4__dmy0 @TEXT("l=17.13u w=1u multi=(1)",key="value",size=0.9,halign="start") => @PLACE(188,-118);
// #RGPP0_4__dmy0 @TEXT("",key="model");
// #RGPP0_5__dmy0 @SET-SYMBOL $RESISTOR;
// #RGPP0_5__dmy0 @PLACE(210,-114) => @ORIENT("R90");
// #RGPP0_5__dmy0 @TEXT("RGPP0_5__dmy0",key="name",size=1.3,halign="start") => @PLACE(213,-111);
// #RGPP0_5__dmy0 @TEXT("l=17.13u w=1u multi=(1)",key="value",size=0.9,halign="start") => @PLACE(213,-118);
// #RGPP0_5__dmy0 @TEXT("",key="model");
// #RGPP1 @SET-SYMBOL $RESISTOR;
// #RGPP1 @PLACE(235,-114) => @ORIENT("R90");
// #RGPP1 @TEXT("RGPP1",key="name",size=1.3,halign="start") => @PLACE(238,-111);
// #RGPP1 @TEXT("l=17.13u w=1u multi=(1)",key="value",size=0.9,halign="start") => @PLACE(238,-118);
// #RGPP1 @TEXT("",key="model");
// #RGPP1_2__dmy0 @SET-SYMBOL $RESISTOR;
// #RGPP1_2__dmy0 @PLACE(260,-114) => @ORIENT("R90");
// #RGPP1_2__dmy0 @TEXT("RGPP1_2__dmy0",key="name",size=1.3,halign="start") => @PLACE(263,-111);
// #RGPP1_2__dmy0 @TEXT("l=17.13u w=1u multi=(1)",key="value",size=0.9,halign="start") => @PLACE(263,-118);
// #RGPP1_2__dmy0 @TEXT("",key="model");
// #RGPP1_3__dmy0 @SET-SYMBOL $RESISTOR;
// #RGPP1_3__dmy0 @PLACE(285,-114) => @ORIENT("R90");
// #RGPP1_3__dmy0 @TEXT("RGPP1_3__dmy0",key="name",size=1.3,halign="start") => @PLACE(288,-111);
// #RGPP1_3__dmy0 @TEXT("l=17.13u w=1u multi=(1)",key="value",size=0.9,halign="start") => @PLACE(288,-118);
// #RGPP1_3__dmy0 @TEXT("",key="model");
// #RGPP1_4__dmy0 @SET-SYMBOL $RESISTOR;
// #RGPP1_4__dmy0 @PLACE(310,-114) => @ORIENT("R90");
// #RGPP1_4__dmy0 @TEXT("RGPP1_4__dmy0",key="name",size=1.3,halign="start") => @PLACE(313,-111);
// #RGPP1_4__dmy0 @TEXT("l=17.13u w=1u multi=(1)",key="value",size=0.9,halign="start") => @PLACE(313,-118);
// #RGPP1_4__dmy0 @TEXT("",key="model");
// #RGPP1_5__dmy0 @SET-SYMBOL $RESISTOR;
// #RGPP1_5__dmy0 @PLACE(335,-114) => @ORIENT("R90");
// #RGPP1_5__dmy0 @TEXT("RGPP1_5__dmy0",key="name",size=1.3,halign="start") => @PLACE(338,-111);
// #RGPP1_5__dmy0 @TEXT("l=17.13u w=1u multi=(1)",key="value",size=0.9,halign="start") => @PLACE(338,-118);
// #RGPP1_5__dmy0 @TEXT("",key="model");
// (104,-99) @TEXT("GPP / 10 series poly sections",size=0.95,halign="start",textcolor="#223d52");
// &"GNNB" @WIRE(mode="straight",linecolor="#30485d",linewidth=0.16) {#XSTD_GNNCN:1 (61.5,0) (61.5,0) #XSTD_GNNBN:2};
// &"GNNDRV" @WIRE(mode="straight",linecolor="#30485d",linewidth=0.16) {#XSTD_GNNCN:2 (95.5,0) (95.5,0) #RGNN0:1};
// &"GNNA" @WIRE(mode="straight",linecolor="#30485d",linewidth=0.16) {#XSTD_GNNBN:1 (32.5,0) (32.5,0) #XSTD_GNNAN:2};
// &"GNNPRE" @WIRE(mode="straight",linecolor="#30485d",linewidth=0.16) {#XSTD_GNNAN:1 (0.5,0) (0.5,0) #X025:4};
// &"GNPB" @WIRE(mode="straight",linecolor="#30485d",linewidth=0.16) {#XSTD_GNPCN:1 (61.5,-38) (61.5,-38) #XSTD_GNPBN:2};
// &"GNPDRV" @WIRE(mode="straight",linecolor="#30485d",linewidth=0.16) {#XSTD_GNPCN:2 (95.5,-38) (95.5,-38) #RGNP0:1};
// &"GNPA" @WIRE(mode="straight",linecolor="#30485d",linewidth=0.16) {#XSTD_GNPBN:1 (32.5,-38) (32.5,-38) #XSTD_GNPAN:2};
// &"H" @WIRE(mode="straight",linecolor="#30485d",linewidth=0.16) {#XSTD_GNPAN:1 (-6.5,-38) (-6.5,-76) #X008:1};
// &"GPNB" @WIRE(mode="straight",linecolor="#30485d",linewidth=0.16) {#XSTD_GPNCN:1 (61.5,-76) (61.5,-76) #XSTD_GPNBN:2};
// &"GPNDRV" @WIRE(mode="straight",linecolor="#30485d",linewidth=0.16) {#XSTD_GPNCN:2 (95.5,-76) (95.5,-76) #RGPN0:1};
// &"GPNA" @WIRE(mode="straight",linecolor="#30485d",linewidth=0.16) {#XSTD_GPNBN:1 (32.5,-76) (32.5,-76) #XSTD_GPNAN:2};
// &"GPNPRE" @WIRE(mode="straight",linecolor="#30485d",linewidth=0.16) {#XSTD_GPNAN:1 (0.5,-76) (0.5,-76) #X008:4};
// &"GPPB" @WIRE(mode="straight",linecolor="#30485d",linewidth=0.16) {#XSTD_GPPCN:1 (61.5,-114) (61.5,-114) #XSTD_GPPBN:2};
// &"GPPDRV" @WIRE(mode="straight",linecolor="#30485d",linewidth=0.16) {#XSTD_GPPCN:2 (95.5,-114) (95.5,-114) #RGPP0:1};
// &"GPPA" @WIRE(mode="straight",linecolor="#30485d",linewidth=0.16) {#XSTD_GPPBN:1 (32.5,-114) (32.5,-114) #XSTD_GPPAN:2};
// &"GNNRG" @WIRE(mode="straight",linecolor="#30485d",linewidth=0.16) {#RGNN1:1 (222.5,0) (222.5,0) #RGNN0_5__dmy0:2};
// &"RGNN1_1__dmy0" @WIRE(mode="straight",linecolor="#30485d",linewidth=0.16) {#RGNN1:2 (247.5,0) (247.5,0) #RGNN1_2__dmy0:1};
// &"RGNN1_2__dmy0" @WIRE(mode="straight",linecolor="#30485d",linewidth=0.16) {#RGNN1_2__dmy0:2 (272.5,0) (272.5,0) #RGNN1_3__dmy0:1};
// &"RGNN1_3__dmy0" @WIRE(mode="straight",linecolor="#30485d",linewidth=0.16) {#RGNN1_3__dmy0:2 (297.5,0) (297.5,0) #RGNN1_4__dmy0:1};
// &"RGNN1_4__dmy0" @WIRE(mode="straight",linecolor="#30485d",linewidth=0.16) {#RGNN1_4__dmy0:2 (322.5,0) (322.5,0) #RGNN1_5__dmy0:1};
// &"RGNN0_1__dmy0" @WIRE(mode="straight",linecolor="#30485d",linewidth=0.16) {#RGNN0:2 (122.5,0) (122.5,0) #RGNN0_2__dmy0:1};
// &"RGNN0_2__dmy0" @WIRE(mode="straight",linecolor="#30485d",linewidth=0.16) {#RGNN0_2__dmy0:2 (147.5,0) (147.5,0) #RGNN0_3__dmy0:1};
// &"RGNN0_3__dmy0" @WIRE(mode="straight",linecolor="#30485d",linewidth=0.16) {#RGNN0_3__dmy0:2 (172.5,0) (172.5,0) #RGNN0_4__dmy0:1};
// &"RGNN0_4__dmy0" @WIRE(mode="straight",linecolor="#30485d",linewidth=0.16) {#RGNN0_4__dmy0:2 (197.5,0) (197.5,0) #RGNN0_5__dmy0:1};
// &"GNPRG" @WIRE(mode="straight",linecolor="#30485d",linewidth=0.16) {#RGNP1:1 (222.5,-38) (222.5,-38) #RGNP0_5__dmy0:2};
// &"RGNP1_1__dmy0" @WIRE(mode="straight",linecolor="#30485d",linewidth=0.16) {#RGNP1:2 (247.5,-38) (247.5,-38) #RGNP1_2__dmy0:1};
// &"RGNP1_2__dmy0" @WIRE(mode="straight",linecolor="#30485d",linewidth=0.16) {#RGNP1_2__dmy0:2 (272.5,-38) (272.5,-38) #RGNP1_3__dmy0:1};
// &"RGNP1_3__dmy0" @WIRE(mode="straight",linecolor="#30485d",linewidth=0.16) {#RGNP1_3__dmy0:2 (297.5,-38) (297.5,-38) #RGNP1_4__dmy0:1};
// &"RGNP1_4__dmy0" @WIRE(mode="straight",linecolor="#30485d",linewidth=0.16) {#RGNP1_4__dmy0:2 (322.5,-38) (322.5,-38) #RGNP1_5__dmy0:1};
// &"RGNP0_1__dmy0" @WIRE(mode="straight",linecolor="#30485d",linewidth=0.16) {#RGNP0:2 (122.5,-38) (122.5,-38) #RGNP0_2__dmy0:1};
// &"RGNP0_2__dmy0" @WIRE(mode="straight",linecolor="#30485d",linewidth=0.16) {#RGNP0_2__dmy0:2 (147.5,-38) (147.5,-38) #RGNP0_3__dmy0:1};
// &"RGNP0_3__dmy0" @WIRE(mode="straight",linecolor="#30485d",linewidth=0.16) {#RGNP0_3__dmy0:2 (172.5,-38) (172.5,-38) #RGNP0_4__dmy0:1};
// &"RGNP0_4__dmy0" @WIRE(mode="straight",linecolor="#30485d",linewidth=0.16) {#RGNP0_4__dmy0:2 (197.5,-38) (197.5,-38) #RGNP0_5__dmy0:1};
// &"GPNRG" @WIRE(mode="straight",linecolor="#30485d",linewidth=0.16) {#RGPN1:1 (222.5,-76) (222.5,-76) #RGPN0_5__dmy0:2};
// &"RGPN1_1__dmy0" @WIRE(mode="straight",linecolor="#30485d",linewidth=0.16) {#RGPN1:2 (247.5,-76) (247.5,-76) #RGPN1_2__dmy0:1};
// &"RGPN1_2__dmy0" @WIRE(mode="straight",linecolor="#30485d",linewidth=0.16) {#RGPN1_2__dmy0:2 (272.5,-76) (272.5,-76) #RGPN1_3__dmy0:1};
// &"RGPN1_3__dmy0" @WIRE(mode="straight",linecolor="#30485d",linewidth=0.16) {#RGPN1_3__dmy0:2 (297.5,-76) (297.5,-76) #RGPN1_4__dmy0:1};
// &"RGPN1_4__dmy0" @WIRE(mode="straight",linecolor="#30485d",linewidth=0.16) {#RGPN1_4__dmy0:2 (322.5,-76) (322.5,-76) #RGPN1_5__dmy0:1};
// &"RGPN0_1__dmy0" @WIRE(mode="straight",linecolor="#30485d",linewidth=0.16) {#RGPN0:2 (122.5,-76) (122.5,-76) #RGPN0_2__dmy0:1};
// &"RGPN0_2__dmy0" @WIRE(mode="straight",linecolor="#30485d",linewidth=0.16) {#RGPN0_2__dmy0:2 (147.5,-76) (147.5,-76) #RGPN0_3__dmy0:1};
// &"RGPN0_3__dmy0" @WIRE(mode="straight",linecolor="#30485d",linewidth=0.16) {#RGPN0_3__dmy0:2 (172.5,-76) (172.5,-76) #RGPN0_4__dmy0:1};
// &"RGPN0_4__dmy0" @WIRE(mode="straight",linecolor="#30485d",linewidth=0.16) {#RGPN0_4__dmy0:2 (197.5,-76) (197.5,-76) #RGPN0_5__dmy0:1};
// &"GPPRG" @WIRE(mode="straight",linecolor="#30485d",linewidth=0.16) {#RGPP1:1 (222.5,-114) (222.5,-114) #RGPP0_5__dmy0:2};
// &"RGPP1_1__dmy0" @WIRE(mode="straight",linecolor="#30485d",linewidth=0.16) {#RGPP1:2 (247.5,-114) (247.5,-114) #RGPP1_2__dmy0:1};
// &"RGPP1_2__dmy0" @WIRE(mode="straight",linecolor="#30485d",linewidth=0.16) {#RGPP1_2__dmy0:2 (272.5,-114) (272.5,-114) #RGPP1_3__dmy0:1};
// &"RGPP1_3__dmy0" @WIRE(mode="straight",linecolor="#30485d",linewidth=0.16) {#RGPP1_3__dmy0:2 (297.5,-114) (297.5,-114) #RGPP1_4__dmy0:1};
// &"RGPP1_4__dmy0" @WIRE(mode="straight",linecolor="#30485d",linewidth=0.16) {#RGPP1_4__dmy0:2 (322.5,-114) (322.5,-114) #RGPP1_5__dmy0:1};
// &"RGPP0_1__dmy0" @WIRE(mode="straight",linecolor="#30485d",linewidth=0.16) {#RGPP0:2 (122.5,-114) (122.5,-114) #RGPP0_2__dmy0:1};
// &"RGPP0_2__dmy0" @WIRE(mode="straight",linecolor="#30485d",linewidth=0.16) {#RGPP0_2__dmy0:2 (147.5,-114) (147.5,-114) #RGPP0_3__dmy0:1};
// &"RGPP0_3__dmy0" @WIRE(mode="straight",linecolor="#30485d",linewidth=0.16) {#RGPP0_3__dmy0:2 (172.5,-114) (172.5,-114) #RGPP0_4__dmy0:1};
// &"RGPP0_4__dmy0" @WIRE(mode="straight",linecolor="#30485d",linewidth=0.16) {#RGPP0_4__dmy0:2 (197.5,-114) (197.5,-114) #RGPP0_5__dmy0:1};
// (-28,-148) @TEXT("GP and GN chains keep their source polarity, device sizing and series R; no zero-delay abstraction.",size=1,halign="start",textcolor="#223d52");
// &"VDD" @WIRE(mode="straight",linecolor="#30485d",linewidth=0.16) {#XSTD_GNNCN:3 (76,10)};
// (76,10.4) @TEXT("VDD",size=1.1,halign="middle",valign="bottom");
// &"VSS" @WIRE(mode="straight",linecolor="#30485d",linewidth=0.16) {#XSTD_GNNCN:4 (76,-10)};
// (76,-10.4) @TEXT("VSS",size=1.1,halign="middle",valign="top");
// &"VDD" @WIRE(mode="straight",linecolor="#30485d",linewidth=0.16) {#XSTD_GNNBN:3 (47,10)};
// (47,10.4) @TEXT("VDD",size=1.1,halign="middle",valign="bottom");
// &"VSS" @WIRE(mode="straight",linecolor="#30485d",linewidth=0.16) {#XSTD_GNNBN:4 (47,-10)};
// (47,-10.4) @TEXT("VSS",size=1.1,halign="middle",valign="top");
// &"VDD" @WIRE(mode="straight",linecolor="#30485d",linewidth=0.16) {#XSTD_GNNAN:3 (18,10)};
// (18,10.4) @TEXT("VDD",size=1.1,halign="middle",valign="bottom");
// &"VSS" @WIRE(mode="straight",linecolor="#30485d",linewidth=0.16) {#XSTD_GNNAN:4 (18,-10)};
// (18,-10.4) @TEXT("VSS",size=1.1,halign="middle",valign="top");
// &"VDD" @WIRE(mode="straight",linecolor="#30485d",linewidth=0.16) {#XSTD_GNPCN:3 (76,-28)};
// (76,-27.6) @TEXT("VDD",size=1.1,halign="middle",valign="bottom");
// &"VSS" @WIRE(mode="straight",linecolor="#30485d",linewidth=0.16) {#XSTD_GNPCN:4 (76,-48)};
// (76,-48.4) @TEXT("VSS",size=1.1,halign="middle",valign="top");
// &"VDD" @WIRE(mode="straight",linecolor="#30485d",linewidth=0.16) {#XSTD_GNPBN:3 (47,-28)};
// (47,-27.6) @TEXT("VDD",size=1.1,halign="middle",valign="bottom");
// &"VSS" @WIRE(mode="straight",linecolor="#30485d",linewidth=0.16) {#XSTD_GNPBN:4 (47,-48)};
// (47,-48.4) @TEXT("VSS",size=1.1,halign="middle",valign="top");
// &"VDD" @WIRE(mode="straight",linecolor="#30485d",linewidth=0.16) {#XSTD_GNPAN:3 (18,-28)};
// (18,-27.6) @TEXT("VDD",size=1.1,halign="middle",valign="bottom");
// &"VSS" @WIRE(mode="straight",linecolor="#30485d",linewidth=0.16) {#XSTD_GNPAN:4 (18,-48)};
// (18,-48.4) @TEXT("VSS",size=1.1,halign="middle",valign="top");
// &"VDD" @WIRE(mode="straight",linecolor="#30485d",linewidth=0.16) {#XSTD_GPNCN:3 (76,-66)};
// (76,-65.6) @TEXT("VDD",size=1.1,halign="middle",valign="bottom");
// &"VSS" @WIRE(mode="straight",linecolor="#30485d",linewidth=0.16) {#XSTD_GPNCN:4 (76,-86)};
// (76,-86.4) @TEXT("VSS",size=1.1,halign="middle",valign="top");
// &"VDD" @WIRE(mode="straight",linecolor="#30485d",linewidth=0.16) {#XSTD_GPNBN:3 (47,-66)};
// (47,-65.6) @TEXT("VDD",size=1.1,halign="middle",valign="bottom");
// &"VSS" @WIRE(mode="straight",linecolor="#30485d",linewidth=0.16) {#XSTD_GPNBN:4 (47,-86)};
// (47,-86.4) @TEXT("VSS",size=1.1,halign="middle",valign="top");
// &"VDD" @WIRE(mode="straight",linecolor="#30485d",linewidth=0.16) {#XSTD_GPNAN:3 (18,-66)};
// (18,-65.6) @TEXT("VDD",size=1.1,halign="middle",valign="bottom");
// &"VSS" @WIRE(mode="straight",linecolor="#30485d",linewidth=0.16) {#XSTD_GPNAN:4 (18,-86)};
// (18,-86.4) @TEXT("VSS",size=1.1,halign="middle",valign="top");
// &"VDD" @WIRE(mode="straight",linecolor="#30485d",linewidth=0.16) {#XSTD_GPPCN:3 (76,-104)};
// (76,-103.6) @TEXT("VDD",size=1.1,halign="middle",valign="bottom");
// &"VSS" @WIRE(mode="straight",linecolor="#30485d",linewidth=0.16) {#XSTD_GPPCN:4 (76,-124)};
// (76,-124.4) @TEXT("VSS",size=1.1,halign="middle",valign="top");
// &"VDD" @WIRE(mode="straight",linecolor="#30485d",linewidth=0.16) {#XSTD_GPPBN:3 (47,-104)};
// (47,-103.6) @TEXT("VDD",size=1.1,halign="middle",valign="bottom");
// &"VSS" @WIRE(mode="straight",linecolor="#30485d",linewidth=0.16) {#XSTD_GPPBN:4 (47,-124)};
// (47,-124.4) @TEXT("VSS",size=1.1,halign="middle",valign="top");
// &"L" @WIRE(mode="straight",linecolor="#30485d",linewidth=0.16) {#XSTD_GPPAN:1 (8,-114)};
// (7.6,-114) @TEXT("L",size=1.1,halign="end",valign="middle");
// &"VDD" @WIRE(mode="straight",linecolor="#30485d",linewidth=0.16) {#XSTD_GPPAN:3 (18,-104)};
// (18,-103.6) @TEXT("VDD",size=1.1,halign="middle",valign="bottom");
// &"VSS" @WIRE(mode="straight",linecolor="#30485d",linewidth=0.16) {#XSTD_GPPAN:4 (18,-124)};
// (18,-124.4) @TEXT("VSS",size=1.1,halign="middle",valign="top");
// &"GNN" @WIRE(mode="straight",linecolor="#30485d",linewidth=0.16) {#RGNN1_5__dmy0:2 (340,0)};
// (340.4,0) @TEXT("GNN",size=1.1,halign="start",valign="middle");
// &"GNP" @WIRE(mode="straight",linecolor="#30485d",linewidth=0.16) {#RGNP1_5__dmy0:2 (340,-38)};
// (340.4,-38) @TEXT("GNP",size=1.1,halign="start",valign="middle");
// &"GPN" @WIRE(mode="straight",linecolor="#30485d",linewidth=0.16) {#RGPN1_5__dmy0:2 (340,-76)};
// (340.4,-76) @TEXT("GPN",size=1.1,halign="start",valign="middle");
// &"GPP" @WIRE(mode="straight",linecolor="#30485d",linewidth=0.16) {#RGPP1_5__dmy0:2 (340,-114)};
// (340.4,-114) @TEXT("GPP",size=1.1,halign="start",valign="middle");
// &"L" @WIRE(mode="straight",linecolor="#30485d",linewidth=0.16) {#X025:1 (-27,0)};
// (-27.4,0) @TEXT("L",size=1.1,halign="end",valign="middle");
// &"VDD" @WIRE(mode="straight",linecolor="#30485d",linewidth=0.16) {#X025:2 (-17,10)};
// (-17,10.4) @TEXT("VDD",size=1.1,halign="middle",valign="bottom");
// &"VSS" @WIRE(mode="straight",linecolor="#30485d",linewidth=0.16) {#X025:3 (-17,-10)};
// (-17,-10.4) @TEXT("VSS",size=1.1,halign="middle",valign="top");
// &"VDD" @WIRE(mode="straight",linecolor="#30485d",linewidth=0.16) {#X008:2 (-17,-66)};
// (-17,-65.6) @TEXT("VDD",size=1.1,halign="middle",valign="bottom");
// &"VSS" @WIRE(mode="straight",linecolor="#30485d",linewidth=0.16) {#X008:3 (-17,-86)};
// (-17,-86.4) @TEXT("VSS",size=1.1,halign="middle",valign="top");
// }
// END SARADC RNL
ends sar8p_refdrv_b0

subckt sar8p_refdrv_b1 GNN GNP GPN GPP H L VDD VSS
    XSTD_GNNCN (GNNB GNNDRV VDD VSS) INVD1BWP12T30P140
    XSTD_GNNBN (GNNA GNNB VDD VSS) INVD1BWP12T30P140
    XSTD_GNNAN (GNNPRE GNNA VDD VSS) INVD1BWP12T30P140
    XSTD_GNPCN (GNPB GNPDRV VDD VSS) INVD1BWP12T30P140
    XSTD_GNPBN (GNPA GNPB VDD VSS) INVD1BWP12T30P140
    XSTD_GNPAN (H GNPA VDD VSS) INVD1BWP12T30P140
    XSTD_GPNCN (GPNB GPNDRV VDD VSS) INVD1BWP12T30P140
    XSTD_GPNBN (GPNA GPNB VDD VSS) INVD1BWP12T30P140
    XSTD_GPNAN (GPNPRE GPNA VDD VSS) INVD1BWP12T30P140
    XSTD_GPPCN (GPPB GPPDRV VDD VSS) INVD1BWP12T30P140
    XSTD_GPPBN (GPPA GPPB VDD VSS) INVD1BWP12T30P140
    XSTD_GPPAN (L GPPA VDD VSS) INVD1BWP12T30P140
//Series configuration of RGNN1
RGNN1  (GNNRG RGNN1_1__dmy0 ) rupolym l=17.13u w=1u m=2 multi=(1)
RGNN1_2__dmy0  (RGNN1_1__dmy0 RGNN1_2__dmy0 ) rupolym l=17.13u w=1u m=2          multi=(1)
RGNN1_3__dmy0  (RGNN1_2__dmy0 RGNN1_3__dmy0 ) rupolym l=17.13u w=1u m=2          multi=(1)
RGNN1_4__dmy0  (RGNN1_3__dmy0 RGNN1_4__dmy0 ) rupolym l=17.13u w=1u m=2          multi=(1)
RGNN1_5__dmy0  (RGNN1_4__dmy0 GNN ) rupolym l=17.13u w=1u m=2 multi=(1)
//End of RGNN1

//Series configuration of RGNN0
RGNN0  (GNNDRV RGNN0_1__dmy0 ) rupolym l=17.13u w=1u m=2 multi=(1)
RGNN0_2__dmy0  (RGNN0_1__dmy0 RGNN0_2__dmy0 ) rupolym l=17.13u w=1u m=2          multi=(1)
RGNN0_3__dmy0  (RGNN0_2__dmy0 RGNN0_3__dmy0 ) rupolym l=17.13u w=1u m=2          multi=(1)
RGNN0_4__dmy0  (RGNN0_3__dmy0 RGNN0_4__dmy0 ) rupolym l=17.13u w=1u m=2          multi=(1)
RGNN0_5__dmy0  (RGNN0_4__dmy0 GNNRG ) rupolym l=17.13u w=1u m=2 multi=(1)
//End of RGNN0

//Series configuration of RGNP1
RGNP1  (GNPRG RGNP1_1__dmy0 ) rupolym l=17.13u w=1u m=2 multi=(1)
RGNP1_2__dmy0  (RGNP1_1__dmy0 RGNP1_2__dmy0 ) rupolym l=17.13u w=1u m=2          multi=(1)
RGNP1_3__dmy0  (RGNP1_2__dmy0 RGNP1_3__dmy0 ) rupolym l=17.13u w=1u m=2          multi=(1)
RGNP1_4__dmy0  (RGNP1_3__dmy0 RGNP1_4__dmy0 ) rupolym l=17.13u w=1u m=2          multi=(1)
RGNP1_5__dmy0  (RGNP1_4__dmy0 GNP ) rupolym l=17.13u w=1u m=2 multi=(1)
//End of RGNP1

//Series configuration of RGNP0
RGNP0  (GNPDRV RGNP0_1__dmy0 ) rupolym l=17.13u w=1u m=2 multi=(1)
RGNP0_2__dmy0  (RGNP0_1__dmy0 RGNP0_2__dmy0 ) rupolym l=17.13u w=1u m=2          multi=(1)
RGNP0_3__dmy0  (RGNP0_2__dmy0 RGNP0_3__dmy0 ) rupolym l=17.13u w=1u m=2          multi=(1)
RGNP0_4__dmy0  (RGNP0_3__dmy0 RGNP0_4__dmy0 ) rupolym l=17.13u w=1u m=2          multi=(1)
RGNP0_5__dmy0  (RGNP0_4__dmy0 GNPRG ) rupolym l=17.13u w=1u m=2 multi=(1)
//End of RGNP0

//Series configuration of RGPN1
RGPN1  (GPNRG RGPN1_1__dmy0 ) rupolym l=17.13u w=1u m=2 multi=(1)
RGPN1_2__dmy0  (RGPN1_1__dmy0 RGPN1_2__dmy0 ) rupolym l=17.13u w=1u m=2          multi=(1)
RGPN1_3__dmy0  (RGPN1_2__dmy0 RGPN1_3__dmy0 ) rupolym l=17.13u w=1u m=2          multi=(1)
RGPN1_4__dmy0  (RGPN1_3__dmy0 RGPN1_4__dmy0 ) rupolym l=17.13u w=1u m=2          multi=(1)
RGPN1_5__dmy0  (RGPN1_4__dmy0 GPN ) rupolym l=17.13u w=1u m=2 multi=(1)
//End of RGPN1

//Series configuration of RGPN0
RGPN0  (GPNDRV RGPN0_1__dmy0 ) rupolym l=17.13u w=1u m=2 multi=(1)
RGPN0_2__dmy0  (RGPN0_1__dmy0 RGPN0_2__dmy0 ) rupolym l=17.13u w=1u m=2          multi=(1)
RGPN0_3__dmy0  (RGPN0_2__dmy0 RGPN0_3__dmy0 ) rupolym l=17.13u w=1u m=2          multi=(1)
RGPN0_4__dmy0  (RGPN0_3__dmy0 RGPN0_4__dmy0 ) rupolym l=17.13u w=1u m=2          multi=(1)
RGPN0_5__dmy0  (RGPN0_4__dmy0 GPNRG ) rupolym l=17.13u w=1u m=2 multi=(1)
//End of RGPN0

//Series configuration of RGPP1
RGPP1  (GPPRG RGPP1_1__dmy0 ) rupolym l=17.13u w=1u m=2 multi=(1)
RGPP1_2__dmy0  (RGPP1_1__dmy0 RGPP1_2__dmy0 ) rupolym l=17.13u w=1u m=2          multi=(1)
RGPP1_3__dmy0  (RGPP1_2__dmy0 RGPP1_3__dmy0 ) rupolym l=17.13u w=1u m=2          multi=(1)
RGPP1_4__dmy0  (RGPP1_3__dmy0 RGPP1_4__dmy0 ) rupolym l=17.13u w=1u m=2          multi=(1)
RGPP1_5__dmy0  (RGPP1_4__dmy0 GPP ) rupolym l=17.13u w=1u m=2 multi=(1)
//End of RGPP1

//Series configuration of RGPP0
RGPP0  (GPPDRV RGPP0_1__dmy0 ) rupolym l=17.13u w=1u m=2 multi=(1)
RGPP0_2__dmy0  (RGPP0_1__dmy0 RGPP0_2__dmy0 ) rupolym l=17.13u w=1u m=2          multi=(1)
RGPP0_3__dmy0  (RGPP0_2__dmy0 RGPP0_3__dmy0 ) rupolym l=17.13u w=1u m=2          multi=(1)
RGPP0_4__dmy0  (RGPP0_3__dmy0 RGPP0_4__dmy0 ) rupolym l=17.13u w=1u m=2          multi=(1)
RGPP0_5__dmy0  (RGPP0_4__dmy0 GPPRG ) rupolym l=17.13u w=1u m=2 multi=(1)
//End of RGPP0

    X025 (L VDD VSS GNNPRE) sar8p_inv
    X008 (H VDD VSS GPNPRE) sar8p_inv
// BEGIN SARADC RNL
// @RNL(author="saradc topology") {
// (-28,27) @TEXT("sar8p_refdrv_b1 / four physical gate-driver chains",size=1.5,halign="start",textcolor="#223d52");
// #X025 @SET-SYMBOL $S_sar8p_inv;
// #X025 @PLACE(-17,0) => @ORIENT("R0");
// #XSTD_GNNAN @SET-SYMBOL $S_INVD1BWP12T30P140;
// #XSTD_GNNAN @PLACE(18,0) => @ORIENT("R0");
// #XSTD_GNNBN @SET-SYMBOL $S_INVD1BWP12T30P140;
// #XSTD_GNNBN @PLACE(47,0) => @ORIENT("R0");
// #XSTD_GNNCN @SET-SYMBOL $S_INVD1BWP12T30P140;
// #XSTD_GNNCN @PLACE(76,0) => @ORIENT("R0");
// #RGNN0 @SET-SYMBOL $RESISTOR;
// #RGNN0 @PLACE(110,0) => @ORIENT("R90");
// #RGNN0 @TEXT("RGNN0",key="name",size=1.3,halign="start") => @PLACE(113,3);
// #RGNN0 @TEXT("l=17.13u w=1u multi=(1)",key="value",size=0.9,halign="start") => @PLACE(113,-4);
// #RGNN0 @TEXT("",key="model");
// #RGNN0_2__dmy0 @SET-SYMBOL $RESISTOR;
// #RGNN0_2__dmy0 @PLACE(135,0) => @ORIENT("R90");
// #RGNN0_2__dmy0 @TEXT("RGNN0_2__dmy0",key="name",size=1.3,halign="start") => @PLACE(138,3);
// #RGNN0_2__dmy0 @TEXT("l=17.13u w=1u multi=(1)",key="value",size=0.9,halign="start") => @PLACE(138,-4);
// #RGNN0_2__dmy0 @TEXT("",key="model");
// #RGNN0_3__dmy0 @SET-SYMBOL $RESISTOR;
// #RGNN0_3__dmy0 @PLACE(160,0) => @ORIENT("R90");
// #RGNN0_3__dmy0 @TEXT("RGNN0_3__dmy0",key="name",size=1.3,halign="start") => @PLACE(163,3);
// #RGNN0_3__dmy0 @TEXT("l=17.13u w=1u multi=(1)",key="value",size=0.9,halign="start") => @PLACE(163,-4);
// #RGNN0_3__dmy0 @TEXT("",key="model");
// #RGNN0_4__dmy0 @SET-SYMBOL $RESISTOR;
// #RGNN0_4__dmy0 @PLACE(185,0) => @ORIENT("R90");
// #RGNN0_4__dmy0 @TEXT("RGNN0_4__dmy0",key="name",size=1.3,halign="start") => @PLACE(188,3);
// #RGNN0_4__dmy0 @TEXT("l=17.13u w=1u multi=(1)",key="value",size=0.9,halign="start") => @PLACE(188,-4);
// #RGNN0_4__dmy0 @TEXT("",key="model");
// #RGNN0_5__dmy0 @SET-SYMBOL $RESISTOR;
// #RGNN0_5__dmy0 @PLACE(210,0) => @ORIENT("R90");
// #RGNN0_5__dmy0 @TEXT("RGNN0_5__dmy0",key="name",size=1.3,halign="start") => @PLACE(213,3);
// #RGNN0_5__dmy0 @TEXT("l=17.13u w=1u multi=(1)",key="value",size=0.9,halign="start") => @PLACE(213,-4);
// #RGNN0_5__dmy0 @TEXT("",key="model");
// #RGNN1 @SET-SYMBOL $RESISTOR;
// #RGNN1 @PLACE(235,0) => @ORIENT("R90");
// #RGNN1 @TEXT("RGNN1",key="name",size=1.3,halign="start") => @PLACE(238,3);
// #RGNN1 @TEXT("l=17.13u w=1u multi=(1)",key="value",size=0.9,halign="start") => @PLACE(238,-4);
// #RGNN1 @TEXT("",key="model");
// #RGNN1_2__dmy0 @SET-SYMBOL $RESISTOR;
// #RGNN1_2__dmy0 @PLACE(260,0) => @ORIENT("R90");
// #RGNN1_2__dmy0 @TEXT("RGNN1_2__dmy0",key="name",size=1.3,halign="start") => @PLACE(263,3);
// #RGNN1_2__dmy0 @TEXT("l=17.13u w=1u multi=(1)",key="value",size=0.9,halign="start") => @PLACE(263,-4);
// #RGNN1_2__dmy0 @TEXT("",key="model");
// #RGNN1_3__dmy0 @SET-SYMBOL $RESISTOR;
// #RGNN1_3__dmy0 @PLACE(285,0) => @ORIENT("R90");
// #RGNN1_3__dmy0 @TEXT("RGNN1_3__dmy0",key="name",size=1.3,halign="start") => @PLACE(288,3);
// #RGNN1_3__dmy0 @TEXT("l=17.13u w=1u multi=(1)",key="value",size=0.9,halign="start") => @PLACE(288,-4);
// #RGNN1_3__dmy0 @TEXT("",key="model");
// #RGNN1_4__dmy0 @SET-SYMBOL $RESISTOR;
// #RGNN1_4__dmy0 @PLACE(310,0) => @ORIENT("R90");
// #RGNN1_4__dmy0 @TEXT("RGNN1_4__dmy0",key="name",size=1.3,halign="start") => @PLACE(313,3);
// #RGNN1_4__dmy0 @TEXT("l=17.13u w=1u multi=(1)",key="value",size=0.9,halign="start") => @PLACE(313,-4);
// #RGNN1_4__dmy0 @TEXT("",key="model");
// #RGNN1_5__dmy0 @SET-SYMBOL $RESISTOR;
// #RGNN1_5__dmy0 @PLACE(335,0) => @ORIENT("R90");
// #RGNN1_5__dmy0 @TEXT("RGNN1_5__dmy0",key="name",size=1.3,halign="start") => @PLACE(338,3);
// #RGNN1_5__dmy0 @TEXT("l=17.13u w=1u multi=(1)",key="value",size=0.9,halign="start") => @PLACE(338,-4);
// #RGNN1_5__dmy0 @TEXT("",key="model");
// (104,15) @TEXT("GNN / 10 series poly sections",size=0.95,halign="start",textcolor="#223d52");
// #XSTD_GNPAN @SET-SYMBOL $S_INVD1BWP12T30P140;
// #XSTD_GNPAN @PLACE(18,-38) => @ORIENT("R0");
// #XSTD_GNPBN @SET-SYMBOL $S_INVD1BWP12T30P140;
// #XSTD_GNPBN @PLACE(47,-38) => @ORIENT("R0");
// #XSTD_GNPCN @SET-SYMBOL $S_INVD1BWP12T30P140;
// #XSTD_GNPCN @PLACE(76,-38) => @ORIENT("R0");
// #RGNP0 @SET-SYMBOL $RESISTOR;
// #RGNP0 @PLACE(110,-38) => @ORIENT("R90");
// #RGNP0 @TEXT("RGNP0",key="name",size=1.3,halign="start") => @PLACE(113,-35);
// #RGNP0 @TEXT("l=17.13u w=1u multi=(1)",key="value",size=0.9,halign="start") => @PLACE(113,-42);
// #RGNP0 @TEXT("",key="model");
// #RGNP0_2__dmy0 @SET-SYMBOL $RESISTOR;
// #RGNP0_2__dmy0 @PLACE(135,-38) => @ORIENT("R90");
// #RGNP0_2__dmy0 @TEXT("RGNP0_2__dmy0",key="name",size=1.3,halign="start") => @PLACE(138,-35);
// #RGNP0_2__dmy0 @TEXT("l=17.13u w=1u multi=(1)",key="value",size=0.9,halign="start") => @PLACE(138,-42);
// #RGNP0_2__dmy0 @TEXT("",key="model");
// #RGNP0_3__dmy0 @SET-SYMBOL $RESISTOR;
// #RGNP0_3__dmy0 @PLACE(160,-38) => @ORIENT("R90");
// #RGNP0_3__dmy0 @TEXT("RGNP0_3__dmy0",key="name",size=1.3,halign="start") => @PLACE(163,-35);
// #RGNP0_3__dmy0 @TEXT("l=17.13u w=1u multi=(1)",key="value",size=0.9,halign="start") => @PLACE(163,-42);
// #RGNP0_3__dmy0 @TEXT("",key="model");
// #RGNP0_4__dmy0 @SET-SYMBOL $RESISTOR;
// #RGNP0_4__dmy0 @PLACE(185,-38) => @ORIENT("R90");
// #RGNP0_4__dmy0 @TEXT("RGNP0_4__dmy0",key="name",size=1.3,halign="start") => @PLACE(188,-35);
// #RGNP0_4__dmy0 @TEXT("l=17.13u w=1u multi=(1)",key="value",size=0.9,halign="start") => @PLACE(188,-42);
// #RGNP0_4__dmy0 @TEXT("",key="model");
// #RGNP0_5__dmy0 @SET-SYMBOL $RESISTOR;
// #RGNP0_5__dmy0 @PLACE(210,-38) => @ORIENT("R90");
// #RGNP0_5__dmy0 @TEXT("RGNP0_5__dmy0",key="name",size=1.3,halign="start") => @PLACE(213,-35);
// #RGNP0_5__dmy0 @TEXT("l=17.13u w=1u multi=(1)",key="value",size=0.9,halign="start") => @PLACE(213,-42);
// #RGNP0_5__dmy0 @TEXT("",key="model");
// #RGNP1 @SET-SYMBOL $RESISTOR;
// #RGNP1 @PLACE(235,-38) => @ORIENT("R90");
// #RGNP1 @TEXT("RGNP1",key="name",size=1.3,halign="start") => @PLACE(238,-35);
// #RGNP1 @TEXT("l=17.13u w=1u multi=(1)",key="value",size=0.9,halign="start") => @PLACE(238,-42);
// #RGNP1 @TEXT("",key="model");
// #RGNP1_2__dmy0 @SET-SYMBOL $RESISTOR;
// #RGNP1_2__dmy0 @PLACE(260,-38) => @ORIENT("R90");
// #RGNP1_2__dmy0 @TEXT("RGNP1_2__dmy0",key="name",size=1.3,halign="start") => @PLACE(263,-35);
// #RGNP1_2__dmy0 @TEXT("l=17.13u w=1u multi=(1)",key="value",size=0.9,halign="start") => @PLACE(263,-42);
// #RGNP1_2__dmy0 @TEXT("",key="model");
// #RGNP1_3__dmy0 @SET-SYMBOL $RESISTOR;
// #RGNP1_3__dmy0 @PLACE(285,-38) => @ORIENT("R90");
// #RGNP1_3__dmy0 @TEXT("RGNP1_3__dmy0",key="name",size=1.3,halign="start") => @PLACE(288,-35);
// #RGNP1_3__dmy0 @TEXT("l=17.13u w=1u multi=(1)",key="value",size=0.9,halign="start") => @PLACE(288,-42);
// #RGNP1_3__dmy0 @TEXT("",key="model");
// #RGNP1_4__dmy0 @SET-SYMBOL $RESISTOR;
// #RGNP1_4__dmy0 @PLACE(310,-38) => @ORIENT("R90");
// #RGNP1_4__dmy0 @TEXT("RGNP1_4__dmy0",key="name",size=1.3,halign="start") => @PLACE(313,-35);
// #RGNP1_4__dmy0 @TEXT("l=17.13u w=1u multi=(1)",key="value",size=0.9,halign="start") => @PLACE(313,-42);
// #RGNP1_4__dmy0 @TEXT("",key="model");
// #RGNP1_5__dmy0 @SET-SYMBOL $RESISTOR;
// #RGNP1_5__dmy0 @PLACE(335,-38) => @ORIENT("R90");
// #RGNP1_5__dmy0 @TEXT("RGNP1_5__dmy0",key="name",size=1.3,halign="start") => @PLACE(338,-35);
// #RGNP1_5__dmy0 @TEXT("l=17.13u w=1u multi=(1)",key="value",size=0.9,halign="start") => @PLACE(338,-42);
// #RGNP1_5__dmy0 @TEXT("",key="model");
// (104,-23) @TEXT("GNP / 10 series poly sections",size=0.95,halign="start",textcolor="#223d52");
// #X008 @SET-SYMBOL $S_sar8p_inv;
// #X008 @PLACE(-17,-76) => @ORIENT("R0");
// #XSTD_GPNAN @SET-SYMBOL $S_INVD1BWP12T30P140;
// #XSTD_GPNAN @PLACE(18,-76) => @ORIENT("R0");
// #XSTD_GPNBN @SET-SYMBOL $S_INVD1BWP12T30P140;
// #XSTD_GPNBN @PLACE(47,-76) => @ORIENT("R0");
// #XSTD_GPNCN @SET-SYMBOL $S_INVD1BWP12T30P140;
// #XSTD_GPNCN @PLACE(76,-76) => @ORIENT("R0");
// #RGPN0 @SET-SYMBOL $RESISTOR;
// #RGPN0 @PLACE(110,-76) => @ORIENT("R90");
// #RGPN0 @TEXT("RGPN0",key="name",size=1.3,halign="start") => @PLACE(113,-73);
// #RGPN0 @TEXT("l=17.13u w=1u multi=(1)",key="value",size=0.9,halign="start") => @PLACE(113,-80);
// #RGPN0 @TEXT("",key="model");
// #RGPN0_2__dmy0 @SET-SYMBOL $RESISTOR;
// #RGPN0_2__dmy0 @PLACE(135,-76) => @ORIENT("R90");
// #RGPN0_2__dmy0 @TEXT("RGPN0_2__dmy0",key="name",size=1.3,halign="start") => @PLACE(138,-73);
// #RGPN0_2__dmy0 @TEXT("l=17.13u w=1u multi=(1)",key="value",size=0.9,halign="start") => @PLACE(138,-80);
// #RGPN0_2__dmy0 @TEXT("",key="model");
// #RGPN0_3__dmy0 @SET-SYMBOL $RESISTOR;
// #RGPN0_3__dmy0 @PLACE(160,-76) => @ORIENT("R90");
// #RGPN0_3__dmy0 @TEXT("RGPN0_3__dmy0",key="name",size=1.3,halign="start") => @PLACE(163,-73);
// #RGPN0_3__dmy0 @TEXT("l=17.13u w=1u multi=(1)",key="value",size=0.9,halign="start") => @PLACE(163,-80);
// #RGPN0_3__dmy0 @TEXT("",key="model");
// #RGPN0_4__dmy0 @SET-SYMBOL $RESISTOR;
// #RGPN0_4__dmy0 @PLACE(185,-76) => @ORIENT("R90");
// #RGPN0_4__dmy0 @TEXT("RGPN0_4__dmy0",key="name",size=1.3,halign="start") => @PLACE(188,-73);
// #RGPN0_4__dmy0 @TEXT("l=17.13u w=1u multi=(1)",key="value",size=0.9,halign="start") => @PLACE(188,-80);
// #RGPN0_4__dmy0 @TEXT("",key="model");
// #RGPN0_5__dmy0 @SET-SYMBOL $RESISTOR;
// #RGPN0_5__dmy0 @PLACE(210,-76) => @ORIENT("R90");
// #RGPN0_5__dmy0 @TEXT("RGPN0_5__dmy0",key="name",size=1.3,halign="start") => @PLACE(213,-73);
// #RGPN0_5__dmy0 @TEXT("l=17.13u w=1u multi=(1)",key="value",size=0.9,halign="start") => @PLACE(213,-80);
// #RGPN0_5__dmy0 @TEXT("",key="model");
// #RGPN1 @SET-SYMBOL $RESISTOR;
// #RGPN1 @PLACE(235,-76) => @ORIENT("R90");
// #RGPN1 @TEXT("RGPN1",key="name",size=1.3,halign="start") => @PLACE(238,-73);
// #RGPN1 @TEXT("l=17.13u w=1u multi=(1)",key="value",size=0.9,halign="start") => @PLACE(238,-80);
// #RGPN1 @TEXT("",key="model");
// #RGPN1_2__dmy0 @SET-SYMBOL $RESISTOR;
// #RGPN1_2__dmy0 @PLACE(260,-76) => @ORIENT("R90");
// #RGPN1_2__dmy0 @TEXT("RGPN1_2__dmy0",key="name",size=1.3,halign="start") => @PLACE(263,-73);
// #RGPN1_2__dmy0 @TEXT("l=17.13u w=1u multi=(1)",key="value",size=0.9,halign="start") => @PLACE(263,-80);
// #RGPN1_2__dmy0 @TEXT("",key="model");
// #RGPN1_3__dmy0 @SET-SYMBOL $RESISTOR;
// #RGPN1_3__dmy0 @PLACE(285,-76) => @ORIENT("R90");
// #RGPN1_3__dmy0 @TEXT("RGPN1_3__dmy0",key="name",size=1.3,halign="start") => @PLACE(288,-73);
// #RGPN1_3__dmy0 @TEXT("l=17.13u w=1u multi=(1)",key="value",size=0.9,halign="start") => @PLACE(288,-80);
// #RGPN1_3__dmy0 @TEXT("",key="model");
// #RGPN1_4__dmy0 @SET-SYMBOL $RESISTOR;
// #RGPN1_4__dmy0 @PLACE(310,-76) => @ORIENT("R90");
// #RGPN1_4__dmy0 @TEXT("RGPN1_4__dmy0",key="name",size=1.3,halign="start") => @PLACE(313,-73);
// #RGPN1_4__dmy0 @TEXT("l=17.13u w=1u multi=(1)",key="value",size=0.9,halign="start") => @PLACE(313,-80);
// #RGPN1_4__dmy0 @TEXT("",key="model");
// #RGPN1_5__dmy0 @SET-SYMBOL $RESISTOR;
// #RGPN1_5__dmy0 @PLACE(335,-76) => @ORIENT("R90");
// #RGPN1_5__dmy0 @TEXT("RGPN1_5__dmy0",key="name",size=1.3,halign="start") => @PLACE(338,-73);
// #RGPN1_5__dmy0 @TEXT("l=17.13u w=1u multi=(1)",key="value",size=0.9,halign="start") => @PLACE(338,-80);
// #RGPN1_5__dmy0 @TEXT("",key="model");
// (104,-61) @TEXT("GPN / 10 series poly sections",size=0.95,halign="start",textcolor="#223d52");
// #XSTD_GPPAN @SET-SYMBOL $S_INVD1BWP12T30P140;
// #XSTD_GPPAN @PLACE(18,-114) => @ORIENT("R0");
// #XSTD_GPPBN @SET-SYMBOL $S_INVD1BWP12T30P140;
// #XSTD_GPPBN @PLACE(47,-114) => @ORIENT("R0");
// #XSTD_GPPCN @SET-SYMBOL $S_INVD1BWP12T30P140;
// #XSTD_GPPCN @PLACE(76,-114) => @ORIENT("R0");
// #RGPP0 @SET-SYMBOL $RESISTOR;
// #RGPP0 @PLACE(110,-114) => @ORIENT("R90");
// #RGPP0 @TEXT("RGPP0",key="name",size=1.3,halign="start") => @PLACE(113,-111);
// #RGPP0 @TEXT("l=17.13u w=1u multi=(1)",key="value",size=0.9,halign="start") => @PLACE(113,-118);
// #RGPP0 @TEXT("",key="model");
// #RGPP0_2__dmy0 @SET-SYMBOL $RESISTOR;
// #RGPP0_2__dmy0 @PLACE(135,-114) => @ORIENT("R90");
// #RGPP0_2__dmy0 @TEXT("RGPP0_2__dmy0",key="name",size=1.3,halign="start") => @PLACE(138,-111);
// #RGPP0_2__dmy0 @TEXT("l=17.13u w=1u multi=(1)",key="value",size=0.9,halign="start") => @PLACE(138,-118);
// #RGPP0_2__dmy0 @TEXT("",key="model");
// #RGPP0_3__dmy0 @SET-SYMBOL $RESISTOR;
// #RGPP0_3__dmy0 @PLACE(160,-114) => @ORIENT("R90");
// #RGPP0_3__dmy0 @TEXT("RGPP0_3__dmy0",key="name",size=1.3,halign="start") => @PLACE(163,-111);
// #RGPP0_3__dmy0 @TEXT("l=17.13u w=1u multi=(1)",key="value",size=0.9,halign="start") => @PLACE(163,-118);
// #RGPP0_3__dmy0 @TEXT("",key="model");
// #RGPP0_4__dmy0 @SET-SYMBOL $RESISTOR;
// #RGPP0_4__dmy0 @PLACE(185,-114) => @ORIENT("R90");
// #RGPP0_4__dmy0 @TEXT("RGPP0_4__dmy0",key="name",size=1.3,halign="start") => @PLACE(188,-111);
// #RGPP0_4__dmy0 @TEXT("l=17.13u w=1u multi=(1)",key="value",size=0.9,halign="start") => @PLACE(188,-118);
// #RGPP0_4__dmy0 @TEXT("",key="model");
// #RGPP0_5__dmy0 @SET-SYMBOL $RESISTOR;
// #RGPP0_5__dmy0 @PLACE(210,-114) => @ORIENT("R90");
// #RGPP0_5__dmy0 @TEXT("RGPP0_5__dmy0",key="name",size=1.3,halign="start") => @PLACE(213,-111);
// #RGPP0_5__dmy0 @TEXT("l=17.13u w=1u multi=(1)",key="value",size=0.9,halign="start") => @PLACE(213,-118);
// #RGPP0_5__dmy0 @TEXT("",key="model");
// #RGPP1 @SET-SYMBOL $RESISTOR;
// #RGPP1 @PLACE(235,-114) => @ORIENT("R90");
// #RGPP1 @TEXT("RGPP1",key="name",size=1.3,halign="start") => @PLACE(238,-111);
// #RGPP1 @TEXT("l=17.13u w=1u multi=(1)",key="value",size=0.9,halign="start") => @PLACE(238,-118);
// #RGPP1 @TEXT("",key="model");
// #RGPP1_2__dmy0 @SET-SYMBOL $RESISTOR;
// #RGPP1_2__dmy0 @PLACE(260,-114) => @ORIENT("R90");
// #RGPP1_2__dmy0 @TEXT("RGPP1_2__dmy0",key="name",size=1.3,halign="start") => @PLACE(263,-111);
// #RGPP1_2__dmy0 @TEXT("l=17.13u w=1u multi=(1)",key="value",size=0.9,halign="start") => @PLACE(263,-118);
// #RGPP1_2__dmy0 @TEXT("",key="model");
// #RGPP1_3__dmy0 @SET-SYMBOL $RESISTOR;
// #RGPP1_3__dmy0 @PLACE(285,-114) => @ORIENT("R90");
// #RGPP1_3__dmy0 @TEXT("RGPP1_3__dmy0",key="name",size=1.3,halign="start") => @PLACE(288,-111);
// #RGPP1_3__dmy0 @TEXT("l=17.13u w=1u multi=(1)",key="value",size=0.9,halign="start") => @PLACE(288,-118);
// #RGPP1_3__dmy0 @TEXT("",key="model");
// #RGPP1_4__dmy0 @SET-SYMBOL $RESISTOR;
// #RGPP1_4__dmy0 @PLACE(310,-114) => @ORIENT("R90");
// #RGPP1_4__dmy0 @TEXT("RGPP1_4__dmy0",key="name",size=1.3,halign="start") => @PLACE(313,-111);
// #RGPP1_4__dmy0 @TEXT("l=17.13u w=1u multi=(1)",key="value",size=0.9,halign="start") => @PLACE(313,-118);
// #RGPP1_4__dmy0 @TEXT("",key="model");
// #RGPP1_5__dmy0 @SET-SYMBOL $RESISTOR;
// #RGPP1_5__dmy0 @PLACE(335,-114) => @ORIENT("R90");
// #RGPP1_5__dmy0 @TEXT("RGPP1_5__dmy0",key="name",size=1.3,halign="start") => @PLACE(338,-111);
// #RGPP1_5__dmy0 @TEXT("l=17.13u w=1u multi=(1)",key="value",size=0.9,halign="start") => @PLACE(338,-118);
// #RGPP1_5__dmy0 @TEXT("",key="model");
// (104,-99) @TEXT("GPP / 10 series poly sections",size=0.95,halign="start",textcolor="#223d52");
// &"GNNB" @WIRE(mode="straight",linecolor="#30485d",linewidth=0.16) {#XSTD_GNNCN:1 (61.5,0) (61.5,0) #XSTD_GNNBN:2};
// &"GNNDRV" @WIRE(mode="straight",linecolor="#30485d",linewidth=0.16) {#XSTD_GNNCN:2 (95.5,0) (95.5,0) #RGNN0:1};
// &"GNNA" @WIRE(mode="straight",linecolor="#30485d",linewidth=0.16) {#XSTD_GNNBN:1 (32.5,0) (32.5,0) #XSTD_GNNAN:2};
// &"GNNPRE" @WIRE(mode="straight",linecolor="#30485d",linewidth=0.16) {#XSTD_GNNAN:1 (0.5,0) (0.5,0) #X025:4};
// &"GNPB" @WIRE(mode="straight",linecolor="#30485d",linewidth=0.16) {#XSTD_GNPCN:1 (61.5,-38) (61.5,-38) #XSTD_GNPBN:2};
// &"GNPDRV" @WIRE(mode="straight",linecolor="#30485d",linewidth=0.16) {#XSTD_GNPCN:2 (95.5,-38) (95.5,-38) #RGNP0:1};
// &"GNPA" @WIRE(mode="straight",linecolor="#30485d",linewidth=0.16) {#XSTD_GNPBN:1 (32.5,-38) (32.5,-38) #XSTD_GNPAN:2};
// &"H" @WIRE(mode="straight",linecolor="#30485d",linewidth=0.16) {#XSTD_GNPAN:1 (-6.5,-38) (-6.5,-76) #X008:1};
// &"GPNB" @WIRE(mode="straight",linecolor="#30485d",linewidth=0.16) {#XSTD_GPNCN:1 (61.5,-76) (61.5,-76) #XSTD_GPNBN:2};
// &"GPNDRV" @WIRE(mode="straight",linecolor="#30485d",linewidth=0.16) {#XSTD_GPNCN:2 (95.5,-76) (95.5,-76) #RGPN0:1};
// &"GPNA" @WIRE(mode="straight",linecolor="#30485d",linewidth=0.16) {#XSTD_GPNBN:1 (32.5,-76) (32.5,-76) #XSTD_GPNAN:2};
// &"GPNPRE" @WIRE(mode="straight",linecolor="#30485d",linewidth=0.16) {#XSTD_GPNAN:1 (0.5,-76) (0.5,-76) #X008:4};
// &"GPPB" @WIRE(mode="straight",linecolor="#30485d",linewidth=0.16) {#XSTD_GPPCN:1 (61.5,-114) (61.5,-114) #XSTD_GPPBN:2};
// &"GPPDRV" @WIRE(mode="straight",linecolor="#30485d",linewidth=0.16) {#XSTD_GPPCN:2 (95.5,-114) (95.5,-114) #RGPP0:1};
// &"GPPA" @WIRE(mode="straight",linecolor="#30485d",linewidth=0.16) {#XSTD_GPPBN:1 (32.5,-114) (32.5,-114) #XSTD_GPPAN:2};
// &"GNNRG" @WIRE(mode="straight",linecolor="#30485d",linewidth=0.16) {#RGNN1:1 (222.5,0) (222.5,0) #RGNN0_5__dmy0:2};
// &"RGNN1_1__dmy0" @WIRE(mode="straight",linecolor="#30485d",linewidth=0.16) {#RGNN1:2 (247.5,0) (247.5,0) #RGNN1_2__dmy0:1};
// &"RGNN1_2__dmy0" @WIRE(mode="straight",linecolor="#30485d",linewidth=0.16) {#RGNN1_2__dmy0:2 (272.5,0) (272.5,0) #RGNN1_3__dmy0:1};
// &"RGNN1_3__dmy0" @WIRE(mode="straight",linecolor="#30485d",linewidth=0.16) {#RGNN1_3__dmy0:2 (297.5,0) (297.5,0) #RGNN1_4__dmy0:1};
// &"RGNN1_4__dmy0" @WIRE(mode="straight",linecolor="#30485d",linewidth=0.16) {#RGNN1_4__dmy0:2 (322.5,0) (322.5,0) #RGNN1_5__dmy0:1};
// &"RGNN0_1__dmy0" @WIRE(mode="straight",linecolor="#30485d",linewidth=0.16) {#RGNN0:2 (122.5,0) (122.5,0) #RGNN0_2__dmy0:1};
// &"RGNN0_2__dmy0" @WIRE(mode="straight",linecolor="#30485d",linewidth=0.16) {#RGNN0_2__dmy0:2 (147.5,0) (147.5,0) #RGNN0_3__dmy0:1};
// &"RGNN0_3__dmy0" @WIRE(mode="straight",linecolor="#30485d",linewidth=0.16) {#RGNN0_3__dmy0:2 (172.5,0) (172.5,0) #RGNN0_4__dmy0:1};
// &"RGNN0_4__dmy0" @WIRE(mode="straight",linecolor="#30485d",linewidth=0.16) {#RGNN0_4__dmy0:2 (197.5,0) (197.5,0) #RGNN0_5__dmy0:1};
// &"GNPRG" @WIRE(mode="straight",linecolor="#30485d",linewidth=0.16) {#RGNP1:1 (222.5,-38) (222.5,-38) #RGNP0_5__dmy0:2};
// &"RGNP1_1__dmy0" @WIRE(mode="straight",linecolor="#30485d",linewidth=0.16) {#RGNP1:2 (247.5,-38) (247.5,-38) #RGNP1_2__dmy0:1};
// &"RGNP1_2__dmy0" @WIRE(mode="straight",linecolor="#30485d",linewidth=0.16) {#RGNP1_2__dmy0:2 (272.5,-38) (272.5,-38) #RGNP1_3__dmy0:1};
// &"RGNP1_3__dmy0" @WIRE(mode="straight",linecolor="#30485d",linewidth=0.16) {#RGNP1_3__dmy0:2 (297.5,-38) (297.5,-38) #RGNP1_4__dmy0:1};
// &"RGNP1_4__dmy0" @WIRE(mode="straight",linecolor="#30485d",linewidth=0.16) {#RGNP1_4__dmy0:2 (322.5,-38) (322.5,-38) #RGNP1_5__dmy0:1};
// &"RGNP0_1__dmy0" @WIRE(mode="straight",linecolor="#30485d",linewidth=0.16) {#RGNP0:2 (122.5,-38) (122.5,-38) #RGNP0_2__dmy0:1};
// &"RGNP0_2__dmy0" @WIRE(mode="straight",linecolor="#30485d",linewidth=0.16) {#RGNP0_2__dmy0:2 (147.5,-38) (147.5,-38) #RGNP0_3__dmy0:1};
// &"RGNP0_3__dmy0" @WIRE(mode="straight",linecolor="#30485d",linewidth=0.16) {#RGNP0_3__dmy0:2 (172.5,-38) (172.5,-38) #RGNP0_4__dmy0:1};
// &"RGNP0_4__dmy0" @WIRE(mode="straight",linecolor="#30485d",linewidth=0.16) {#RGNP0_4__dmy0:2 (197.5,-38) (197.5,-38) #RGNP0_5__dmy0:1};
// &"GPNRG" @WIRE(mode="straight",linecolor="#30485d",linewidth=0.16) {#RGPN1:1 (222.5,-76) (222.5,-76) #RGPN0_5__dmy0:2};
// &"RGPN1_1__dmy0" @WIRE(mode="straight",linecolor="#30485d",linewidth=0.16) {#RGPN1:2 (247.5,-76) (247.5,-76) #RGPN1_2__dmy0:1};
// &"RGPN1_2__dmy0" @WIRE(mode="straight",linecolor="#30485d",linewidth=0.16) {#RGPN1_2__dmy0:2 (272.5,-76) (272.5,-76) #RGPN1_3__dmy0:1};
// &"RGPN1_3__dmy0" @WIRE(mode="straight",linecolor="#30485d",linewidth=0.16) {#RGPN1_3__dmy0:2 (297.5,-76) (297.5,-76) #RGPN1_4__dmy0:1};
// &"RGPN1_4__dmy0" @WIRE(mode="straight",linecolor="#30485d",linewidth=0.16) {#RGPN1_4__dmy0:2 (322.5,-76) (322.5,-76) #RGPN1_5__dmy0:1};
// &"RGPN0_1__dmy0" @WIRE(mode="straight",linecolor="#30485d",linewidth=0.16) {#RGPN0:2 (122.5,-76) (122.5,-76) #RGPN0_2__dmy0:1};
// &"RGPN0_2__dmy0" @WIRE(mode="straight",linecolor="#30485d",linewidth=0.16) {#RGPN0_2__dmy0:2 (147.5,-76) (147.5,-76) #RGPN0_3__dmy0:1};
// &"RGPN0_3__dmy0" @WIRE(mode="straight",linecolor="#30485d",linewidth=0.16) {#RGPN0_3__dmy0:2 (172.5,-76) (172.5,-76) #RGPN0_4__dmy0:1};
// &"RGPN0_4__dmy0" @WIRE(mode="straight",linecolor="#30485d",linewidth=0.16) {#RGPN0_4__dmy0:2 (197.5,-76) (197.5,-76) #RGPN0_5__dmy0:1};
// &"GPPRG" @WIRE(mode="straight",linecolor="#30485d",linewidth=0.16) {#RGPP1:1 (222.5,-114) (222.5,-114) #RGPP0_5__dmy0:2};
// &"RGPP1_1__dmy0" @WIRE(mode="straight",linecolor="#30485d",linewidth=0.16) {#RGPP1:2 (247.5,-114) (247.5,-114) #RGPP1_2__dmy0:1};
// &"RGPP1_2__dmy0" @WIRE(mode="straight",linecolor="#30485d",linewidth=0.16) {#RGPP1_2__dmy0:2 (272.5,-114) (272.5,-114) #RGPP1_3__dmy0:1};
// &"RGPP1_3__dmy0" @WIRE(mode="straight",linecolor="#30485d",linewidth=0.16) {#RGPP1_3__dmy0:2 (297.5,-114) (297.5,-114) #RGPP1_4__dmy0:1};
// &"RGPP1_4__dmy0" @WIRE(mode="straight",linecolor="#30485d",linewidth=0.16) {#RGPP1_4__dmy0:2 (322.5,-114) (322.5,-114) #RGPP1_5__dmy0:1};
// &"RGPP0_1__dmy0" @WIRE(mode="straight",linecolor="#30485d",linewidth=0.16) {#RGPP0:2 (122.5,-114) (122.5,-114) #RGPP0_2__dmy0:1};
// &"RGPP0_2__dmy0" @WIRE(mode="straight",linecolor="#30485d",linewidth=0.16) {#RGPP0_2__dmy0:2 (147.5,-114) (147.5,-114) #RGPP0_3__dmy0:1};
// &"RGPP0_3__dmy0" @WIRE(mode="straight",linecolor="#30485d",linewidth=0.16) {#RGPP0_3__dmy0:2 (172.5,-114) (172.5,-114) #RGPP0_4__dmy0:1};
// &"RGPP0_4__dmy0" @WIRE(mode="straight",linecolor="#30485d",linewidth=0.16) {#RGPP0_4__dmy0:2 (197.5,-114) (197.5,-114) #RGPP0_5__dmy0:1};
// (-28,-148) @TEXT("GP and GN chains keep their source polarity, device sizing and series R; no zero-delay abstraction.",size=1,halign="start",textcolor="#223d52");
// &"VDD" @WIRE(mode="straight",linecolor="#30485d",linewidth=0.16) {#XSTD_GNNCN:3 (76,10)};
// (76,10.4) @TEXT("VDD",size=1.1,halign="middle",valign="bottom");
// &"VSS" @WIRE(mode="straight",linecolor="#30485d",linewidth=0.16) {#XSTD_GNNCN:4 (76,-10)};
// (76,-10.4) @TEXT("VSS",size=1.1,halign="middle",valign="top");
// &"VDD" @WIRE(mode="straight",linecolor="#30485d",linewidth=0.16) {#XSTD_GNNBN:3 (47,10)};
// (47,10.4) @TEXT("VDD",size=1.1,halign="middle",valign="bottom");
// &"VSS" @WIRE(mode="straight",linecolor="#30485d",linewidth=0.16) {#XSTD_GNNBN:4 (47,-10)};
// (47,-10.4) @TEXT("VSS",size=1.1,halign="middle",valign="top");
// &"VDD" @WIRE(mode="straight",linecolor="#30485d",linewidth=0.16) {#XSTD_GNNAN:3 (18,10)};
// (18,10.4) @TEXT("VDD",size=1.1,halign="middle",valign="bottom");
// &"VSS" @WIRE(mode="straight",linecolor="#30485d",linewidth=0.16) {#XSTD_GNNAN:4 (18,-10)};
// (18,-10.4) @TEXT("VSS",size=1.1,halign="middle",valign="top");
// &"VDD" @WIRE(mode="straight",linecolor="#30485d",linewidth=0.16) {#XSTD_GNPCN:3 (76,-28)};
// (76,-27.6) @TEXT("VDD",size=1.1,halign="middle",valign="bottom");
// &"VSS" @WIRE(mode="straight",linecolor="#30485d",linewidth=0.16) {#XSTD_GNPCN:4 (76,-48)};
// (76,-48.4) @TEXT("VSS",size=1.1,halign="middle",valign="top");
// &"VDD" @WIRE(mode="straight",linecolor="#30485d",linewidth=0.16) {#XSTD_GNPBN:3 (47,-28)};
// (47,-27.6) @TEXT("VDD",size=1.1,halign="middle",valign="bottom");
// &"VSS" @WIRE(mode="straight",linecolor="#30485d",linewidth=0.16) {#XSTD_GNPBN:4 (47,-48)};
// (47,-48.4) @TEXT("VSS",size=1.1,halign="middle",valign="top");
// &"VDD" @WIRE(mode="straight",linecolor="#30485d",linewidth=0.16) {#XSTD_GNPAN:3 (18,-28)};
// (18,-27.6) @TEXT("VDD",size=1.1,halign="middle",valign="bottom");
// &"VSS" @WIRE(mode="straight",linecolor="#30485d",linewidth=0.16) {#XSTD_GNPAN:4 (18,-48)};
// (18,-48.4) @TEXT("VSS",size=1.1,halign="middle",valign="top");
// &"VDD" @WIRE(mode="straight",linecolor="#30485d",linewidth=0.16) {#XSTD_GPNCN:3 (76,-66)};
// (76,-65.6) @TEXT("VDD",size=1.1,halign="middle",valign="bottom");
// &"VSS" @WIRE(mode="straight",linecolor="#30485d",linewidth=0.16) {#XSTD_GPNCN:4 (76,-86)};
// (76,-86.4) @TEXT("VSS",size=1.1,halign="middle",valign="top");
// &"VDD" @WIRE(mode="straight",linecolor="#30485d",linewidth=0.16) {#XSTD_GPNBN:3 (47,-66)};
// (47,-65.6) @TEXT("VDD",size=1.1,halign="middle",valign="bottom");
// &"VSS" @WIRE(mode="straight",linecolor="#30485d",linewidth=0.16) {#XSTD_GPNBN:4 (47,-86)};
// (47,-86.4) @TEXT("VSS",size=1.1,halign="middle",valign="top");
// &"VDD" @WIRE(mode="straight",linecolor="#30485d",linewidth=0.16) {#XSTD_GPNAN:3 (18,-66)};
// (18,-65.6) @TEXT("VDD",size=1.1,halign="middle",valign="bottom");
// &"VSS" @WIRE(mode="straight",linecolor="#30485d",linewidth=0.16) {#XSTD_GPNAN:4 (18,-86)};
// (18,-86.4) @TEXT("VSS",size=1.1,halign="middle",valign="top");
// &"VDD" @WIRE(mode="straight",linecolor="#30485d",linewidth=0.16) {#XSTD_GPPCN:3 (76,-104)};
// (76,-103.6) @TEXT("VDD",size=1.1,halign="middle",valign="bottom");
// &"VSS" @WIRE(mode="straight",linecolor="#30485d",linewidth=0.16) {#XSTD_GPPCN:4 (76,-124)};
// (76,-124.4) @TEXT("VSS",size=1.1,halign="middle",valign="top");
// &"VDD" @WIRE(mode="straight",linecolor="#30485d",linewidth=0.16) {#XSTD_GPPBN:3 (47,-104)};
// (47,-103.6) @TEXT("VDD",size=1.1,halign="middle",valign="bottom");
// &"VSS" @WIRE(mode="straight",linecolor="#30485d",linewidth=0.16) {#XSTD_GPPBN:4 (47,-124)};
// (47,-124.4) @TEXT("VSS",size=1.1,halign="middle",valign="top");
// &"L" @WIRE(mode="straight",linecolor="#30485d",linewidth=0.16) {#XSTD_GPPAN:1 (8,-114)};
// (7.6,-114) @TEXT("L",size=1.1,halign="end",valign="middle");
// &"VDD" @WIRE(mode="straight",linecolor="#30485d",linewidth=0.16) {#XSTD_GPPAN:3 (18,-104)};
// (18,-103.6) @TEXT("VDD",size=1.1,halign="middle",valign="bottom");
// &"VSS" @WIRE(mode="straight",linecolor="#30485d",linewidth=0.16) {#XSTD_GPPAN:4 (18,-124)};
// (18,-124.4) @TEXT("VSS",size=1.1,halign="middle",valign="top");
// &"GNN" @WIRE(mode="straight",linecolor="#30485d",linewidth=0.16) {#RGNN1_5__dmy0:2 (340,0)};
// (340.4,0) @TEXT("GNN",size=1.1,halign="start",valign="middle");
// &"GNP" @WIRE(mode="straight",linecolor="#30485d",linewidth=0.16) {#RGNP1_5__dmy0:2 (340,-38)};
// (340.4,-38) @TEXT("GNP",size=1.1,halign="start",valign="middle");
// &"GPN" @WIRE(mode="straight",linecolor="#30485d",linewidth=0.16) {#RGPN1_5__dmy0:2 (340,-76)};
// (340.4,-76) @TEXT("GPN",size=1.1,halign="start",valign="middle");
// &"GPP" @WIRE(mode="straight",linecolor="#30485d",linewidth=0.16) {#RGPP1_5__dmy0:2 (340,-114)};
// (340.4,-114) @TEXT("GPP",size=1.1,halign="start",valign="middle");
// &"L" @WIRE(mode="straight",linecolor="#30485d",linewidth=0.16) {#X025:1 (-27,0)};
// (-27.4,0) @TEXT("L",size=1.1,halign="end",valign="middle");
// &"VDD" @WIRE(mode="straight",linecolor="#30485d",linewidth=0.16) {#X025:2 (-17,10)};
// (-17,10.4) @TEXT("VDD",size=1.1,halign="middle",valign="bottom");
// &"VSS" @WIRE(mode="straight",linecolor="#30485d",linewidth=0.16) {#X025:3 (-17,-10)};
// (-17,-10.4) @TEXT("VSS",size=1.1,halign="middle",valign="top");
// &"VDD" @WIRE(mode="straight",linecolor="#30485d",linewidth=0.16) {#X008:2 (-17,-66)};
// (-17,-65.6) @TEXT("VDD",size=1.1,halign="middle",valign="bottom");
// &"VSS" @WIRE(mode="straight",linecolor="#30485d",linewidth=0.16) {#X008:3 (-17,-86)};
// (-17,-86.4) @TEXT("VSS",size=1.1,halign="middle",valign="top");
// }
// END SARADC RNL
ends sar8p_refdrv_b1

subckt sar8p_refdrv_b2 GNN GNP GPN GPP H L VDD VSS
    XSTD_GNNCN (GNNB GNNDRV VDD VSS) INVD1BWP12T30P140
    XSTD_GNNBN (GNNA GNNB VDD VSS) INVD1BWP12T30P140
    XSTD_GNNAN (GNNPRE GNNA VDD VSS) INVD1BWP12T30P140
    XSTD_GNPCN (GNPB GNPDRV VDD VSS) INVD1BWP12T30P140
    XSTD_GNPBN (GNPA GNPB VDD VSS) INVD1BWP12T30P140
    XSTD_GNPAN (H GNPA VDD VSS) INVD1BWP12T30P140
    XSTD_GPNCN (GPNB GPNDRV VDD VSS) INVD1BWP12T30P140
    XSTD_GPNBN (GPNA GPNB VDD VSS) INVD1BWP12T30P140
    XSTD_GPNAN (GPNPRE GPNA VDD VSS) INVD1BWP12T30P140
    XSTD_GPPCN (GPPB GPPDRV VDD VSS) INVD1BWP12T30P140
    XSTD_GPPBN (GPPA GPPB VDD VSS) INVD1BWP12T30P140
    XSTD_GPPAN (L GPPA VDD VSS) INVD1BWP12T30P140
//Series configuration of RGNN1
RGNN1  (GNNRG RGNN1_1__dmy0 ) rupolym l=17.13u w=1u m=4 multi=(1)
RGNN1_2__dmy0  (RGNN1_1__dmy0 RGNN1_2__dmy0 ) rupolym l=17.13u w=1u m=4          multi=(1)
RGNN1_3__dmy0  (RGNN1_2__dmy0 RGNN1_3__dmy0 ) rupolym l=17.13u w=1u m=4          multi=(1)
RGNN1_4__dmy0  (RGNN1_3__dmy0 RGNN1_4__dmy0 ) rupolym l=17.13u w=1u m=4          multi=(1)
RGNN1_5__dmy0  (RGNN1_4__dmy0 GNN ) rupolym l=17.13u w=1u m=4 multi=(1)
//End of RGNN1

//Series configuration of RGNN0
RGNN0  (GNNDRV RGNN0_1__dmy0 ) rupolym l=17.13u w=1u m=4 multi=(1)
RGNN0_2__dmy0  (RGNN0_1__dmy0 RGNN0_2__dmy0 ) rupolym l=17.13u w=1u m=4          multi=(1)
RGNN0_3__dmy0  (RGNN0_2__dmy0 RGNN0_3__dmy0 ) rupolym l=17.13u w=1u m=4          multi=(1)
RGNN0_4__dmy0  (RGNN0_3__dmy0 RGNN0_4__dmy0 ) rupolym l=17.13u w=1u m=4          multi=(1)
RGNN0_5__dmy0  (RGNN0_4__dmy0 GNNRG ) rupolym l=17.13u w=1u m=4 multi=(1)
//End of RGNN0

//Series configuration of RGNP1
RGNP1  (GNPRG RGNP1_1__dmy0 ) rupolym l=17.13u w=1u m=4 multi=(1)
RGNP1_2__dmy0  (RGNP1_1__dmy0 RGNP1_2__dmy0 ) rupolym l=17.13u w=1u m=4          multi=(1)
RGNP1_3__dmy0  (RGNP1_2__dmy0 RGNP1_3__dmy0 ) rupolym l=17.13u w=1u m=4          multi=(1)
RGNP1_4__dmy0  (RGNP1_3__dmy0 RGNP1_4__dmy0 ) rupolym l=17.13u w=1u m=4          multi=(1)
RGNP1_5__dmy0  (RGNP1_4__dmy0 GNP ) rupolym l=17.13u w=1u m=4 multi=(1)
//End of RGNP1

//Series configuration of RGNP0
RGNP0  (GNPDRV RGNP0_1__dmy0 ) rupolym l=17.13u w=1u m=4 multi=(1)
RGNP0_2__dmy0  (RGNP0_1__dmy0 RGNP0_2__dmy0 ) rupolym l=17.13u w=1u m=4          multi=(1)
RGNP0_3__dmy0  (RGNP0_2__dmy0 RGNP0_3__dmy0 ) rupolym l=17.13u w=1u m=4          multi=(1)
RGNP0_4__dmy0  (RGNP0_3__dmy0 RGNP0_4__dmy0 ) rupolym l=17.13u w=1u m=4          multi=(1)
RGNP0_5__dmy0  (RGNP0_4__dmy0 GNPRG ) rupolym l=17.13u w=1u m=4 multi=(1)
//End of RGNP0

//Series configuration of RGPN1
RGPN1  (GPNRG RGPN1_1__dmy0 ) rupolym l=17.13u w=1u m=4 multi=(1)
RGPN1_2__dmy0  (RGPN1_1__dmy0 RGPN1_2__dmy0 ) rupolym l=17.13u w=1u m=4          multi=(1)
RGPN1_3__dmy0  (RGPN1_2__dmy0 RGPN1_3__dmy0 ) rupolym l=17.13u w=1u m=4          multi=(1)
RGPN1_4__dmy0  (RGPN1_3__dmy0 RGPN1_4__dmy0 ) rupolym l=17.13u w=1u m=4          multi=(1)
RGPN1_5__dmy0  (RGPN1_4__dmy0 GPN ) rupolym l=17.13u w=1u m=4 multi=(1)
//End of RGPN1

//Series configuration of RGPN0
RGPN0  (GPNDRV RGPN0_1__dmy0 ) rupolym l=17.13u w=1u m=4 multi=(1)
RGPN0_2__dmy0  (RGPN0_1__dmy0 RGPN0_2__dmy0 ) rupolym l=17.13u w=1u m=4          multi=(1)
RGPN0_3__dmy0  (RGPN0_2__dmy0 RGPN0_3__dmy0 ) rupolym l=17.13u w=1u m=4          multi=(1)
RGPN0_4__dmy0  (RGPN0_3__dmy0 RGPN0_4__dmy0 ) rupolym l=17.13u w=1u m=4          multi=(1)
RGPN0_5__dmy0  (RGPN0_4__dmy0 GPNRG ) rupolym l=17.13u w=1u m=4 multi=(1)
//End of RGPN0

//Series configuration of RGPP1
RGPP1  (GPPRG RGPP1_1__dmy0 ) rupolym l=17.13u w=1u m=4 multi=(1)
RGPP1_2__dmy0  (RGPP1_1__dmy0 RGPP1_2__dmy0 ) rupolym l=17.13u w=1u m=4          multi=(1)
RGPP1_3__dmy0  (RGPP1_2__dmy0 RGPP1_3__dmy0 ) rupolym l=17.13u w=1u m=4          multi=(1)
RGPP1_4__dmy0  (RGPP1_3__dmy0 RGPP1_4__dmy0 ) rupolym l=17.13u w=1u m=4          multi=(1)
RGPP1_5__dmy0  (RGPP1_4__dmy0 GPP ) rupolym l=17.13u w=1u m=4 multi=(1)
//End of RGPP1

//Series configuration of RGPP0
RGPP0  (GPPDRV RGPP0_1__dmy0 ) rupolym l=17.13u w=1u m=4 multi=(1)
RGPP0_2__dmy0  (RGPP0_1__dmy0 RGPP0_2__dmy0 ) rupolym l=17.13u w=1u m=4          multi=(1)
RGPP0_3__dmy0  (RGPP0_2__dmy0 RGPP0_3__dmy0 ) rupolym l=17.13u w=1u m=4          multi=(1)
RGPP0_4__dmy0  (RGPP0_3__dmy0 RGPP0_4__dmy0 ) rupolym l=17.13u w=1u m=4          multi=(1)
RGPP0_5__dmy0  (RGPP0_4__dmy0 GPPRG ) rupolym l=17.13u w=1u m=4 multi=(1)
//End of RGPP0

    X025 (L VDD VSS GNNPRE) sar8p_inv
    X008 (H VDD VSS GPNPRE) sar8p_inv
// BEGIN SARADC RNL
// @RNL(author="saradc topology") {
// (-28,27) @TEXT("sar8p_refdrv_b2 / four physical gate-driver chains",size=1.5,halign="start",textcolor="#223d52");
// #X025 @SET-SYMBOL $S_sar8p_inv;
// #X025 @PLACE(-17,0) => @ORIENT("R0");
// #XSTD_GNNAN @SET-SYMBOL $S_INVD1BWP12T30P140;
// #XSTD_GNNAN @PLACE(18,0) => @ORIENT("R0");
// #XSTD_GNNBN @SET-SYMBOL $S_INVD1BWP12T30P140;
// #XSTD_GNNBN @PLACE(47,0) => @ORIENT("R0");
// #XSTD_GNNCN @SET-SYMBOL $S_INVD1BWP12T30P140;
// #XSTD_GNNCN @PLACE(76,0) => @ORIENT("R0");
// #RGNN0 @SET-SYMBOL $RESISTOR;
// #RGNN0 @PLACE(110,0) => @ORIENT("R90");
// #RGNN0 @TEXT("RGNN0",key="name",size=1.3,halign="start") => @PLACE(113,3);
// #RGNN0 @TEXT("l=17.13u w=1u multi=(1)",key="value",size=0.9,halign="start") => @PLACE(113,-4);
// #RGNN0 @TEXT("",key="model");
// #RGNN0_2__dmy0 @SET-SYMBOL $RESISTOR;
// #RGNN0_2__dmy0 @PLACE(135,0) => @ORIENT("R90");
// #RGNN0_2__dmy0 @TEXT("RGNN0_2__dmy0",key="name",size=1.3,halign="start") => @PLACE(138,3);
// #RGNN0_2__dmy0 @TEXT("l=17.13u w=1u multi=(1)",key="value",size=0.9,halign="start") => @PLACE(138,-4);
// #RGNN0_2__dmy0 @TEXT("",key="model");
// #RGNN0_3__dmy0 @SET-SYMBOL $RESISTOR;
// #RGNN0_3__dmy0 @PLACE(160,0) => @ORIENT("R90");
// #RGNN0_3__dmy0 @TEXT("RGNN0_3__dmy0",key="name",size=1.3,halign="start") => @PLACE(163,3);
// #RGNN0_3__dmy0 @TEXT("l=17.13u w=1u multi=(1)",key="value",size=0.9,halign="start") => @PLACE(163,-4);
// #RGNN0_3__dmy0 @TEXT("",key="model");
// #RGNN0_4__dmy0 @SET-SYMBOL $RESISTOR;
// #RGNN0_4__dmy0 @PLACE(185,0) => @ORIENT("R90");
// #RGNN0_4__dmy0 @TEXT("RGNN0_4__dmy0",key="name",size=1.3,halign="start") => @PLACE(188,3);
// #RGNN0_4__dmy0 @TEXT("l=17.13u w=1u multi=(1)",key="value",size=0.9,halign="start") => @PLACE(188,-4);
// #RGNN0_4__dmy0 @TEXT("",key="model");
// #RGNN0_5__dmy0 @SET-SYMBOL $RESISTOR;
// #RGNN0_5__dmy0 @PLACE(210,0) => @ORIENT("R90");
// #RGNN0_5__dmy0 @TEXT("RGNN0_5__dmy0",key="name",size=1.3,halign="start") => @PLACE(213,3);
// #RGNN0_5__dmy0 @TEXT("l=17.13u w=1u multi=(1)",key="value",size=0.9,halign="start") => @PLACE(213,-4);
// #RGNN0_5__dmy0 @TEXT("",key="model");
// #RGNN1 @SET-SYMBOL $RESISTOR;
// #RGNN1 @PLACE(235,0) => @ORIENT("R90");
// #RGNN1 @TEXT("RGNN1",key="name",size=1.3,halign="start") => @PLACE(238,3);
// #RGNN1 @TEXT("l=17.13u w=1u multi=(1)",key="value",size=0.9,halign="start") => @PLACE(238,-4);
// #RGNN1 @TEXT("",key="model");
// #RGNN1_2__dmy0 @SET-SYMBOL $RESISTOR;
// #RGNN1_2__dmy0 @PLACE(260,0) => @ORIENT("R90");
// #RGNN1_2__dmy0 @TEXT("RGNN1_2__dmy0",key="name",size=1.3,halign="start") => @PLACE(263,3);
// #RGNN1_2__dmy0 @TEXT("l=17.13u w=1u multi=(1)",key="value",size=0.9,halign="start") => @PLACE(263,-4);
// #RGNN1_2__dmy0 @TEXT("",key="model");
// #RGNN1_3__dmy0 @SET-SYMBOL $RESISTOR;
// #RGNN1_3__dmy0 @PLACE(285,0) => @ORIENT("R90");
// #RGNN1_3__dmy0 @TEXT("RGNN1_3__dmy0",key="name",size=1.3,halign="start") => @PLACE(288,3);
// #RGNN1_3__dmy0 @TEXT("l=17.13u w=1u multi=(1)",key="value",size=0.9,halign="start") => @PLACE(288,-4);
// #RGNN1_3__dmy0 @TEXT("",key="model");
// #RGNN1_4__dmy0 @SET-SYMBOL $RESISTOR;
// #RGNN1_4__dmy0 @PLACE(310,0) => @ORIENT("R90");
// #RGNN1_4__dmy0 @TEXT("RGNN1_4__dmy0",key="name",size=1.3,halign="start") => @PLACE(313,3);
// #RGNN1_4__dmy0 @TEXT("l=17.13u w=1u multi=(1)",key="value",size=0.9,halign="start") => @PLACE(313,-4);
// #RGNN1_4__dmy0 @TEXT("",key="model");
// #RGNN1_5__dmy0 @SET-SYMBOL $RESISTOR;
// #RGNN1_5__dmy0 @PLACE(335,0) => @ORIENT("R90");
// #RGNN1_5__dmy0 @TEXT("RGNN1_5__dmy0",key="name",size=1.3,halign="start") => @PLACE(338,3);
// #RGNN1_5__dmy0 @TEXT("l=17.13u w=1u multi=(1)",key="value",size=0.9,halign="start") => @PLACE(338,-4);
// #RGNN1_5__dmy0 @TEXT("",key="model");
// (104,15) @TEXT("GNN / 10 series poly sections",size=0.95,halign="start",textcolor="#223d52");
// #XSTD_GNPAN @SET-SYMBOL $S_INVD1BWP12T30P140;
// #XSTD_GNPAN @PLACE(18,-38) => @ORIENT("R0");
// #XSTD_GNPBN @SET-SYMBOL $S_INVD1BWP12T30P140;
// #XSTD_GNPBN @PLACE(47,-38) => @ORIENT("R0");
// #XSTD_GNPCN @SET-SYMBOL $S_INVD1BWP12T30P140;
// #XSTD_GNPCN @PLACE(76,-38) => @ORIENT("R0");
// #RGNP0 @SET-SYMBOL $RESISTOR;
// #RGNP0 @PLACE(110,-38) => @ORIENT("R90");
// #RGNP0 @TEXT("RGNP0",key="name",size=1.3,halign="start") => @PLACE(113,-35);
// #RGNP0 @TEXT("l=17.13u w=1u multi=(1)",key="value",size=0.9,halign="start") => @PLACE(113,-42);
// #RGNP0 @TEXT("",key="model");
// #RGNP0_2__dmy0 @SET-SYMBOL $RESISTOR;
// #RGNP0_2__dmy0 @PLACE(135,-38) => @ORIENT("R90");
// #RGNP0_2__dmy0 @TEXT("RGNP0_2__dmy0",key="name",size=1.3,halign="start") => @PLACE(138,-35);
// #RGNP0_2__dmy0 @TEXT("l=17.13u w=1u multi=(1)",key="value",size=0.9,halign="start") => @PLACE(138,-42);
// #RGNP0_2__dmy0 @TEXT("",key="model");
// #RGNP0_3__dmy0 @SET-SYMBOL $RESISTOR;
// #RGNP0_3__dmy0 @PLACE(160,-38) => @ORIENT("R90");
// #RGNP0_3__dmy0 @TEXT("RGNP0_3__dmy0",key="name",size=1.3,halign="start") => @PLACE(163,-35);
// #RGNP0_3__dmy0 @TEXT("l=17.13u w=1u multi=(1)",key="value",size=0.9,halign="start") => @PLACE(163,-42);
// #RGNP0_3__dmy0 @TEXT("",key="model");
// #RGNP0_4__dmy0 @SET-SYMBOL $RESISTOR;
// #RGNP0_4__dmy0 @PLACE(185,-38) => @ORIENT("R90");
// #RGNP0_4__dmy0 @TEXT("RGNP0_4__dmy0",key="name",size=1.3,halign="start") => @PLACE(188,-35);
// #RGNP0_4__dmy0 @TEXT("l=17.13u w=1u multi=(1)",key="value",size=0.9,halign="start") => @PLACE(188,-42);
// #RGNP0_4__dmy0 @TEXT("",key="model");
// #RGNP0_5__dmy0 @SET-SYMBOL $RESISTOR;
// #RGNP0_5__dmy0 @PLACE(210,-38) => @ORIENT("R90");
// #RGNP0_5__dmy0 @TEXT("RGNP0_5__dmy0",key="name",size=1.3,halign="start") => @PLACE(213,-35);
// #RGNP0_5__dmy0 @TEXT("l=17.13u w=1u multi=(1)",key="value",size=0.9,halign="start") => @PLACE(213,-42);
// #RGNP0_5__dmy0 @TEXT("",key="model");
// #RGNP1 @SET-SYMBOL $RESISTOR;
// #RGNP1 @PLACE(235,-38) => @ORIENT("R90");
// #RGNP1 @TEXT("RGNP1",key="name",size=1.3,halign="start") => @PLACE(238,-35);
// #RGNP1 @TEXT("l=17.13u w=1u multi=(1)",key="value",size=0.9,halign="start") => @PLACE(238,-42);
// #RGNP1 @TEXT("",key="model");
// #RGNP1_2__dmy0 @SET-SYMBOL $RESISTOR;
// #RGNP1_2__dmy0 @PLACE(260,-38) => @ORIENT("R90");
// #RGNP1_2__dmy0 @TEXT("RGNP1_2__dmy0",key="name",size=1.3,halign="start") => @PLACE(263,-35);
// #RGNP1_2__dmy0 @TEXT("l=17.13u w=1u multi=(1)",key="value",size=0.9,halign="start") => @PLACE(263,-42);
// #RGNP1_2__dmy0 @TEXT("",key="model");
// #RGNP1_3__dmy0 @SET-SYMBOL $RESISTOR;
// #RGNP1_3__dmy0 @PLACE(285,-38) => @ORIENT("R90");
// #RGNP1_3__dmy0 @TEXT("RGNP1_3__dmy0",key="name",size=1.3,halign="start") => @PLACE(288,-35);
// #RGNP1_3__dmy0 @TEXT("l=17.13u w=1u multi=(1)",key="value",size=0.9,halign="start") => @PLACE(288,-42);
// #RGNP1_3__dmy0 @TEXT("",key="model");
// #RGNP1_4__dmy0 @SET-SYMBOL $RESISTOR;
// #RGNP1_4__dmy0 @PLACE(310,-38) => @ORIENT("R90");
// #RGNP1_4__dmy0 @TEXT("RGNP1_4__dmy0",key="name",size=1.3,halign="start") => @PLACE(313,-35);
// #RGNP1_4__dmy0 @TEXT("l=17.13u w=1u multi=(1)",key="value",size=0.9,halign="start") => @PLACE(313,-42);
// #RGNP1_4__dmy0 @TEXT("",key="model");
// #RGNP1_5__dmy0 @SET-SYMBOL $RESISTOR;
// #RGNP1_5__dmy0 @PLACE(335,-38) => @ORIENT("R90");
// #RGNP1_5__dmy0 @TEXT("RGNP1_5__dmy0",key="name",size=1.3,halign="start") => @PLACE(338,-35);
// #RGNP1_5__dmy0 @TEXT("l=17.13u w=1u multi=(1)",key="value",size=0.9,halign="start") => @PLACE(338,-42);
// #RGNP1_5__dmy0 @TEXT("",key="model");
// (104,-23) @TEXT("GNP / 10 series poly sections",size=0.95,halign="start",textcolor="#223d52");
// #X008 @SET-SYMBOL $S_sar8p_inv;
// #X008 @PLACE(-17,-76) => @ORIENT("R0");
// #XSTD_GPNAN @SET-SYMBOL $S_INVD1BWP12T30P140;
// #XSTD_GPNAN @PLACE(18,-76) => @ORIENT("R0");
// #XSTD_GPNBN @SET-SYMBOL $S_INVD1BWP12T30P140;
// #XSTD_GPNBN @PLACE(47,-76) => @ORIENT("R0");
// #XSTD_GPNCN @SET-SYMBOL $S_INVD1BWP12T30P140;
// #XSTD_GPNCN @PLACE(76,-76) => @ORIENT("R0");
// #RGPN0 @SET-SYMBOL $RESISTOR;
// #RGPN0 @PLACE(110,-76) => @ORIENT("R90");
// #RGPN0 @TEXT("RGPN0",key="name",size=1.3,halign="start") => @PLACE(113,-73);
// #RGPN0 @TEXT("l=17.13u w=1u multi=(1)",key="value",size=0.9,halign="start") => @PLACE(113,-80);
// #RGPN0 @TEXT("",key="model");
// #RGPN0_2__dmy0 @SET-SYMBOL $RESISTOR;
// #RGPN0_2__dmy0 @PLACE(135,-76) => @ORIENT("R90");
// #RGPN0_2__dmy0 @TEXT("RGPN0_2__dmy0",key="name",size=1.3,halign="start") => @PLACE(138,-73);
// #RGPN0_2__dmy0 @TEXT("l=17.13u w=1u multi=(1)",key="value",size=0.9,halign="start") => @PLACE(138,-80);
// #RGPN0_2__dmy0 @TEXT("",key="model");
// #RGPN0_3__dmy0 @SET-SYMBOL $RESISTOR;
// #RGPN0_3__dmy0 @PLACE(160,-76) => @ORIENT("R90");
// #RGPN0_3__dmy0 @TEXT("RGPN0_3__dmy0",key="name",size=1.3,halign="start") => @PLACE(163,-73);
// #RGPN0_3__dmy0 @TEXT("l=17.13u w=1u multi=(1)",key="value",size=0.9,halign="start") => @PLACE(163,-80);
// #RGPN0_3__dmy0 @TEXT("",key="model");
// #RGPN0_4__dmy0 @SET-SYMBOL $RESISTOR;
// #RGPN0_4__dmy0 @PLACE(185,-76) => @ORIENT("R90");
// #RGPN0_4__dmy0 @TEXT("RGPN0_4__dmy0",key="name",size=1.3,halign="start") => @PLACE(188,-73);
// #RGPN0_4__dmy0 @TEXT("l=17.13u w=1u multi=(1)",key="value",size=0.9,halign="start") => @PLACE(188,-80);
// #RGPN0_4__dmy0 @TEXT("",key="model");
// #RGPN0_5__dmy0 @SET-SYMBOL $RESISTOR;
// #RGPN0_5__dmy0 @PLACE(210,-76) => @ORIENT("R90");
// #RGPN0_5__dmy0 @TEXT("RGPN0_5__dmy0",key="name",size=1.3,halign="start") => @PLACE(213,-73);
// #RGPN0_5__dmy0 @TEXT("l=17.13u w=1u multi=(1)",key="value",size=0.9,halign="start") => @PLACE(213,-80);
// #RGPN0_5__dmy0 @TEXT("",key="model");
// #RGPN1 @SET-SYMBOL $RESISTOR;
// #RGPN1 @PLACE(235,-76) => @ORIENT("R90");
// #RGPN1 @TEXT("RGPN1",key="name",size=1.3,halign="start") => @PLACE(238,-73);
// #RGPN1 @TEXT("l=17.13u w=1u multi=(1)",key="value",size=0.9,halign="start") => @PLACE(238,-80);
// #RGPN1 @TEXT("",key="model");
// #RGPN1_2__dmy0 @SET-SYMBOL $RESISTOR;
// #RGPN1_2__dmy0 @PLACE(260,-76) => @ORIENT("R90");
// #RGPN1_2__dmy0 @TEXT("RGPN1_2__dmy0",key="name",size=1.3,halign="start") => @PLACE(263,-73);
// #RGPN1_2__dmy0 @TEXT("l=17.13u w=1u multi=(1)",key="value",size=0.9,halign="start") => @PLACE(263,-80);
// #RGPN1_2__dmy0 @TEXT("",key="model");
// #RGPN1_3__dmy0 @SET-SYMBOL $RESISTOR;
// #RGPN1_3__dmy0 @PLACE(285,-76) => @ORIENT("R90");
// #RGPN1_3__dmy0 @TEXT("RGPN1_3__dmy0",key="name",size=1.3,halign="start") => @PLACE(288,-73);
// #RGPN1_3__dmy0 @TEXT("l=17.13u w=1u multi=(1)",key="value",size=0.9,halign="start") => @PLACE(288,-80);
// #RGPN1_3__dmy0 @TEXT("",key="model");
// #RGPN1_4__dmy0 @SET-SYMBOL $RESISTOR;
// #RGPN1_4__dmy0 @PLACE(310,-76) => @ORIENT("R90");
// #RGPN1_4__dmy0 @TEXT("RGPN1_4__dmy0",key="name",size=1.3,halign="start") => @PLACE(313,-73);
// #RGPN1_4__dmy0 @TEXT("l=17.13u w=1u multi=(1)",key="value",size=0.9,halign="start") => @PLACE(313,-80);
// #RGPN1_4__dmy0 @TEXT("",key="model");
// #RGPN1_5__dmy0 @SET-SYMBOL $RESISTOR;
// #RGPN1_5__dmy0 @PLACE(335,-76) => @ORIENT("R90");
// #RGPN1_5__dmy0 @TEXT("RGPN1_5__dmy0",key="name",size=1.3,halign="start") => @PLACE(338,-73);
// #RGPN1_5__dmy0 @TEXT("l=17.13u w=1u multi=(1)",key="value",size=0.9,halign="start") => @PLACE(338,-80);
// #RGPN1_5__dmy0 @TEXT("",key="model");
// (104,-61) @TEXT("GPN / 10 series poly sections",size=0.95,halign="start",textcolor="#223d52");
// #XSTD_GPPAN @SET-SYMBOL $S_INVD1BWP12T30P140;
// #XSTD_GPPAN @PLACE(18,-114) => @ORIENT("R0");
// #XSTD_GPPBN @SET-SYMBOL $S_INVD1BWP12T30P140;
// #XSTD_GPPBN @PLACE(47,-114) => @ORIENT("R0");
// #XSTD_GPPCN @SET-SYMBOL $S_INVD1BWP12T30P140;
// #XSTD_GPPCN @PLACE(76,-114) => @ORIENT("R0");
// #RGPP0 @SET-SYMBOL $RESISTOR;
// #RGPP0 @PLACE(110,-114) => @ORIENT("R90");
// #RGPP0 @TEXT("RGPP0",key="name",size=1.3,halign="start") => @PLACE(113,-111);
// #RGPP0 @TEXT("l=17.13u w=1u multi=(1)",key="value",size=0.9,halign="start") => @PLACE(113,-118);
// #RGPP0 @TEXT("",key="model");
// #RGPP0_2__dmy0 @SET-SYMBOL $RESISTOR;
// #RGPP0_2__dmy0 @PLACE(135,-114) => @ORIENT("R90");
// #RGPP0_2__dmy0 @TEXT("RGPP0_2__dmy0",key="name",size=1.3,halign="start") => @PLACE(138,-111);
// #RGPP0_2__dmy0 @TEXT("l=17.13u w=1u multi=(1)",key="value",size=0.9,halign="start") => @PLACE(138,-118);
// #RGPP0_2__dmy0 @TEXT("",key="model");
// #RGPP0_3__dmy0 @SET-SYMBOL $RESISTOR;
// #RGPP0_3__dmy0 @PLACE(160,-114) => @ORIENT("R90");
// #RGPP0_3__dmy0 @TEXT("RGPP0_3__dmy0",key="name",size=1.3,halign="start") => @PLACE(163,-111);
// #RGPP0_3__dmy0 @TEXT("l=17.13u w=1u multi=(1)",key="value",size=0.9,halign="start") => @PLACE(163,-118);
// #RGPP0_3__dmy0 @TEXT("",key="model");
// #RGPP0_4__dmy0 @SET-SYMBOL $RESISTOR;
// #RGPP0_4__dmy0 @PLACE(185,-114) => @ORIENT("R90");
// #RGPP0_4__dmy0 @TEXT("RGPP0_4__dmy0",key="name",size=1.3,halign="start") => @PLACE(188,-111);
// #RGPP0_4__dmy0 @TEXT("l=17.13u w=1u multi=(1)",key="value",size=0.9,halign="start") => @PLACE(188,-118);
// #RGPP0_4__dmy0 @TEXT("",key="model");
// #RGPP0_5__dmy0 @SET-SYMBOL $RESISTOR;
// #RGPP0_5__dmy0 @PLACE(210,-114) => @ORIENT("R90");
// #RGPP0_5__dmy0 @TEXT("RGPP0_5__dmy0",key="name",size=1.3,halign="start") => @PLACE(213,-111);
// #RGPP0_5__dmy0 @TEXT("l=17.13u w=1u multi=(1)",key="value",size=0.9,halign="start") => @PLACE(213,-118);
// #RGPP0_5__dmy0 @TEXT("",key="model");
// #RGPP1 @SET-SYMBOL $RESISTOR;
// #RGPP1 @PLACE(235,-114) => @ORIENT("R90");
// #RGPP1 @TEXT("RGPP1",key="name",size=1.3,halign="start") => @PLACE(238,-111);
// #RGPP1 @TEXT("l=17.13u w=1u multi=(1)",key="value",size=0.9,halign="start") => @PLACE(238,-118);
// #RGPP1 @TEXT("",key="model");
// #RGPP1_2__dmy0 @SET-SYMBOL $RESISTOR;
// #RGPP1_2__dmy0 @PLACE(260,-114) => @ORIENT("R90");
// #RGPP1_2__dmy0 @TEXT("RGPP1_2__dmy0",key="name",size=1.3,halign="start") => @PLACE(263,-111);
// #RGPP1_2__dmy0 @TEXT("l=17.13u w=1u multi=(1)",key="value",size=0.9,halign="start") => @PLACE(263,-118);
// #RGPP1_2__dmy0 @TEXT("",key="model");
// #RGPP1_3__dmy0 @SET-SYMBOL $RESISTOR;
// #RGPP1_3__dmy0 @PLACE(285,-114) => @ORIENT("R90");
// #RGPP1_3__dmy0 @TEXT("RGPP1_3__dmy0",key="name",size=1.3,halign="start") => @PLACE(288,-111);
// #RGPP1_3__dmy0 @TEXT("l=17.13u w=1u multi=(1)",key="value",size=0.9,halign="start") => @PLACE(288,-118);
// #RGPP1_3__dmy0 @TEXT("",key="model");
// #RGPP1_4__dmy0 @SET-SYMBOL $RESISTOR;
// #RGPP1_4__dmy0 @PLACE(310,-114) => @ORIENT("R90");
// #RGPP1_4__dmy0 @TEXT("RGPP1_4__dmy0",key="name",size=1.3,halign="start") => @PLACE(313,-111);
// #RGPP1_4__dmy0 @TEXT("l=17.13u w=1u multi=(1)",key="value",size=0.9,halign="start") => @PLACE(313,-118);
// #RGPP1_4__dmy0 @TEXT("",key="model");
// #RGPP1_5__dmy0 @SET-SYMBOL $RESISTOR;
// #RGPP1_5__dmy0 @PLACE(335,-114) => @ORIENT("R90");
// #RGPP1_5__dmy0 @TEXT("RGPP1_5__dmy0",key="name",size=1.3,halign="start") => @PLACE(338,-111);
// #RGPP1_5__dmy0 @TEXT("l=17.13u w=1u multi=(1)",key="value",size=0.9,halign="start") => @PLACE(338,-118);
// #RGPP1_5__dmy0 @TEXT("",key="model");
// (104,-99) @TEXT("GPP / 10 series poly sections",size=0.95,halign="start",textcolor="#223d52");
// &"GNNB" @WIRE(mode="straight",linecolor="#30485d",linewidth=0.16) {#XSTD_GNNCN:1 (61.5,0) (61.5,0) #XSTD_GNNBN:2};
// &"GNNDRV" @WIRE(mode="straight",linecolor="#30485d",linewidth=0.16) {#XSTD_GNNCN:2 (95.5,0) (95.5,0) #RGNN0:1};
// &"GNNA" @WIRE(mode="straight",linecolor="#30485d",linewidth=0.16) {#XSTD_GNNBN:1 (32.5,0) (32.5,0) #XSTD_GNNAN:2};
// &"GNNPRE" @WIRE(mode="straight",linecolor="#30485d",linewidth=0.16) {#XSTD_GNNAN:1 (0.5,0) (0.5,0) #X025:4};
// &"GNPB" @WIRE(mode="straight",linecolor="#30485d",linewidth=0.16) {#XSTD_GNPCN:1 (61.5,-38) (61.5,-38) #XSTD_GNPBN:2};
// &"GNPDRV" @WIRE(mode="straight",linecolor="#30485d",linewidth=0.16) {#XSTD_GNPCN:2 (95.5,-38) (95.5,-38) #RGNP0:1};
// &"GNPA" @WIRE(mode="straight",linecolor="#30485d",linewidth=0.16) {#XSTD_GNPBN:1 (32.5,-38) (32.5,-38) #XSTD_GNPAN:2};
// &"H" @WIRE(mode="straight",linecolor="#30485d",linewidth=0.16) {#XSTD_GNPAN:1 (-6.5,-38) (-6.5,-76) #X008:1};
// &"GPNB" @WIRE(mode="straight",linecolor="#30485d",linewidth=0.16) {#XSTD_GPNCN:1 (61.5,-76) (61.5,-76) #XSTD_GPNBN:2};
// &"GPNDRV" @WIRE(mode="straight",linecolor="#30485d",linewidth=0.16) {#XSTD_GPNCN:2 (95.5,-76) (95.5,-76) #RGPN0:1};
// &"GPNA" @WIRE(mode="straight",linecolor="#30485d",linewidth=0.16) {#XSTD_GPNBN:1 (32.5,-76) (32.5,-76) #XSTD_GPNAN:2};
// &"GPNPRE" @WIRE(mode="straight",linecolor="#30485d",linewidth=0.16) {#XSTD_GPNAN:1 (0.5,-76) (0.5,-76) #X008:4};
// &"GPPB" @WIRE(mode="straight",linecolor="#30485d",linewidth=0.16) {#XSTD_GPPCN:1 (61.5,-114) (61.5,-114) #XSTD_GPPBN:2};
// &"GPPDRV" @WIRE(mode="straight",linecolor="#30485d",linewidth=0.16) {#XSTD_GPPCN:2 (95.5,-114) (95.5,-114) #RGPP0:1};
// &"GPPA" @WIRE(mode="straight",linecolor="#30485d",linewidth=0.16) {#XSTD_GPPBN:1 (32.5,-114) (32.5,-114) #XSTD_GPPAN:2};
// &"GNNRG" @WIRE(mode="straight",linecolor="#30485d",linewidth=0.16) {#RGNN1:1 (222.5,0) (222.5,0) #RGNN0_5__dmy0:2};
// &"RGNN1_1__dmy0" @WIRE(mode="straight",linecolor="#30485d",linewidth=0.16) {#RGNN1:2 (247.5,0) (247.5,0) #RGNN1_2__dmy0:1};
// &"RGNN1_2__dmy0" @WIRE(mode="straight",linecolor="#30485d",linewidth=0.16) {#RGNN1_2__dmy0:2 (272.5,0) (272.5,0) #RGNN1_3__dmy0:1};
// &"RGNN1_3__dmy0" @WIRE(mode="straight",linecolor="#30485d",linewidth=0.16) {#RGNN1_3__dmy0:2 (297.5,0) (297.5,0) #RGNN1_4__dmy0:1};
// &"RGNN1_4__dmy0" @WIRE(mode="straight",linecolor="#30485d",linewidth=0.16) {#RGNN1_4__dmy0:2 (322.5,0) (322.5,0) #RGNN1_5__dmy0:1};
// &"RGNN0_1__dmy0" @WIRE(mode="straight",linecolor="#30485d",linewidth=0.16) {#RGNN0:2 (122.5,0) (122.5,0) #RGNN0_2__dmy0:1};
// &"RGNN0_2__dmy0" @WIRE(mode="straight",linecolor="#30485d",linewidth=0.16) {#RGNN0_2__dmy0:2 (147.5,0) (147.5,0) #RGNN0_3__dmy0:1};
// &"RGNN0_3__dmy0" @WIRE(mode="straight",linecolor="#30485d",linewidth=0.16) {#RGNN0_3__dmy0:2 (172.5,0) (172.5,0) #RGNN0_4__dmy0:1};
// &"RGNN0_4__dmy0" @WIRE(mode="straight",linecolor="#30485d",linewidth=0.16) {#RGNN0_4__dmy0:2 (197.5,0) (197.5,0) #RGNN0_5__dmy0:1};
// &"GNPRG" @WIRE(mode="straight",linecolor="#30485d",linewidth=0.16) {#RGNP1:1 (222.5,-38) (222.5,-38) #RGNP0_5__dmy0:2};
// &"RGNP1_1__dmy0" @WIRE(mode="straight",linecolor="#30485d",linewidth=0.16) {#RGNP1:2 (247.5,-38) (247.5,-38) #RGNP1_2__dmy0:1};
// &"RGNP1_2__dmy0" @WIRE(mode="straight",linecolor="#30485d",linewidth=0.16) {#RGNP1_2__dmy0:2 (272.5,-38) (272.5,-38) #RGNP1_3__dmy0:1};
// &"RGNP1_3__dmy0" @WIRE(mode="straight",linecolor="#30485d",linewidth=0.16) {#RGNP1_3__dmy0:2 (297.5,-38) (297.5,-38) #RGNP1_4__dmy0:1};
// &"RGNP1_4__dmy0" @WIRE(mode="straight",linecolor="#30485d",linewidth=0.16) {#RGNP1_4__dmy0:2 (322.5,-38) (322.5,-38) #RGNP1_5__dmy0:1};
// &"RGNP0_1__dmy0" @WIRE(mode="straight",linecolor="#30485d",linewidth=0.16) {#RGNP0:2 (122.5,-38) (122.5,-38) #RGNP0_2__dmy0:1};
// &"RGNP0_2__dmy0" @WIRE(mode="straight",linecolor="#30485d",linewidth=0.16) {#RGNP0_2__dmy0:2 (147.5,-38) (147.5,-38) #RGNP0_3__dmy0:1};
// &"RGNP0_3__dmy0" @WIRE(mode="straight",linecolor="#30485d",linewidth=0.16) {#RGNP0_3__dmy0:2 (172.5,-38) (172.5,-38) #RGNP0_4__dmy0:1};
// &"RGNP0_4__dmy0" @WIRE(mode="straight",linecolor="#30485d",linewidth=0.16) {#RGNP0_4__dmy0:2 (197.5,-38) (197.5,-38) #RGNP0_5__dmy0:1};
// &"GPNRG" @WIRE(mode="straight",linecolor="#30485d",linewidth=0.16) {#RGPN1:1 (222.5,-76) (222.5,-76) #RGPN0_5__dmy0:2};
// &"RGPN1_1__dmy0" @WIRE(mode="straight",linecolor="#30485d",linewidth=0.16) {#RGPN1:2 (247.5,-76) (247.5,-76) #RGPN1_2__dmy0:1};
// &"RGPN1_2__dmy0" @WIRE(mode="straight",linecolor="#30485d",linewidth=0.16) {#RGPN1_2__dmy0:2 (272.5,-76) (272.5,-76) #RGPN1_3__dmy0:1};
// &"RGPN1_3__dmy0" @WIRE(mode="straight",linecolor="#30485d",linewidth=0.16) {#RGPN1_3__dmy0:2 (297.5,-76) (297.5,-76) #RGPN1_4__dmy0:1};
// &"RGPN1_4__dmy0" @WIRE(mode="straight",linecolor="#30485d",linewidth=0.16) {#RGPN1_4__dmy0:2 (322.5,-76) (322.5,-76) #RGPN1_5__dmy0:1};
// &"RGPN0_1__dmy0" @WIRE(mode="straight",linecolor="#30485d",linewidth=0.16) {#RGPN0:2 (122.5,-76) (122.5,-76) #RGPN0_2__dmy0:1};
// &"RGPN0_2__dmy0" @WIRE(mode="straight",linecolor="#30485d",linewidth=0.16) {#RGPN0_2__dmy0:2 (147.5,-76) (147.5,-76) #RGPN0_3__dmy0:1};
// &"RGPN0_3__dmy0" @WIRE(mode="straight",linecolor="#30485d",linewidth=0.16) {#RGPN0_3__dmy0:2 (172.5,-76) (172.5,-76) #RGPN0_4__dmy0:1};
// &"RGPN0_4__dmy0" @WIRE(mode="straight",linecolor="#30485d",linewidth=0.16) {#RGPN0_4__dmy0:2 (197.5,-76) (197.5,-76) #RGPN0_5__dmy0:1};
// &"GPPRG" @WIRE(mode="straight",linecolor="#30485d",linewidth=0.16) {#RGPP1:1 (222.5,-114) (222.5,-114) #RGPP0_5__dmy0:2};
// &"RGPP1_1__dmy0" @WIRE(mode="straight",linecolor="#30485d",linewidth=0.16) {#RGPP1:2 (247.5,-114) (247.5,-114) #RGPP1_2__dmy0:1};
// &"RGPP1_2__dmy0" @WIRE(mode="straight",linecolor="#30485d",linewidth=0.16) {#RGPP1_2__dmy0:2 (272.5,-114) (272.5,-114) #RGPP1_3__dmy0:1};
// &"RGPP1_3__dmy0" @WIRE(mode="straight",linecolor="#30485d",linewidth=0.16) {#RGPP1_3__dmy0:2 (297.5,-114) (297.5,-114) #RGPP1_4__dmy0:1};
// &"RGPP1_4__dmy0" @WIRE(mode="straight",linecolor="#30485d",linewidth=0.16) {#RGPP1_4__dmy0:2 (322.5,-114) (322.5,-114) #RGPP1_5__dmy0:1};
// &"RGPP0_1__dmy0" @WIRE(mode="straight",linecolor="#30485d",linewidth=0.16) {#RGPP0:2 (122.5,-114) (122.5,-114) #RGPP0_2__dmy0:1};
// &"RGPP0_2__dmy0" @WIRE(mode="straight",linecolor="#30485d",linewidth=0.16) {#RGPP0_2__dmy0:2 (147.5,-114) (147.5,-114) #RGPP0_3__dmy0:1};
// &"RGPP0_3__dmy0" @WIRE(mode="straight",linecolor="#30485d",linewidth=0.16) {#RGPP0_3__dmy0:2 (172.5,-114) (172.5,-114) #RGPP0_4__dmy0:1};
// &"RGPP0_4__dmy0" @WIRE(mode="straight",linecolor="#30485d",linewidth=0.16) {#RGPP0_4__dmy0:2 (197.5,-114) (197.5,-114) #RGPP0_5__dmy0:1};
// (-28,-148) @TEXT("GP and GN chains keep their source polarity, device sizing and series R; no zero-delay abstraction.",size=1,halign="start",textcolor="#223d52");
// &"VDD" @WIRE(mode="straight",linecolor="#30485d",linewidth=0.16) {#XSTD_GNNCN:3 (76,10)};
// (76,10.4) @TEXT("VDD",size=1.1,halign="middle",valign="bottom");
// &"VSS" @WIRE(mode="straight",linecolor="#30485d",linewidth=0.16) {#XSTD_GNNCN:4 (76,-10)};
// (76,-10.4) @TEXT("VSS",size=1.1,halign="middle",valign="top");
// &"VDD" @WIRE(mode="straight",linecolor="#30485d",linewidth=0.16) {#XSTD_GNNBN:3 (47,10)};
// (47,10.4) @TEXT("VDD",size=1.1,halign="middle",valign="bottom");
// &"VSS" @WIRE(mode="straight",linecolor="#30485d",linewidth=0.16) {#XSTD_GNNBN:4 (47,-10)};
// (47,-10.4) @TEXT("VSS",size=1.1,halign="middle",valign="top");
// &"VDD" @WIRE(mode="straight",linecolor="#30485d",linewidth=0.16) {#XSTD_GNNAN:3 (18,10)};
// (18,10.4) @TEXT("VDD",size=1.1,halign="middle",valign="bottom");
// &"VSS" @WIRE(mode="straight",linecolor="#30485d",linewidth=0.16) {#XSTD_GNNAN:4 (18,-10)};
// (18,-10.4) @TEXT("VSS",size=1.1,halign="middle",valign="top");
// &"VDD" @WIRE(mode="straight",linecolor="#30485d",linewidth=0.16) {#XSTD_GNPCN:3 (76,-28)};
// (76,-27.6) @TEXT("VDD",size=1.1,halign="middle",valign="bottom");
// &"VSS" @WIRE(mode="straight",linecolor="#30485d",linewidth=0.16) {#XSTD_GNPCN:4 (76,-48)};
// (76,-48.4) @TEXT("VSS",size=1.1,halign="middle",valign="top");
// &"VDD" @WIRE(mode="straight",linecolor="#30485d",linewidth=0.16) {#XSTD_GNPBN:3 (47,-28)};
// (47,-27.6) @TEXT("VDD",size=1.1,halign="middle",valign="bottom");
// &"VSS" @WIRE(mode="straight",linecolor="#30485d",linewidth=0.16) {#XSTD_GNPBN:4 (47,-48)};
// (47,-48.4) @TEXT("VSS",size=1.1,halign="middle",valign="top");
// &"VDD" @WIRE(mode="straight",linecolor="#30485d",linewidth=0.16) {#XSTD_GNPAN:3 (18,-28)};
// (18,-27.6) @TEXT("VDD",size=1.1,halign="middle",valign="bottom");
// &"VSS" @WIRE(mode="straight",linecolor="#30485d",linewidth=0.16) {#XSTD_GNPAN:4 (18,-48)};
// (18,-48.4) @TEXT("VSS",size=1.1,halign="middle",valign="top");
// &"VDD" @WIRE(mode="straight",linecolor="#30485d",linewidth=0.16) {#XSTD_GPNCN:3 (76,-66)};
// (76,-65.6) @TEXT("VDD",size=1.1,halign="middle",valign="bottom");
// &"VSS" @WIRE(mode="straight",linecolor="#30485d",linewidth=0.16) {#XSTD_GPNCN:4 (76,-86)};
// (76,-86.4) @TEXT("VSS",size=1.1,halign="middle",valign="top");
// &"VDD" @WIRE(mode="straight",linecolor="#30485d",linewidth=0.16) {#XSTD_GPNBN:3 (47,-66)};
// (47,-65.6) @TEXT("VDD",size=1.1,halign="middle",valign="bottom");
// &"VSS" @WIRE(mode="straight",linecolor="#30485d",linewidth=0.16) {#XSTD_GPNBN:4 (47,-86)};
// (47,-86.4) @TEXT("VSS",size=1.1,halign="middle",valign="top");
// &"VDD" @WIRE(mode="straight",linecolor="#30485d",linewidth=0.16) {#XSTD_GPNAN:3 (18,-66)};
// (18,-65.6) @TEXT("VDD",size=1.1,halign="middle",valign="bottom");
// &"VSS" @WIRE(mode="straight",linecolor="#30485d",linewidth=0.16) {#XSTD_GPNAN:4 (18,-86)};
// (18,-86.4) @TEXT("VSS",size=1.1,halign="middle",valign="top");
// &"VDD" @WIRE(mode="straight",linecolor="#30485d",linewidth=0.16) {#XSTD_GPPCN:3 (76,-104)};
// (76,-103.6) @TEXT("VDD",size=1.1,halign="middle",valign="bottom");
// &"VSS" @WIRE(mode="straight",linecolor="#30485d",linewidth=0.16) {#XSTD_GPPCN:4 (76,-124)};
// (76,-124.4) @TEXT("VSS",size=1.1,halign="middle",valign="top");
// &"VDD" @WIRE(mode="straight",linecolor="#30485d",linewidth=0.16) {#XSTD_GPPBN:3 (47,-104)};
// (47,-103.6) @TEXT("VDD",size=1.1,halign="middle",valign="bottom");
// &"VSS" @WIRE(mode="straight",linecolor="#30485d",linewidth=0.16) {#XSTD_GPPBN:4 (47,-124)};
// (47,-124.4) @TEXT("VSS",size=1.1,halign="middle",valign="top");
// &"L" @WIRE(mode="straight",linecolor="#30485d",linewidth=0.16) {#XSTD_GPPAN:1 (8,-114)};
// (7.6,-114) @TEXT("L",size=1.1,halign="end",valign="middle");
// &"VDD" @WIRE(mode="straight",linecolor="#30485d",linewidth=0.16) {#XSTD_GPPAN:3 (18,-104)};
// (18,-103.6) @TEXT("VDD",size=1.1,halign="middle",valign="bottom");
// &"VSS" @WIRE(mode="straight",linecolor="#30485d",linewidth=0.16) {#XSTD_GPPAN:4 (18,-124)};
// (18,-124.4) @TEXT("VSS",size=1.1,halign="middle",valign="top");
// &"GNN" @WIRE(mode="straight",linecolor="#30485d",linewidth=0.16) {#RGNN1_5__dmy0:2 (340,0)};
// (340.4,0) @TEXT("GNN",size=1.1,halign="start",valign="middle");
// &"GNP" @WIRE(mode="straight",linecolor="#30485d",linewidth=0.16) {#RGNP1_5__dmy0:2 (340,-38)};
// (340.4,-38) @TEXT("GNP",size=1.1,halign="start",valign="middle");
// &"GPN" @WIRE(mode="straight",linecolor="#30485d",linewidth=0.16) {#RGPN1_5__dmy0:2 (340,-76)};
// (340.4,-76) @TEXT("GPN",size=1.1,halign="start",valign="middle");
// &"GPP" @WIRE(mode="straight",linecolor="#30485d",linewidth=0.16) {#RGPP1_5__dmy0:2 (340,-114)};
// (340.4,-114) @TEXT("GPP",size=1.1,halign="start",valign="middle");
// &"L" @WIRE(mode="straight",linecolor="#30485d",linewidth=0.16) {#X025:1 (-27,0)};
// (-27.4,0) @TEXT("L",size=1.1,halign="end",valign="middle");
// &"VDD" @WIRE(mode="straight",linecolor="#30485d",linewidth=0.16) {#X025:2 (-17,10)};
// (-17,10.4) @TEXT("VDD",size=1.1,halign="middle",valign="bottom");
// &"VSS" @WIRE(mode="straight",linecolor="#30485d",linewidth=0.16) {#X025:3 (-17,-10)};
// (-17,-10.4) @TEXT("VSS",size=1.1,halign="middle",valign="top");
// &"VDD" @WIRE(mode="straight",linecolor="#30485d",linewidth=0.16) {#X008:2 (-17,-66)};
// (-17,-65.6) @TEXT("VDD",size=1.1,halign="middle",valign="bottom");
// &"VSS" @WIRE(mode="straight",linecolor="#30485d",linewidth=0.16) {#X008:3 (-17,-86)};
// (-17,-86.4) @TEXT("VSS",size=1.1,halign="middle",valign="top");
// }
// END SARADC RNL
ends sar8p_refdrv_b2

subckt sar8p_refdrv_b3 GNN GNP GPN GPP H L VDD VSS
    XSTD_GNNCN (GNNB GNNDRV VDD VSS) INVD1BWP12T30P140
    XSTD_GNNBN (GNNA GNNB VDD VSS) INVD1BWP12T30P140
    XSTD_GNNAN (GNNPRE GNNA VDD VSS) INVD1BWP12T30P140
    XSTD_GNPCN (GNPB GNPDRV VDD VSS) INVD1BWP12T30P140
    XSTD_GNPBN (GNPA GNPB VDD VSS) INVD1BWP12T30P140
    XSTD_GNPAN (H GNPA VDD VSS) INVD1BWP12T30P140
    XSTD_GPNCN (GPNB GPNDRV VDD VSS) INVD1BWP12T30P140
    XSTD_GPNBN (GPNA GPNB VDD VSS) INVD1BWP12T30P140
    XSTD_GPNAN (GPNPRE GPNA VDD VSS) INVD1BWP12T30P140
    XSTD_GPPCN (GPPB GPPDRV VDD VSS) INVD1BWP12T30P140
    XSTD_GPPBN (GPPA GPPB VDD VSS) INVD1BWP12T30P140
    XSTD_GPPAN (L GPPA VDD VSS) INVD1BWP12T30P140
//Series configuration of RGNN1
RGNN1  (GNNRG RGNN1_1__dmy0 ) rupolym l=17.13u w=1u m=8 multi=(1)
RGNN1_2__dmy0  (RGNN1_1__dmy0 RGNN1_2__dmy0 ) rupolym l=17.13u w=1u m=8          multi=(1)
RGNN1_3__dmy0  (RGNN1_2__dmy0 RGNN1_3__dmy0 ) rupolym l=17.13u w=1u m=8          multi=(1)
RGNN1_4__dmy0  (RGNN1_3__dmy0 RGNN1_4__dmy0 ) rupolym l=17.13u w=1u m=8          multi=(1)
RGNN1_5__dmy0  (RGNN1_4__dmy0 GNN ) rupolym l=17.13u w=1u m=8 multi=(1)
//End of RGNN1

//Series configuration of RGNN0
RGNN0  (GNNDRV RGNN0_1__dmy0 ) rupolym l=17.13u w=1u m=8 multi=(1)
RGNN0_2__dmy0  (RGNN0_1__dmy0 RGNN0_2__dmy0 ) rupolym l=17.13u w=1u m=8          multi=(1)
RGNN0_3__dmy0  (RGNN0_2__dmy0 RGNN0_3__dmy0 ) rupolym l=17.13u w=1u m=8          multi=(1)
RGNN0_4__dmy0  (RGNN0_3__dmy0 RGNN0_4__dmy0 ) rupolym l=17.13u w=1u m=8          multi=(1)
RGNN0_5__dmy0  (RGNN0_4__dmy0 GNNRG ) rupolym l=17.13u w=1u m=8 multi=(1)
//End of RGNN0

//Series configuration of RGNP1
RGNP1  (GNPRG RGNP1_1__dmy0 ) rupolym l=17.13u w=1u m=8 multi=(1)
RGNP1_2__dmy0  (RGNP1_1__dmy0 RGNP1_2__dmy0 ) rupolym l=17.13u w=1u m=8          multi=(1)
RGNP1_3__dmy0  (RGNP1_2__dmy0 RGNP1_3__dmy0 ) rupolym l=17.13u w=1u m=8          multi=(1)
RGNP1_4__dmy0  (RGNP1_3__dmy0 RGNP1_4__dmy0 ) rupolym l=17.13u w=1u m=8          multi=(1)
RGNP1_5__dmy0  (RGNP1_4__dmy0 GNP ) rupolym l=17.13u w=1u m=8 multi=(1)
//End of RGNP1

//Series configuration of RGNP0
RGNP0  (GNPDRV RGNP0_1__dmy0 ) rupolym l=17.13u w=1u m=8 multi=(1)
RGNP0_2__dmy0  (RGNP0_1__dmy0 RGNP0_2__dmy0 ) rupolym l=17.13u w=1u m=8          multi=(1)
RGNP0_3__dmy0  (RGNP0_2__dmy0 RGNP0_3__dmy0 ) rupolym l=17.13u w=1u m=8          multi=(1)
RGNP0_4__dmy0  (RGNP0_3__dmy0 RGNP0_4__dmy0 ) rupolym l=17.13u w=1u m=8          multi=(1)
RGNP0_5__dmy0  (RGNP0_4__dmy0 GNPRG ) rupolym l=17.13u w=1u m=8 multi=(1)
//End of RGNP0

//Series configuration of RGPN1
RGPN1  (GPNRG RGPN1_1__dmy0 ) rupolym l=17.13u w=1u m=8 multi=(1)
RGPN1_2__dmy0  (RGPN1_1__dmy0 RGPN1_2__dmy0 ) rupolym l=17.13u w=1u m=8          multi=(1)
RGPN1_3__dmy0  (RGPN1_2__dmy0 RGPN1_3__dmy0 ) rupolym l=17.13u w=1u m=8          multi=(1)
RGPN1_4__dmy0  (RGPN1_3__dmy0 RGPN1_4__dmy0 ) rupolym l=17.13u w=1u m=8          multi=(1)
RGPN1_5__dmy0  (RGPN1_4__dmy0 GPN ) rupolym l=17.13u w=1u m=8 multi=(1)
//End of RGPN1

//Series configuration of RGPN0
RGPN0  (GPNDRV RGPN0_1__dmy0 ) rupolym l=17.13u w=1u m=8 multi=(1)
RGPN0_2__dmy0  (RGPN0_1__dmy0 RGPN0_2__dmy0 ) rupolym l=17.13u w=1u m=8          multi=(1)
RGPN0_3__dmy0  (RGPN0_2__dmy0 RGPN0_3__dmy0 ) rupolym l=17.13u w=1u m=8          multi=(1)
RGPN0_4__dmy0  (RGPN0_3__dmy0 RGPN0_4__dmy0 ) rupolym l=17.13u w=1u m=8          multi=(1)
RGPN0_5__dmy0  (RGPN0_4__dmy0 GPNRG ) rupolym l=17.13u w=1u m=8 multi=(1)
//End of RGPN0

//Series configuration of RGPP1
RGPP1  (GPPRG RGPP1_1__dmy0 ) rupolym l=17.13u w=1u m=8 multi=(1)
RGPP1_2__dmy0  (RGPP1_1__dmy0 RGPP1_2__dmy0 ) rupolym l=17.13u w=1u m=8          multi=(1)
RGPP1_3__dmy0  (RGPP1_2__dmy0 RGPP1_3__dmy0 ) rupolym l=17.13u w=1u m=8          multi=(1)
RGPP1_4__dmy0  (RGPP1_3__dmy0 RGPP1_4__dmy0 ) rupolym l=17.13u w=1u m=8          multi=(1)
RGPP1_5__dmy0  (RGPP1_4__dmy0 GPP ) rupolym l=17.13u w=1u m=8 multi=(1)
//End of RGPP1

//Series configuration of RGPP0
RGPP0  (GPPDRV RGPP0_1__dmy0 ) rupolym l=17.13u w=1u m=8 multi=(1)
RGPP0_2__dmy0  (RGPP0_1__dmy0 RGPP0_2__dmy0 ) rupolym l=17.13u w=1u m=8          multi=(1)
RGPP0_3__dmy0  (RGPP0_2__dmy0 RGPP0_3__dmy0 ) rupolym l=17.13u w=1u m=8          multi=(1)
RGPP0_4__dmy0  (RGPP0_3__dmy0 RGPP0_4__dmy0 ) rupolym l=17.13u w=1u m=8          multi=(1)
RGPP0_5__dmy0  (RGPP0_4__dmy0 GPPRG ) rupolym l=17.13u w=1u m=8 multi=(1)
//End of RGPP0

    X025 (L VDD VSS GNNPRE) sar8p_inv
    X008 (H VDD VSS GPNPRE) sar8p_inv
// BEGIN SARADC RNL
// @RNL(author="saradc topology") {
// (-28,27) @TEXT("sar8p_refdrv_b3 / four physical gate-driver chains",size=1.5,halign="start",textcolor="#223d52");
// #X025 @SET-SYMBOL $S_sar8p_inv;
// #X025 @PLACE(-17,0) => @ORIENT("R0");
// #XSTD_GNNAN @SET-SYMBOL $S_INVD1BWP12T30P140;
// #XSTD_GNNAN @PLACE(18,0) => @ORIENT("R0");
// #XSTD_GNNBN @SET-SYMBOL $S_INVD1BWP12T30P140;
// #XSTD_GNNBN @PLACE(47,0) => @ORIENT("R0");
// #XSTD_GNNCN @SET-SYMBOL $S_INVD1BWP12T30P140;
// #XSTD_GNNCN @PLACE(76,0) => @ORIENT("R0");
// #RGNN0 @SET-SYMBOL $RESISTOR;
// #RGNN0 @PLACE(110,0) => @ORIENT("R90");
// #RGNN0 @TEXT("RGNN0",key="name",size=1.3,halign="start") => @PLACE(113,3);
// #RGNN0 @TEXT("l=17.13u w=1u multi=(1)",key="value",size=0.9,halign="start") => @PLACE(113,-4);
// #RGNN0 @TEXT("",key="model");
// #RGNN0_2__dmy0 @SET-SYMBOL $RESISTOR;
// #RGNN0_2__dmy0 @PLACE(135,0) => @ORIENT("R90");
// #RGNN0_2__dmy0 @TEXT("RGNN0_2__dmy0",key="name",size=1.3,halign="start") => @PLACE(138,3);
// #RGNN0_2__dmy0 @TEXT("l=17.13u w=1u multi=(1)",key="value",size=0.9,halign="start") => @PLACE(138,-4);
// #RGNN0_2__dmy0 @TEXT("",key="model");
// #RGNN0_3__dmy0 @SET-SYMBOL $RESISTOR;
// #RGNN0_3__dmy0 @PLACE(160,0) => @ORIENT("R90");
// #RGNN0_3__dmy0 @TEXT("RGNN0_3__dmy0",key="name",size=1.3,halign="start") => @PLACE(163,3);
// #RGNN0_3__dmy0 @TEXT("l=17.13u w=1u multi=(1)",key="value",size=0.9,halign="start") => @PLACE(163,-4);
// #RGNN0_3__dmy0 @TEXT("",key="model");
// #RGNN0_4__dmy0 @SET-SYMBOL $RESISTOR;
// #RGNN0_4__dmy0 @PLACE(185,0) => @ORIENT("R90");
// #RGNN0_4__dmy0 @TEXT("RGNN0_4__dmy0",key="name",size=1.3,halign="start") => @PLACE(188,3);
// #RGNN0_4__dmy0 @TEXT("l=17.13u w=1u multi=(1)",key="value",size=0.9,halign="start") => @PLACE(188,-4);
// #RGNN0_4__dmy0 @TEXT("",key="model");
// #RGNN0_5__dmy0 @SET-SYMBOL $RESISTOR;
// #RGNN0_5__dmy0 @PLACE(210,0) => @ORIENT("R90");
// #RGNN0_5__dmy0 @TEXT("RGNN0_5__dmy0",key="name",size=1.3,halign="start") => @PLACE(213,3);
// #RGNN0_5__dmy0 @TEXT("l=17.13u w=1u multi=(1)",key="value",size=0.9,halign="start") => @PLACE(213,-4);
// #RGNN0_5__dmy0 @TEXT("",key="model");
// #RGNN1 @SET-SYMBOL $RESISTOR;
// #RGNN1 @PLACE(235,0) => @ORIENT("R90");
// #RGNN1 @TEXT("RGNN1",key="name",size=1.3,halign="start") => @PLACE(238,3);
// #RGNN1 @TEXT("l=17.13u w=1u multi=(1)",key="value",size=0.9,halign="start") => @PLACE(238,-4);
// #RGNN1 @TEXT("",key="model");
// #RGNN1_2__dmy0 @SET-SYMBOL $RESISTOR;
// #RGNN1_2__dmy0 @PLACE(260,0) => @ORIENT("R90");
// #RGNN1_2__dmy0 @TEXT("RGNN1_2__dmy0",key="name",size=1.3,halign="start") => @PLACE(263,3);
// #RGNN1_2__dmy0 @TEXT("l=17.13u w=1u multi=(1)",key="value",size=0.9,halign="start") => @PLACE(263,-4);
// #RGNN1_2__dmy0 @TEXT("",key="model");
// #RGNN1_3__dmy0 @SET-SYMBOL $RESISTOR;
// #RGNN1_3__dmy0 @PLACE(285,0) => @ORIENT("R90");
// #RGNN1_3__dmy0 @TEXT("RGNN1_3__dmy0",key="name",size=1.3,halign="start") => @PLACE(288,3);
// #RGNN1_3__dmy0 @TEXT("l=17.13u w=1u multi=(1)",key="value",size=0.9,halign="start") => @PLACE(288,-4);
// #RGNN1_3__dmy0 @TEXT("",key="model");
// #RGNN1_4__dmy0 @SET-SYMBOL $RESISTOR;
// #RGNN1_4__dmy0 @PLACE(310,0) => @ORIENT("R90");
// #RGNN1_4__dmy0 @TEXT("RGNN1_4__dmy0",key="name",size=1.3,halign="start") => @PLACE(313,3);
// #RGNN1_4__dmy0 @TEXT("l=17.13u w=1u multi=(1)",key="value",size=0.9,halign="start") => @PLACE(313,-4);
// #RGNN1_4__dmy0 @TEXT("",key="model");
// #RGNN1_5__dmy0 @SET-SYMBOL $RESISTOR;
// #RGNN1_5__dmy0 @PLACE(335,0) => @ORIENT("R90");
// #RGNN1_5__dmy0 @TEXT("RGNN1_5__dmy0",key="name",size=1.3,halign="start") => @PLACE(338,3);
// #RGNN1_5__dmy0 @TEXT("l=17.13u w=1u multi=(1)",key="value",size=0.9,halign="start") => @PLACE(338,-4);
// #RGNN1_5__dmy0 @TEXT("",key="model");
// (104,15) @TEXT("GNN / 10 series poly sections",size=0.95,halign="start",textcolor="#223d52");
// #XSTD_GNPAN @SET-SYMBOL $S_INVD1BWP12T30P140;
// #XSTD_GNPAN @PLACE(18,-38) => @ORIENT("R0");
// #XSTD_GNPBN @SET-SYMBOL $S_INVD1BWP12T30P140;
// #XSTD_GNPBN @PLACE(47,-38) => @ORIENT("R0");
// #XSTD_GNPCN @SET-SYMBOL $S_INVD1BWP12T30P140;
// #XSTD_GNPCN @PLACE(76,-38) => @ORIENT("R0");
// #RGNP0 @SET-SYMBOL $RESISTOR;
// #RGNP0 @PLACE(110,-38) => @ORIENT("R90");
// #RGNP0 @TEXT("RGNP0",key="name",size=1.3,halign="start") => @PLACE(113,-35);
// #RGNP0 @TEXT("l=17.13u w=1u multi=(1)",key="value",size=0.9,halign="start") => @PLACE(113,-42);
// #RGNP0 @TEXT("",key="model");
// #RGNP0_2__dmy0 @SET-SYMBOL $RESISTOR;
// #RGNP0_2__dmy0 @PLACE(135,-38) => @ORIENT("R90");
// #RGNP0_2__dmy0 @TEXT("RGNP0_2__dmy0",key="name",size=1.3,halign="start") => @PLACE(138,-35);
// #RGNP0_2__dmy0 @TEXT("l=17.13u w=1u multi=(1)",key="value",size=0.9,halign="start") => @PLACE(138,-42);
// #RGNP0_2__dmy0 @TEXT("",key="model");
// #RGNP0_3__dmy0 @SET-SYMBOL $RESISTOR;
// #RGNP0_3__dmy0 @PLACE(160,-38) => @ORIENT("R90");
// #RGNP0_3__dmy0 @TEXT("RGNP0_3__dmy0",key="name",size=1.3,halign="start") => @PLACE(163,-35);
// #RGNP0_3__dmy0 @TEXT("l=17.13u w=1u multi=(1)",key="value",size=0.9,halign="start") => @PLACE(163,-42);
// #RGNP0_3__dmy0 @TEXT("",key="model");
// #RGNP0_4__dmy0 @SET-SYMBOL $RESISTOR;
// #RGNP0_4__dmy0 @PLACE(185,-38) => @ORIENT("R90");
// #RGNP0_4__dmy0 @TEXT("RGNP0_4__dmy0",key="name",size=1.3,halign="start") => @PLACE(188,-35);
// #RGNP0_4__dmy0 @TEXT("l=17.13u w=1u multi=(1)",key="value",size=0.9,halign="start") => @PLACE(188,-42);
// #RGNP0_4__dmy0 @TEXT("",key="model");
// #RGNP0_5__dmy0 @SET-SYMBOL $RESISTOR;
// #RGNP0_5__dmy0 @PLACE(210,-38) => @ORIENT("R90");
// #RGNP0_5__dmy0 @TEXT("RGNP0_5__dmy0",key="name",size=1.3,halign="start") => @PLACE(213,-35);
// #RGNP0_5__dmy0 @TEXT("l=17.13u w=1u multi=(1)",key="value",size=0.9,halign="start") => @PLACE(213,-42);
// #RGNP0_5__dmy0 @TEXT("",key="model");
// #RGNP1 @SET-SYMBOL $RESISTOR;
// #RGNP1 @PLACE(235,-38) => @ORIENT("R90");
// #RGNP1 @TEXT("RGNP1",key="name",size=1.3,halign="start") => @PLACE(238,-35);
// #RGNP1 @TEXT("l=17.13u w=1u multi=(1)",key="value",size=0.9,halign="start") => @PLACE(238,-42);
// #RGNP1 @TEXT("",key="model");
// #RGNP1_2__dmy0 @SET-SYMBOL $RESISTOR;
// #RGNP1_2__dmy0 @PLACE(260,-38) => @ORIENT("R90");
// #RGNP1_2__dmy0 @TEXT("RGNP1_2__dmy0",key="name",size=1.3,halign="start") => @PLACE(263,-35);
// #RGNP1_2__dmy0 @TEXT("l=17.13u w=1u multi=(1)",key="value",size=0.9,halign="start") => @PLACE(263,-42);
// #RGNP1_2__dmy0 @TEXT("",key="model");
// #RGNP1_3__dmy0 @SET-SYMBOL $RESISTOR;
// #RGNP1_3__dmy0 @PLACE(285,-38) => @ORIENT("R90");
// #RGNP1_3__dmy0 @TEXT("RGNP1_3__dmy0",key="name",size=1.3,halign="start") => @PLACE(288,-35);
// #RGNP1_3__dmy0 @TEXT("l=17.13u w=1u multi=(1)",key="value",size=0.9,halign="start") => @PLACE(288,-42);
// #RGNP1_3__dmy0 @TEXT("",key="model");
// #RGNP1_4__dmy0 @SET-SYMBOL $RESISTOR;
// #RGNP1_4__dmy0 @PLACE(310,-38) => @ORIENT("R90");
// #RGNP1_4__dmy0 @TEXT("RGNP1_4__dmy0",key="name",size=1.3,halign="start") => @PLACE(313,-35);
// #RGNP1_4__dmy0 @TEXT("l=17.13u w=1u multi=(1)",key="value",size=0.9,halign="start") => @PLACE(313,-42);
// #RGNP1_4__dmy0 @TEXT("",key="model");
// #RGNP1_5__dmy0 @SET-SYMBOL $RESISTOR;
// #RGNP1_5__dmy0 @PLACE(335,-38) => @ORIENT("R90");
// #RGNP1_5__dmy0 @TEXT("RGNP1_5__dmy0",key="name",size=1.3,halign="start") => @PLACE(338,-35);
// #RGNP1_5__dmy0 @TEXT("l=17.13u w=1u multi=(1)",key="value",size=0.9,halign="start") => @PLACE(338,-42);
// #RGNP1_5__dmy0 @TEXT("",key="model");
// (104,-23) @TEXT("GNP / 10 series poly sections",size=0.95,halign="start",textcolor="#223d52");
// #X008 @SET-SYMBOL $S_sar8p_inv;
// #X008 @PLACE(-17,-76) => @ORIENT("R0");
// #XSTD_GPNAN @SET-SYMBOL $S_INVD1BWP12T30P140;
// #XSTD_GPNAN @PLACE(18,-76) => @ORIENT("R0");
// #XSTD_GPNBN @SET-SYMBOL $S_INVD1BWP12T30P140;
// #XSTD_GPNBN @PLACE(47,-76) => @ORIENT("R0");
// #XSTD_GPNCN @SET-SYMBOL $S_INVD1BWP12T30P140;
// #XSTD_GPNCN @PLACE(76,-76) => @ORIENT("R0");
// #RGPN0 @SET-SYMBOL $RESISTOR;
// #RGPN0 @PLACE(110,-76) => @ORIENT("R90");
// #RGPN0 @TEXT("RGPN0",key="name",size=1.3,halign="start") => @PLACE(113,-73);
// #RGPN0 @TEXT("l=17.13u w=1u multi=(1)",key="value",size=0.9,halign="start") => @PLACE(113,-80);
// #RGPN0 @TEXT("",key="model");
// #RGPN0_2__dmy0 @SET-SYMBOL $RESISTOR;
// #RGPN0_2__dmy0 @PLACE(135,-76) => @ORIENT("R90");
// #RGPN0_2__dmy0 @TEXT("RGPN0_2__dmy0",key="name",size=1.3,halign="start") => @PLACE(138,-73);
// #RGPN0_2__dmy0 @TEXT("l=17.13u w=1u multi=(1)",key="value",size=0.9,halign="start") => @PLACE(138,-80);
// #RGPN0_2__dmy0 @TEXT("",key="model");
// #RGPN0_3__dmy0 @SET-SYMBOL $RESISTOR;
// #RGPN0_3__dmy0 @PLACE(160,-76) => @ORIENT("R90");
// #RGPN0_3__dmy0 @TEXT("RGPN0_3__dmy0",key="name",size=1.3,halign="start") => @PLACE(163,-73);
// #RGPN0_3__dmy0 @TEXT("l=17.13u w=1u multi=(1)",key="value",size=0.9,halign="start") => @PLACE(163,-80);
// #RGPN0_3__dmy0 @TEXT("",key="model");
// #RGPN0_4__dmy0 @SET-SYMBOL $RESISTOR;
// #RGPN0_4__dmy0 @PLACE(185,-76) => @ORIENT("R90");
// #RGPN0_4__dmy0 @TEXT("RGPN0_4__dmy0",key="name",size=1.3,halign="start") => @PLACE(188,-73);
// #RGPN0_4__dmy0 @TEXT("l=17.13u w=1u multi=(1)",key="value",size=0.9,halign="start") => @PLACE(188,-80);
// #RGPN0_4__dmy0 @TEXT("",key="model");
// #RGPN0_5__dmy0 @SET-SYMBOL $RESISTOR;
// #RGPN0_5__dmy0 @PLACE(210,-76) => @ORIENT("R90");
// #RGPN0_5__dmy0 @TEXT("RGPN0_5__dmy0",key="name",size=1.3,halign="start") => @PLACE(213,-73);
// #RGPN0_5__dmy0 @TEXT("l=17.13u w=1u multi=(1)",key="value",size=0.9,halign="start") => @PLACE(213,-80);
// #RGPN0_5__dmy0 @TEXT("",key="model");
// #RGPN1 @SET-SYMBOL $RESISTOR;
// #RGPN1 @PLACE(235,-76) => @ORIENT("R90");
// #RGPN1 @TEXT("RGPN1",key="name",size=1.3,halign="start") => @PLACE(238,-73);
// #RGPN1 @TEXT("l=17.13u w=1u multi=(1)",key="value",size=0.9,halign="start") => @PLACE(238,-80);
// #RGPN1 @TEXT("",key="model");
// #RGPN1_2__dmy0 @SET-SYMBOL $RESISTOR;
// #RGPN1_2__dmy0 @PLACE(260,-76) => @ORIENT("R90");
// #RGPN1_2__dmy0 @TEXT("RGPN1_2__dmy0",key="name",size=1.3,halign="start") => @PLACE(263,-73);
// #RGPN1_2__dmy0 @TEXT("l=17.13u w=1u multi=(1)",key="value",size=0.9,halign="start") => @PLACE(263,-80);
// #RGPN1_2__dmy0 @TEXT("",key="model");
// #RGPN1_3__dmy0 @SET-SYMBOL $RESISTOR;
// #RGPN1_3__dmy0 @PLACE(285,-76) => @ORIENT("R90");
// #RGPN1_3__dmy0 @TEXT("RGPN1_3__dmy0",key="name",size=1.3,halign="start") => @PLACE(288,-73);
// #RGPN1_3__dmy0 @TEXT("l=17.13u w=1u multi=(1)",key="value",size=0.9,halign="start") => @PLACE(288,-80);
// #RGPN1_3__dmy0 @TEXT("",key="model");
// #RGPN1_4__dmy0 @SET-SYMBOL $RESISTOR;
// #RGPN1_4__dmy0 @PLACE(310,-76) => @ORIENT("R90");
// #RGPN1_4__dmy0 @TEXT("RGPN1_4__dmy0",key="name",size=1.3,halign="start") => @PLACE(313,-73);
// #RGPN1_4__dmy0 @TEXT("l=17.13u w=1u multi=(1)",key="value",size=0.9,halign="start") => @PLACE(313,-80);
// #RGPN1_4__dmy0 @TEXT("",key="model");
// #RGPN1_5__dmy0 @SET-SYMBOL $RESISTOR;
// #RGPN1_5__dmy0 @PLACE(335,-76) => @ORIENT("R90");
// #RGPN1_5__dmy0 @TEXT("RGPN1_5__dmy0",key="name",size=1.3,halign="start") => @PLACE(338,-73);
// #RGPN1_5__dmy0 @TEXT("l=17.13u w=1u multi=(1)",key="value",size=0.9,halign="start") => @PLACE(338,-80);
// #RGPN1_5__dmy0 @TEXT("",key="model");
// (104,-61) @TEXT("GPN / 10 series poly sections",size=0.95,halign="start",textcolor="#223d52");
// #XSTD_GPPAN @SET-SYMBOL $S_INVD1BWP12T30P140;
// #XSTD_GPPAN @PLACE(18,-114) => @ORIENT("R0");
// #XSTD_GPPBN @SET-SYMBOL $S_INVD1BWP12T30P140;
// #XSTD_GPPBN @PLACE(47,-114) => @ORIENT("R0");
// #XSTD_GPPCN @SET-SYMBOL $S_INVD1BWP12T30P140;
// #XSTD_GPPCN @PLACE(76,-114) => @ORIENT("R0");
// #RGPP0 @SET-SYMBOL $RESISTOR;
// #RGPP0 @PLACE(110,-114) => @ORIENT("R90");
// #RGPP0 @TEXT("RGPP0",key="name",size=1.3,halign="start") => @PLACE(113,-111);
// #RGPP0 @TEXT("l=17.13u w=1u multi=(1)",key="value",size=0.9,halign="start") => @PLACE(113,-118);
// #RGPP0 @TEXT("",key="model");
// #RGPP0_2__dmy0 @SET-SYMBOL $RESISTOR;
// #RGPP0_2__dmy0 @PLACE(135,-114) => @ORIENT("R90");
// #RGPP0_2__dmy0 @TEXT("RGPP0_2__dmy0",key="name",size=1.3,halign="start") => @PLACE(138,-111);
// #RGPP0_2__dmy0 @TEXT("l=17.13u w=1u multi=(1)",key="value",size=0.9,halign="start") => @PLACE(138,-118);
// #RGPP0_2__dmy0 @TEXT("",key="model");
// #RGPP0_3__dmy0 @SET-SYMBOL $RESISTOR;
// #RGPP0_3__dmy0 @PLACE(160,-114) => @ORIENT("R90");
// #RGPP0_3__dmy0 @TEXT("RGPP0_3__dmy0",key="name",size=1.3,halign="start") => @PLACE(163,-111);
// #RGPP0_3__dmy0 @TEXT("l=17.13u w=1u multi=(1)",key="value",size=0.9,halign="start") => @PLACE(163,-118);
// #RGPP0_3__dmy0 @TEXT("",key="model");
// #RGPP0_4__dmy0 @SET-SYMBOL $RESISTOR;
// #RGPP0_4__dmy0 @PLACE(185,-114) => @ORIENT("R90");
// #RGPP0_4__dmy0 @TEXT("RGPP0_4__dmy0",key="name",size=1.3,halign="start") => @PLACE(188,-111);
// #RGPP0_4__dmy0 @TEXT("l=17.13u w=1u multi=(1)",key="value",size=0.9,halign="start") => @PLACE(188,-118);
// #RGPP0_4__dmy0 @TEXT("",key="model");
// #RGPP0_5__dmy0 @SET-SYMBOL $RESISTOR;
// #RGPP0_5__dmy0 @PLACE(210,-114) => @ORIENT("R90");
// #RGPP0_5__dmy0 @TEXT("RGPP0_5__dmy0",key="name",size=1.3,halign="start") => @PLACE(213,-111);
// #RGPP0_5__dmy0 @TEXT("l=17.13u w=1u multi=(1)",key="value",size=0.9,halign="start") => @PLACE(213,-118);
// #RGPP0_5__dmy0 @TEXT("",key="model");
// #RGPP1 @SET-SYMBOL $RESISTOR;
// #RGPP1 @PLACE(235,-114) => @ORIENT("R90");
// #RGPP1 @TEXT("RGPP1",key="name",size=1.3,halign="start") => @PLACE(238,-111);
// #RGPP1 @TEXT("l=17.13u w=1u multi=(1)",key="value",size=0.9,halign="start") => @PLACE(238,-118);
// #RGPP1 @TEXT("",key="model");
// #RGPP1_2__dmy0 @SET-SYMBOL $RESISTOR;
// #RGPP1_2__dmy0 @PLACE(260,-114) => @ORIENT("R90");
// #RGPP1_2__dmy0 @TEXT("RGPP1_2__dmy0",key="name",size=1.3,halign="start") => @PLACE(263,-111);
// #RGPP1_2__dmy0 @TEXT("l=17.13u w=1u multi=(1)",key="value",size=0.9,halign="start") => @PLACE(263,-118);
// #RGPP1_2__dmy0 @TEXT("",key="model");
// #RGPP1_3__dmy0 @SET-SYMBOL $RESISTOR;
// #RGPP1_3__dmy0 @PLACE(285,-114) => @ORIENT("R90");
// #RGPP1_3__dmy0 @TEXT("RGPP1_3__dmy0",key="name",size=1.3,halign="start") => @PLACE(288,-111);
// #RGPP1_3__dmy0 @TEXT("l=17.13u w=1u multi=(1)",key="value",size=0.9,halign="start") => @PLACE(288,-118);
// #RGPP1_3__dmy0 @TEXT("",key="model");
// #RGPP1_4__dmy0 @SET-SYMBOL $RESISTOR;
// #RGPP1_4__dmy0 @PLACE(310,-114) => @ORIENT("R90");
// #RGPP1_4__dmy0 @TEXT("RGPP1_4__dmy0",key="name",size=1.3,halign="start") => @PLACE(313,-111);
// #RGPP1_4__dmy0 @TEXT("l=17.13u w=1u multi=(1)",key="value",size=0.9,halign="start") => @PLACE(313,-118);
// #RGPP1_4__dmy0 @TEXT("",key="model");
// #RGPP1_5__dmy0 @SET-SYMBOL $RESISTOR;
// #RGPP1_5__dmy0 @PLACE(335,-114) => @ORIENT("R90");
// #RGPP1_5__dmy0 @TEXT("RGPP1_5__dmy0",key="name",size=1.3,halign="start") => @PLACE(338,-111);
// #RGPP1_5__dmy0 @TEXT("l=17.13u w=1u multi=(1)",key="value",size=0.9,halign="start") => @PLACE(338,-118);
// #RGPP1_5__dmy0 @TEXT("",key="model");
// (104,-99) @TEXT("GPP / 10 series poly sections",size=0.95,halign="start",textcolor="#223d52");
// &"GNNB" @WIRE(mode="straight",linecolor="#30485d",linewidth=0.16) {#XSTD_GNNCN:1 (61.5,0) (61.5,0) #XSTD_GNNBN:2};
// &"GNNDRV" @WIRE(mode="straight",linecolor="#30485d",linewidth=0.16) {#XSTD_GNNCN:2 (95.5,0) (95.5,0) #RGNN0:1};
// &"GNNA" @WIRE(mode="straight",linecolor="#30485d",linewidth=0.16) {#XSTD_GNNBN:1 (32.5,0) (32.5,0) #XSTD_GNNAN:2};
// &"GNNPRE" @WIRE(mode="straight",linecolor="#30485d",linewidth=0.16) {#XSTD_GNNAN:1 (0.5,0) (0.5,0) #X025:4};
// &"GNPB" @WIRE(mode="straight",linecolor="#30485d",linewidth=0.16) {#XSTD_GNPCN:1 (61.5,-38) (61.5,-38) #XSTD_GNPBN:2};
// &"GNPDRV" @WIRE(mode="straight",linecolor="#30485d",linewidth=0.16) {#XSTD_GNPCN:2 (95.5,-38) (95.5,-38) #RGNP0:1};
// &"GNPA" @WIRE(mode="straight",linecolor="#30485d",linewidth=0.16) {#XSTD_GNPBN:1 (32.5,-38) (32.5,-38) #XSTD_GNPAN:2};
// &"H" @WIRE(mode="straight",linecolor="#30485d",linewidth=0.16) {#XSTD_GNPAN:1 (-6.5,-38) (-6.5,-76) #X008:1};
// &"GPNB" @WIRE(mode="straight",linecolor="#30485d",linewidth=0.16) {#XSTD_GPNCN:1 (61.5,-76) (61.5,-76) #XSTD_GPNBN:2};
// &"GPNDRV" @WIRE(mode="straight",linecolor="#30485d",linewidth=0.16) {#XSTD_GPNCN:2 (95.5,-76) (95.5,-76) #RGPN0:1};
// &"GPNA" @WIRE(mode="straight",linecolor="#30485d",linewidth=0.16) {#XSTD_GPNBN:1 (32.5,-76) (32.5,-76) #XSTD_GPNAN:2};
// &"GPNPRE" @WIRE(mode="straight",linecolor="#30485d",linewidth=0.16) {#XSTD_GPNAN:1 (0.5,-76) (0.5,-76) #X008:4};
// &"GPPB" @WIRE(mode="straight",linecolor="#30485d",linewidth=0.16) {#XSTD_GPPCN:1 (61.5,-114) (61.5,-114) #XSTD_GPPBN:2};
// &"GPPDRV" @WIRE(mode="straight",linecolor="#30485d",linewidth=0.16) {#XSTD_GPPCN:2 (95.5,-114) (95.5,-114) #RGPP0:1};
// &"GPPA" @WIRE(mode="straight",linecolor="#30485d",linewidth=0.16) {#XSTD_GPPBN:1 (32.5,-114) (32.5,-114) #XSTD_GPPAN:2};
// &"GNNRG" @WIRE(mode="straight",linecolor="#30485d",linewidth=0.16) {#RGNN1:1 (222.5,0) (222.5,0) #RGNN0_5__dmy0:2};
// &"RGNN1_1__dmy0" @WIRE(mode="straight",linecolor="#30485d",linewidth=0.16) {#RGNN1:2 (247.5,0) (247.5,0) #RGNN1_2__dmy0:1};
// &"RGNN1_2__dmy0" @WIRE(mode="straight",linecolor="#30485d",linewidth=0.16) {#RGNN1_2__dmy0:2 (272.5,0) (272.5,0) #RGNN1_3__dmy0:1};
// &"RGNN1_3__dmy0" @WIRE(mode="straight",linecolor="#30485d",linewidth=0.16) {#RGNN1_3__dmy0:2 (297.5,0) (297.5,0) #RGNN1_4__dmy0:1};
// &"RGNN1_4__dmy0" @WIRE(mode="straight",linecolor="#30485d",linewidth=0.16) {#RGNN1_4__dmy0:2 (322.5,0) (322.5,0) #RGNN1_5__dmy0:1};
// &"RGNN0_1__dmy0" @WIRE(mode="straight",linecolor="#30485d",linewidth=0.16) {#RGNN0:2 (122.5,0) (122.5,0) #RGNN0_2__dmy0:1};
// &"RGNN0_2__dmy0" @WIRE(mode="straight",linecolor="#30485d",linewidth=0.16) {#RGNN0_2__dmy0:2 (147.5,0) (147.5,0) #RGNN0_3__dmy0:1};
// &"RGNN0_3__dmy0" @WIRE(mode="straight",linecolor="#30485d",linewidth=0.16) {#RGNN0_3__dmy0:2 (172.5,0) (172.5,0) #RGNN0_4__dmy0:1};
// &"RGNN0_4__dmy0" @WIRE(mode="straight",linecolor="#30485d",linewidth=0.16) {#RGNN0_4__dmy0:2 (197.5,0) (197.5,0) #RGNN0_5__dmy0:1};
// &"GNPRG" @WIRE(mode="straight",linecolor="#30485d",linewidth=0.16) {#RGNP1:1 (222.5,-38) (222.5,-38) #RGNP0_5__dmy0:2};
// &"RGNP1_1__dmy0" @WIRE(mode="straight",linecolor="#30485d",linewidth=0.16) {#RGNP1:2 (247.5,-38) (247.5,-38) #RGNP1_2__dmy0:1};
// &"RGNP1_2__dmy0" @WIRE(mode="straight",linecolor="#30485d",linewidth=0.16) {#RGNP1_2__dmy0:2 (272.5,-38) (272.5,-38) #RGNP1_3__dmy0:1};
// &"RGNP1_3__dmy0" @WIRE(mode="straight",linecolor="#30485d",linewidth=0.16) {#RGNP1_3__dmy0:2 (297.5,-38) (297.5,-38) #RGNP1_4__dmy0:1};
// &"RGNP1_4__dmy0" @WIRE(mode="straight",linecolor="#30485d",linewidth=0.16) {#RGNP1_4__dmy0:2 (322.5,-38) (322.5,-38) #RGNP1_5__dmy0:1};
// &"RGNP0_1__dmy0" @WIRE(mode="straight",linecolor="#30485d",linewidth=0.16) {#RGNP0:2 (122.5,-38) (122.5,-38) #RGNP0_2__dmy0:1};
// &"RGNP0_2__dmy0" @WIRE(mode="straight",linecolor="#30485d",linewidth=0.16) {#RGNP0_2__dmy0:2 (147.5,-38) (147.5,-38) #RGNP0_3__dmy0:1};
// &"RGNP0_3__dmy0" @WIRE(mode="straight",linecolor="#30485d",linewidth=0.16) {#RGNP0_3__dmy0:2 (172.5,-38) (172.5,-38) #RGNP0_4__dmy0:1};
// &"RGNP0_4__dmy0" @WIRE(mode="straight",linecolor="#30485d",linewidth=0.16) {#RGNP0_4__dmy0:2 (197.5,-38) (197.5,-38) #RGNP0_5__dmy0:1};
// &"GPNRG" @WIRE(mode="straight",linecolor="#30485d",linewidth=0.16) {#RGPN1:1 (222.5,-76) (222.5,-76) #RGPN0_5__dmy0:2};
// &"RGPN1_1__dmy0" @WIRE(mode="straight",linecolor="#30485d",linewidth=0.16) {#RGPN1:2 (247.5,-76) (247.5,-76) #RGPN1_2__dmy0:1};
// &"RGPN1_2__dmy0" @WIRE(mode="straight",linecolor="#30485d",linewidth=0.16) {#RGPN1_2__dmy0:2 (272.5,-76) (272.5,-76) #RGPN1_3__dmy0:1};
// &"RGPN1_3__dmy0" @WIRE(mode="straight",linecolor="#30485d",linewidth=0.16) {#RGPN1_3__dmy0:2 (297.5,-76) (297.5,-76) #RGPN1_4__dmy0:1};
// &"RGPN1_4__dmy0" @WIRE(mode="straight",linecolor="#30485d",linewidth=0.16) {#RGPN1_4__dmy0:2 (322.5,-76) (322.5,-76) #RGPN1_5__dmy0:1};
// &"RGPN0_1__dmy0" @WIRE(mode="straight",linecolor="#30485d",linewidth=0.16) {#RGPN0:2 (122.5,-76) (122.5,-76) #RGPN0_2__dmy0:1};
// &"RGPN0_2__dmy0" @WIRE(mode="straight",linecolor="#30485d",linewidth=0.16) {#RGPN0_2__dmy0:2 (147.5,-76) (147.5,-76) #RGPN0_3__dmy0:1};
// &"RGPN0_3__dmy0" @WIRE(mode="straight",linecolor="#30485d",linewidth=0.16) {#RGPN0_3__dmy0:2 (172.5,-76) (172.5,-76) #RGPN0_4__dmy0:1};
// &"RGPN0_4__dmy0" @WIRE(mode="straight",linecolor="#30485d",linewidth=0.16) {#RGPN0_4__dmy0:2 (197.5,-76) (197.5,-76) #RGPN0_5__dmy0:1};
// &"GPPRG" @WIRE(mode="straight",linecolor="#30485d",linewidth=0.16) {#RGPP1:1 (222.5,-114) (222.5,-114) #RGPP0_5__dmy0:2};
// &"RGPP1_1__dmy0" @WIRE(mode="straight",linecolor="#30485d",linewidth=0.16) {#RGPP1:2 (247.5,-114) (247.5,-114) #RGPP1_2__dmy0:1};
// &"RGPP1_2__dmy0" @WIRE(mode="straight",linecolor="#30485d",linewidth=0.16) {#RGPP1_2__dmy0:2 (272.5,-114) (272.5,-114) #RGPP1_3__dmy0:1};
// &"RGPP1_3__dmy0" @WIRE(mode="straight",linecolor="#30485d",linewidth=0.16) {#RGPP1_3__dmy0:2 (297.5,-114) (297.5,-114) #RGPP1_4__dmy0:1};
// &"RGPP1_4__dmy0" @WIRE(mode="straight",linecolor="#30485d",linewidth=0.16) {#RGPP1_4__dmy0:2 (322.5,-114) (322.5,-114) #RGPP1_5__dmy0:1};
// &"RGPP0_1__dmy0" @WIRE(mode="straight",linecolor="#30485d",linewidth=0.16) {#RGPP0:2 (122.5,-114) (122.5,-114) #RGPP0_2__dmy0:1};
// &"RGPP0_2__dmy0" @WIRE(mode="straight",linecolor="#30485d",linewidth=0.16) {#RGPP0_2__dmy0:2 (147.5,-114) (147.5,-114) #RGPP0_3__dmy0:1};
// &"RGPP0_3__dmy0" @WIRE(mode="straight",linecolor="#30485d",linewidth=0.16) {#RGPP0_3__dmy0:2 (172.5,-114) (172.5,-114) #RGPP0_4__dmy0:1};
// &"RGPP0_4__dmy0" @WIRE(mode="straight",linecolor="#30485d",linewidth=0.16) {#RGPP0_4__dmy0:2 (197.5,-114) (197.5,-114) #RGPP0_5__dmy0:1};
// (-28,-148) @TEXT("GP and GN chains keep their source polarity, device sizing and series R; no zero-delay abstraction.",size=1,halign="start",textcolor="#223d52");
// &"VDD" @WIRE(mode="straight",linecolor="#30485d",linewidth=0.16) {#XSTD_GNNCN:3 (76,10)};
// (76,10.4) @TEXT("VDD",size=1.1,halign="middle",valign="bottom");
// &"VSS" @WIRE(mode="straight",linecolor="#30485d",linewidth=0.16) {#XSTD_GNNCN:4 (76,-10)};
// (76,-10.4) @TEXT("VSS",size=1.1,halign="middle",valign="top");
// &"VDD" @WIRE(mode="straight",linecolor="#30485d",linewidth=0.16) {#XSTD_GNNBN:3 (47,10)};
// (47,10.4) @TEXT("VDD",size=1.1,halign="middle",valign="bottom");
// &"VSS" @WIRE(mode="straight",linecolor="#30485d",linewidth=0.16) {#XSTD_GNNBN:4 (47,-10)};
// (47,-10.4) @TEXT("VSS",size=1.1,halign="middle",valign="top");
// &"VDD" @WIRE(mode="straight",linecolor="#30485d",linewidth=0.16) {#XSTD_GNNAN:3 (18,10)};
// (18,10.4) @TEXT("VDD",size=1.1,halign="middle",valign="bottom");
// &"VSS" @WIRE(mode="straight",linecolor="#30485d",linewidth=0.16) {#XSTD_GNNAN:4 (18,-10)};
// (18,-10.4) @TEXT("VSS",size=1.1,halign="middle",valign="top");
// &"VDD" @WIRE(mode="straight",linecolor="#30485d",linewidth=0.16) {#XSTD_GNPCN:3 (76,-28)};
// (76,-27.6) @TEXT("VDD",size=1.1,halign="middle",valign="bottom");
// &"VSS" @WIRE(mode="straight",linecolor="#30485d",linewidth=0.16) {#XSTD_GNPCN:4 (76,-48)};
// (76,-48.4) @TEXT("VSS",size=1.1,halign="middle",valign="top");
// &"VDD" @WIRE(mode="straight",linecolor="#30485d",linewidth=0.16) {#XSTD_GNPBN:3 (47,-28)};
// (47,-27.6) @TEXT("VDD",size=1.1,halign="middle",valign="bottom");
// &"VSS" @WIRE(mode="straight",linecolor="#30485d",linewidth=0.16) {#XSTD_GNPBN:4 (47,-48)};
// (47,-48.4) @TEXT("VSS",size=1.1,halign="middle",valign="top");
// &"VDD" @WIRE(mode="straight",linecolor="#30485d",linewidth=0.16) {#XSTD_GNPAN:3 (18,-28)};
// (18,-27.6) @TEXT("VDD",size=1.1,halign="middle",valign="bottom");
// &"VSS" @WIRE(mode="straight",linecolor="#30485d",linewidth=0.16) {#XSTD_GNPAN:4 (18,-48)};
// (18,-48.4) @TEXT("VSS",size=1.1,halign="middle",valign="top");
// &"VDD" @WIRE(mode="straight",linecolor="#30485d",linewidth=0.16) {#XSTD_GPNCN:3 (76,-66)};
// (76,-65.6) @TEXT("VDD",size=1.1,halign="middle",valign="bottom");
// &"VSS" @WIRE(mode="straight",linecolor="#30485d",linewidth=0.16) {#XSTD_GPNCN:4 (76,-86)};
// (76,-86.4) @TEXT("VSS",size=1.1,halign="middle",valign="top");
// &"VDD" @WIRE(mode="straight",linecolor="#30485d",linewidth=0.16) {#XSTD_GPNBN:3 (47,-66)};
// (47,-65.6) @TEXT("VDD",size=1.1,halign="middle",valign="bottom");
// &"VSS" @WIRE(mode="straight",linecolor="#30485d",linewidth=0.16) {#XSTD_GPNBN:4 (47,-86)};
// (47,-86.4) @TEXT("VSS",size=1.1,halign="middle",valign="top");
// &"VDD" @WIRE(mode="straight",linecolor="#30485d",linewidth=0.16) {#XSTD_GPNAN:3 (18,-66)};
// (18,-65.6) @TEXT("VDD",size=1.1,halign="middle",valign="bottom");
// &"VSS" @WIRE(mode="straight",linecolor="#30485d",linewidth=0.16) {#XSTD_GPNAN:4 (18,-86)};
// (18,-86.4) @TEXT("VSS",size=1.1,halign="middle",valign="top");
// &"VDD" @WIRE(mode="straight",linecolor="#30485d",linewidth=0.16) {#XSTD_GPPCN:3 (76,-104)};
// (76,-103.6) @TEXT("VDD",size=1.1,halign="middle",valign="bottom");
// &"VSS" @WIRE(mode="straight",linecolor="#30485d",linewidth=0.16) {#XSTD_GPPCN:4 (76,-124)};
// (76,-124.4) @TEXT("VSS",size=1.1,halign="middle",valign="top");
// &"VDD" @WIRE(mode="straight",linecolor="#30485d",linewidth=0.16) {#XSTD_GPPBN:3 (47,-104)};
// (47,-103.6) @TEXT("VDD",size=1.1,halign="middle",valign="bottom");
// &"VSS" @WIRE(mode="straight",linecolor="#30485d",linewidth=0.16) {#XSTD_GPPBN:4 (47,-124)};
// (47,-124.4) @TEXT("VSS",size=1.1,halign="middle",valign="top");
// &"L" @WIRE(mode="straight",linecolor="#30485d",linewidth=0.16) {#XSTD_GPPAN:1 (8,-114)};
// (7.6,-114) @TEXT("L",size=1.1,halign="end",valign="middle");
// &"VDD" @WIRE(mode="straight",linecolor="#30485d",linewidth=0.16) {#XSTD_GPPAN:3 (18,-104)};
// (18,-103.6) @TEXT("VDD",size=1.1,halign="middle",valign="bottom");
// &"VSS" @WIRE(mode="straight",linecolor="#30485d",linewidth=0.16) {#XSTD_GPPAN:4 (18,-124)};
// (18,-124.4) @TEXT("VSS",size=1.1,halign="middle",valign="top");
// &"GNN" @WIRE(mode="straight",linecolor="#30485d",linewidth=0.16) {#RGNN1_5__dmy0:2 (340,0)};
// (340.4,0) @TEXT("GNN",size=1.1,halign="start",valign="middle");
// &"GNP" @WIRE(mode="straight",linecolor="#30485d",linewidth=0.16) {#RGNP1_5__dmy0:2 (340,-38)};
// (340.4,-38) @TEXT("GNP",size=1.1,halign="start",valign="middle");
// &"GPN" @WIRE(mode="straight",linecolor="#30485d",linewidth=0.16) {#RGPN1_5__dmy0:2 (340,-76)};
// (340.4,-76) @TEXT("GPN",size=1.1,halign="start",valign="middle");
// &"GPP" @WIRE(mode="straight",linecolor="#30485d",linewidth=0.16) {#RGPP1_5__dmy0:2 (340,-114)};
// (340.4,-114) @TEXT("GPP",size=1.1,halign="start",valign="middle");
// &"L" @WIRE(mode="straight",linecolor="#30485d",linewidth=0.16) {#X025:1 (-27,0)};
// (-27.4,0) @TEXT("L",size=1.1,halign="end",valign="middle");
// &"VDD" @WIRE(mode="straight",linecolor="#30485d",linewidth=0.16) {#X025:2 (-17,10)};
// (-17,10.4) @TEXT("VDD",size=1.1,halign="middle",valign="bottom");
// &"VSS" @WIRE(mode="straight",linecolor="#30485d",linewidth=0.16) {#X025:3 (-17,-10)};
// (-17,-10.4) @TEXT("VSS",size=1.1,halign="middle",valign="top");
// &"VDD" @WIRE(mode="straight",linecolor="#30485d",linewidth=0.16) {#X008:2 (-17,-66)};
// (-17,-65.6) @TEXT("VDD",size=1.1,halign="middle",valign="bottom");
// &"VSS" @WIRE(mode="straight",linecolor="#30485d",linewidth=0.16) {#X008:3 (-17,-86)};
// (-17,-86.4) @TEXT("VSS",size=1.1,halign="middle",valign="top");
// }
// END SARADC RNL
ends sar8p_refdrv_b3

subckt sar8p_refdrv_b4 GNN GNP GPN GPP H L VDD VSS
    XSTD_GNNCN (GNNB GNNDRV VDD VSS) INVD1BWP12T30P140
    XSTD_GNNBN (GNNA GNNB VDD VSS) INVD1BWP12T30P140
    XSTD_GNNAN (GNNPRE GNNA VDD VSS) INVD1BWP12T30P140
    XSTD_GNPCN (GNPB GNPDRV VDD VSS) INVD1BWP12T30P140
    XSTD_GNPBN (GNPA GNPB VDD VSS) INVD1BWP12T30P140
    XSTD_GNPAN (H GNPA VDD VSS) INVD1BWP12T30P140
    XSTD_GPNCN (GPNB GPNDRV VDD VSS) INVD1BWP12T30P140
    XSTD_GPNBN (GPNA GPNB VDD VSS) INVD1BWP12T30P140
    XSTD_GPNAN (GPNPRE GPNA VDD VSS) INVD1BWP12T30P140
    XSTD_GPPCN (GPPB GPPDRV VDD VSS) INVD1BWP12T30P140
    XSTD_GPPBN (GPPA GPPB VDD VSS) INVD1BWP12T30P140
    XSTD_GPPAN (L GPPA VDD VSS) INVD1BWP12T30P140
//Series configuration of RGNN1
RGNN1  (GNNRG RGNN1_1__dmy0 ) rupolym l=17.13u w=1u m=16 multi=(1)
RGNN1_2__dmy0  (RGNN1_1__dmy0 RGNN1_2__dmy0 ) rupolym l=17.13u w=1u m=16          multi=(1)
RGNN1_3__dmy0  (RGNN1_2__dmy0 RGNN1_3__dmy0 ) rupolym l=17.13u w=1u m=16          multi=(1)
RGNN1_4__dmy0  (RGNN1_3__dmy0 RGNN1_4__dmy0 ) rupolym l=17.13u w=1u m=16          multi=(1)
RGNN1_5__dmy0  (RGNN1_4__dmy0 GNN ) rupolym l=17.13u w=1u m=16 multi=(1)
//End of RGNN1

//Series configuration of RGNN0
RGNN0  (GNNDRV RGNN0_1__dmy0 ) rupolym l=17.13u w=1u m=16 multi=(1)
RGNN0_2__dmy0  (RGNN0_1__dmy0 RGNN0_2__dmy0 ) rupolym l=17.13u w=1u m=16          multi=(1)
RGNN0_3__dmy0  (RGNN0_2__dmy0 RGNN0_3__dmy0 ) rupolym l=17.13u w=1u m=16          multi=(1)
RGNN0_4__dmy0  (RGNN0_3__dmy0 RGNN0_4__dmy0 ) rupolym l=17.13u w=1u m=16          multi=(1)
RGNN0_5__dmy0  (RGNN0_4__dmy0 GNNRG ) rupolym l=17.13u w=1u m=16 multi=(1)
//End of RGNN0

//Series configuration of RGNP1
RGNP1  (GNPRG RGNP1_1__dmy0 ) rupolym l=17.13u w=1u m=16 multi=(1)
RGNP1_2__dmy0  (RGNP1_1__dmy0 RGNP1_2__dmy0 ) rupolym l=17.13u w=1u m=16          multi=(1)
RGNP1_3__dmy0  (RGNP1_2__dmy0 RGNP1_3__dmy0 ) rupolym l=17.13u w=1u m=16          multi=(1)
RGNP1_4__dmy0  (RGNP1_3__dmy0 RGNP1_4__dmy0 ) rupolym l=17.13u w=1u m=16          multi=(1)
RGNP1_5__dmy0  (RGNP1_4__dmy0 GNP ) rupolym l=17.13u w=1u m=16 multi=(1)
//End of RGNP1

//Series configuration of RGNP0
RGNP0  (GNPDRV RGNP0_1__dmy0 ) rupolym l=17.13u w=1u m=16 multi=(1)
RGNP0_2__dmy0  (RGNP0_1__dmy0 RGNP0_2__dmy0 ) rupolym l=17.13u w=1u m=16          multi=(1)
RGNP0_3__dmy0  (RGNP0_2__dmy0 RGNP0_3__dmy0 ) rupolym l=17.13u w=1u m=16          multi=(1)
RGNP0_4__dmy0  (RGNP0_3__dmy0 RGNP0_4__dmy0 ) rupolym l=17.13u w=1u m=16          multi=(1)
RGNP0_5__dmy0  (RGNP0_4__dmy0 GNPRG ) rupolym l=17.13u w=1u m=16 multi=(1)
//End of RGNP0

//Series configuration of RGPN1
RGPN1  (GPNRG RGPN1_1__dmy0 ) rupolym l=17.13u w=1u m=16 multi=(1)
RGPN1_2__dmy0  (RGPN1_1__dmy0 RGPN1_2__dmy0 ) rupolym l=17.13u w=1u m=16          multi=(1)
RGPN1_3__dmy0  (RGPN1_2__dmy0 RGPN1_3__dmy0 ) rupolym l=17.13u w=1u m=16          multi=(1)
RGPN1_4__dmy0  (RGPN1_3__dmy0 RGPN1_4__dmy0 ) rupolym l=17.13u w=1u m=16          multi=(1)
RGPN1_5__dmy0  (RGPN1_4__dmy0 GPN ) rupolym l=17.13u w=1u m=16 multi=(1)
//End of RGPN1

//Series configuration of RGPN0
RGPN0  (GPNDRV RGPN0_1__dmy0 ) rupolym l=17.13u w=1u m=16 multi=(1)
RGPN0_2__dmy0  (RGPN0_1__dmy0 RGPN0_2__dmy0 ) rupolym l=17.13u w=1u m=16          multi=(1)
RGPN0_3__dmy0  (RGPN0_2__dmy0 RGPN0_3__dmy0 ) rupolym l=17.13u w=1u m=16          multi=(1)
RGPN0_4__dmy0  (RGPN0_3__dmy0 RGPN0_4__dmy0 ) rupolym l=17.13u w=1u m=16          multi=(1)
RGPN0_5__dmy0  (RGPN0_4__dmy0 GPNRG ) rupolym l=17.13u w=1u m=16 multi=(1)
//End of RGPN0

//Series configuration of RGPP1
RGPP1  (GPPRG RGPP1_1__dmy0 ) rupolym l=17.13u w=1u m=16 multi=(1)
RGPP1_2__dmy0  (RGPP1_1__dmy0 RGPP1_2__dmy0 ) rupolym l=17.13u w=1u m=16          multi=(1)
RGPP1_3__dmy0  (RGPP1_2__dmy0 RGPP1_3__dmy0 ) rupolym l=17.13u w=1u m=16          multi=(1)
RGPP1_4__dmy0  (RGPP1_3__dmy0 RGPP1_4__dmy0 ) rupolym l=17.13u w=1u m=16          multi=(1)
RGPP1_5__dmy0  (RGPP1_4__dmy0 GPP ) rupolym l=17.13u w=1u m=16 multi=(1)
//End of RGPP1

//Series configuration of RGPP0
RGPP0  (GPPDRV RGPP0_1__dmy0 ) rupolym l=17.13u w=1u m=16 multi=(1)
RGPP0_2__dmy0  (RGPP0_1__dmy0 RGPP0_2__dmy0 ) rupolym l=17.13u w=1u m=16          multi=(1)
RGPP0_3__dmy0  (RGPP0_2__dmy0 RGPP0_3__dmy0 ) rupolym l=17.13u w=1u m=16          multi=(1)
RGPP0_4__dmy0  (RGPP0_3__dmy0 RGPP0_4__dmy0 ) rupolym l=17.13u w=1u m=16          multi=(1)
RGPP0_5__dmy0  (RGPP0_4__dmy0 GPPRG ) rupolym l=17.13u w=1u m=16 multi=(1)
//End of RGPP0

    X025 (L VDD VSS GNNPRE) sar8p_inv
    X008 (H VDD VSS GPNPRE) sar8p_inv
// BEGIN SARADC RNL
// @RNL(author="saradc topology") {
// (-28,27) @TEXT("sar8p_refdrv_b4 / four physical gate-driver chains",size=1.5,halign="start",textcolor="#223d52");
// #X025 @SET-SYMBOL $S_sar8p_inv;
// #X025 @PLACE(-17,0) => @ORIENT("R0");
// #XSTD_GNNAN @SET-SYMBOL $S_INVD1BWP12T30P140;
// #XSTD_GNNAN @PLACE(18,0) => @ORIENT("R0");
// #XSTD_GNNBN @SET-SYMBOL $S_INVD1BWP12T30P140;
// #XSTD_GNNBN @PLACE(47,0) => @ORIENT("R0");
// #XSTD_GNNCN @SET-SYMBOL $S_INVD1BWP12T30P140;
// #XSTD_GNNCN @PLACE(76,0) => @ORIENT("R0");
// #RGNN0 @SET-SYMBOL $RESISTOR;
// #RGNN0 @PLACE(110,0) => @ORIENT("R90");
// #RGNN0 @TEXT("RGNN0",key="name",size=1.3,halign="start") => @PLACE(113,3);
// #RGNN0 @TEXT("l=17.13u w=1u multi=(1)",key="value",size=0.9,halign="start") => @PLACE(113,-4);
// #RGNN0 @TEXT("",key="model");
// #RGNN0_2__dmy0 @SET-SYMBOL $RESISTOR;
// #RGNN0_2__dmy0 @PLACE(135,0) => @ORIENT("R90");
// #RGNN0_2__dmy0 @TEXT("RGNN0_2__dmy0",key="name",size=1.3,halign="start") => @PLACE(138,3);
// #RGNN0_2__dmy0 @TEXT("l=17.13u w=1u multi=(1)",key="value",size=0.9,halign="start") => @PLACE(138,-4);
// #RGNN0_2__dmy0 @TEXT("",key="model");
// #RGNN0_3__dmy0 @SET-SYMBOL $RESISTOR;
// #RGNN0_3__dmy0 @PLACE(160,0) => @ORIENT("R90");
// #RGNN0_3__dmy0 @TEXT("RGNN0_3__dmy0",key="name",size=1.3,halign="start") => @PLACE(163,3);
// #RGNN0_3__dmy0 @TEXT("l=17.13u w=1u multi=(1)",key="value",size=0.9,halign="start") => @PLACE(163,-4);
// #RGNN0_3__dmy0 @TEXT("",key="model");
// #RGNN0_4__dmy0 @SET-SYMBOL $RESISTOR;
// #RGNN0_4__dmy0 @PLACE(185,0) => @ORIENT("R90");
// #RGNN0_4__dmy0 @TEXT("RGNN0_4__dmy0",key="name",size=1.3,halign="start") => @PLACE(188,3);
// #RGNN0_4__dmy0 @TEXT("l=17.13u w=1u multi=(1)",key="value",size=0.9,halign="start") => @PLACE(188,-4);
// #RGNN0_4__dmy0 @TEXT("",key="model");
// #RGNN0_5__dmy0 @SET-SYMBOL $RESISTOR;
// #RGNN0_5__dmy0 @PLACE(210,0) => @ORIENT("R90");
// #RGNN0_5__dmy0 @TEXT("RGNN0_5__dmy0",key="name",size=1.3,halign="start") => @PLACE(213,3);
// #RGNN0_5__dmy0 @TEXT("l=17.13u w=1u multi=(1)",key="value",size=0.9,halign="start") => @PLACE(213,-4);
// #RGNN0_5__dmy0 @TEXT("",key="model");
// #RGNN1 @SET-SYMBOL $RESISTOR;
// #RGNN1 @PLACE(235,0) => @ORIENT("R90");
// #RGNN1 @TEXT("RGNN1",key="name",size=1.3,halign="start") => @PLACE(238,3);
// #RGNN1 @TEXT("l=17.13u w=1u multi=(1)",key="value",size=0.9,halign="start") => @PLACE(238,-4);
// #RGNN1 @TEXT("",key="model");
// #RGNN1_2__dmy0 @SET-SYMBOL $RESISTOR;
// #RGNN1_2__dmy0 @PLACE(260,0) => @ORIENT("R90");
// #RGNN1_2__dmy0 @TEXT("RGNN1_2__dmy0",key="name",size=1.3,halign="start") => @PLACE(263,3);
// #RGNN1_2__dmy0 @TEXT("l=17.13u w=1u multi=(1)",key="value",size=0.9,halign="start") => @PLACE(263,-4);
// #RGNN1_2__dmy0 @TEXT("",key="model");
// #RGNN1_3__dmy0 @SET-SYMBOL $RESISTOR;
// #RGNN1_3__dmy0 @PLACE(285,0) => @ORIENT("R90");
// #RGNN1_3__dmy0 @TEXT("RGNN1_3__dmy0",key="name",size=1.3,halign="start") => @PLACE(288,3);
// #RGNN1_3__dmy0 @TEXT("l=17.13u w=1u multi=(1)",key="value",size=0.9,halign="start") => @PLACE(288,-4);
// #RGNN1_3__dmy0 @TEXT("",key="model");
// #RGNN1_4__dmy0 @SET-SYMBOL $RESISTOR;
// #RGNN1_4__dmy0 @PLACE(310,0) => @ORIENT("R90");
// #RGNN1_4__dmy0 @TEXT("RGNN1_4__dmy0",key="name",size=1.3,halign="start") => @PLACE(313,3);
// #RGNN1_4__dmy0 @TEXT("l=17.13u w=1u multi=(1)",key="value",size=0.9,halign="start") => @PLACE(313,-4);
// #RGNN1_4__dmy0 @TEXT("",key="model");
// #RGNN1_5__dmy0 @SET-SYMBOL $RESISTOR;
// #RGNN1_5__dmy0 @PLACE(335,0) => @ORIENT("R90");
// #RGNN1_5__dmy0 @TEXT("RGNN1_5__dmy0",key="name",size=1.3,halign="start") => @PLACE(338,3);
// #RGNN1_5__dmy0 @TEXT("l=17.13u w=1u multi=(1)",key="value",size=0.9,halign="start") => @PLACE(338,-4);
// #RGNN1_5__dmy0 @TEXT("",key="model");
// (104,15) @TEXT("GNN / 10 series poly sections",size=0.95,halign="start",textcolor="#223d52");
// #XSTD_GNPAN @SET-SYMBOL $S_INVD1BWP12T30P140;
// #XSTD_GNPAN @PLACE(18,-38) => @ORIENT("R0");
// #XSTD_GNPBN @SET-SYMBOL $S_INVD1BWP12T30P140;
// #XSTD_GNPBN @PLACE(47,-38) => @ORIENT("R0");
// #XSTD_GNPCN @SET-SYMBOL $S_INVD1BWP12T30P140;
// #XSTD_GNPCN @PLACE(76,-38) => @ORIENT("R0");
// #RGNP0 @SET-SYMBOL $RESISTOR;
// #RGNP0 @PLACE(110,-38) => @ORIENT("R90");
// #RGNP0 @TEXT("RGNP0",key="name",size=1.3,halign="start") => @PLACE(113,-35);
// #RGNP0 @TEXT("l=17.13u w=1u multi=(1)",key="value",size=0.9,halign="start") => @PLACE(113,-42);
// #RGNP0 @TEXT("",key="model");
// #RGNP0_2__dmy0 @SET-SYMBOL $RESISTOR;
// #RGNP0_2__dmy0 @PLACE(135,-38) => @ORIENT("R90");
// #RGNP0_2__dmy0 @TEXT("RGNP0_2__dmy0",key="name",size=1.3,halign="start") => @PLACE(138,-35);
// #RGNP0_2__dmy0 @TEXT("l=17.13u w=1u multi=(1)",key="value",size=0.9,halign="start") => @PLACE(138,-42);
// #RGNP0_2__dmy0 @TEXT("",key="model");
// #RGNP0_3__dmy0 @SET-SYMBOL $RESISTOR;
// #RGNP0_3__dmy0 @PLACE(160,-38) => @ORIENT("R90");
// #RGNP0_3__dmy0 @TEXT("RGNP0_3__dmy0",key="name",size=1.3,halign="start") => @PLACE(163,-35);
// #RGNP0_3__dmy0 @TEXT("l=17.13u w=1u multi=(1)",key="value",size=0.9,halign="start") => @PLACE(163,-42);
// #RGNP0_3__dmy0 @TEXT("",key="model");
// #RGNP0_4__dmy0 @SET-SYMBOL $RESISTOR;
// #RGNP0_4__dmy0 @PLACE(185,-38) => @ORIENT("R90");
// #RGNP0_4__dmy0 @TEXT("RGNP0_4__dmy0",key="name",size=1.3,halign="start") => @PLACE(188,-35);
// #RGNP0_4__dmy0 @TEXT("l=17.13u w=1u multi=(1)",key="value",size=0.9,halign="start") => @PLACE(188,-42);
// #RGNP0_4__dmy0 @TEXT("",key="model");
// #RGNP0_5__dmy0 @SET-SYMBOL $RESISTOR;
// #RGNP0_5__dmy0 @PLACE(210,-38) => @ORIENT("R90");
// #RGNP0_5__dmy0 @TEXT("RGNP0_5__dmy0",key="name",size=1.3,halign="start") => @PLACE(213,-35);
// #RGNP0_5__dmy0 @TEXT("l=17.13u w=1u multi=(1)",key="value",size=0.9,halign="start") => @PLACE(213,-42);
// #RGNP0_5__dmy0 @TEXT("",key="model");
// #RGNP1 @SET-SYMBOL $RESISTOR;
// #RGNP1 @PLACE(235,-38) => @ORIENT("R90");
// #RGNP1 @TEXT("RGNP1",key="name",size=1.3,halign="start") => @PLACE(238,-35);
// #RGNP1 @TEXT("l=17.13u w=1u multi=(1)",key="value",size=0.9,halign="start") => @PLACE(238,-42);
// #RGNP1 @TEXT("",key="model");
// #RGNP1_2__dmy0 @SET-SYMBOL $RESISTOR;
// #RGNP1_2__dmy0 @PLACE(260,-38) => @ORIENT("R90");
// #RGNP1_2__dmy0 @TEXT("RGNP1_2__dmy0",key="name",size=1.3,halign="start") => @PLACE(263,-35);
// #RGNP1_2__dmy0 @TEXT("l=17.13u w=1u multi=(1)",key="value",size=0.9,halign="start") => @PLACE(263,-42);
// #RGNP1_2__dmy0 @TEXT("",key="model");
// #RGNP1_3__dmy0 @SET-SYMBOL $RESISTOR;
// #RGNP1_3__dmy0 @PLACE(285,-38) => @ORIENT("R90");
// #RGNP1_3__dmy0 @TEXT("RGNP1_3__dmy0",key="name",size=1.3,halign="start") => @PLACE(288,-35);
// #RGNP1_3__dmy0 @TEXT("l=17.13u w=1u multi=(1)",key="value",size=0.9,halign="start") => @PLACE(288,-42);
// #RGNP1_3__dmy0 @TEXT("",key="model");
// #RGNP1_4__dmy0 @SET-SYMBOL $RESISTOR;
// #RGNP1_4__dmy0 @PLACE(310,-38) => @ORIENT("R90");
// #RGNP1_4__dmy0 @TEXT("RGNP1_4__dmy0",key="name",size=1.3,halign="start") => @PLACE(313,-35);
// #RGNP1_4__dmy0 @TEXT("l=17.13u w=1u multi=(1)",key="value",size=0.9,halign="start") => @PLACE(313,-42);
// #RGNP1_4__dmy0 @TEXT("",key="model");
// #RGNP1_5__dmy0 @SET-SYMBOL $RESISTOR;
// #RGNP1_5__dmy0 @PLACE(335,-38) => @ORIENT("R90");
// #RGNP1_5__dmy0 @TEXT("RGNP1_5__dmy0",key="name",size=1.3,halign="start") => @PLACE(338,-35);
// #RGNP1_5__dmy0 @TEXT("l=17.13u w=1u multi=(1)",key="value",size=0.9,halign="start") => @PLACE(338,-42);
// #RGNP1_5__dmy0 @TEXT("",key="model");
// (104,-23) @TEXT("GNP / 10 series poly sections",size=0.95,halign="start",textcolor="#223d52");
// #X008 @SET-SYMBOL $S_sar8p_inv;
// #X008 @PLACE(-17,-76) => @ORIENT("R0");
// #XSTD_GPNAN @SET-SYMBOL $S_INVD1BWP12T30P140;
// #XSTD_GPNAN @PLACE(18,-76) => @ORIENT("R0");
// #XSTD_GPNBN @SET-SYMBOL $S_INVD1BWP12T30P140;
// #XSTD_GPNBN @PLACE(47,-76) => @ORIENT("R0");
// #XSTD_GPNCN @SET-SYMBOL $S_INVD1BWP12T30P140;
// #XSTD_GPNCN @PLACE(76,-76) => @ORIENT("R0");
// #RGPN0 @SET-SYMBOL $RESISTOR;
// #RGPN0 @PLACE(110,-76) => @ORIENT("R90");
// #RGPN0 @TEXT("RGPN0",key="name",size=1.3,halign="start") => @PLACE(113,-73);
// #RGPN0 @TEXT("l=17.13u w=1u multi=(1)",key="value",size=0.9,halign="start") => @PLACE(113,-80);
// #RGPN0 @TEXT("",key="model");
// #RGPN0_2__dmy0 @SET-SYMBOL $RESISTOR;
// #RGPN0_2__dmy0 @PLACE(135,-76) => @ORIENT("R90");
// #RGPN0_2__dmy0 @TEXT("RGPN0_2__dmy0",key="name",size=1.3,halign="start") => @PLACE(138,-73);
// #RGPN0_2__dmy0 @TEXT("l=17.13u w=1u multi=(1)",key="value",size=0.9,halign="start") => @PLACE(138,-80);
// #RGPN0_2__dmy0 @TEXT("",key="model");
// #RGPN0_3__dmy0 @SET-SYMBOL $RESISTOR;
// #RGPN0_3__dmy0 @PLACE(160,-76) => @ORIENT("R90");
// #RGPN0_3__dmy0 @TEXT("RGPN0_3__dmy0",key="name",size=1.3,halign="start") => @PLACE(163,-73);
// #RGPN0_3__dmy0 @TEXT("l=17.13u w=1u multi=(1)",key="value",size=0.9,halign="start") => @PLACE(163,-80);
// #RGPN0_3__dmy0 @TEXT("",key="model");
// #RGPN0_4__dmy0 @SET-SYMBOL $RESISTOR;
// #RGPN0_4__dmy0 @PLACE(185,-76) => @ORIENT("R90");
// #RGPN0_4__dmy0 @TEXT("RGPN0_4__dmy0",key="name",size=1.3,halign="start") => @PLACE(188,-73);
// #RGPN0_4__dmy0 @TEXT("l=17.13u w=1u multi=(1)",key="value",size=0.9,halign="start") => @PLACE(188,-80);
// #RGPN0_4__dmy0 @TEXT("",key="model");
// #RGPN0_5__dmy0 @SET-SYMBOL $RESISTOR;
// #RGPN0_5__dmy0 @PLACE(210,-76) => @ORIENT("R90");
// #RGPN0_5__dmy0 @TEXT("RGPN0_5__dmy0",key="name",size=1.3,halign="start") => @PLACE(213,-73);
// #RGPN0_5__dmy0 @TEXT("l=17.13u w=1u multi=(1)",key="value",size=0.9,halign="start") => @PLACE(213,-80);
// #RGPN0_5__dmy0 @TEXT("",key="model");
// #RGPN1 @SET-SYMBOL $RESISTOR;
// #RGPN1 @PLACE(235,-76) => @ORIENT("R90");
// #RGPN1 @TEXT("RGPN1",key="name",size=1.3,halign="start") => @PLACE(238,-73);
// #RGPN1 @TEXT("l=17.13u w=1u multi=(1)",key="value",size=0.9,halign="start") => @PLACE(238,-80);
// #RGPN1 @TEXT("",key="model");
// #RGPN1_2__dmy0 @SET-SYMBOL $RESISTOR;
// #RGPN1_2__dmy0 @PLACE(260,-76) => @ORIENT("R90");
// #RGPN1_2__dmy0 @TEXT("RGPN1_2__dmy0",key="name",size=1.3,halign="start") => @PLACE(263,-73);
// #RGPN1_2__dmy0 @TEXT("l=17.13u w=1u multi=(1)",key="value",size=0.9,halign="start") => @PLACE(263,-80);
// #RGPN1_2__dmy0 @TEXT("",key="model");
// #RGPN1_3__dmy0 @SET-SYMBOL $RESISTOR;
// #RGPN1_3__dmy0 @PLACE(285,-76) => @ORIENT("R90");
// #RGPN1_3__dmy0 @TEXT("RGPN1_3__dmy0",key="name",size=1.3,halign="start") => @PLACE(288,-73);
// #RGPN1_3__dmy0 @TEXT("l=17.13u w=1u multi=(1)",key="value",size=0.9,halign="start") => @PLACE(288,-80);
// #RGPN1_3__dmy0 @TEXT("",key="model");
// #RGPN1_4__dmy0 @SET-SYMBOL $RESISTOR;
// #RGPN1_4__dmy0 @PLACE(310,-76) => @ORIENT("R90");
// #RGPN1_4__dmy0 @TEXT("RGPN1_4__dmy0",key="name",size=1.3,halign="start") => @PLACE(313,-73);
// #RGPN1_4__dmy0 @TEXT("l=17.13u w=1u multi=(1)",key="value",size=0.9,halign="start") => @PLACE(313,-80);
// #RGPN1_4__dmy0 @TEXT("",key="model");
// #RGPN1_5__dmy0 @SET-SYMBOL $RESISTOR;
// #RGPN1_5__dmy0 @PLACE(335,-76) => @ORIENT("R90");
// #RGPN1_5__dmy0 @TEXT("RGPN1_5__dmy0",key="name",size=1.3,halign="start") => @PLACE(338,-73);
// #RGPN1_5__dmy0 @TEXT("l=17.13u w=1u multi=(1)",key="value",size=0.9,halign="start") => @PLACE(338,-80);
// #RGPN1_5__dmy0 @TEXT("",key="model");
// (104,-61) @TEXT("GPN / 10 series poly sections",size=0.95,halign="start",textcolor="#223d52");
// #XSTD_GPPAN @SET-SYMBOL $S_INVD1BWP12T30P140;
// #XSTD_GPPAN @PLACE(18,-114) => @ORIENT("R0");
// #XSTD_GPPBN @SET-SYMBOL $S_INVD1BWP12T30P140;
// #XSTD_GPPBN @PLACE(47,-114) => @ORIENT("R0");
// #XSTD_GPPCN @SET-SYMBOL $S_INVD1BWP12T30P140;
// #XSTD_GPPCN @PLACE(76,-114) => @ORIENT("R0");
// #RGPP0 @SET-SYMBOL $RESISTOR;
// #RGPP0 @PLACE(110,-114) => @ORIENT("R90");
// #RGPP0 @TEXT("RGPP0",key="name",size=1.3,halign="start") => @PLACE(113,-111);
// #RGPP0 @TEXT("l=17.13u w=1u multi=(1)",key="value",size=0.9,halign="start") => @PLACE(113,-118);
// #RGPP0 @TEXT("",key="model");
// #RGPP0_2__dmy0 @SET-SYMBOL $RESISTOR;
// #RGPP0_2__dmy0 @PLACE(135,-114) => @ORIENT("R90");
// #RGPP0_2__dmy0 @TEXT("RGPP0_2__dmy0",key="name",size=1.3,halign="start") => @PLACE(138,-111);
// #RGPP0_2__dmy0 @TEXT("l=17.13u w=1u multi=(1)",key="value",size=0.9,halign="start") => @PLACE(138,-118);
// #RGPP0_2__dmy0 @TEXT("",key="model");
// #RGPP0_3__dmy0 @SET-SYMBOL $RESISTOR;
// #RGPP0_3__dmy0 @PLACE(160,-114) => @ORIENT("R90");
// #RGPP0_3__dmy0 @TEXT("RGPP0_3__dmy0",key="name",size=1.3,halign="start") => @PLACE(163,-111);
// #RGPP0_3__dmy0 @TEXT("l=17.13u w=1u multi=(1)",key="value",size=0.9,halign="start") => @PLACE(163,-118);
// #RGPP0_3__dmy0 @TEXT("",key="model");
// #RGPP0_4__dmy0 @SET-SYMBOL $RESISTOR;
// #RGPP0_4__dmy0 @PLACE(185,-114) => @ORIENT("R90");
// #RGPP0_4__dmy0 @TEXT("RGPP0_4__dmy0",key="name",size=1.3,halign="start") => @PLACE(188,-111);
// #RGPP0_4__dmy0 @TEXT("l=17.13u w=1u multi=(1)",key="value",size=0.9,halign="start") => @PLACE(188,-118);
// #RGPP0_4__dmy0 @TEXT("",key="model");
// #RGPP0_5__dmy0 @SET-SYMBOL $RESISTOR;
// #RGPP0_5__dmy0 @PLACE(210,-114) => @ORIENT("R90");
// #RGPP0_5__dmy0 @TEXT("RGPP0_5__dmy0",key="name",size=1.3,halign="start") => @PLACE(213,-111);
// #RGPP0_5__dmy0 @TEXT("l=17.13u w=1u multi=(1)",key="value",size=0.9,halign="start") => @PLACE(213,-118);
// #RGPP0_5__dmy0 @TEXT("",key="model");
// #RGPP1 @SET-SYMBOL $RESISTOR;
// #RGPP1 @PLACE(235,-114) => @ORIENT("R90");
// #RGPP1 @TEXT("RGPP1",key="name",size=1.3,halign="start") => @PLACE(238,-111);
// #RGPP1 @TEXT("l=17.13u w=1u multi=(1)",key="value",size=0.9,halign="start") => @PLACE(238,-118);
// #RGPP1 @TEXT("",key="model");
// #RGPP1_2__dmy0 @SET-SYMBOL $RESISTOR;
// #RGPP1_2__dmy0 @PLACE(260,-114) => @ORIENT("R90");
// #RGPP1_2__dmy0 @TEXT("RGPP1_2__dmy0",key="name",size=1.3,halign="start") => @PLACE(263,-111);
// #RGPP1_2__dmy0 @TEXT("l=17.13u w=1u multi=(1)",key="value",size=0.9,halign="start") => @PLACE(263,-118);
// #RGPP1_2__dmy0 @TEXT("",key="model");
// #RGPP1_3__dmy0 @SET-SYMBOL $RESISTOR;
// #RGPP1_3__dmy0 @PLACE(285,-114) => @ORIENT("R90");
// #RGPP1_3__dmy0 @TEXT("RGPP1_3__dmy0",key="name",size=1.3,halign="start") => @PLACE(288,-111);
// #RGPP1_3__dmy0 @TEXT("l=17.13u w=1u multi=(1)",key="value",size=0.9,halign="start") => @PLACE(288,-118);
// #RGPP1_3__dmy0 @TEXT("",key="model");
// #RGPP1_4__dmy0 @SET-SYMBOL $RESISTOR;
// #RGPP1_4__dmy0 @PLACE(310,-114) => @ORIENT("R90");
// #RGPP1_4__dmy0 @TEXT("RGPP1_4__dmy0",key="name",size=1.3,halign="start") => @PLACE(313,-111);
// #RGPP1_4__dmy0 @TEXT("l=17.13u w=1u multi=(1)",key="value",size=0.9,halign="start") => @PLACE(313,-118);
// #RGPP1_4__dmy0 @TEXT("",key="model");
// #RGPP1_5__dmy0 @SET-SYMBOL $RESISTOR;
// #RGPP1_5__dmy0 @PLACE(335,-114) => @ORIENT("R90");
// #RGPP1_5__dmy0 @TEXT("RGPP1_5__dmy0",key="name",size=1.3,halign="start") => @PLACE(338,-111);
// #RGPP1_5__dmy0 @TEXT("l=17.13u w=1u multi=(1)",key="value",size=0.9,halign="start") => @PLACE(338,-118);
// #RGPP1_5__dmy0 @TEXT("",key="model");
// (104,-99) @TEXT("GPP / 10 series poly sections",size=0.95,halign="start",textcolor="#223d52");
// &"GNNB" @WIRE(mode="straight",linecolor="#30485d",linewidth=0.16) {#XSTD_GNNCN:1 (61.5,0) (61.5,0) #XSTD_GNNBN:2};
// &"GNNDRV" @WIRE(mode="straight",linecolor="#30485d",linewidth=0.16) {#XSTD_GNNCN:2 (95.5,0) (95.5,0) #RGNN0:1};
// &"GNNA" @WIRE(mode="straight",linecolor="#30485d",linewidth=0.16) {#XSTD_GNNBN:1 (32.5,0) (32.5,0) #XSTD_GNNAN:2};
// &"GNNPRE" @WIRE(mode="straight",linecolor="#30485d",linewidth=0.16) {#XSTD_GNNAN:1 (0.5,0) (0.5,0) #X025:4};
// &"GNPB" @WIRE(mode="straight",linecolor="#30485d",linewidth=0.16) {#XSTD_GNPCN:1 (61.5,-38) (61.5,-38) #XSTD_GNPBN:2};
// &"GNPDRV" @WIRE(mode="straight",linecolor="#30485d",linewidth=0.16) {#XSTD_GNPCN:2 (95.5,-38) (95.5,-38) #RGNP0:1};
// &"GNPA" @WIRE(mode="straight",linecolor="#30485d",linewidth=0.16) {#XSTD_GNPBN:1 (32.5,-38) (32.5,-38) #XSTD_GNPAN:2};
// &"H" @WIRE(mode="straight",linecolor="#30485d",linewidth=0.16) {#XSTD_GNPAN:1 (-6.5,-38) (-6.5,-76) #X008:1};
// &"GPNB" @WIRE(mode="straight",linecolor="#30485d",linewidth=0.16) {#XSTD_GPNCN:1 (61.5,-76) (61.5,-76) #XSTD_GPNBN:2};
// &"GPNDRV" @WIRE(mode="straight",linecolor="#30485d",linewidth=0.16) {#XSTD_GPNCN:2 (95.5,-76) (95.5,-76) #RGPN0:1};
// &"GPNA" @WIRE(mode="straight",linecolor="#30485d",linewidth=0.16) {#XSTD_GPNBN:1 (32.5,-76) (32.5,-76) #XSTD_GPNAN:2};
// &"GPNPRE" @WIRE(mode="straight",linecolor="#30485d",linewidth=0.16) {#XSTD_GPNAN:1 (0.5,-76) (0.5,-76) #X008:4};
// &"GPPB" @WIRE(mode="straight",linecolor="#30485d",linewidth=0.16) {#XSTD_GPPCN:1 (61.5,-114) (61.5,-114) #XSTD_GPPBN:2};
// &"GPPDRV" @WIRE(mode="straight",linecolor="#30485d",linewidth=0.16) {#XSTD_GPPCN:2 (95.5,-114) (95.5,-114) #RGPP0:1};
// &"GPPA" @WIRE(mode="straight",linecolor="#30485d",linewidth=0.16) {#XSTD_GPPBN:1 (32.5,-114) (32.5,-114) #XSTD_GPPAN:2};
// &"GNNRG" @WIRE(mode="straight",linecolor="#30485d",linewidth=0.16) {#RGNN1:1 (222.5,0) (222.5,0) #RGNN0_5__dmy0:2};
// &"RGNN1_1__dmy0" @WIRE(mode="straight",linecolor="#30485d",linewidth=0.16) {#RGNN1:2 (247.5,0) (247.5,0) #RGNN1_2__dmy0:1};
// &"RGNN1_2__dmy0" @WIRE(mode="straight",linecolor="#30485d",linewidth=0.16) {#RGNN1_2__dmy0:2 (272.5,0) (272.5,0) #RGNN1_3__dmy0:1};
// &"RGNN1_3__dmy0" @WIRE(mode="straight",linecolor="#30485d",linewidth=0.16) {#RGNN1_3__dmy0:2 (297.5,0) (297.5,0) #RGNN1_4__dmy0:1};
// &"RGNN1_4__dmy0" @WIRE(mode="straight",linecolor="#30485d",linewidth=0.16) {#RGNN1_4__dmy0:2 (322.5,0) (322.5,0) #RGNN1_5__dmy0:1};
// &"RGNN0_1__dmy0" @WIRE(mode="straight",linecolor="#30485d",linewidth=0.16) {#RGNN0:2 (122.5,0) (122.5,0) #RGNN0_2__dmy0:1};
// &"RGNN0_2__dmy0" @WIRE(mode="straight",linecolor="#30485d",linewidth=0.16) {#RGNN0_2__dmy0:2 (147.5,0) (147.5,0) #RGNN0_3__dmy0:1};
// &"RGNN0_3__dmy0" @WIRE(mode="straight",linecolor="#30485d",linewidth=0.16) {#RGNN0_3__dmy0:2 (172.5,0) (172.5,0) #RGNN0_4__dmy0:1};
// &"RGNN0_4__dmy0" @WIRE(mode="straight",linecolor="#30485d",linewidth=0.16) {#RGNN0_4__dmy0:2 (197.5,0) (197.5,0) #RGNN0_5__dmy0:1};
// &"GNPRG" @WIRE(mode="straight",linecolor="#30485d",linewidth=0.16) {#RGNP1:1 (222.5,-38) (222.5,-38) #RGNP0_5__dmy0:2};
// &"RGNP1_1__dmy0" @WIRE(mode="straight",linecolor="#30485d",linewidth=0.16) {#RGNP1:2 (247.5,-38) (247.5,-38) #RGNP1_2__dmy0:1};
// &"RGNP1_2__dmy0" @WIRE(mode="straight",linecolor="#30485d",linewidth=0.16) {#RGNP1_2__dmy0:2 (272.5,-38) (272.5,-38) #RGNP1_3__dmy0:1};
// &"RGNP1_3__dmy0" @WIRE(mode="straight",linecolor="#30485d",linewidth=0.16) {#RGNP1_3__dmy0:2 (297.5,-38) (297.5,-38) #RGNP1_4__dmy0:1};
// &"RGNP1_4__dmy0" @WIRE(mode="straight",linecolor="#30485d",linewidth=0.16) {#RGNP1_4__dmy0:2 (322.5,-38) (322.5,-38) #RGNP1_5__dmy0:1};
// &"RGNP0_1__dmy0" @WIRE(mode="straight",linecolor="#30485d",linewidth=0.16) {#RGNP0:2 (122.5,-38) (122.5,-38) #RGNP0_2__dmy0:1};
// &"RGNP0_2__dmy0" @WIRE(mode="straight",linecolor="#30485d",linewidth=0.16) {#RGNP0_2__dmy0:2 (147.5,-38) (147.5,-38) #RGNP0_3__dmy0:1};
// &"RGNP0_3__dmy0" @WIRE(mode="straight",linecolor="#30485d",linewidth=0.16) {#RGNP0_3__dmy0:2 (172.5,-38) (172.5,-38) #RGNP0_4__dmy0:1};
// &"RGNP0_4__dmy0" @WIRE(mode="straight",linecolor="#30485d",linewidth=0.16) {#RGNP0_4__dmy0:2 (197.5,-38) (197.5,-38) #RGNP0_5__dmy0:1};
// &"GPNRG" @WIRE(mode="straight",linecolor="#30485d",linewidth=0.16) {#RGPN1:1 (222.5,-76) (222.5,-76) #RGPN0_5__dmy0:2};
// &"RGPN1_1__dmy0" @WIRE(mode="straight",linecolor="#30485d",linewidth=0.16) {#RGPN1:2 (247.5,-76) (247.5,-76) #RGPN1_2__dmy0:1};
// &"RGPN1_2__dmy0" @WIRE(mode="straight",linecolor="#30485d",linewidth=0.16) {#RGPN1_2__dmy0:2 (272.5,-76) (272.5,-76) #RGPN1_3__dmy0:1};
// &"RGPN1_3__dmy0" @WIRE(mode="straight",linecolor="#30485d",linewidth=0.16) {#RGPN1_3__dmy0:2 (297.5,-76) (297.5,-76) #RGPN1_4__dmy0:1};
// &"RGPN1_4__dmy0" @WIRE(mode="straight",linecolor="#30485d",linewidth=0.16) {#RGPN1_4__dmy0:2 (322.5,-76) (322.5,-76) #RGPN1_5__dmy0:1};
// &"RGPN0_1__dmy0" @WIRE(mode="straight",linecolor="#30485d",linewidth=0.16) {#RGPN0:2 (122.5,-76) (122.5,-76) #RGPN0_2__dmy0:1};
// &"RGPN0_2__dmy0" @WIRE(mode="straight",linecolor="#30485d",linewidth=0.16) {#RGPN0_2__dmy0:2 (147.5,-76) (147.5,-76) #RGPN0_3__dmy0:1};
// &"RGPN0_3__dmy0" @WIRE(mode="straight",linecolor="#30485d",linewidth=0.16) {#RGPN0_3__dmy0:2 (172.5,-76) (172.5,-76) #RGPN0_4__dmy0:1};
// &"RGPN0_4__dmy0" @WIRE(mode="straight",linecolor="#30485d",linewidth=0.16) {#RGPN0_4__dmy0:2 (197.5,-76) (197.5,-76) #RGPN0_5__dmy0:1};
// &"GPPRG" @WIRE(mode="straight",linecolor="#30485d",linewidth=0.16) {#RGPP1:1 (222.5,-114) (222.5,-114) #RGPP0_5__dmy0:2};
// &"RGPP1_1__dmy0" @WIRE(mode="straight",linecolor="#30485d",linewidth=0.16) {#RGPP1:2 (247.5,-114) (247.5,-114) #RGPP1_2__dmy0:1};
// &"RGPP1_2__dmy0" @WIRE(mode="straight",linecolor="#30485d",linewidth=0.16) {#RGPP1_2__dmy0:2 (272.5,-114) (272.5,-114) #RGPP1_3__dmy0:1};
// &"RGPP1_3__dmy0" @WIRE(mode="straight",linecolor="#30485d",linewidth=0.16) {#RGPP1_3__dmy0:2 (297.5,-114) (297.5,-114) #RGPP1_4__dmy0:1};
// &"RGPP1_4__dmy0" @WIRE(mode="straight",linecolor="#30485d",linewidth=0.16) {#RGPP1_4__dmy0:2 (322.5,-114) (322.5,-114) #RGPP1_5__dmy0:1};
// &"RGPP0_1__dmy0" @WIRE(mode="straight",linecolor="#30485d",linewidth=0.16) {#RGPP0:2 (122.5,-114) (122.5,-114) #RGPP0_2__dmy0:1};
// &"RGPP0_2__dmy0" @WIRE(mode="straight",linecolor="#30485d",linewidth=0.16) {#RGPP0_2__dmy0:2 (147.5,-114) (147.5,-114) #RGPP0_3__dmy0:1};
// &"RGPP0_3__dmy0" @WIRE(mode="straight",linecolor="#30485d",linewidth=0.16) {#RGPP0_3__dmy0:2 (172.5,-114) (172.5,-114) #RGPP0_4__dmy0:1};
// &"RGPP0_4__dmy0" @WIRE(mode="straight",linecolor="#30485d",linewidth=0.16) {#RGPP0_4__dmy0:2 (197.5,-114) (197.5,-114) #RGPP0_5__dmy0:1};
// (-28,-148) @TEXT("GP and GN chains keep their source polarity, device sizing and series R; no zero-delay abstraction.",size=1,halign="start",textcolor="#223d52");
// &"VDD" @WIRE(mode="straight",linecolor="#30485d",linewidth=0.16) {#XSTD_GNNCN:3 (76,10)};
// (76,10.4) @TEXT("VDD",size=1.1,halign="middle",valign="bottom");
// &"VSS" @WIRE(mode="straight",linecolor="#30485d",linewidth=0.16) {#XSTD_GNNCN:4 (76,-10)};
// (76,-10.4) @TEXT("VSS",size=1.1,halign="middle",valign="top");
// &"VDD" @WIRE(mode="straight",linecolor="#30485d",linewidth=0.16) {#XSTD_GNNBN:3 (47,10)};
// (47,10.4) @TEXT("VDD",size=1.1,halign="middle",valign="bottom");
// &"VSS" @WIRE(mode="straight",linecolor="#30485d",linewidth=0.16) {#XSTD_GNNBN:4 (47,-10)};
// (47,-10.4) @TEXT("VSS",size=1.1,halign="middle",valign="top");
// &"VDD" @WIRE(mode="straight",linecolor="#30485d",linewidth=0.16) {#XSTD_GNNAN:3 (18,10)};
// (18,10.4) @TEXT("VDD",size=1.1,halign="middle",valign="bottom");
// &"VSS" @WIRE(mode="straight",linecolor="#30485d",linewidth=0.16) {#XSTD_GNNAN:4 (18,-10)};
// (18,-10.4) @TEXT("VSS",size=1.1,halign="middle",valign="top");
// &"VDD" @WIRE(mode="straight",linecolor="#30485d",linewidth=0.16) {#XSTD_GNPCN:3 (76,-28)};
// (76,-27.6) @TEXT("VDD",size=1.1,halign="middle",valign="bottom");
// &"VSS" @WIRE(mode="straight",linecolor="#30485d",linewidth=0.16) {#XSTD_GNPCN:4 (76,-48)};
// (76,-48.4) @TEXT("VSS",size=1.1,halign="middle",valign="top");
// &"VDD" @WIRE(mode="straight",linecolor="#30485d",linewidth=0.16) {#XSTD_GNPBN:3 (47,-28)};
// (47,-27.6) @TEXT("VDD",size=1.1,halign="middle",valign="bottom");
// &"VSS" @WIRE(mode="straight",linecolor="#30485d",linewidth=0.16) {#XSTD_GNPBN:4 (47,-48)};
// (47,-48.4) @TEXT("VSS",size=1.1,halign="middle",valign="top");
// &"VDD" @WIRE(mode="straight",linecolor="#30485d",linewidth=0.16) {#XSTD_GNPAN:3 (18,-28)};
// (18,-27.6) @TEXT("VDD",size=1.1,halign="middle",valign="bottom");
// &"VSS" @WIRE(mode="straight",linecolor="#30485d",linewidth=0.16) {#XSTD_GNPAN:4 (18,-48)};
// (18,-48.4) @TEXT("VSS",size=1.1,halign="middle",valign="top");
// &"VDD" @WIRE(mode="straight",linecolor="#30485d",linewidth=0.16) {#XSTD_GPNCN:3 (76,-66)};
// (76,-65.6) @TEXT("VDD",size=1.1,halign="middle",valign="bottom");
// &"VSS" @WIRE(mode="straight",linecolor="#30485d",linewidth=0.16) {#XSTD_GPNCN:4 (76,-86)};
// (76,-86.4) @TEXT("VSS",size=1.1,halign="middle",valign="top");
// &"VDD" @WIRE(mode="straight",linecolor="#30485d",linewidth=0.16) {#XSTD_GPNBN:3 (47,-66)};
// (47,-65.6) @TEXT("VDD",size=1.1,halign="middle",valign="bottom");
// &"VSS" @WIRE(mode="straight",linecolor="#30485d",linewidth=0.16) {#XSTD_GPNBN:4 (47,-86)};
// (47,-86.4) @TEXT("VSS",size=1.1,halign="middle",valign="top");
// &"VDD" @WIRE(mode="straight",linecolor="#30485d",linewidth=0.16) {#XSTD_GPNAN:3 (18,-66)};
// (18,-65.6) @TEXT("VDD",size=1.1,halign="middle",valign="bottom");
// &"VSS" @WIRE(mode="straight",linecolor="#30485d",linewidth=0.16) {#XSTD_GPNAN:4 (18,-86)};
// (18,-86.4) @TEXT("VSS",size=1.1,halign="middle",valign="top");
// &"VDD" @WIRE(mode="straight",linecolor="#30485d",linewidth=0.16) {#XSTD_GPPCN:3 (76,-104)};
// (76,-103.6) @TEXT("VDD",size=1.1,halign="middle",valign="bottom");
// &"VSS" @WIRE(mode="straight",linecolor="#30485d",linewidth=0.16) {#XSTD_GPPCN:4 (76,-124)};
// (76,-124.4) @TEXT("VSS",size=1.1,halign="middle",valign="top");
// &"VDD" @WIRE(mode="straight",linecolor="#30485d",linewidth=0.16) {#XSTD_GPPBN:3 (47,-104)};
// (47,-103.6) @TEXT("VDD",size=1.1,halign="middle",valign="bottom");
// &"VSS" @WIRE(mode="straight",linecolor="#30485d",linewidth=0.16) {#XSTD_GPPBN:4 (47,-124)};
// (47,-124.4) @TEXT("VSS",size=1.1,halign="middle",valign="top");
// &"L" @WIRE(mode="straight",linecolor="#30485d",linewidth=0.16) {#XSTD_GPPAN:1 (8,-114)};
// (7.6,-114) @TEXT("L",size=1.1,halign="end",valign="middle");
// &"VDD" @WIRE(mode="straight",linecolor="#30485d",linewidth=0.16) {#XSTD_GPPAN:3 (18,-104)};
// (18,-103.6) @TEXT("VDD",size=1.1,halign="middle",valign="bottom");
// &"VSS" @WIRE(mode="straight",linecolor="#30485d",linewidth=0.16) {#XSTD_GPPAN:4 (18,-124)};
// (18,-124.4) @TEXT("VSS",size=1.1,halign="middle",valign="top");
// &"GNN" @WIRE(mode="straight",linecolor="#30485d",linewidth=0.16) {#RGNN1_5__dmy0:2 (340,0)};
// (340.4,0) @TEXT("GNN",size=1.1,halign="start",valign="middle");
// &"GNP" @WIRE(mode="straight",linecolor="#30485d",linewidth=0.16) {#RGNP1_5__dmy0:2 (340,-38)};
// (340.4,-38) @TEXT("GNP",size=1.1,halign="start",valign="middle");
// &"GPN" @WIRE(mode="straight",linecolor="#30485d",linewidth=0.16) {#RGPN1_5__dmy0:2 (340,-76)};
// (340.4,-76) @TEXT("GPN",size=1.1,halign="start",valign="middle");
// &"GPP" @WIRE(mode="straight",linecolor="#30485d",linewidth=0.16) {#RGPP1_5__dmy0:2 (340,-114)};
// (340.4,-114) @TEXT("GPP",size=1.1,halign="start",valign="middle");
// &"L" @WIRE(mode="straight",linecolor="#30485d",linewidth=0.16) {#X025:1 (-27,0)};
// (-27.4,0) @TEXT("L",size=1.1,halign="end",valign="middle");
// &"VDD" @WIRE(mode="straight",linecolor="#30485d",linewidth=0.16) {#X025:2 (-17,10)};
// (-17,10.4) @TEXT("VDD",size=1.1,halign="middle",valign="bottom");
// &"VSS" @WIRE(mode="straight",linecolor="#30485d",linewidth=0.16) {#X025:3 (-17,-10)};
// (-17,-10.4) @TEXT("VSS",size=1.1,halign="middle",valign="top");
// &"VDD" @WIRE(mode="straight",linecolor="#30485d",linewidth=0.16) {#X008:2 (-17,-66)};
// (-17,-65.6) @TEXT("VDD",size=1.1,halign="middle",valign="bottom");
// &"VSS" @WIRE(mode="straight",linecolor="#30485d",linewidth=0.16) {#X008:3 (-17,-86)};
// (-17,-86.4) @TEXT("VSS",size=1.1,halign="middle",valign="top");
// }
// END SARADC RNL
ends sar8p_refdrv_b4

subckt sar8p_refdrv_b5 GNN GNP GPN GPP H L VDD VSS
    XSTD_GNNCN (GNNB GNNDRV VDD VSS) INVD1BWP12T30P140
    XSTD_GNNBN (GNNA GNNB VDD VSS) INVD1BWP12T30P140
    XSTD_GNNAN (GNNPRE GNNA VDD VSS) INVD1BWP12T30P140
    XSTD_GNPCN (GNPB GNPDRV VDD VSS) INVD1BWP12T30P140
    XSTD_GNPBN (GNPA GNPB VDD VSS) INVD1BWP12T30P140
    XSTD_GNPAN (H GNPA VDD VSS) INVD1BWP12T30P140
    XSTD_GPNCN (GPNB GPNDRV VDD VSS) INVD1BWP12T30P140
    XSTD_GPNBN (GPNA GPNB VDD VSS) INVD1BWP12T30P140
    XSTD_GPNAN (GPNPRE GPNA VDD VSS) INVD1BWP12T30P140
    XSTD_GPPCN (GPPB GPPDRV VDD VSS) INVD1BWP12T30P140
    XSTD_GPPBN (GPPA GPPB VDD VSS) INVD1BWP12T30P140
    XSTD_GPPAN (L GPPA VDD VSS) INVD1BWP12T30P140
//Series configuration of RGNN1
RGNN1  (GNNRG RGNN1_1__dmy0 ) rupolym l=17.13u w=1u m=32 multi=(1)
RGNN1_2__dmy0  (RGNN1_1__dmy0 RGNN1_2__dmy0 ) rupolym l=17.13u w=1u m=32          multi=(1)
RGNN1_3__dmy0  (RGNN1_2__dmy0 RGNN1_3__dmy0 ) rupolym l=17.13u w=1u m=32          multi=(1)
RGNN1_4__dmy0  (RGNN1_3__dmy0 RGNN1_4__dmy0 ) rupolym l=17.13u w=1u m=32          multi=(1)
RGNN1_5__dmy0  (RGNN1_4__dmy0 GNN ) rupolym l=17.13u w=1u m=32 multi=(1)
//End of RGNN1

//Series configuration of RGNN0
RGNN0  (GNNDRV RGNN0_1__dmy0 ) rupolym l=17.13u w=1u m=32 multi=(1)
RGNN0_2__dmy0  (RGNN0_1__dmy0 RGNN0_2__dmy0 ) rupolym l=17.13u w=1u m=32          multi=(1)
RGNN0_3__dmy0  (RGNN0_2__dmy0 RGNN0_3__dmy0 ) rupolym l=17.13u w=1u m=32          multi=(1)
RGNN0_4__dmy0  (RGNN0_3__dmy0 RGNN0_4__dmy0 ) rupolym l=17.13u w=1u m=32          multi=(1)
RGNN0_5__dmy0  (RGNN0_4__dmy0 GNNRG ) rupolym l=17.13u w=1u m=32 multi=(1)
//End of RGNN0

//Series configuration of RGNP1
RGNP1  (GNPRG RGNP1_1__dmy0 ) rupolym l=17.13u w=1u m=32 multi=(1)
RGNP1_2__dmy0  (RGNP1_1__dmy0 RGNP1_2__dmy0 ) rupolym l=17.13u w=1u m=32          multi=(1)
RGNP1_3__dmy0  (RGNP1_2__dmy0 RGNP1_3__dmy0 ) rupolym l=17.13u w=1u m=32          multi=(1)
RGNP1_4__dmy0  (RGNP1_3__dmy0 RGNP1_4__dmy0 ) rupolym l=17.13u w=1u m=32          multi=(1)
RGNP1_5__dmy0  (RGNP1_4__dmy0 GNP ) rupolym l=17.13u w=1u m=32 multi=(1)
//End of RGNP1

//Series configuration of RGNP0
RGNP0  (GNPDRV RGNP0_1__dmy0 ) rupolym l=17.13u w=1u m=32 multi=(1)
RGNP0_2__dmy0  (RGNP0_1__dmy0 RGNP0_2__dmy0 ) rupolym l=17.13u w=1u m=32          multi=(1)
RGNP0_3__dmy0  (RGNP0_2__dmy0 RGNP0_3__dmy0 ) rupolym l=17.13u w=1u m=32          multi=(1)
RGNP0_4__dmy0  (RGNP0_3__dmy0 RGNP0_4__dmy0 ) rupolym l=17.13u w=1u m=32          multi=(1)
RGNP0_5__dmy0  (RGNP0_4__dmy0 GNPRG ) rupolym l=17.13u w=1u m=32 multi=(1)
//End of RGNP0

//Series configuration of RGPN1
RGPN1  (GPNRG RGPN1_1__dmy0 ) rupolym l=17.13u w=1u m=32 multi=(1)
RGPN1_2__dmy0  (RGPN1_1__dmy0 RGPN1_2__dmy0 ) rupolym l=17.13u w=1u m=32          multi=(1)
RGPN1_3__dmy0  (RGPN1_2__dmy0 RGPN1_3__dmy0 ) rupolym l=17.13u w=1u m=32          multi=(1)
RGPN1_4__dmy0  (RGPN1_3__dmy0 RGPN1_4__dmy0 ) rupolym l=17.13u w=1u m=32          multi=(1)
RGPN1_5__dmy0  (RGPN1_4__dmy0 GPN ) rupolym l=17.13u w=1u m=32 multi=(1)
//End of RGPN1

//Series configuration of RGPN0
RGPN0  (GPNDRV RGPN0_1__dmy0 ) rupolym l=17.13u w=1u m=32 multi=(1)
RGPN0_2__dmy0  (RGPN0_1__dmy0 RGPN0_2__dmy0 ) rupolym l=17.13u w=1u m=32          multi=(1)
RGPN0_3__dmy0  (RGPN0_2__dmy0 RGPN0_3__dmy0 ) rupolym l=17.13u w=1u m=32          multi=(1)
RGPN0_4__dmy0  (RGPN0_3__dmy0 RGPN0_4__dmy0 ) rupolym l=17.13u w=1u m=32          multi=(1)
RGPN0_5__dmy0  (RGPN0_4__dmy0 GPNRG ) rupolym l=17.13u w=1u m=32 multi=(1)
//End of RGPN0

//Series configuration of RGPP1
RGPP1  (GPPRG RGPP1_1__dmy0 ) rupolym l=17.13u w=1u m=32 multi=(1)
RGPP1_2__dmy0  (RGPP1_1__dmy0 RGPP1_2__dmy0 ) rupolym l=17.13u w=1u m=32          multi=(1)
RGPP1_3__dmy0  (RGPP1_2__dmy0 RGPP1_3__dmy0 ) rupolym l=17.13u w=1u m=32          multi=(1)
RGPP1_4__dmy0  (RGPP1_3__dmy0 RGPP1_4__dmy0 ) rupolym l=17.13u w=1u m=32          multi=(1)
RGPP1_5__dmy0  (RGPP1_4__dmy0 GPP ) rupolym l=17.13u w=1u m=32 multi=(1)
//End of RGPP1

//Series configuration of RGPP0
RGPP0  (GPPDRV RGPP0_1__dmy0 ) rupolym l=17.13u w=1u m=32 multi=(1)
RGPP0_2__dmy0  (RGPP0_1__dmy0 RGPP0_2__dmy0 ) rupolym l=17.13u w=1u m=32          multi=(1)
RGPP0_3__dmy0  (RGPP0_2__dmy0 RGPP0_3__dmy0 ) rupolym l=17.13u w=1u m=32          multi=(1)
RGPP0_4__dmy0  (RGPP0_3__dmy0 RGPP0_4__dmy0 ) rupolym l=17.13u w=1u m=32          multi=(1)
RGPP0_5__dmy0  (RGPP0_4__dmy0 GPPRG ) rupolym l=17.13u w=1u m=32 multi=(1)
//End of RGPP0

    X025 (L VDD VSS GNNPRE) sar8p_inv
    X008 (H VDD VSS GPNPRE) sar8p_inv
// BEGIN SARADC RNL
// @RNL(author="saradc topology") {
// (-28,27) @TEXT("sar8p_refdrv_b5 / four physical gate-driver chains",size=1.5,halign="start",textcolor="#223d52");
// #X025 @SET-SYMBOL $S_sar8p_inv;
// #X025 @PLACE(-17,0) => @ORIENT("R0");
// #XSTD_GNNAN @SET-SYMBOL $S_INVD1BWP12T30P140;
// #XSTD_GNNAN @PLACE(18,0) => @ORIENT("R0");
// #XSTD_GNNBN @SET-SYMBOL $S_INVD1BWP12T30P140;
// #XSTD_GNNBN @PLACE(47,0) => @ORIENT("R0");
// #XSTD_GNNCN @SET-SYMBOL $S_INVD1BWP12T30P140;
// #XSTD_GNNCN @PLACE(76,0) => @ORIENT("R0");
// #RGNN0 @SET-SYMBOL $RESISTOR;
// #RGNN0 @PLACE(110,0) => @ORIENT("R90");
// #RGNN0 @TEXT("RGNN0",key="name",size=1.3,halign="start") => @PLACE(113,3);
// #RGNN0 @TEXT("l=17.13u w=1u multi=(1)",key="value",size=0.9,halign="start") => @PLACE(113,-4);
// #RGNN0 @TEXT("",key="model");
// #RGNN0_2__dmy0 @SET-SYMBOL $RESISTOR;
// #RGNN0_2__dmy0 @PLACE(135,0) => @ORIENT("R90");
// #RGNN0_2__dmy0 @TEXT("RGNN0_2__dmy0",key="name",size=1.3,halign="start") => @PLACE(138,3);
// #RGNN0_2__dmy0 @TEXT("l=17.13u w=1u multi=(1)",key="value",size=0.9,halign="start") => @PLACE(138,-4);
// #RGNN0_2__dmy0 @TEXT("",key="model");
// #RGNN0_3__dmy0 @SET-SYMBOL $RESISTOR;
// #RGNN0_3__dmy0 @PLACE(160,0) => @ORIENT("R90");
// #RGNN0_3__dmy0 @TEXT("RGNN0_3__dmy0",key="name",size=1.3,halign="start") => @PLACE(163,3);
// #RGNN0_3__dmy0 @TEXT("l=17.13u w=1u multi=(1)",key="value",size=0.9,halign="start") => @PLACE(163,-4);
// #RGNN0_3__dmy0 @TEXT("",key="model");
// #RGNN0_4__dmy0 @SET-SYMBOL $RESISTOR;
// #RGNN0_4__dmy0 @PLACE(185,0) => @ORIENT("R90");
// #RGNN0_4__dmy0 @TEXT("RGNN0_4__dmy0",key="name",size=1.3,halign="start") => @PLACE(188,3);
// #RGNN0_4__dmy0 @TEXT("l=17.13u w=1u multi=(1)",key="value",size=0.9,halign="start") => @PLACE(188,-4);
// #RGNN0_4__dmy0 @TEXT("",key="model");
// #RGNN0_5__dmy0 @SET-SYMBOL $RESISTOR;
// #RGNN0_5__dmy0 @PLACE(210,0) => @ORIENT("R90");
// #RGNN0_5__dmy0 @TEXT("RGNN0_5__dmy0",key="name",size=1.3,halign="start") => @PLACE(213,3);
// #RGNN0_5__dmy0 @TEXT("l=17.13u w=1u multi=(1)",key="value",size=0.9,halign="start") => @PLACE(213,-4);
// #RGNN0_5__dmy0 @TEXT("",key="model");
// #RGNN1 @SET-SYMBOL $RESISTOR;
// #RGNN1 @PLACE(235,0) => @ORIENT("R90");
// #RGNN1 @TEXT("RGNN1",key="name",size=1.3,halign="start") => @PLACE(238,3);
// #RGNN1 @TEXT("l=17.13u w=1u multi=(1)",key="value",size=0.9,halign="start") => @PLACE(238,-4);
// #RGNN1 @TEXT("",key="model");
// #RGNN1_2__dmy0 @SET-SYMBOL $RESISTOR;
// #RGNN1_2__dmy0 @PLACE(260,0) => @ORIENT("R90");
// #RGNN1_2__dmy0 @TEXT("RGNN1_2__dmy0",key="name",size=1.3,halign="start") => @PLACE(263,3);
// #RGNN1_2__dmy0 @TEXT("l=17.13u w=1u multi=(1)",key="value",size=0.9,halign="start") => @PLACE(263,-4);
// #RGNN1_2__dmy0 @TEXT("",key="model");
// #RGNN1_3__dmy0 @SET-SYMBOL $RESISTOR;
// #RGNN1_3__dmy0 @PLACE(285,0) => @ORIENT("R90");
// #RGNN1_3__dmy0 @TEXT("RGNN1_3__dmy0",key="name",size=1.3,halign="start") => @PLACE(288,3);
// #RGNN1_3__dmy0 @TEXT("l=17.13u w=1u multi=(1)",key="value",size=0.9,halign="start") => @PLACE(288,-4);
// #RGNN1_3__dmy0 @TEXT("",key="model");
// #RGNN1_4__dmy0 @SET-SYMBOL $RESISTOR;
// #RGNN1_4__dmy0 @PLACE(310,0) => @ORIENT("R90");
// #RGNN1_4__dmy0 @TEXT("RGNN1_4__dmy0",key="name",size=1.3,halign="start") => @PLACE(313,3);
// #RGNN1_4__dmy0 @TEXT("l=17.13u w=1u multi=(1)",key="value",size=0.9,halign="start") => @PLACE(313,-4);
// #RGNN1_4__dmy0 @TEXT("",key="model");
// #RGNN1_5__dmy0 @SET-SYMBOL $RESISTOR;
// #RGNN1_5__dmy0 @PLACE(335,0) => @ORIENT("R90");
// #RGNN1_5__dmy0 @TEXT("RGNN1_5__dmy0",key="name",size=1.3,halign="start") => @PLACE(338,3);
// #RGNN1_5__dmy0 @TEXT("l=17.13u w=1u multi=(1)",key="value",size=0.9,halign="start") => @PLACE(338,-4);
// #RGNN1_5__dmy0 @TEXT("",key="model");
// (104,15) @TEXT("GNN / 10 series poly sections",size=0.95,halign="start",textcolor="#223d52");
// #XSTD_GNPAN @SET-SYMBOL $S_INVD1BWP12T30P140;
// #XSTD_GNPAN @PLACE(18,-38) => @ORIENT("R0");
// #XSTD_GNPBN @SET-SYMBOL $S_INVD1BWP12T30P140;
// #XSTD_GNPBN @PLACE(47,-38) => @ORIENT("R0");
// #XSTD_GNPCN @SET-SYMBOL $S_INVD1BWP12T30P140;
// #XSTD_GNPCN @PLACE(76,-38) => @ORIENT("R0");
// #RGNP0 @SET-SYMBOL $RESISTOR;
// #RGNP0 @PLACE(110,-38) => @ORIENT("R90");
// #RGNP0 @TEXT("RGNP0",key="name",size=1.3,halign="start") => @PLACE(113,-35);
// #RGNP0 @TEXT("l=17.13u w=1u multi=(1)",key="value",size=0.9,halign="start") => @PLACE(113,-42);
// #RGNP0 @TEXT("",key="model");
// #RGNP0_2__dmy0 @SET-SYMBOL $RESISTOR;
// #RGNP0_2__dmy0 @PLACE(135,-38) => @ORIENT("R90");
// #RGNP0_2__dmy0 @TEXT("RGNP0_2__dmy0",key="name",size=1.3,halign="start") => @PLACE(138,-35);
// #RGNP0_2__dmy0 @TEXT("l=17.13u w=1u multi=(1)",key="value",size=0.9,halign="start") => @PLACE(138,-42);
// #RGNP0_2__dmy0 @TEXT("",key="model");
// #RGNP0_3__dmy0 @SET-SYMBOL $RESISTOR;
// #RGNP0_3__dmy0 @PLACE(160,-38) => @ORIENT("R90");
// #RGNP0_3__dmy0 @TEXT("RGNP0_3__dmy0",key="name",size=1.3,halign="start") => @PLACE(163,-35);
// #RGNP0_3__dmy0 @TEXT("l=17.13u w=1u multi=(1)",key="value",size=0.9,halign="start") => @PLACE(163,-42);
// #RGNP0_3__dmy0 @TEXT("",key="model");
// #RGNP0_4__dmy0 @SET-SYMBOL $RESISTOR;
// #RGNP0_4__dmy0 @PLACE(185,-38) => @ORIENT("R90");
// #RGNP0_4__dmy0 @TEXT("RGNP0_4__dmy0",key="name",size=1.3,halign="start") => @PLACE(188,-35);
// #RGNP0_4__dmy0 @TEXT("l=17.13u w=1u multi=(1)",key="value",size=0.9,halign="start") => @PLACE(188,-42);
// #RGNP0_4__dmy0 @TEXT("",key="model");
// #RGNP0_5__dmy0 @SET-SYMBOL $RESISTOR;
// #RGNP0_5__dmy0 @PLACE(210,-38) => @ORIENT("R90");
// #RGNP0_5__dmy0 @TEXT("RGNP0_5__dmy0",key="name",size=1.3,halign="start") => @PLACE(213,-35);
// #RGNP0_5__dmy0 @TEXT("l=17.13u w=1u multi=(1)",key="value",size=0.9,halign="start") => @PLACE(213,-42);
// #RGNP0_5__dmy0 @TEXT("",key="model");
// #RGNP1 @SET-SYMBOL $RESISTOR;
// #RGNP1 @PLACE(235,-38) => @ORIENT("R90");
// #RGNP1 @TEXT("RGNP1",key="name",size=1.3,halign="start") => @PLACE(238,-35);
// #RGNP1 @TEXT("l=17.13u w=1u multi=(1)",key="value",size=0.9,halign="start") => @PLACE(238,-42);
// #RGNP1 @TEXT("",key="model");
// #RGNP1_2__dmy0 @SET-SYMBOL $RESISTOR;
// #RGNP1_2__dmy0 @PLACE(260,-38) => @ORIENT("R90");
// #RGNP1_2__dmy0 @TEXT("RGNP1_2__dmy0",key="name",size=1.3,halign="start") => @PLACE(263,-35);
// #RGNP1_2__dmy0 @TEXT("l=17.13u w=1u multi=(1)",key="value",size=0.9,halign="start") => @PLACE(263,-42);
// #RGNP1_2__dmy0 @TEXT("",key="model");
// #RGNP1_3__dmy0 @SET-SYMBOL $RESISTOR;
// #RGNP1_3__dmy0 @PLACE(285,-38) => @ORIENT("R90");
// #RGNP1_3__dmy0 @TEXT("RGNP1_3__dmy0",key="name",size=1.3,halign="start") => @PLACE(288,-35);
// #RGNP1_3__dmy0 @TEXT("l=17.13u w=1u multi=(1)",key="value",size=0.9,halign="start") => @PLACE(288,-42);
// #RGNP1_3__dmy0 @TEXT("",key="model");
// #RGNP1_4__dmy0 @SET-SYMBOL $RESISTOR;
// #RGNP1_4__dmy0 @PLACE(310,-38) => @ORIENT("R90");
// #RGNP1_4__dmy0 @TEXT("RGNP1_4__dmy0",key="name",size=1.3,halign="start") => @PLACE(313,-35);
// #RGNP1_4__dmy0 @TEXT("l=17.13u w=1u multi=(1)",key="value",size=0.9,halign="start") => @PLACE(313,-42);
// #RGNP1_4__dmy0 @TEXT("",key="model");
// #RGNP1_5__dmy0 @SET-SYMBOL $RESISTOR;
// #RGNP1_5__dmy0 @PLACE(335,-38) => @ORIENT("R90");
// #RGNP1_5__dmy0 @TEXT("RGNP1_5__dmy0",key="name",size=1.3,halign="start") => @PLACE(338,-35);
// #RGNP1_5__dmy0 @TEXT("l=17.13u w=1u multi=(1)",key="value",size=0.9,halign="start") => @PLACE(338,-42);
// #RGNP1_5__dmy0 @TEXT("",key="model");
// (104,-23) @TEXT("GNP / 10 series poly sections",size=0.95,halign="start",textcolor="#223d52");
// #X008 @SET-SYMBOL $S_sar8p_inv;
// #X008 @PLACE(-17,-76) => @ORIENT("R0");
// #XSTD_GPNAN @SET-SYMBOL $S_INVD1BWP12T30P140;
// #XSTD_GPNAN @PLACE(18,-76) => @ORIENT("R0");
// #XSTD_GPNBN @SET-SYMBOL $S_INVD1BWP12T30P140;
// #XSTD_GPNBN @PLACE(47,-76) => @ORIENT("R0");
// #XSTD_GPNCN @SET-SYMBOL $S_INVD1BWP12T30P140;
// #XSTD_GPNCN @PLACE(76,-76) => @ORIENT("R0");
// #RGPN0 @SET-SYMBOL $RESISTOR;
// #RGPN0 @PLACE(110,-76) => @ORIENT("R90");
// #RGPN0 @TEXT("RGPN0",key="name",size=1.3,halign="start") => @PLACE(113,-73);
// #RGPN0 @TEXT("l=17.13u w=1u multi=(1)",key="value",size=0.9,halign="start") => @PLACE(113,-80);
// #RGPN0 @TEXT("",key="model");
// #RGPN0_2__dmy0 @SET-SYMBOL $RESISTOR;
// #RGPN0_2__dmy0 @PLACE(135,-76) => @ORIENT("R90");
// #RGPN0_2__dmy0 @TEXT("RGPN0_2__dmy0",key="name",size=1.3,halign="start") => @PLACE(138,-73);
// #RGPN0_2__dmy0 @TEXT("l=17.13u w=1u multi=(1)",key="value",size=0.9,halign="start") => @PLACE(138,-80);
// #RGPN0_2__dmy0 @TEXT("",key="model");
// #RGPN0_3__dmy0 @SET-SYMBOL $RESISTOR;
// #RGPN0_3__dmy0 @PLACE(160,-76) => @ORIENT("R90");
// #RGPN0_3__dmy0 @TEXT("RGPN0_3__dmy0",key="name",size=1.3,halign="start") => @PLACE(163,-73);
// #RGPN0_3__dmy0 @TEXT("l=17.13u w=1u multi=(1)",key="value",size=0.9,halign="start") => @PLACE(163,-80);
// #RGPN0_3__dmy0 @TEXT("",key="model");
// #RGPN0_4__dmy0 @SET-SYMBOL $RESISTOR;
// #RGPN0_4__dmy0 @PLACE(185,-76) => @ORIENT("R90");
// #RGPN0_4__dmy0 @TEXT("RGPN0_4__dmy0",key="name",size=1.3,halign="start") => @PLACE(188,-73);
// #RGPN0_4__dmy0 @TEXT("l=17.13u w=1u multi=(1)",key="value",size=0.9,halign="start") => @PLACE(188,-80);
// #RGPN0_4__dmy0 @TEXT("",key="model");
// #RGPN0_5__dmy0 @SET-SYMBOL $RESISTOR;
// #RGPN0_5__dmy0 @PLACE(210,-76) => @ORIENT("R90");
// #RGPN0_5__dmy0 @TEXT("RGPN0_5__dmy0",key="name",size=1.3,halign="start") => @PLACE(213,-73);
// #RGPN0_5__dmy0 @TEXT("l=17.13u w=1u multi=(1)",key="value",size=0.9,halign="start") => @PLACE(213,-80);
// #RGPN0_5__dmy0 @TEXT("",key="model");
// #RGPN1 @SET-SYMBOL $RESISTOR;
// #RGPN1 @PLACE(235,-76) => @ORIENT("R90");
// #RGPN1 @TEXT("RGPN1",key="name",size=1.3,halign="start") => @PLACE(238,-73);
// #RGPN1 @TEXT("l=17.13u w=1u multi=(1)",key="value",size=0.9,halign="start") => @PLACE(238,-80);
// #RGPN1 @TEXT("",key="model");
// #RGPN1_2__dmy0 @SET-SYMBOL $RESISTOR;
// #RGPN1_2__dmy0 @PLACE(260,-76) => @ORIENT("R90");
// #RGPN1_2__dmy0 @TEXT("RGPN1_2__dmy0",key="name",size=1.3,halign="start") => @PLACE(263,-73);
// #RGPN1_2__dmy0 @TEXT("l=17.13u w=1u multi=(1)",key="value",size=0.9,halign="start") => @PLACE(263,-80);
// #RGPN1_2__dmy0 @TEXT("",key="model");
// #RGPN1_3__dmy0 @SET-SYMBOL $RESISTOR;
// #RGPN1_3__dmy0 @PLACE(285,-76) => @ORIENT("R90");
// #RGPN1_3__dmy0 @TEXT("RGPN1_3__dmy0",key="name",size=1.3,halign="start") => @PLACE(288,-73);
// #RGPN1_3__dmy0 @TEXT("l=17.13u w=1u multi=(1)",key="value",size=0.9,halign="start") => @PLACE(288,-80);
// #RGPN1_3__dmy0 @TEXT("",key="model");
// #RGPN1_4__dmy0 @SET-SYMBOL $RESISTOR;
// #RGPN1_4__dmy0 @PLACE(310,-76) => @ORIENT("R90");
// #RGPN1_4__dmy0 @TEXT("RGPN1_4__dmy0",key="name",size=1.3,halign="start") => @PLACE(313,-73);
// #RGPN1_4__dmy0 @TEXT("l=17.13u w=1u multi=(1)",key="value",size=0.9,halign="start") => @PLACE(313,-80);
// #RGPN1_4__dmy0 @TEXT("",key="model");
// #RGPN1_5__dmy0 @SET-SYMBOL $RESISTOR;
// #RGPN1_5__dmy0 @PLACE(335,-76) => @ORIENT("R90");
// #RGPN1_5__dmy0 @TEXT("RGPN1_5__dmy0",key="name",size=1.3,halign="start") => @PLACE(338,-73);
// #RGPN1_5__dmy0 @TEXT("l=17.13u w=1u multi=(1)",key="value",size=0.9,halign="start") => @PLACE(338,-80);
// #RGPN1_5__dmy0 @TEXT("",key="model");
// (104,-61) @TEXT("GPN / 10 series poly sections",size=0.95,halign="start",textcolor="#223d52");
// #XSTD_GPPAN @SET-SYMBOL $S_INVD1BWP12T30P140;
// #XSTD_GPPAN @PLACE(18,-114) => @ORIENT("R0");
// #XSTD_GPPBN @SET-SYMBOL $S_INVD1BWP12T30P140;
// #XSTD_GPPBN @PLACE(47,-114) => @ORIENT("R0");
// #XSTD_GPPCN @SET-SYMBOL $S_INVD1BWP12T30P140;
// #XSTD_GPPCN @PLACE(76,-114) => @ORIENT("R0");
// #RGPP0 @SET-SYMBOL $RESISTOR;
// #RGPP0 @PLACE(110,-114) => @ORIENT("R90");
// #RGPP0 @TEXT("RGPP0",key="name",size=1.3,halign="start") => @PLACE(113,-111);
// #RGPP0 @TEXT("l=17.13u w=1u multi=(1)",key="value",size=0.9,halign="start") => @PLACE(113,-118);
// #RGPP0 @TEXT("",key="model");
// #RGPP0_2__dmy0 @SET-SYMBOL $RESISTOR;
// #RGPP0_2__dmy0 @PLACE(135,-114) => @ORIENT("R90");
// #RGPP0_2__dmy0 @TEXT("RGPP0_2__dmy0",key="name",size=1.3,halign="start") => @PLACE(138,-111);
// #RGPP0_2__dmy0 @TEXT("l=17.13u w=1u multi=(1)",key="value",size=0.9,halign="start") => @PLACE(138,-118);
// #RGPP0_2__dmy0 @TEXT("",key="model");
// #RGPP0_3__dmy0 @SET-SYMBOL $RESISTOR;
// #RGPP0_3__dmy0 @PLACE(160,-114) => @ORIENT("R90");
// #RGPP0_3__dmy0 @TEXT("RGPP0_3__dmy0",key="name",size=1.3,halign="start") => @PLACE(163,-111);
// #RGPP0_3__dmy0 @TEXT("l=17.13u w=1u multi=(1)",key="value",size=0.9,halign="start") => @PLACE(163,-118);
// #RGPP0_3__dmy0 @TEXT("",key="model");
// #RGPP0_4__dmy0 @SET-SYMBOL $RESISTOR;
// #RGPP0_4__dmy0 @PLACE(185,-114) => @ORIENT("R90");
// #RGPP0_4__dmy0 @TEXT("RGPP0_4__dmy0",key="name",size=1.3,halign="start") => @PLACE(188,-111);
// #RGPP0_4__dmy0 @TEXT("l=17.13u w=1u multi=(1)",key="value",size=0.9,halign="start") => @PLACE(188,-118);
// #RGPP0_4__dmy0 @TEXT("",key="model");
// #RGPP0_5__dmy0 @SET-SYMBOL $RESISTOR;
// #RGPP0_5__dmy0 @PLACE(210,-114) => @ORIENT("R90");
// #RGPP0_5__dmy0 @TEXT("RGPP0_5__dmy0",key="name",size=1.3,halign="start") => @PLACE(213,-111);
// #RGPP0_5__dmy0 @TEXT("l=17.13u w=1u multi=(1)",key="value",size=0.9,halign="start") => @PLACE(213,-118);
// #RGPP0_5__dmy0 @TEXT("",key="model");
// #RGPP1 @SET-SYMBOL $RESISTOR;
// #RGPP1 @PLACE(235,-114) => @ORIENT("R90");
// #RGPP1 @TEXT("RGPP1",key="name",size=1.3,halign="start") => @PLACE(238,-111);
// #RGPP1 @TEXT("l=17.13u w=1u multi=(1)",key="value",size=0.9,halign="start") => @PLACE(238,-118);
// #RGPP1 @TEXT("",key="model");
// #RGPP1_2__dmy0 @SET-SYMBOL $RESISTOR;
// #RGPP1_2__dmy0 @PLACE(260,-114) => @ORIENT("R90");
// #RGPP1_2__dmy0 @TEXT("RGPP1_2__dmy0",key="name",size=1.3,halign="start") => @PLACE(263,-111);
// #RGPP1_2__dmy0 @TEXT("l=17.13u w=1u multi=(1)",key="value",size=0.9,halign="start") => @PLACE(263,-118);
// #RGPP1_2__dmy0 @TEXT("",key="model");
// #RGPP1_3__dmy0 @SET-SYMBOL $RESISTOR;
// #RGPP1_3__dmy0 @PLACE(285,-114) => @ORIENT("R90");
// #RGPP1_3__dmy0 @TEXT("RGPP1_3__dmy0",key="name",size=1.3,halign="start") => @PLACE(288,-111);
// #RGPP1_3__dmy0 @TEXT("l=17.13u w=1u multi=(1)",key="value",size=0.9,halign="start") => @PLACE(288,-118);
// #RGPP1_3__dmy0 @TEXT("",key="model");
// #RGPP1_4__dmy0 @SET-SYMBOL $RESISTOR;
// #RGPP1_4__dmy0 @PLACE(310,-114) => @ORIENT("R90");
// #RGPP1_4__dmy0 @TEXT("RGPP1_4__dmy0",key="name",size=1.3,halign="start") => @PLACE(313,-111);
// #RGPP1_4__dmy0 @TEXT("l=17.13u w=1u multi=(1)",key="value",size=0.9,halign="start") => @PLACE(313,-118);
// #RGPP1_4__dmy0 @TEXT("",key="model");
// #RGPP1_5__dmy0 @SET-SYMBOL $RESISTOR;
// #RGPP1_5__dmy0 @PLACE(335,-114) => @ORIENT("R90");
// #RGPP1_5__dmy0 @TEXT("RGPP1_5__dmy0",key="name",size=1.3,halign="start") => @PLACE(338,-111);
// #RGPP1_5__dmy0 @TEXT("l=17.13u w=1u multi=(1)",key="value",size=0.9,halign="start") => @PLACE(338,-118);
// #RGPP1_5__dmy0 @TEXT("",key="model");
// (104,-99) @TEXT("GPP / 10 series poly sections",size=0.95,halign="start",textcolor="#223d52");
// &"GNNB" @WIRE(mode="straight",linecolor="#30485d",linewidth=0.16) {#XSTD_GNNCN:1 (61.5,0) (61.5,0) #XSTD_GNNBN:2};
// &"GNNDRV" @WIRE(mode="straight",linecolor="#30485d",linewidth=0.16) {#XSTD_GNNCN:2 (95.5,0) (95.5,0) #RGNN0:1};
// &"GNNA" @WIRE(mode="straight",linecolor="#30485d",linewidth=0.16) {#XSTD_GNNBN:1 (32.5,0) (32.5,0) #XSTD_GNNAN:2};
// &"GNNPRE" @WIRE(mode="straight",linecolor="#30485d",linewidth=0.16) {#XSTD_GNNAN:1 (0.5,0) (0.5,0) #X025:4};
// &"GNPB" @WIRE(mode="straight",linecolor="#30485d",linewidth=0.16) {#XSTD_GNPCN:1 (61.5,-38) (61.5,-38) #XSTD_GNPBN:2};
// &"GNPDRV" @WIRE(mode="straight",linecolor="#30485d",linewidth=0.16) {#XSTD_GNPCN:2 (95.5,-38) (95.5,-38) #RGNP0:1};
// &"GNPA" @WIRE(mode="straight",linecolor="#30485d",linewidth=0.16) {#XSTD_GNPBN:1 (32.5,-38) (32.5,-38) #XSTD_GNPAN:2};
// &"H" @WIRE(mode="straight",linecolor="#30485d",linewidth=0.16) {#XSTD_GNPAN:1 (-6.5,-38) (-6.5,-76) #X008:1};
// &"GPNB" @WIRE(mode="straight",linecolor="#30485d",linewidth=0.16) {#XSTD_GPNCN:1 (61.5,-76) (61.5,-76) #XSTD_GPNBN:2};
// &"GPNDRV" @WIRE(mode="straight",linecolor="#30485d",linewidth=0.16) {#XSTD_GPNCN:2 (95.5,-76) (95.5,-76) #RGPN0:1};
// &"GPNA" @WIRE(mode="straight",linecolor="#30485d",linewidth=0.16) {#XSTD_GPNBN:1 (32.5,-76) (32.5,-76) #XSTD_GPNAN:2};
// &"GPNPRE" @WIRE(mode="straight",linecolor="#30485d",linewidth=0.16) {#XSTD_GPNAN:1 (0.5,-76) (0.5,-76) #X008:4};
// &"GPPB" @WIRE(mode="straight",linecolor="#30485d",linewidth=0.16) {#XSTD_GPPCN:1 (61.5,-114) (61.5,-114) #XSTD_GPPBN:2};
// &"GPPDRV" @WIRE(mode="straight",linecolor="#30485d",linewidth=0.16) {#XSTD_GPPCN:2 (95.5,-114) (95.5,-114) #RGPP0:1};
// &"GPPA" @WIRE(mode="straight",linecolor="#30485d",linewidth=0.16) {#XSTD_GPPBN:1 (32.5,-114) (32.5,-114) #XSTD_GPPAN:2};
// &"GNNRG" @WIRE(mode="straight",linecolor="#30485d",linewidth=0.16) {#RGNN1:1 (222.5,0) (222.5,0) #RGNN0_5__dmy0:2};
// &"RGNN1_1__dmy0" @WIRE(mode="straight",linecolor="#30485d",linewidth=0.16) {#RGNN1:2 (247.5,0) (247.5,0) #RGNN1_2__dmy0:1};
// &"RGNN1_2__dmy0" @WIRE(mode="straight",linecolor="#30485d",linewidth=0.16) {#RGNN1_2__dmy0:2 (272.5,0) (272.5,0) #RGNN1_3__dmy0:1};
// &"RGNN1_3__dmy0" @WIRE(mode="straight",linecolor="#30485d",linewidth=0.16) {#RGNN1_3__dmy0:2 (297.5,0) (297.5,0) #RGNN1_4__dmy0:1};
// &"RGNN1_4__dmy0" @WIRE(mode="straight",linecolor="#30485d",linewidth=0.16) {#RGNN1_4__dmy0:2 (322.5,0) (322.5,0) #RGNN1_5__dmy0:1};
// &"RGNN0_1__dmy0" @WIRE(mode="straight",linecolor="#30485d",linewidth=0.16) {#RGNN0:2 (122.5,0) (122.5,0) #RGNN0_2__dmy0:1};
// &"RGNN0_2__dmy0" @WIRE(mode="straight",linecolor="#30485d",linewidth=0.16) {#RGNN0_2__dmy0:2 (147.5,0) (147.5,0) #RGNN0_3__dmy0:1};
// &"RGNN0_3__dmy0" @WIRE(mode="straight",linecolor="#30485d",linewidth=0.16) {#RGNN0_3__dmy0:2 (172.5,0) (172.5,0) #RGNN0_4__dmy0:1};
// &"RGNN0_4__dmy0" @WIRE(mode="straight",linecolor="#30485d",linewidth=0.16) {#RGNN0_4__dmy0:2 (197.5,0) (197.5,0) #RGNN0_5__dmy0:1};
// &"GNPRG" @WIRE(mode="straight",linecolor="#30485d",linewidth=0.16) {#RGNP1:1 (222.5,-38) (222.5,-38) #RGNP0_5__dmy0:2};
// &"RGNP1_1__dmy0" @WIRE(mode="straight",linecolor="#30485d",linewidth=0.16) {#RGNP1:2 (247.5,-38) (247.5,-38) #RGNP1_2__dmy0:1};
// &"RGNP1_2__dmy0" @WIRE(mode="straight",linecolor="#30485d",linewidth=0.16) {#RGNP1_2__dmy0:2 (272.5,-38) (272.5,-38) #RGNP1_3__dmy0:1};
// &"RGNP1_3__dmy0" @WIRE(mode="straight",linecolor="#30485d",linewidth=0.16) {#RGNP1_3__dmy0:2 (297.5,-38) (297.5,-38) #RGNP1_4__dmy0:1};
// &"RGNP1_4__dmy0" @WIRE(mode="straight",linecolor="#30485d",linewidth=0.16) {#RGNP1_4__dmy0:2 (322.5,-38) (322.5,-38) #RGNP1_5__dmy0:1};
// &"RGNP0_1__dmy0" @WIRE(mode="straight",linecolor="#30485d",linewidth=0.16) {#RGNP0:2 (122.5,-38) (122.5,-38) #RGNP0_2__dmy0:1};
// &"RGNP0_2__dmy0" @WIRE(mode="straight",linecolor="#30485d",linewidth=0.16) {#RGNP0_2__dmy0:2 (147.5,-38) (147.5,-38) #RGNP0_3__dmy0:1};
// &"RGNP0_3__dmy0" @WIRE(mode="straight",linecolor="#30485d",linewidth=0.16) {#RGNP0_3__dmy0:2 (172.5,-38) (172.5,-38) #RGNP0_4__dmy0:1};
// &"RGNP0_4__dmy0" @WIRE(mode="straight",linecolor="#30485d",linewidth=0.16) {#RGNP0_4__dmy0:2 (197.5,-38) (197.5,-38) #RGNP0_5__dmy0:1};
// &"GPNRG" @WIRE(mode="straight",linecolor="#30485d",linewidth=0.16) {#RGPN1:1 (222.5,-76) (222.5,-76) #RGPN0_5__dmy0:2};
// &"RGPN1_1__dmy0" @WIRE(mode="straight",linecolor="#30485d",linewidth=0.16) {#RGPN1:2 (247.5,-76) (247.5,-76) #RGPN1_2__dmy0:1};
// &"RGPN1_2__dmy0" @WIRE(mode="straight",linecolor="#30485d",linewidth=0.16) {#RGPN1_2__dmy0:2 (272.5,-76) (272.5,-76) #RGPN1_3__dmy0:1};
// &"RGPN1_3__dmy0" @WIRE(mode="straight",linecolor="#30485d",linewidth=0.16) {#RGPN1_3__dmy0:2 (297.5,-76) (297.5,-76) #RGPN1_4__dmy0:1};
// &"RGPN1_4__dmy0" @WIRE(mode="straight",linecolor="#30485d",linewidth=0.16) {#RGPN1_4__dmy0:2 (322.5,-76) (322.5,-76) #RGPN1_5__dmy0:1};
// &"RGPN0_1__dmy0" @WIRE(mode="straight",linecolor="#30485d",linewidth=0.16) {#RGPN0:2 (122.5,-76) (122.5,-76) #RGPN0_2__dmy0:1};
// &"RGPN0_2__dmy0" @WIRE(mode="straight",linecolor="#30485d",linewidth=0.16) {#RGPN0_2__dmy0:2 (147.5,-76) (147.5,-76) #RGPN0_3__dmy0:1};
// &"RGPN0_3__dmy0" @WIRE(mode="straight",linecolor="#30485d",linewidth=0.16) {#RGPN0_3__dmy0:2 (172.5,-76) (172.5,-76) #RGPN0_4__dmy0:1};
// &"RGPN0_4__dmy0" @WIRE(mode="straight",linecolor="#30485d",linewidth=0.16) {#RGPN0_4__dmy0:2 (197.5,-76) (197.5,-76) #RGPN0_5__dmy0:1};
// &"GPPRG" @WIRE(mode="straight",linecolor="#30485d",linewidth=0.16) {#RGPP1:1 (222.5,-114) (222.5,-114) #RGPP0_5__dmy0:2};
// &"RGPP1_1__dmy0" @WIRE(mode="straight",linecolor="#30485d",linewidth=0.16) {#RGPP1:2 (247.5,-114) (247.5,-114) #RGPP1_2__dmy0:1};
// &"RGPP1_2__dmy0" @WIRE(mode="straight",linecolor="#30485d",linewidth=0.16) {#RGPP1_2__dmy0:2 (272.5,-114) (272.5,-114) #RGPP1_3__dmy0:1};
// &"RGPP1_3__dmy0" @WIRE(mode="straight",linecolor="#30485d",linewidth=0.16) {#RGPP1_3__dmy0:2 (297.5,-114) (297.5,-114) #RGPP1_4__dmy0:1};
// &"RGPP1_4__dmy0" @WIRE(mode="straight",linecolor="#30485d",linewidth=0.16) {#RGPP1_4__dmy0:2 (322.5,-114) (322.5,-114) #RGPP1_5__dmy0:1};
// &"RGPP0_1__dmy0" @WIRE(mode="straight",linecolor="#30485d",linewidth=0.16) {#RGPP0:2 (122.5,-114) (122.5,-114) #RGPP0_2__dmy0:1};
// &"RGPP0_2__dmy0" @WIRE(mode="straight",linecolor="#30485d",linewidth=0.16) {#RGPP0_2__dmy0:2 (147.5,-114) (147.5,-114) #RGPP0_3__dmy0:1};
// &"RGPP0_3__dmy0" @WIRE(mode="straight",linecolor="#30485d",linewidth=0.16) {#RGPP0_3__dmy0:2 (172.5,-114) (172.5,-114) #RGPP0_4__dmy0:1};
// &"RGPP0_4__dmy0" @WIRE(mode="straight",linecolor="#30485d",linewidth=0.16) {#RGPP0_4__dmy0:2 (197.5,-114) (197.5,-114) #RGPP0_5__dmy0:1};
// (-28,-148) @TEXT("GP and GN chains keep their source polarity, device sizing and series R; no zero-delay abstraction.",size=1,halign="start",textcolor="#223d52");
// &"VDD" @WIRE(mode="straight",linecolor="#30485d",linewidth=0.16) {#XSTD_GNNCN:3 (76,10)};
// (76,10.4) @TEXT("VDD",size=1.1,halign="middle",valign="bottom");
// &"VSS" @WIRE(mode="straight",linecolor="#30485d",linewidth=0.16) {#XSTD_GNNCN:4 (76,-10)};
// (76,-10.4) @TEXT("VSS",size=1.1,halign="middle",valign="top");
// &"VDD" @WIRE(mode="straight",linecolor="#30485d",linewidth=0.16) {#XSTD_GNNBN:3 (47,10)};
// (47,10.4) @TEXT("VDD",size=1.1,halign="middle",valign="bottom");
// &"VSS" @WIRE(mode="straight",linecolor="#30485d",linewidth=0.16) {#XSTD_GNNBN:4 (47,-10)};
// (47,-10.4) @TEXT("VSS",size=1.1,halign="middle",valign="top");
// &"VDD" @WIRE(mode="straight",linecolor="#30485d",linewidth=0.16) {#XSTD_GNNAN:3 (18,10)};
// (18,10.4) @TEXT("VDD",size=1.1,halign="middle",valign="bottom");
// &"VSS" @WIRE(mode="straight",linecolor="#30485d",linewidth=0.16) {#XSTD_GNNAN:4 (18,-10)};
// (18,-10.4) @TEXT("VSS",size=1.1,halign="middle",valign="top");
// &"VDD" @WIRE(mode="straight",linecolor="#30485d",linewidth=0.16) {#XSTD_GNPCN:3 (76,-28)};
// (76,-27.6) @TEXT("VDD",size=1.1,halign="middle",valign="bottom");
// &"VSS" @WIRE(mode="straight",linecolor="#30485d",linewidth=0.16) {#XSTD_GNPCN:4 (76,-48)};
// (76,-48.4) @TEXT("VSS",size=1.1,halign="middle",valign="top");
// &"VDD" @WIRE(mode="straight",linecolor="#30485d",linewidth=0.16) {#XSTD_GNPBN:3 (47,-28)};
// (47,-27.6) @TEXT("VDD",size=1.1,halign="middle",valign="bottom");
// &"VSS" @WIRE(mode="straight",linecolor="#30485d",linewidth=0.16) {#XSTD_GNPBN:4 (47,-48)};
// (47,-48.4) @TEXT("VSS",size=1.1,halign="middle",valign="top");
// &"VDD" @WIRE(mode="straight",linecolor="#30485d",linewidth=0.16) {#XSTD_GNPAN:3 (18,-28)};
// (18,-27.6) @TEXT("VDD",size=1.1,halign="middle",valign="bottom");
// &"VSS" @WIRE(mode="straight",linecolor="#30485d",linewidth=0.16) {#XSTD_GNPAN:4 (18,-48)};
// (18,-48.4) @TEXT("VSS",size=1.1,halign="middle",valign="top");
// &"VDD" @WIRE(mode="straight",linecolor="#30485d",linewidth=0.16) {#XSTD_GPNCN:3 (76,-66)};
// (76,-65.6) @TEXT("VDD",size=1.1,halign="middle",valign="bottom");
// &"VSS" @WIRE(mode="straight",linecolor="#30485d",linewidth=0.16) {#XSTD_GPNCN:4 (76,-86)};
// (76,-86.4) @TEXT("VSS",size=1.1,halign="middle",valign="top");
// &"VDD" @WIRE(mode="straight",linecolor="#30485d",linewidth=0.16) {#XSTD_GPNBN:3 (47,-66)};
// (47,-65.6) @TEXT("VDD",size=1.1,halign="middle",valign="bottom");
// &"VSS" @WIRE(mode="straight",linecolor="#30485d",linewidth=0.16) {#XSTD_GPNBN:4 (47,-86)};
// (47,-86.4) @TEXT("VSS",size=1.1,halign="middle",valign="top");
// &"VDD" @WIRE(mode="straight",linecolor="#30485d",linewidth=0.16) {#XSTD_GPNAN:3 (18,-66)};
// (18,-65.6) @TEXT("VDD",size=1.1,halign="middle",valign="bottom");
// &"VSS" @WIRE(mode="straight",linecolor="#30485d",linewidth=0.16) {#XSTD_GPNAN:4 (18,-86)};
// (18,-86.4) @TEXT("VSS",size=1.1,halign="middle",valign="top");
// &"VDD" @WIRE(mode="straight",linecolor="#30485d",linewidth=0.16) {#XSTD_GPPCN:3 (76,-104)};
// (76,-103.6) @TEXT("VDD",size=1.1,halign="middle",valign="bottom");
// &"VSS" @WIRE(mode="straight",linecolor="#30485d",linewidth=0.16) {#XSTD_GPPCN:4 (76,-124)};
// (76,-124.4) @TEXT("VSS",size=1.1,halign="middle",valign="top");
// &"VDD" @WIRE(mode="straight",linecolor="#30485d",linewidth=0.16) {#XSTD_GPPBN:3 (47,-104)};
// (47,-103.6) @TEXT("VDD",size=1.1,halign="middle",valign="bottom");
// &"VSS" @WIRE(mode="straight",linecolor="#30485d",linewidth=0.16) {#XSTD_GPPBN:4 (47,-124)};
// (47,-124.4) @TEXT("VSS",size=1.1,halign="middle",valign="top");
// &"L" @WIRE(mode="straight",linecolor="#30485d",linewidth=0.16) {#XSTD_GPPAN:1 (8,-114)};
// (7.6,-114) @TEXT("L",size=1.1,halign="end",valign="middle");
// &"VDD" @WIRE(mode="straight",linecolor="#30485d",linewidth=0.16) {#XSTD_GPPAN:3 (18,-104)};
// (18,-103.6) @TEXT("VDD",size=1.1,halign="middle",valign="bottom");
// &"VSS" @WIRE(mode="straight",linecolor="#30485d",linewidth=0.16) {#XSTD_GPPAN:4 (18,-124)};
// (18,-124.4) @TEXT("VSS",size=1.1,halign="middle",valign="top");
// &"GNN" @WIRE(mode="straight",linecolor="#30485d",linewidth=0.16) {#RGNN1_5__dmy0:2 (340,0)};
// (340.4,0) @TEXT("GNN",size=1.1,halign="start",valign="middle");
// &"GNP" @WIRE(mode="straight",linecolor="#30485d",linewidth=0.16) {#RGNP1_5__dmy0:2 (340,-38)};
// (340.4,-38) @TEXT("GNP",size=1.1,halign="start",valign="middle");
// &"GPN" @WIRE(mode="straight",linecolor="#30485d",linewidth=0.16) {#RGPN1_5__dmy0:2 (340,-76)};
// (340.4,-76) @TEXT("GPN",size=1.1,halign="start",valign="middle");
// &"GPP" @WIRE(mode="straight",linecolor="#30485d",linewidth=0.16) {#RGPP1_5__dmy0:2 (340,-114)};
// (340.4,-114) @TEXT("GPP",size=1.1,halign="start",valign="middle");
// &"L" @WIRE(mode="straight",linecolor="#30485d",linewidth=0.16) {#X025:1 (-27,0)};
// (-27.4,0) @TEXT("L",size=1.1,halign="end",valign="middle");
// &"VDD" @WIRE(mode="straight",linecolor="#30485d",linewidth=0.16) {#X025:2 (-17,10)};
// (-17,10.4) @TEXT("VDD",size=1.1,halign="middle",valign="bottom");
// &"VSS" @WIRE(mode="straight",linecolor="#30485d",linewidth=0.16) {#X025:3 (-17,-10)};
// (-17,-10.4) @TEXT("VSS",size=1.1,halign="middle",valign="top");
// &"VDD" @WIRE(mode="straight",linecolor="#30485d",linewidth=0.16) {#X008:2 (-17,-66)};
// (-17,-65.6) @TEXT("VDD",size=1.1,halign="middle",valign="bottom");
// &"VSS" @WIRE(mode="straight",linecolor="#30485d",linewidth=0.16) {#X008:3 (-17,-86)};
// (-17,-86.4) @TEXT("VSS",size=1.1,halign="middle",valign="top");
// }
// END SARADC RNL
ends sar8p_refdrv_b5

subckt sar8p_refdrv_b6 GNN GNP GPN GPP H L VDD VSS
    XSTD_GNNCN (GNNB GNNDRV VDD VSS) INVD1BWP12T30P140
    XSTD_GNNBN (GNNA GNNB VDD VSS) INVD1BWP12T30P140
    XSTD_GNNAN (GNNPRE GNNA VDD VSS) INVD1BWP12T30P140
    XSTD_GNPCN (GNPB GNPDRV VDD VSS) INVD1BWP12T30P140
    XSTD_GNPBN (GNPA GNPB VDD VSS) INVD1BWP12T30P140
    XSTD_GNPAN (H GNPA VDD VSS) INVD1BWP12T30P140
    XSTD_GPNCN (GPNB GPNDRV VDD VSS) INVD1BWP12T30P140
    XSTD_GPNBN (GPNA GPNB VDD VSS) INVD1BWP12T30P140
    XSTD_GPNAN (GPNPRE GPNA VDD VSS) INVD1BWP12T30P140
    XSTD_GPPCN (GPPB GPPDRV VDD VSS) INVD1BWP12T30P140
    XSTD_GPPBN (GPPA GPPB VDD VSS) INVD1BWP12T30P140
    XSTD_GPPAN (L GPPA VDD VSS) INVD1BWP12T30P140
//Series configuration of RGNN1
RGNN1  (GNNRG RGNN1_1__dmy0 ) rupolym l=17.13u w=1u m=64 multi=(1)
RGNN1_2__dmy0  (RGNN1_1__dmy0 RGNN1_2__dmy0 ) rupolym l=17.13u w=1u m=64          multi=(1)
RGNN1_3__dmy0  (RGNN1_2__dmy0 RGNN1_3__dmy0 ) rupolym l=17.13u w=1u m=64          multi=(1)
RGNN1_4__dmy0  (RGNN1_3__dmy0 RGNN1_4__dmy0 ) rupolym l=17.13u w=1u m=64          multi=(1)
RGNN1_5__dmy0  (RGNN1_4__dmy0 GNN ) rupolym l=17.13u w=1u m=64 multi=(1)
//End of RGNN1

//Series configuration of RGNN0
RGNN0  (GNNDRV RGNN0_1__dmy0 ) rupolym l=17.13u w=1u m=64 multi=(1)
RGNN0_2__dmy0  (RGNN0_1__dmy0 RGNN0_2__dmy0 ) rupolym l=17.13u w=1u m=64          multi=(1)
RGNN0_3__dmy0  (RGNN0_2__dmy0 RGNN0_3__dmy0 ) rupolym l=17.13u w=1u m=64          multi=(1)
RGNN0_4__dmy0  (RGNN0_3__dmy0 RGNN0_4__dmy0 ) rupolym l=17.13u w=1u m=64          multi=(1)
RGNN0_5__dmy0  (RGNN0_4__dmy0 GNNRG ) rupolym l=17.13u w=1u m=64 multi=(1)
//End of RGNN0

//Series configuration of RGNP1
RGNP1  (GNPRG RGNP1_1__dmy0 ) rupolym l=17.13u w=1u m=64 multi=(1)
RGNP1_2__dmy0  (RGNP1_1__dmy0 RGNP1_2__dmy0 ) rupolym l=17.13u w=1u m=64          multi=(1)
RGNP1_3__dmy0  (RGNP1_2__dmy0 RGNP1_3__dmy0 ) rupolym l=17.13u w=1u m=64          multi=(1)
RGNP1_4__dmy0  (RGNP1_3__dmy0 RGNP1_4__dmy0 ) rupolym l=17.13u w=1u m=64          multi=(1)
RGNP1_5__dmy0  (RGNP1_4__dmy0 GNP ) rupolym l=17.13u w=1u m=64 multi=(1)
//End of RGNP1

//Series configuration of RGNP0
RGNP0  (GNPDRV RGNP0_1__dmy0 ) rupolym l=17.13u w=1u m=64 multi=(1)
RGNP0_2__dmy0  (RGNP0_1__dmy0 RGNP0_2__dmy0 ) rupolym l=17.13u w=1u m=64          multi=(1)
RGNP0_3__dmy0  (RGNP0_2__dmy0 RGNP0_3__dmy0 ) rupolym l=17.13u w=1u m=64          multi=(1)
RGNP0_4__dmy0  (RGNP0_3__dmy0 RGNP0_4__dmy0 ) rupolym l=17.13u w=1u m=64          multi=(1)
RGNP0_5__dmy0  (RGNP0_4__dmy0 GNPRG ) rupolym l=17.13u w=1u m=64 multi=(1)
//End of RGNP0

//Series configuration of RGPN1
RGPN1  (GPNRG RGPN1_1__dmy0 ) rupolym l=17.13u w=1u m=64 multi=(1)
RGPN1_2__dmy0  (RGPN1_1__dmy0 RGPN1_2__dmy0 ) rupolym l=17.13u w=1u m=64          multi=(1)
RGPN1_3__dmy0  (RGPN1_2__dmy0 RGPN1_3__dmy0 ) rupolym l=17.13u w=1u m=64          multi=(1)
RGPN1_4__dmy0  (RGPN1_3__dmy0 RGPN1_4__dmy0 ) rupolym l=17.13u w=1u m=64          multi=(1)
RGPN1_5__dmy0  (RGPN1_4__dmy0 GPN ) rupolym l=17.13u w=1u m=64 multi=(1)
//End of RGPN1

//Series configuration of RGPN0
RGPN0  (GPNDRV RGPN0_1__dmy0 ) rupolym l=17.13u w=1u m=64 multi=(1)
RGPN0_2__dmy0  (RGPN0_1__dmy0 RGPN0_2__dmy0 ) rupolym l=17.13u w=1u m=64          multi=(1)
RGPN0_3__dmy0  (RGPN0_2__dmy0 RGPN0_3__dmy0 ) rupolym l=17.13u w=1u m=64          multi=(1)
RGPN0_4__dmy0  (RGPN0_3__dmy0 RGPN0_4__dmy0 ) rupolym l=17.13u w=1u m=64          multi=(1)
RGPN0_5__dmy0  (RGPN0_4__dmy0 GPNRG ) rupolym l=17.13u w=1u m=64 multi=(1)
//End of RGPN0

//Series configuration of RGPP1
RGPP1  (GPPRG RGPP1_1__dmy0 ) rupolym l=17.13u w=1u m=64 multi=(1)
RGPP1_2__dmy0  (RGPP1_1__dmy0 RGPP1_2__dmy0 ) rupolym l=17.13u w=1u m=64          multi=(1)
RGPP1_3__dmy0  (RGPP1_2__dmy0 RGPP1_3__dmy0 ) rupolym l=17.13u w=1u m=64          multi=(1)
RGPP1_4__dmy0  (RGPP1_3__dmy0 RGPP1_4__dmy0 ) rupolym l=17.13u w=1u m=64          multi=(1)
RGPP1_5__dmy0  (RGPP1_4__dmy0 GPP ) rupolym l=17.13u w=1u m=64 multi=(1)
//End of RGPP1

//Series configuration of RGPP0
RGPP0  (GPPDRV RGPP0_1__dmy0 ) rupolym l=17.13u w=1u m=64 multi=(1)
RGPP0_2__dmy0  (RGPP0_1__dmy0 RGPP0_2__dmy0 ) rupolym l=17.13u w=1u m=64          multi=(1)
RGPP0_3__dmy0  (RGPP0_2__dmy0 RGPP0_3__dmy0 ) rupolym l=17.13u w=1u m=64          multi=(1)
RGPP0_4__dmy0  (RGPP0_3__dmy0 RGPP0_4__dmy0 ) rupolym l=17.13u w=1u m=64          multi=(1)
RGPP0_5__dmy0  (RGPP0_4__dmy0 GPPRG ) rupolym l=17.13u w=1u m=64 multi=(1)
//End of RGPP0

    X025 (L VDD VSS GNNPRE) sar8p_inv
    X008 (H VDD VSS GPNPRE) sar8p_inv
// BEGIN SARADC RNL
// @RNL(author="saradc topology") {
// (-28,27) @TEXT("sar8p_refdrv_b6 / four physical gate-driver chains",size=1.5,halign="start",textcolor="#223d52");
// #X025 @SET-SYMBOL $S_sar8p_inv;
// #X025 @PLACE(-17,0) => @ORIENT("R0");
// #XSTD_GNNAN @SET-SYMBOL $S_INVD1BWP12T30P140;
// #XSTD_GNNAN @PLACE(18,0) => @ORIENT("R0");
// #XSTD_GNNBN @SET-SYMBOL $S_INVD1BWP12T30P140;
// #XSTD_GNNBN @PLACE(47,0) => @ORIENT("R0");
// #XSTD_GNNCN @SET-SYMBOL $S_INVD1BWP12T30P140;
// #XSTD_GNNCN @PLACE(76,0) => @ORIENT("R0");
// #RGNN0 @SET-SYMBOL $RESISTOR;
// #RGNN0 @PLACE(110,0) => @ORIENT("R90");
// #RGNN0 @TEXT("RGNN0",key="name",size=1.3,halign="start") => @PLACE(113,3);
// #RGNN0 @TEXT("l=17.13u w=1u multi=(1)",key="value",size=0.9,halign="start") => @PLACE(113,-4);
// #RGNN0 @TEXT("",key="model");
// #RGNN0_2__dmy0 @SET-SYMBOL $RESISTOR;
// #RGNN0_2__dmy0 @PLACE(135,0) => @ORIENT("R90");
// #RGNN0_2__dmy0 @TEXT("RGNN0_2__dmy0",key="name",size=1.3,halign="start") => @PLACE(138,3);
// #RGNN0_2__dmy0 @TEXT("l=17.13u w=1u multi=(1)",key="value",size=0.9,halign="start") => @PLACE(138,-4);
// #RGNN0_2__dmy0 @TEXT("",key="model");
// #RGNN0_3__dmy0 @SET-SYMBOL $RESISTOR;
// #RGNN0_3__dmy0 @PLACE(160,0) => @ORIENT("R90");
// #RGNN0_3__dmy0 @TEXT("RGNN0_3__dmy0",key="name",size=1.3,halign="start") => @PLACE(163,3);
// #RGNN0_3__dmy0 @TEXT("l=17.13u w=1u multi=(1)",key="value",size=0.9,halign="start") => @PLACE(163,-4);
// #RGNN0_3__dmy0 @TEXT("",key="model");
// #RGNN0_4__dmy0 @SET-SYMBOL $RESISTOR;
// #RGNN0_4__dmy0 @PLACE(185,0) => @ORIENT("R90");
// #RGNN0_4__dmy0 @TEXT("RGNN0_4__dmy0",key="name",size=1.3,halign="start") => @PLACE(188,3);
// #RGNN0_4__dmy0 @TEXT("l=17.13u w=1u multi=(1)",key="value",size=0.9,halign="start") => @PLACE(188,-4);
// #RGNN0_4__dmy0 @TEXT("",key="model");
// #RGNN0_5__dmy0 @SET-SYMBOL $RESISTOR;
// #RGNN0_5__dmy0 @PLACE(210,0) => @ORIENT("R90");
// #RGNN0_5__dmy0 @TEXT("RGNN0_5__dmy0",key="name",size=1.3,halign="start") => @PLACE(213,3);
// #RGNN0_5__dmy0 @TEXT("l=17.13u w=1u multi=(1)",key="value",size=0.9,halign="start") => @PLACE(213,-4);
// #RGNN0_5__dmy0 @TEXT("",key="model");
// #RGNN1 @SET-SYMBOL $RESISTOR;
// #RGNN1 @PLACE(235,0) => @ORIENT("R90");
// #RGNN1 @TEXT("RGNN1",key="name",size=1.3,halign="start") => @PLACE(238,3);
// #RGNN1 @TEXT("l=17.13u w=1u multi=(1)",key="value",size=0.9,halign="start") => @PLACE(238,-4);
// #RGNN1 @TEXT("",key="model");
// #RGNN1_2__dmy0 @SET-SYMBOL $RESISTOR;
// #RGNN1_2__dmy0 @PLACE(260,0) => @ORIENT("R90");
// #RGNN1_2__dmy0 @TEXT("RGNN1_2__dmy0",key="name",size=1.3,halign="start") => @PLACE(263,3);
// #RGNN1_2__dmy0 @TEXT("l=17.13u w=1u multi=(1)",key="value",size=0.9,halign="start") => @PLACE(263,-4);
// #RGNN1_2__dmy0 @TEXT("",key="model");
// #RGNN1_3__dmy0 @SET-SYMBOL $RESISTOR;
// #RGNN1_3__dmy0 @PLACE(285,0) => @ORIENT("R90");
// #RGNN1_3__dmy0 @TEXT("RGNN1_3__dmy0",key="name",size=1.3,halign="start") => @PLACE(288,3);
// #RGNN1_3__dmy0 @TEXT("l=17.13u w=1u multi=(1)",key="value",size=0.9,halign="start") => @PLACE(288,-4);
// #RGNN1_3__dmy0 @TEXT("",key="model");
// #RGNN1_4__dmy0 @SET-SYMBOL $RESISTOR;
// #RGNN1_4__dmy0 @PLACE(310,0) => @ORIENT("R90");
// #RGNN1_4__dmy0 @TEXT("RGNN1_4__dmy0",key="name",size=1.3,halign="start") => @PLACE(313,3);
// #RGNN1_4__dmy0 @TEXT("l=17.13u w=1u multi=(1)",key="value",size=0.9,halign="start") => @PLACE(313,-4);
// #RGNN1_4__dmy0 @TEXT("",key="model");
// #RGNN1_5__dmy0 @SET-SYMBOL $RESISTOR;
// #RGNN1_5__dmy0 @PLACE(335,0) => @ORIENT("R90");
// #RGNN1_5__dmy0 @TEXT("RGNN1_5__dmy0",key="name",size=1.3,halign="start") => @PLACE(338,3);
// #RGNN1_5__dmy0 @TEXT("l=17.13u w=1u multi=(1)",key="value",size=0.9,halign="start") => @PLACE(338,-4);
// #RGNN1_5__dmy0 @TEXT("",key="model");
// (104,15) @TEXT("GNN / 10 series poly sections",size=0.95,halign="start",textcolor="#223d52");
// #XSTD_GNPAN @SET-SYMBOL $S_INVD1BWP12T30P140;
// #XSTD_GNPAN @PLACE(18,-38) => @ORIENT("R0");
// #XSTD_GNPBN @SET-SYMBOL $S_INVD1BWP12T30P140;
// #XSTD_GNPBN @PLACE(47,-38) => @ORIENT("R0");
// #XSTD_GNPCN @SET-SYMBOL $S_INVD1BWP12T30P140;
// #XSTD_GNPCN @PLACE(76,-38) => @ORIENT("R0");
// #RGNP0 @SET-SYMBOL $RESISTOR;
// #RGNP0 @PLACE(110,-38) => @ORIENT("R90");
// #RGNP0 @TEXT("RGNP0",key="name",size=1.3,halign="start") => @PLACE(113,-35);
// #RGNP0 @TEXT("l=17.13u w=1u multi=(1)",key="value",size=0.9,halign="start") => @PLACE(113,-42);
// #RGNP0 @TEXT("",key="model");
// #RGNP0_2__dmy0 @SET-SYMBOL $RESISTOR;
// #RGNP0_2__dmy0 @PLACE(135,-38) => @ORIENT("R90");
// #RGNP0_2__dmy0 @TEXT("RGNP0_2__dmy0",key="name",size=1.3,halign="start") => @PLACE(138,-35);
// #RGNP0_2__dmy0 @TEXT("l=17.13u w=1u multi=(1)",key="value",size=0.9,halign="start") => @PLACE(138,-42);
// #RGNP0_2__dmy0 @TEXT("",key="model");
// #RGNP0_3__dmy0 @SET-SYMBOL $RESISTOR;
// #RGNP0_3__dmy0 @PLACE(160,-38) => @ORIENT("R90");
// #RGNP0_3__dmy0 @TEXT("RGNP0_3__dmy0",key="name",size=1.3,halign="start") => @PLACE(163,-35);
// #RGNP0_3__dmy0 @TEXT("l=17.13u w=1u multi=(1)",key="value",size=0.9,halign="start") => @PLACE(163,-42);
// #RGNP0_3__dmy0 @TEXT("",key="model");
// #RGNP0_4__dmy0 @SET-SYMBOL $RESISTOR;
// #RGNP0_4__dmy0 @PLACE(185,-38) => @ORIENT("R90");
// #RGNP0_4__dmy0 @TEXT("RGNP0_4__dmy0",key="name",size=1.3,halign="start") => @PLACE(188,-35);
// #RGNP0_4__dmy0 @TEXT("l=17.13u w=1u multi=(1)",key="value",size=0.9,halign="start") => @PLACE(188,-42);
// #RGNP0_4__dmy0 @TEXT("",key="model");
// #RGNP0_5__dmy0 @SET-SYMBOL $RESISTOR;
// #RGNP0_5__dmy0 @PLACE(210,-38) => @ORIENT("R90");
// #RGNP0_5__dmy0 @TEXT("RGNP0_5__dmy0",key="name",size=1.3,halign="start") => @PLACE(213,-35);
// #RGNP0_5__dmy0 @TEXT("l=17.13u w=1u multi=(1)",key="value",size=0.9,halign="start") => @PLACE(213,-42);
// #RGNP0_5__dmy0 @TEXT("",key="model");
// #RGNP1 @SET-SYMBOL $RESISTOR;
// #RGNP1 @PLACE(235,-38) => @ORIENT("R90");
// #RGNP1 @TEXT("RGNP1",key="name",size=1.3,halign="start") => @PLACE(238,-35);
// #RGNP1 @TEXT("l=17.13u w=1u multi=(1)",key="value",size=0.9,halign="start") => @PLACE(238,-42);
// #RGNP1 @TEXT("",key="model");
// #RGNP1_2__dmy0 @SET-SYMBOL $RESISTOR;
// #RGNP1_2__dmy0 @PLACE(260,-38) => @ORIENT("R90");
// #RGNP1_2__dmy0 @TEXT("RGNP1_2__dmy0",key="name",size=1.3,halign="start") => @PLACE(263,-35);
// #RGNP1_2__dmy0 @TEXT("l=17.13u w=1u multi=(1)",key="value",size=0.9,halign="start") => @PLACE(263,-42);
// #RGNP1_2__dmy0 @TEXT("",key="model");
// #RGNP1_3__dmy0 @SET-SYMBOL $RESISTOR;
// #RGNP1_3__dmy0 @PLACE(285,-38) => @ORIENT("R90");
// #RGNP1_3__dmy0 @TEXT("RGNP1_3__dmy0",key="name",size=1.3,halign="start") => @PLACE(288,-35);
// #RGNP1_3__dmy0 @TEXT("l=17.13u w=1u multi=(1)",key="value",size=0.9,halign="start") => @PLACE(288,-42);
// #RGNP1_3__dmy0 @TEXT("",key="model");
// #RGNP1_4__dmy0 @SET-SYMBOL $RESISTOR;
// #RGNP1_4__dmy0 @PLACE(310,-38) => @ORIENT("R90");
// #RGNP1_4__dmy0 @TEXT("RGNP1_4__dmy0",key="name",size=1.3,halign="start") => @PLACE(313,-35);
// #RGNP1_4__dmy0 @TEXT("l=17.13u w=1u multi=(1)",key="value",size=0.9,halign="start") => @PLACE(313,-42);
// #RGNP1_4__dmy0 @TEXT("",key="model");
// #RGNP1_5__dmy0 @SET-SYMBOL $RESISTOR;
// #RGNP1_5__dmy0 @PLACE(335,-38) => @ORIENT("R90");
// #RGNP1_5__dmy0 @TEXT("RGNP1_5__dmy0",key="name",size=1.3,halign="start") => @PLACE(338,-35);
// #RGNP1_5__dmy0 @TEXT("l=17.13u w=1u multi=(1)",key="value",size=0.9,halign="start") => @PLACE(338,-42);
// #RGNP1_5__dmy0 @TEXT("",key="model");
// (104,-23) @TEXT("GNP / 10 series poly sections",size=0.95,halign="start",textcolor="#223d52");
// #X008 @SET-SYMBOL $S_sar8p_inv;
// #X008 @PLACE(-17,-76) => @ORIENT("R0");
// #XSTD_GPNAN @SET-SYMBOL $S_INVD1BWP12T30P140;
// #XSTD_GPNAN @PLACE(18,-76) => @ORIENT("R0");
// #XSTD_GPNBN @SET-SYMBOL $S_INVD1BWP12T30P140;
// #XSTD_GPNBN @PLACE(47,-76) => @ORIENT("R0");
// #XSTD_GPNCN @SET-SYMBOL $S_INVD1BWP12T30P140;
// #XSTD_GPNCN @PLACE(76,-76) => @ORIENT("R0");
// #RGPN0 @SET-SYMBOL $RESISTOR;
// #RGPN0 @PLACE(110,-76) => @ORIENT("R90");
// #RGPN0 @TEXT("RGPN0",key="name",size=1.3,halign="start") => @PLACE(113,-73);
// #RGPN0 @TEXT("l=17.13u w=1u multi=(1)",key="value",size=0.9,halign="start") => @PLACE(113,-80);
// #RGPN0 @TEXT("",key="model");
// #RGPN0_2__dmy0 @SET-SYMBOL $RESISTOR;
// #RGPN0_2__dmy0 @PLACE(135,-76) => @ORIENT("R90");
// #RGPN0_2__dmy0 @TEXT("RGPN0_2__dmy0",key="name",size=1.3,halign="start") => @PLACE(138,-73);
// #RGPN0_2__dmy0 @TEXT("l=17.13u w=1u multi=(1)",key="value",size=0.9,halign="start") => @PLACE(138,-80);
// #RGPN0_2__dmy0 @TEXT("",key="model");
// #RGPN0_3__dmy0 @SET-SYMBOL $RESISTOR;
// #RGPN0_3__dmy0 @PLACE(160,-76) => @ORIENT("R90");
// #RGPN0_3__dmy0 @TEXT("RGPN0_3__dmy0",key="name",size=1.3,halign="start") => @PLACE(163,-73);
// #RGPN0_3__dmy0 @TEXT("l=17.13u w=1u multi=(1)",key="value",size=0.9,halign="start") => @PLACE(163,-80);
// #RGPN0_3__dmy0 @TEXT("",key="model");
// #RGPN0_4__dmy0 @SET-SYMBOL $RESISTOR;
// #RGPN0_4__dmy0 @PLACE(185,-76) => @ORIENT("R90");
// #RGPN0_4__dmy0 @TEXT("RGPN0_4__dmy0",key="name",size=1.3,halign="start") => @PLACE(188,-73);
// #RGPN0_4__dmy0 @TEXT("l=17.13u w=1u multi=(1)",key="value",size=0.9,halign="start") => @PLACE(188,-80);
// #RGPN0_4__dmy0 @TEXT("",key="model");
// #RGPN0_5__dmy0 @SET-SYMBOL $RESISTOR;
// #RGPN0_5__dmy0 @PLACE(210,-76) => @ORIENT("R90");
// #RGPN0_5__dmy0 @TEXT("RGPN0_5__dmy0",key="name",size=1.3,halign="start") => @PLACE(213,-73);
// #RGPN0_5__dmy0 @TEXT("l=17.13u w=1u multi=(1)",key="value",size=0.9,halign="start") => @PLACE(213,-80);
// #RGPN0_5__dmy0 @TEXT("",key="model");
// #RGPN1 @SET-SYMBOL $RESISTOR;
// #RGPN1 @PLACE(235,-76) => @ORIENT("R90");
// #RGPN1 @TEXT("RGPN1",key="name",size=1.3,halign="start") => @PLACE(238,-73);
// #RGPN1 @TEXT("l=17.13u w=1u multi=(1)",key="value",size=0.9,halign="start") => @PLACE(238,-80);
// #RGPN1 @TEXT("",key="model");
// #RGPN1_2__dmy0 @SET-SYMBOL $RESISTOR;
// #RGPN1_2__dmy0 @PLACE(260,-76) => @ORIENT("R90");
// #RGPN1_2__dmy0 @TEXT("RGPN1_2__dmy0",key="name",size=1.3,halign="start") => @PLACE(263,-73);
// #RGPN1_2__dmy0 @TEXT("l=17.13u w=1u multi=(1)",key="value",size=0.9,halign="start") => @PLACE(263,-80);
// #RGPN1_2__dmy0 @TEXT("",key="model");
// #RGPN1_3__dmy0 @SET-SYMBOL $RESISTOR;
// #RGPN1_3__dmy0 @PLACE(285,-76) => @ORIENT("R90");
// #RGPN1_3__dmy0 @TEXT("RGPN1_3__dmy0",key="name",size=1.3,halign="start") => @PLACE(288,-73);
// #RGPN1_3__dmy0 @TEXT("l=17.13u w=1u multi=(1)",key="value",size=0.9,halign="start") => @PLACE(288,-80);
// #RGPN1_3__dmy0 @TEXT("",key="model");
// #RGPN1_4__dmy0 @SET-SYMBOL $RESISTOR;
// #RGPN1_4__dmy0 @PLACE(310,-76) => @ORIENT("R90");
// #RGPN1_4__dmy0 @TEXT("RGPN1_4__dmy0",key="name",size=1.3,halign="start") => @PLACE(313,-73);
// #RGPN1_4__dmy0 @TEXT("l=17.13u w=1u multi=(1)",key="value",size=0.9,halign="start") => @PLACE(313,-80);
// #RGPN1_4__dmy0 @TEXT("",key="model");
// #RGPN1_5__dmy0 @SET-SYMBOL $RESISTOR;
// #RGPN1_5__dmy0 @PLACE(335,-76) => @ORIENT("R90");
// #RGPN1_5__dmy0 @TEXT("RGPN1_5__dmy0",key="name",size=1.3,halign="start") => @PLACE(338,-73);
// #RGPN1_5__dmy0 @TEXT("l=17.13u w=1u multi=(1)",key="value",size=0.9,halign="start") => @PLACE(338,-80);
// #RGPN1_5__dmy0 @TEXT("",key="model");
// (104,-61) @TEXT("GPN / 10 series poly sections",size=0.95,halign="start",textcolor="#223d52");
// #XSTD_GPPAN @SET-SYMBOL $S_INVD1BWP12T30P140;
// #XSTD_GPPAN @PLACE(18,-114) => @ORIENT("R0");
// #XSTD_GPPBN @SET-SYMBOL $S_INVD1BWP12T30P140;
// #XSTD_GPPBN @PLACE(47,-114) => @ORIENT("R0");
// #XSTD_GPPCN @SET-SYMBOL $S_INVD1BWP12T30P140;
// #XSTD_GPPCN @PLACE(76,-114) => @ORIENT("R0");
// #RGPP0 @SET-SYMBOL $RESISTOR;
// #RGPP0 @PLACE(110,-114) => @ORIENT("R90");
// #RGPP0 @TEXT("RGPP0",key="name",size=1.3,halign="start") => @PLACE(113,-111);
// #RGPP0 @TEXT("l=17.13u w=1u multi=(1)",key="value",size=0.9,halign="start") => @PLACE(113,-118);
// #RGPP0 @TEXT("",key="model");
// #RGPP0_2__dmy0 @SET-SYMBOL $RESISTOR;
// #RGPP0_2__dmy0 @PLACE(135,-114) => @ORIENT("R90");
// #RGPP0_2__dmy0 @TEXT("RGPP0_2__dmy0",key="name",size=1.3,halign="start") => @PLACE(138,-111);
// #RGPP0_2__dmy0 @TEXT("l=17.13u w=1u multi=(1)",key="value",size=0.9,halign="start") => @PLACE(138,-118);
// #RGPP0_2__dmy0 @TEXT("",key="model");
// #RGPP0_3__dmy0 @SET-SYMBOL $RESISTOR;
// #RGPP0_3__dmy0 @PLACE(160,-114) => @ORIENT("R90");
// #RGPP0_3__dmy0 @TEXT("RGPP0_3__dmy0",key="name",size=1.3,halign="start") => @PLACE(163,-111);
// #RGPP0_3__dmy0 @TEXT("l=17.13u w=1u multi=(1)",key="value",size=0.9,halign="start") => @PLACE(163,-118);
// #RGPP0_3__dmy0 @TEXT("",key="model");
// #RGPP0_4__dmy0 @SET-SYMBOL $RESISTOR;
// #RGPP0_4__dmy0 @PLACE(185,-114) => @ORIENT("R90");
// #RGPP0_4__dmy0 @TEXT("RGPP0_4__dmy0",key="name",size=1.3,halign="start") => @PLACE(188,-111);
// #RGPP0_4__dmy0 @TEXT("l=17.13u w=1u multi=(1)",key="value",size=0.9,halign="start") => @PLACE(188,-118);
// #RGPP0_4__dmy0 @TEXT("",key="model");
// #RGPP0_5__dmy0 @SET-SYMBOL $RESISTOR;
// #RGPP0_5__dmy0 @PLACE(210,-114) => @ORIENT("R90");
// #RGPP0_5__dmy0 @TEXT("RGPP0_5__dmy0",key="name",size=1.3,halign="start") => @PLACE(213,-111);
// #RGPP0_5__dmy0 @TEXT("l=17.13u w=1u multi=(1)",key="value",size=0.9,halign="start") => @PLACE(213,-118);
// #RGPP0_5__dmy0 @TEXT("",key="model");
// #RGPP1 @SET-SYMBOL $RESISTOR;
// #RGPP1 @PLACE(235,-114) => @ORIENT("R90");
// #RGPP1 @TEXT("RGPP1",key="name",size=1.3,halign="start") => @PLACE(238,-111);
// #RGPP1 @TEXT("l=17.13u w=1u multi=(1)",key="value",size=0.9,halign="start") => @PLACE(238,-118);
// #RGPP1 @TEXT("",key="model");
// #RGPP1_2__dmy0 @SET-SYMBOL $RESISTOR;
// #RGPP1_2__dmy0 @PLACE(260,-114) => @ORIENT("R90");
// #RGPP1_2__dmy0 @TEXT("RGPP1_2__dmy0",key="name",size=1.3,halign="start") => @PLACE(263,-111);
// #RGPP1_2__dmy0 @TEXT("l=17.13u w=1u multi=(1)",key="value",size=0.9,halign="start") => @PLACE(263,-118);
// #RGPP1_2__dmy0 @TEXT("",key="model");
// #RGPP1_3__dmy0 @SET-SYMBOL $RESISTOR;
// #RGPP1_3__dmy0 @PLACE(285,-114) => @ORIENT("R90");
// #RGPP1_3__dmy0 @TEXT("RGPP1_3__dmy0",key="name",size=1.3,halign="start") => @PLACE(288,-111);
// #RGPP1_3__dmy0 @TEXT("l=17.13u w=1u multi=(1)",key="value",size=0.9,halign="start") => @PLACE(288,-118);
// #RGPP1_3__dmy0 @TEXT("",key="model");
// #RGPP1_4__dmy0 @SET-SYMBOL $RESISTOR;
// #RGPP1_4__dmy0 @PLACE(310,-114) => @ORIENT("R90");
// #RGPP1_4__dmy0 @TEXT("RGPP1_4__dmy0",key="name",size=1.3,halign="start") => @PLACE(313,-111);
// #RGPP1_4__dmy0 @TEXT("l=17.13u w=1u multi=(1)",key="value",size=0.9,halign="start") => @PLACE(313,-118);
// #RGPP1_4__dmy0 @TEXT("",key="model");
// #RGPP1_5__dmy0 @SET-SYMBOL $RESISTOR;
// #RGPP1_5__dmy0 @PLACE(335,-114) => @ORIENT("R90");
// #RGPP1_5__dmy0 @TEXT("RGPP1_5__dmy0",key="name",size=1.3,halign="start") => @PLACE(338,-111);
// #RGPP1_5__dmy0 @TEXT("l=17.13u w=1u multi=(1)",key="value",size=0.9,halign="start") => @PLACE(338,-118);
// #RGPP1_5__dmy0 @TEXT("",key="model");
// (104,-99) @TEXT("GPP / 10 series poly sections",size=0.95,halign="start",textcolor="#223d52");
// &"GNNB" @WIRE(mode="straight",linecolor="#30485d",linewidth=0.16) {#XSTD_GNNCN:1 (61.5,0) (61.5,0) #XSTD_GNNBN:2};
// &"GNNDRV" @WIRE(mode="straight",linecolor="#30485d",linewidth=0.16) {#XSTD_GNNCN:2 (95.5,0) (95.5,0) #RGNN0:1};
// &"GNNA" @WIRE(mode="straight",linecolor="#30485d",linewidth=0.16) {#XSTD_GNNBN:1 (32.5,0) (32.5,0) #XSTD_GNNAN:2};
// &"GNNPRE" @WIRE(mode="straight",linecolor="#30485d",linewidth=0.16) {#XSTD_GNNAN:1 (0.5,0) (0.5,0) #X025:4};
// &"GNPB" @WIRE(mode="straight",linecolor="#30485d",linewidth=0.16) {#XSTD_GNPCN:1 (61.5,-38) (61.5,-38) #XSTD_GNPBN:2};
// &"GNPDRV" @WIRE(mode="straight",linecolor="#30485d",linewidth=0.16) {#XSTD_GNPCN:2 (95.5,-38) (95.5,-38) #RGNP0:1};
// &"GNPA" @WIRE(mode="straight",linecolor="#30485d",linewidth=0.16) {#XSTD_GNPBN:1 (32.5,-38) (32.5,-38) #XSTD_GNPAN:2};
// &"H" @WIRE(mode="straight",linecolor="#30485d",linewidth=0.16) {#XSTD_GNPAN:1 (-6.5,-38) (-6.5,-76) #X008:1};
// &"GPNB" @WIRE(mode="straight",linecolor="#30485d",linewidth=0.16) {#XSTD_GPNCN:1 (61.5,-76) (61.5,-76) #XSTD_GPNBN:2};
// &"GPNDRV" @WIRE(mode="straight",linecolor="#30485d",linewidth=0.16) {#XSTD_GPNCN:2 (95.5,-76) (95.5,-76) #RGPN0:1};
// &"GPNA" @WIRE(mode="straight",linecolor="#30485d",linewidth=0.16) {#XSTD_GPNBN:1 (32.5,-76) (32.5,-76) #XSTD_GPNAN:2};
// &"GPNPRE" @WIRE(mode="straight",linecolor="#30485d",linewidth=0.16) {#XSTD_GPNAN:1 (0.5,-76) (0.5,-76) #X008:4};
// &"GPPB" @WIRE(mode="straight",linecolor="#30485d",linewidth=0.16) {#XSTD_GPPCN:1 (61.5,-114) (61.5,-114) #XSTD_GPPBN:2};
// &"GPPDRV" @WIRE(mode="straight",linecolor="#30485d",linewidth=0.16) {#XSTD_GPPCN:2 (95.5,-114) (95.5,-114) #RGPP0:1};
// &"GPPA" @WIRE(mode="straight",linecolor="#30485d",linewidth=0.16) {#XSTD_GPPBN:1 (32.5,-114) (32.5,-114) #XSTD_GPPAN:2};
// &"GNNRG" @WIRE(mode="straight",linecolor="#30485d",linewidth=0.16) {#RGNN1:1 (222.5,0) (222.5,0) #RGNN0_5__dmy0:2};
// &"RGNN1_1__dmy0" @WIRE(mode="straight",linecolor="#30485d",linewidth=0.16) {#RGNN1:2 (247.5,0) (247.5,0) #RGNN1_2__dmy0:1};
// &"RGNN1_2__dmy0" @WIRE(mode="straight",linecolor="#30485d",linewidth=0.16) {#RGNN1_2__dmy0:2 (272.5,0) (272.5,0) #RGNN1_3__dmy0:1};
// &"RGNN1_3__dmy0" @WIRE(mode="straight",linecolor="#30485d",linewidth=0.16) {#RGNN1_3__dmy0:2 (297.5,0) (297.5,0) #RGNN1_4__dmy0:1};
// &"RGNN1_4__dmy0" @WIRE(mode="straight",linecolor="#30485d",linewidth=0.16) {#RGNN1_4__dmy0:2 (322.5,0) (322.5,0) #RGNN1_5__dmy0:1};
// &"RGNN0_1__dmy0" @WIRE(mode="straight",linecolor="#30485d",linewidth=0.16) {#RGNN0:2 (122.5,0) (122.5,0) #RGNN0_2__dmy0:1};
// &"RGNN0_2__dmy0" @WIRE(mode="straight",linecolor="#30485d",linewidth=0.16) {#RGNN0_2__dmy0:2 (147.5,0) (147.5,0) #RGNN0_3__dmy0:1};
// &"RGNN0_3__dmy0" @WIRE(mode="straight",linecolor="#30485d",linewidth=0.16) {#RGNN0_3__dmy0:2 (172.5,0) (172.5,0) #RGNN0_4__dmy0:1};
// &"RGNN0_4__dmy0" @WIRE(mode="straight",linecolor="#30485d",linewidth=0.16) {#RGNN0_4__dmy0:2 (197.5,0) (197.5,0) #RGNN0_5__dmy0:1};
// &"GNPRG" @WIRE(mode="straight",linecolor="#30485d",linewidth=0.16) {#RGNP1:1 (222.5,-38) (222.5,-38) #RGNP0_5__dmy0:2};
// &"RGNP1_1__dmy0" @WIRE(mode="straight",linecolor="#30485d",linewidth=0.16) {#RGNP1:2 (247.5,-38) (247.5,-38) #RGNP1_2__dmy0:1};
// &"RGNP1_2__dmy0" @WIRE(mode="straight",linecolor="#30485d",linewidth=0.16) {#RGNP1_2__dmy0:2 (272.5,-38) (272.5,-38) #RGNP1_3__dmy0:1};
// &"RGNP1_3__dmy0" @WIRE(mode="straight",linecolor="#30485d",linewidth=0.16) {#RGNP1_3__dmy0:2 (297.5,-38) (297.5,-38) #RGNP1_4__dmy0:1};
// &"RGNP1_4__dmy0" @WIRE(mode="straight",linecolor="#30485d",linewidth=0.16) {#RGNP1_4__dmy0:2 (322.5,-38) (322.5,-38) #RGNP1_5__dmy0:1};
// &"RGNP0_1__dmy0" @WIRE(mode="straight",linecolor="#30485d",linewidth=0.16) {#RGNP0:2 (122.5,-38) (122.5,-38) #RGNP0_2__dmy0:1};
// &"RGNP0_2__dmy0" @WIRE(mode="straight",linecolor="#30485d",linewidth=0.16) {#RGNP0_2__dmy0:2 (147.5,-38) (147.5,-38) #RGNP0_3__dmy0:1};
// &"RGNP0_3__dmy0" @WIRE(mode="straight",linecolor="#30485d",linewidth=0.16) {#RGNP0_3__dmy0:2 (172.5,-38) (172.5,-38) #RGNP0_4__dmy0:1};
// &"RGNP0_4__dmy0" @WIRE(mode="straight",linecolor="#30485d",linewidth=0.16) {#RGNP0_4__dmy0:2 (197.5,-38) (197.5,-38) #RGNP0_5__dmy0:1};
// &"GPNRG" @WIRE(mode="straight",linecolor="#30485d",linewidth=0.16) {#RGPN1:1 (222.5,-76) (222.5,-76) #RGPN0_5__dmy0:2};
// &"RGPN1_1__dmy0" @WIRE(mode="straight",linecolor="#30485d",linewidth=0.16) {#RGPN1:2 (247.5,-76) (247.5,-76) #RGPN1_2__dmy0:1};
// &"RGPN1_2__dmy0" @WIRE(mode="straight",linecolor="#30485d",linewidth=0.16) {#RGPN1_2__dmy0:2 (272.5,-76) (272.5,-76) #RGPN1_3__dmy0:1};
// &"RGPN1_3__dmy0" @WIRE(mode="straight",linecolor="#30485d",linewidth=0.16) {#RGPN1_3__dmy0:2 (297.5,-76) (297.5,-76) #RGPN1_4__dmy0:1};
// &"RGPN1_4__dmy0" @WIRE(mode="straight",linecolor="#30485d",linewidth=0.16) {#RGPN1_4__dmy0:2 (322.5,-76) (322.5,-76) #RGPN1_5__dmy0:1};
// &"RGPN0_1__dmy0" @WIRE(mode="straight",linecolor="#30485d",linewidth=0.16) {#RGPN0:2 (122.5,-76) (122.5,-76) #RGPN0_2__dmy0:1};
// &"RGPN0_2__dmy0" @WIRE(mode="straight",linecolor="#30485d",linewidth=0.16) {#RGPN0_2__dmy0:2 (147.5,-76) (147.5,-76) #RGPN0_3__dmy0:1};
// &"RGPN0_3__dmy0" @WIRE(mode="straight",linecolor="#30485d",linewidth=0.16) {#RGPN0_3__dmy0:2 (172.5,-76) (172.5,-76) #RGPN0_4__dmy0:1};
// &"RGPN0_4__dmy0" @WIRE(mode="straight",linecolor="#30485d",linewidth=0.16) {#RGPN0_4__dmy0:2 (197.5,-76) (197.5,-76) #RGPN0_5__dmy0:1};
// &"GPPRG" @WIRE(mode="straight",linecolor="#30485d",linewidth=0.16) {#RGPP1:1 (222.5,-114) (222.5,-114) #RGPP0_5__dmy0:2};
// &"RGPP1_1__dmy0" @WIRE(mode="straight",linecolor="#30485d",linewidth=0.16) {#RGPP1:2 (247.5,-114) (247.5,-114) #RGPP1_2__dmy0:1};
// &"RGPP1_2__dmy0" @WIRE(mode="straight",linecolor="#30485d",linewidth=0.16) {#RGPP1_2__dmy0:2 (272.5,-114) (272.5,-114) #RGPP1_3__dmy0:1};
// &"RGPP1_3__dmy0" @WIRE(mode="straight",linecolor="#30485d",linewidth=0.16) {#RGPP1_3__dmy0:2 (297.5,-114) (297.5,-114) #RGPP1_4__dmy0:1};
// &"RGPP1_4__dmy0" @WIRE(mode="straight",linecolor="#30485d",linewidth=0.16) {#RGPP1_4__dmy0:2 (322.5,-114) (322.5,-114) #RGPP1_5__dmy0:1};
// &"RGPP0_1__dmy0" @WIRE(mode="straight",linecolor="#30485d",linewidth=0.16) {#RGPP0:2 (122.5,-114) (122.5,-114) #RGPP0_2__dmy0:1};
// &"RGPP0_2__dmy0" @WIRE(mode="straight",linecolor="#30485d",linewidth=0.16) {#RGPP0_2__dmy0:2 (147.5,-114) (147.5,-114) #RGPP0_3__dmy0:1};
// &"RGPP0_3__dmy0" @WIRE(mode="straight",linecolor="#30485d",linewidth=0.16) {#RGPP0_3__dmy0:2 (172.5,-114) (172.5,-114) #RGPP0_4__dmy0:1};
// &"RGPP0_4__dmy0" @WIRE(mode="straight",linecolor="#30485d",linewidth=0.16) {#RGPP0_4__dmy0:2 (197.5,-114) (197.5,-114) #RGPP0_5__dmy0:1};
// (-28,-148) @TEXT("GP and GN chains keep their source polarity, device sizing and series R; no zero-delay abstraction.",size=1,halign="start",textcolor="#223d52");
// &"VDD" @WIRE(mode="straight",linecolor="#30485d",linewidth=0.16) {#XSTD_GNNCN:3 (76,10)};
// (76,10.4) @TEXT("VDD",size=1.1,halign="middle",valign="bottom");
// &"VSS" @WIRE(mode="straight",linecolor="#30485d",linewidth=0.16) {#XSTD_GNNCN:4 (76,-10)};
// (76,-10.4) @TEXT("VSS",size=1.1,halign="middle",valign="top");
// &"VDD" @WIRE(mode="straight",linecolor="#30485d",linewidth=0.16) {#XSTD_GNNBN:3 (47,10)};
// (47,10.4) @TEXT("VDD",size=1.1,halign="middle",valign="bottom");
// &"VSS" @WIRE(mode="straight",linecolor="#30485d",linewidth=0.16) {#XSTD_GNNBN:4 (47,-10)};
// (47,-10.4) @TEXT("VSS",size=1.1,halign="middle",valign="top");
// &"VDD" @WIRE(mode="straight",linecolor="#30485d",linewidth=0.16) {#XSTD_GNNAN:3 (18,10)};
// (18,10.4) @TEXT("VDD",size=1.1,halign="middle",valign="bottom");
// &"VSS" @WIRE(mode="straight",linecolor="#30485d",linewidth=0.16) {#XSTD_GNNAN:4 (18,-10)};
// (18,-10.4) @TEXT("VSS",size=1.1,halign="middle",valign="top");
// &"VDD" @WIRE(mode="straight",linecolor="#30485d",linewidth=0.16) {#XSTD_GNPCN:3 (76,-28)};
// (76,-27.6) @TEXT("VDD",size=1.1,halign="middle",valign="bottom");
// &"VSS" @WIRE(mode="straight",linecolor="#30485d",linewidth=0.16) {#XSTD_GNPCN:4 (76,-48)};
// (76,-48.4) @TEXT("VSS",size=1.1,halign="middle",valign="top");
// &"VDD" @WIRE(mode="straight",linecolor="#30485d",linewidth=0.16) {#XSTD_GNPBN:3 (47,-28)};
// (47,-27.6) @TEXT("VDD",size=1.1,halign="middle",valign="bottom");
// &"VSS" @WIRE(mode="straight",linecolor="#30485d",linewidth=0.16) {#XSTD_GNPBN:4 (47,-48)};
// (47,-48.4) @TEXT("VSS",size=1.1,halign="middle",valign="top");
// &"VDD" @WIRE(mode="straight",linecolor="#30485d",linewidth=0.16) {#XSTD_GNPAN:3 (18,-28)};
// (18,-27.6) @TEXT("VDD",size=1.1,halign="middle",valign="bottom");
// &"VSS" @WIRE(mode="straight",linecolor="#30485d",linewidth=0.16) {#XSTD_GNPAN:4 (18,-48)};
// (18,-48.4) @TEXT("VSS",size=1.1,halign="middle",valign="top");
// &"VDD" @WIRE(mode="straight",linecolor="#30485d",linewidth=0.16) {#XSTD_GPNCN:3 (76,-66)};
// (76,-65.6) @TEXT("VDD",size=1.1,halign="middle",valign="bottom");
// &"VSS" @WIRE(mode="straight",linecolor="#30485d",linewidth=0.16) {#XSTD_GPNCN:4 (76,-86)};
// (76,-86.4) @TEXT("VSS",size=1.1,halign="middle",valign="top");
// &"VDD" @WIRE(mode="straight",linecolor="#30485d",linewidth=0.16) {#XSTD_GPNBN:3 (47,-66)};
// (47,-65.6) @TEXT("VDD",size=1.1,halign="middle",valign="bottom");
// &"VSS" @WIRE(mode="straight",linecolor="#30485d",linewidth=0.16) {#XSTD_GPNBN:4 (47,-86)};
// (47,-86.4) @TEXT("VSS",size=1.1,halign="middle",valign="top");
// &"VDD" @WIRE(mode="straight",linecolor="#30485d",linewidth=0.16) {#XSTD_GPNAN:3 (18,-66)};
// (18,-65.6) @TEXT("VDD",size=1.1,halign="middle",valign="bottom");
// &"VSS" @WIRE(mode="straight",linecolor="#30485d",linewidth=0.16) {#XSTD_GPNAN:4 (18,-86)};
// (18,-86.4) @TEXT("VSS",size=1.1,halign="middle",valign="top");
// &"VDD" @WIRE(mode="straight",linecolor="#30485d",linewidth=0.16) {#XSTD_GPPCN:3 (76,-104)};
// (76,-103.6) @TEXT("VDD",size=1.1,halign="middle",valign="bottom");
// &"VSS" @WIRE(mode="straight",linecolor="#30485d",linewidth=0.16) {#XSTD_GPPCN:4 (76,-124)};
// (76,-124.4) @TEXT("VSS",size=1.1,halign="middle",valign="top");
// &"VDD" @WIRE(mode="straight",linecolor="#30485d",linewidth=0.16) {#XSTD_GPPBN:3 (47,-104)};
// (47,-103.6) @TEXT("VDD",size=1.1,halign="middle",valign="bottom");
// &"VSS" @WIRE(mode="straight",linecolor="#30485d",linewidth=0.16) {#XSTD_GPPBN:4 (47,-124)};
// (47,-124.4) @TEXT("VSS",size=1.1,halign="middle",valign="top");
// &"L" @WIRE(mode="straight",linecolor="#30485d",linewidth=0.16) {#XSTD_GPPAN:1 (8,-114)};
// (7.6,-114) @TEXT("L",size=1.1,halign="end",valign="middle");
// &"VDD" @WIRE(mode="straight",linecolor="#30485d",linewidth=0.16) {#XSTD_GPPAN:3 (18,-104)};
// (18,-103.6) @TEXT("VDD",size=1.1,halign="middle",valign="bottom");
// &"VSS" @WIRE(mode="straight",linecolor="#30485d",linewidth=0.16) {#XSTD_GPPAN:4 (18,-124)};
// (18,-124.4) @TEXT("VSS",size=1.1,halign="middle",valign="top");
// &"GNN" @WIRE(mode="straight",linecolor="#30485d",linewidth=0.16) {#RGNN1_5__dmy0:2 (340,0)};
// (340.4,0) @TEXT("GNN",size=1.1,halign="start",valign="middle");
// &"GNP" @WIRE(mode="straight",linecolor="#30485d",linewidth=0.16) {#RGNP1_5__dmy0:2 (340,-38)};
// (340.4,-38) @TEXT("GNP",size=1.1,halign="start",valign="middle");
// &"GPN" @WIRE(mode="straight",linecolor="#30485d",linewidth=0.16) {#RGPN1_5__dmy0:2 (340,-76)};
// (340.4,-76) @TEXT("GPN",size=1.1,halign="start",valign="middle");
// &"GPP" @WIRE(mode="straight",linecolor="#30485d",linewidth=0.16) {#RGPP1_5__dmy0:2 (340,-114)};
// (340.4,-114) @TEXT("GPP",size=1.1,halign="start",valign="middle");
// &"L" @WIRE(mode="straight",linecolor="#30485d",linewidth=0.16) {#X025:1 (-27,0)};
// (-27.4,0) @TEXT("L",size=1.1,halign="end",valign="middle");
// &"VDD" @WIRE(mode="straight",linecolor="#30485d",linewidth=0.16) {#X025:2 (-17,10)};
// (-17,10.4) @TEXT("VDD",size=1.1,halign="middle",valign="bottom");
// &"VSS" @WIRE(mode="straight",linecolor="#30485d",linewidth=0.16) {#X025:3 (-17,-10)};
// (-17,-10.4) @TEXT("VSS",size=1.1,halign="middle",valign="top");
// &"VDD" @WIRE(mode="straight",linecolor="#30485d",linewidth=0.16) {#X008:2 (-17,-66)};
// (-17,-65.6) @TEXT("VDD",size=1.1,halign="middle",valign="bottom");
// &"VSS" @WIRE(mode="straight",linecolor="#30485d",linewidth=0.16) {#X008:3 (-17,-86)};
// (-17,-86.4) @TEXT("VSS",size=1.1,halign="middle",valign="top");
// }
// END SARADC RNL
ends sar8p_refdrv_b6

subckt sar8p_refdrv_b7 GNN GNP GPN GPP H L VDD VSS
    XSTD_GNNCN (GNNB GNNDRV VDD VSS) INVD1BWP12T30P140
    XSTD_GNNBN (GNNA GNNB VDD VSS) INVD1BWP12T30P140
    XSTD_GNNAN (GNNPRE GNNA VDD VSS) INVD1BWP12T30P140
    XSTD_GNPCN (GNPB GNPDRV VDD VSS) INVD1BWP12T30P140
    XSTD_GNPBN (GNPA GNPB VDD VSS) INVD1BWP12T30P140
    XSTD_GNPAN (H GNPA VDD VSS) INVD1BWP12T30P140
    XSTD_GPNCN (GPNB GPNDRV VDD VSS) INVD1BWP12T30P140
    XSTD_GPNBN (GPNA GPNB VDD VSS) INVD1BWP12T30P140
    XSTD_GPNAN (GPNPRE GPNA VDD VSS) INVD1BWP12T30P140
    XSTD_GPPCN (GPPB GPPDRV VDD VSS) INVD1BWP12T30P140
    XSTD_GPPBN (GPPA GPPB VDD VSS) INVD1BWP12T30P140
    XSTD_GPPAN (L GPPA VDD VSS) INVD1BWP12T30P140
//Series configuration of RGNN1
RGNN1  (GNNRG RGNN1_1__dmy0 ) rupolym l=17.13u w=1u m=128 multi=(1)
RGNN1_2__dmy0  (RGNN1_1__dmy0 RGNN1_2__dmy0 ) rupolym l=17.13u w=1u m=128          multi=(1)
RGNN1_3__dmy0  (RGNN1_2__dmy0 RGNN1_3__dmy0 ) rupolym l=17.13u w=1u m=128          multi=(1)
RGNN1_4__dmy0  (RGNN1_3__dmy0 RGNN1_4__dmy0 ) rupolym l=17.13u w=1u m=128          multi=(1)
RGNN1_5__dmy0  (RGNN1_4__dmy0 GNN ) rupolym l=17.13u w=1u m=128 multi=(1)
//End of RGNN1

//Series configuration of RGNN0
RGNN0  (GNNDRV RGNN0_1__dmy0 ) rupolym l=17.13u w=1u m=128 multi=(1)
RGNN0_2__dmy0  (RGNN0_1__dmy0 RGNN0_2__dmy0 ) rupolym l=17.13u w=1u m=128          multi=(1)
RGNN0_3__dmy0  (RGNN0_2__dmy0 RGNN0_3__dmy0 ) rupolym l=17.13u w=1u m=128          multi=(1)
RGNN0_4__dmy0  (RGNN0_3__dmy0 RGNN0_4__dmy0 ) rupolym l=17.13u w=1u m=128          multi=(1)
RGNN0_5__dmy0  (RGNN0_4__dmy0 GNNRG ) rupolym l=17.13u w=1u m=128          multi=(1)
//End of RGNN0

//Series configuration of RGNP1
RGNP1  (GNPRG RGNP1_1__dmy0 ) rupolym l=17.13u w=1u m=128 multi=(1)
RGNP1_2__dmy0  (RGNP1_1__dmy0 RGNP1_2__dmy0 ) rupolym l=17.13u w=1u m=128          multi=(1)
RGNP1_3__dmy0  (RGNP1_2__dmy0 RGNP1_3__dmy0 ) rupolym l=17.13u w=1u m=128          multi=(1)
RGNP1_4__dmy0  (RGNP1_3__dmy0 RGNP1_4__dmy0 ) rupolym l=17.13u w=1u m=128          multi=(1)
RGNP1_5__dmy0  (RGNP1_4__dmy0 GNP ) rupolym l=17.13u w=1u m=128 multi=(1)
//End of RGNP1

//Series configuration of RGNP0
RGNP0  (GNPDRV RGNP0_1__dmy0 ) rupolym l=17.13u w=1u m=128 multi=(1)
RGNP0_2__dmy0  (RGNP0_1__dmy0 RGNP0_2__dmy0 ) rupolym l=17.13u w=1u m=128          multi=(1)
RGNP0_3__dmy0  (RGNP0_2__dmy0 RGNP0_3__dmy0 ) rupolym l=17.13u w=1u m=128          multi=(1)
RGNP0_4__dmy0  (RGNP0_3__dmy0 RGNP0_4__dmy0 ) rupolym l=17.13u w=1u m=128          multi=(1)
RGNP0_5__dmy0  (RGNP0_4__dmy0 GNPRG ) rupolym l=17.13u w=1u m=128          multi=(1)
//End of RGNP0

//Series configuration of RGPN1
RGPN1  (GPNRG RGPN1_1__dmy0 ) rupolym l=17.13u w=1u m=128 multi=(1)
RGPN1_2__dmy0  (RGPN1_1__dmy0 RGPN1_2__dmy0 ) rupolym l=17.13u w=1u m=128          multi=(1)
RGPN1_3__dmy0  (RGPN1_2__dmy0 RGPN1_3__dmy0 ) rupolym l=17.13u w=1u m=128          multi=(1)
RGPN1_4__dmy0  (RGPN1_3__dmy0 RGPN1_4__dmy0 ) rupolym l=17.13u w=1u m=128          multi=(1)
RGPN1_5__dmy0  (RGPN1_4__dmy0 GPN ) rupolym l=17.13u w=1u m=128 multi=(1)
//End of RGPN1

//Series configuration of RGPN0
RGPN0  (GPNDRV RGPN0_1__dmy0 ) rupolym l=17.13u w=1u m=128 multi=(1)
RGPN0_2__dmy0  (RGPN0_1__dmy0 RGPN0_2__dmy0 ) rupolym l=17.13u w=1u m=128          multi=(1)
RGPN0_3__dmy0  (RGPN0_2__dmy0 RGPN0_3__dmy0 ) rupolym l=17.13u w=1u m=128          multi=(1)
RGPN0_4__dmy0  (RGPN0_3__dmy0 RGPN0_4__dmy0 ) rupolym l=17.13u w=1u m=128          multi=(1)
RGPN0_5__dmy0  (RGPN0_4__dmy0 GPNRG ) rupolym l=17.13u w=1u m=128          multi=(1)
//End of RGPN0

//Series configuration of RGPP1
RGPP1  (GPPRG RGPP1_1__dmy0 ) rupolym l=17.13u w=1u m=128 multi=(1)
RGPP1_2__dmy0  (RGPP1_1__dmy0 RGPP1_2__dmy0 ) rupolym l=17.13u w=1u m=128          multi=(1)
RGPP1_3__dmy0  (RGPP1_2__dmy0 RGPP1_3__dmy0 ) rupolym l=17.13u w=1u m=128          multi=(1)
RGPP1_4__dmy0  (RGPP1_3__dmy0 RGPP1_4__dmy0 ) rupolym l=17.13u w=1u m=128          multi=(1)
RGPP1_5__dmy0  (RGPP1_4__dmy0 GPP ) rupolym l=17.13u w=1u m=128 multi=(1)
//End of RGPP1

//Series configuration of RGPP0
RGPP0  (GPPDRV RGPP0_1__dmy0 ) rupolym l=17.13u w=1u m=128 multi=(1)
RGPP0_2__dmy0  (RGPP0_1__dmy0 RGPP0_2__dmy0 ) rupolym l=17.13u w=1u m=128          multi=(1)
RGPP0_3__dmy0  (RGPP0_2__dmy0 RGPP0_3__dmy0 ) rupolym l=17.13u w=1u m=128          multi=(1)
RGPP0_4__dmy0  (RGPP0_3__dmy0 RGPP0_4__dmy0 ) rupolym l=17.13u w=1u m=128          multi=(1)
RGPP0_5__dmy0  (RGPP0_4__dmy0 GPPRG ) rupolym l=17.13u w=1u m=128          multi=(1)
//End of RGPP0

    X025 (L VDD VSS GNNPRE) sar8p_inv
    X008 (H VDD VSS GPNPRE) sar8p_inv
// BEGIN SARADC RNL
// @RNL(author="saradc topology") {
// (-28,27) @TEXT("sar8p_refdrv_b7 / four physical gate-driver chains",size=1.5,halign="start",textcolor="#223d52");
// #X025 @SET-SYMBOL $S_sar8p_inv;
// #X025 @PLACE(-17,0) => @ORIENT("R0");
// #XSTD_GNNAN @SET-SYMBOL $S_INVD1BWP12T30P140;
// #XSTD_GNNAN @PLACE(18,0) => @ORIENT("R0");
// #XSTD_GNNBN @SET-SYMBOL $S_INVD1BWP12T30P140;
// #XSTD_GNNBN @PLACE(47,0) => @ORIENT("R0");
// #XSTD_GNNCN @SET-SYMBOL $S_INVD1BWP12T30P140;
// #XSTD_GNNCN @PLACE(76,0) => @ORIENT("R0");
// #RGNN0 @SET-SYMBOL $RESISTOR;
// #RGNN0 @PLACE(110,0) => @ORIENT("R90");
// #RGNN0 @TEXT("RGNN0",key="name",size=1.3,halign="start") => @PLACE(113,3);
// #RGNN0 @TEXT("l=17.13u w=1u multi=(1)",key="value",size=0.9,halign="start") => @PLACE(113,-4);
// #RGNN0 @TEXT("",key="model");
// #RGNN0_2__dmy0 @SET-SYMBOL $RESISTOR;
// #RGNN0_2__dmy0 @PLACE(135,0) => @ORIENT("R90");
// #RGNN0_2__dmy0 @TEXT("RGNN0_2__dmy0",key="name",size=1.3,halign="start") => @PLACE(138,3);
// #RGNN0_2__dmy0 @TEXT("l=17.13u w=1u multi=(1)",key="value",size=0.9,halign="start") => @PLACE(138,-4);
// #RGNN0_2__dmy0 @TEXT("",key="model");
// #RGNN0_3__dmy0 @SET-SYMBOL $RESISTOR;
// #RGNN0_3__dmy0 @PLACE(160,0) => @ORIENT("R90");
// #RGNN0_3__dmy0 @TEXT("RGNN0_3__dmy0",key="name",size=1.3,halign="start") => @PLACE(163,3);
// #RGNN0_3__dmy0 @TEXT("l=17.13u w=1u multi=(1)",key="value",size=0.9,halign="start") => @PLACE(163,-4);
// #RGNN0_3__dmy0 @TEXT("",key="model");
// #RGNN0_4__dmy0 @SET-SYMBOL $RESISTOR;
// #RGNN0_4__dmy0 @PLACE(185,0) => @ORIENT("R90");
// #RGNN0_4__dmy0 @TEXT("RGNN0_4__dmy0",key="name",size=1.3,halign="start") => @PLACE(188,3);
// #RGNN0_4__dmy0 @TEXT("l=17.13u w=1u multi=(1)",key="value",size=0.9,halign="start") => @PLACE(188,-4);
// #RGNN0_4__dmy0 @TEXT("",key="model");
// #RGNN0_5__dmy0 @SET-SYMBOL $RESISTOR;
// #RGNN0_5__dmy0 @PLACE(210,0) => @ORIENT("R90");
// #RGNN0_5__dmy0 @TEXT("RGNN0_5__dmy0",key="name",size=1.3,halign="start") => @PLACE(213,3);
// #RGNN0_5__dmy0 @TEXT("l=17.13u w=1u multi=(1)",key="value",size=0.9,halign="start") => @PLACE(213,-4);
// #RGNN0_5__dmy0 @TEXT("",key="model");
// #RGNN1 @SET-SYMBOL $RESISTOR;
// #RGNN1 @PLACE(235,0) => @ORIENT("R90");
// #RGNN1 @TEXT("RGNN1",key="name",size=1.3,halign="start") => @PLACE(238,3);
// #RGNN1 @TEXT("l=17.13u w=1u multi=(1)",key="value",size=0.9,halign="start") => @PLACE(238,-4);
// #RGNN1 @TEXT("",key="model");
// #RGNN1_2__dmy0 @SET-SYMBOL $RESISTOR;
// #RGNN1_2__dmy0 @PLACE(260,0) => @ORIENT("R90");
// #RGNN1_2__dmy0 @TEXT("RGNN1_2__dmy0",key="name",size=1.3,halign="start") => @PLACE(263,3);
// #RGNN1_2__dmy0 @TEXT("l=17.13u w=1u multi=(1)",key="value",size=0.9,halign="start") => @PLACE(263,-4);
// #RGNN1_2__dmy0 @TEXT("",key="model");
// #RGNN1_3__dmy0 @SET-SYMBOL $RESISTOR;
// #RGNN1_3__dmy0 @PLACE(285,0) => @ORIENT("R90");
// #RGNN1_3__dmy0 @TEXT("RGNN1_3__dmy0",key="name",size=1.3,halign="start") => @PLACE(288,3);
// #RGNN1_3__dmy0 @TEXT("l=17.13u w=1u multi=(1)",key="value",size=0.9,halign="start") => @PLACE(288,-4);
// #RGNN1_3__dmy0 @TEXT("",key="model");
// #RGNN1_4__dmy0 @SET-SYMBOL $RESISTOR;
// #RGNN1_4__dmy0 @PLACE(310,0) => @ORIENT("R90");
// #RGNN1_4__dmy0 @TEXT("RGNN1_4__dmy0",key="name",size=1.3,halign="start") => @PLACE(313,3);
// #RGNN1_4__dmy0 @TEXT("l=17.13u w=1u multi=(1)",key="value",size=0.9,halign="start") => @PLACE(313,-4);
// #RGNN1_4__dmy0 @TEXT("",key="model");
// #RGNN1_5__dmy0 @SET-SYMBOL $RESISTOR;
// #RGNN1_5__dmy0 @PLACE(335,0) => @ORIENT("R90");
// #RGNN1_5__dmy0 @TEXT("RGNN1_5__dmy0",key="name",size=1.3,halign="start") => @PLACE(338,3);
// #RGNN1_5__dmy0 @TEXT("l=17.13u w=1u multi=(1)",key="value",size=0.9,halign="start") => @PLACE(338,-4);
// #RGNN1_5__dmy0 @TEXT("",key="model");
// (104,15) @TEXT("GNN / 10 series poly sections",size=0.95,halign="start",textcolor="#223d52");
// #XSTD_GNPAN @SET-SYMBOL $S_INVD1BWP12T30P140;
// #XSTD_GNPAN @PLACE(18,-38) => @ORIENT("R0");
// #XSTD_GNPBN @SET-SYMBOL $S_INVD1BWP12T30P140;
// #XSTD_GNPBN @PLACE(47,-38) => @ORIENT("R0");
// #XSTD_GNPCN @SET-SYMBOL $S_INVD1BWP12T30P140;
// #XSTD_GNPCN @PLACE(76,-38) => @ORIENT("R0");
// #RGNP0 @SET-SYMBOL $RESISTOR;
// #RGNP0 @PLACE(110,-38) => @ORIENT("R90");
// #RGNP0 @TEXT("RGNP0",key="name",size=1.3,halign="start") => @PLACE(113,-35);
// #RGNP0 @TEXT("l=17.13u w=1u multi=(1)",key="value",size=0.9,halign="start") => @PLACE(113,-42);
// #RGNP0 @TEXT("",key="model");
// #RGNP0_2__dmy0 @SET-SYMBOL $RESISTOR;
// #RGNP0_2__dmy0 @PLACE(135,-38) => @ORIENT("R90");
// #RGNP0_2__dmy0 @TEXT("RGNP0_2__dmy0",key="name",size=1.3,halign="start") => @PLACE(138,-35);
// #RGNP0_2__dmy0 @TEXT("l=17.13u w=1u multi=(1)",key="value",size=0.9,halign="start") => @PLACE(138,-42);
// #RGNP0_2__dmy0 @TEXT("",key="model");
// #RGNP0_3__dmy0 @SET-SYMBOL $RESISTOR;
// #RGNP0_3__dmy0 @PLACE(160,-38) => @ORIENT("R90");
// #RGNP0_3__dmy0 @TEXT("RGNP0_3__dmy0",key="name",size=1.3,halign="start") => @PLACE(163,-35);
// #RGNP0_3__dmy0 @TEXT("l=17.13u w=1u multi=(1)",key="value",size=0.9,halign="start") => @PLACE(163,-42);
// #RGNP0_3__dmy0 @TEXT("",key="model");
// #RGNP0_4__dmy0 @SET-SYMBOL $RESISTOR;
// #RGNP0_4__dmy0 @PLACE(185,-38) => @ORIENT("R90");
// #RGNP0_4__dmy0 @TEXT("RGNP0_4__dmy0",key="name",size=1.3,halign="start") => @PLACE(188,-35);
// #RGNP0_4__dmy0 @TEXT("l=17.13u w=1u multi=(1)",key="value",size=0.9,halign="start") => @PLACE(188,-42);
// #RGNP0_4__dmy0 @TEXT("",key="model");
// #RGNP0_5__dmy0 @SET-SYMBOL $RESISTOR;
// #RGNP0_5__dmy0 @PLACE(210,-38) => @ORIENT("R90");
// #RGNP0_5__dmy0 @TEXT("RGNP0_5__dmy0",key="name",size=1.3,halign="start") => @PLACE(213,-35);
// #RGNP0_5__dmy0 @TEXT("l=17.13u w=1u multi=(1)",key="value",size=0.9,halign="start") => @PLACE(213,-42);
// #RGNP0_5__dmy0 @TEXT("",key="model");
// #RGNP1 @SET-SYMBOL $RESISTOR;
// #RGNP1 @PLACE(235,-38) => @ORIENT("R90");
// #RGNP1 @TEXT("RGNP1",key="name",size=1.3,halign="start") => @PLACE(238,-35);
// #RGNP1 @TEXT("l=17.13u w=1u multi=(1)",key="value",size=0.9,halign="start") => @PLACE(238,-42);
// #RGNP1 @TEXT("",key="model");
// #RGNP1_2__dmy0 @SET-SYMBOL $RESISTOR;
// #RGNP1_2__dmy0 @PLACE(260,-38) => @ORIENT("R90");
// #RGNP1_2__dmy0 @TEXT("RGNP1_2__dmy0",key="name",size=1.3,halign="start") => @PLACE(263,-35);
// #RGNP1_2__dmy0 @TEXT("l=17.13u w=1u multi=(1)",key="value",size=0.9,halign="start") => @PLACE(263,-42);
// #RGNP1_2__dmy0 @TEXT("",key="model");
// #RGNP1_3__dmy0 @SET-SYMBOL $RESISTOR;
// #RGNP1_3__dmy0 @PLACE(285,-38) => @ORIENT("R90");
// #RGNP1_3__dmy0 @TEXT("RGNP1_3__dmy0",key="name",size=1.3,halign="start") => @PLACE(288,-35);
// #RGNP1_3__dmy0 @TEXT("l=17.13u w=1u multi=(1)",key="value",size=0.9,halign="start") => @PLACE(288,-42);
// #RGNP1_3__dmy0 @TEXT("",key="model");
// #RGNP1_4__dmy0 @SET-SYMBOL $RESISTOR;
// #RGNP1_4__dmy0 @PLACE(310,-38) => @ORIENT("R90");
// #RGNP1_4__dmy0 @TEXT("RGNP1_4__dmy0",key="name",size=1.3,halign="start") => @PLACE(313,-35);
// #RGNP1_4__dmy0 @TEXT("l=17.13u w=1u multi=(1)",key="value",size=0.9,halign="start") => @PLACE(313,-42);
// #RGNP1_4__dmy0 @TEXT("",key="model");
// #RGNP1_5__dmy0 @SET-SYMBOL $RESISTOR;
// #RGNP1_5__dmy0 @PLACE(335,-38) => @ORIENT("R90");
// #RGNP1_5__dmy0 @TEXT("RGNP1_5__dmy0",key="name",size=1.3,halign="start") => @PLACE(338,-35);
// #RGNP1_5__dmy0 @TEXT("l=17.13u w=1u multi=(1)",key="value",size=0.9,halign="start") => @PLACE(338,-42);
// #RGNP1_5__dmy0 @TEXT("",key="model");
// (104,-23) @TEXT("GNP / 10 series poly sections",size=0.95,halign="start",textcolor="#223d52");
// #X008 @SET-SYMBOL $S_sar8p_inv;
// #X008 @PLACE(-17,-76) => @ORIENT("R0");
// #XSTD_GPNAN @SET-SYMBOL $S_INVD1BWP12T30P140;
// #XSTD_GPNAN @PLACE(18,-76) => @ORIENT("R0");
// #XSTD_GPNBN @SET-SYMBOL $S_INVD1BWP12T30P140;
// #XSTD_GPNBN @PLACE(47,-76) => @ORIENT("R0");
// #XSTD_GPNCN @SET-SYMBOL $S_INVD1BWP12T30P140;
// #XSTD_GPNCN @PLACE(76,-76) => @ORIENT("R0");
// #RGPN0 @SET-SYMBOL $RESISTOR;
// #RGPN0 @PLACE(110,-76) => @ORIENT("R90");
// #RGPN0 @TEXT("RGPN0",key="name",size=1.3,halign="start") => @PLACE(113,-73);
// #RGPN0 @TEXT("l=17.13u w=1u multi=(1)",key="value",size=0.9,halign="start") => @PLACE(113,-80);
// #RGPN0 @TEXT("",key="model");
// #RGPN0_2__dmy0 @SET-SYMBOL $RESISTOR;
// #RGPN0_2__dmy0 @PLACE(135,-76) => @ORIENT("R90");
// #RGPN0_2__dmy0 @TEXT("RGPN0_2__dmy0",key="name",size=1.3,halign="start") => @PLACE(138,-73);
// #RGPN0_2__dmy0 @TEXT("l=17.13u w=1u multi=(1)",key="value",size=0.9,halign="start") => @PLACE(138,-80);
// #RGPN0_2__dmy0 @TEXT("",key="model");
// #RGPN0_3__dmy0 @SET-SYMBOL $RESISTOR;
// #RGPN0_3__dmy0 @PLACE(160,-76) => @ORIENT("R90");
// #RGPN0_3__dmy0 @TEXT("RGPN0_3__dmy0",key="name",size=1.3,halign="start") => @PLACE(163,-73);
// #RGPN0_3__dmy0 @TEXT("l=17.13u w=1u multi=(1)",key="value",size=0.9,halign="start") => @PLACE(163,-80);
// #RGPN0_3__dmy0 @TEXT("",key="model");
// #RGPN0_4__dmy0 @SET-SYMBOL $RESISTOR;
// #RGPN0_4__dmy0 @PLACE(185,-76) => @ORIENT("R90");
// #RGPN0_4__dmy0 @TEXT("RGPN0_4__dmy0",key="name",size=1.3,halign="start") => @PLACE(188,-73);
// #RGPN0_4__dmy0 @TEXT("l=17.13u w=1u multi=(1)",key="value",size=0.9,halign="start") => @PLACE(188,-80);
// #RGPN0_4__dmy0 @TEXT("",key="model");
// #RGPN0_5__dmy0 @SET-SYMBOL $RESISTOR;
// #RGPN0_5__dmy0 @PLACE(210,-76) => @ORIENT("R90");
// #RGPN0_5__dmy0 @TEXT("RGPN0_5__dmy0",key="name",size=1.3,halign="start") => @PLACE(213,-73);
// #RGPN0_5__dmy0 @TEXT("l=17.13u w=1u multi=(1)",key="value",size=0.9,halign="start") => @PLACE(213,-80);
// #RGPN0_5__dmy0 @TEXT("",key="model");
// #RGPN1 @SET-SYMBOL $RESISTOR;
// #RGPN1 @PLACE(235,-76) => @ORIENT("R90");
// #RGPN1 @TEXT("RGPN1",key="name",size=1.3,halign="start") => @PLACE(238,-73);
// #RGPN1 @TEXT("l=17.13u w=1u multi=(1)",key="value",size=0.9,halign="start") => @PLACE(238,-80);
// #RGPN1 @TEXT("",key="model");
// #RGPN1_2__dmy0 @SET-SYMBOL $RESISTOR;
// #RGPN1_2__dmy0 @PLACE(260,-76) => @ORIENT("R90");
// #RGPN1_2__dmy0 @TEXT("RGPN1_2__dmy0",key="name",size=1.3,halign="start") => @PLACE(263,-73);
// #RGPN1_2__dmy0 @TEXT("l=17.13u w=1u multi=(1)",key="value",size=0.9,halign="start") => @PLACE(263,-80);
// #RGPN1_2__dmy0 @TEXT("",key="model");
// #RGPN1_3__dmy0 @SET-SYMBOL $RESISTOR;
// #RGPN1_3__dmy0 @PLACE(285,-76) => @ORIENT("R90");
// #RGPN1_3__dmy0 @TEXT("RGPN1_3__dmy0",key="name",size=1.3,halign="start") => @PLACE(288,-73);
// #RGPN1_3__dmy0 @TEXT("l=17.13u w=1u multi=(1)",key="value",size=0.9,halign="start") => @PLACE(288,-80);
// #RGPN1_3__dmy0 @TEXT("",key="model");
// #RGPN1_4__dmy0 @SET-SYMBOL $RESISTOR;
// #RGPN1_4__dmy0 @PLACE(310,-76) => @ORIENT("R90");
// #RGPN1_4__dmy0 @TEXT("RGPN1_4__dmy0",key="name",size=1.3,halign="start") => @PLACE(313,-73);
// #RGPN1_4__dmy0 @TEXT("l=17.13u w=1u multi=(1)",key="value",size=0.9,halign="start") => @PLACE(313,-80);
// #RGPN1_4__dmy0 @TEXT("",key="model");
// #RGPN1_5__dmy0 @SET-SYMBOL $RESISTOR;
// #RGPN1_5__dmy0 @PLACE(335,-76) => @ORIENT("R90");
// #RGPN1_5__dmy0 @TEXT("RGPN1_5__dmy0",key="name",size=1.3,halign="start") => @PLACE(338,-73);
// #RGPN1_5__dmy0 @TEXT("l=17.13u w=1u multi=(1)",key="value",size=0.9,halign="start") => @PLACE(338,-80);
// #RGPN1_5__dmy0 @TEXT("",key="model");
// (104,-61) @TEXT("GPN / 10 series poly sections",size=0.95,halign="start",textcolor="#223d52");
// #XSTD_GPPAN @SET-SYMBOL $S_INVD1BWP12T30P140;
// #XSTD_GPPAN @PLACE(18,-114) => @ORIENT("R0");
// #XSTD_GPPBN @SET-SYMBOL $S_INVD1BWP12T30P140;
// #XSTD_GPPBN @PLACE(47,-114) => @ORIENT("R0");
// #XSTD_GPPCN @SET-SYMBOL $S_INVD1BWP12T30P140;
// #XSTD_GPPCN @PLACE(76,-114) => @ORIENT("R0");
// #RGPP0 @SET-SYMBOL $RESISTOR;
// #RGPP0 @PLACE(110,-114) => @ORIENT("R90");
// #RGPP0 @TEXT("RGPP0",key="name",size=1.3,halign="start") => @PLACE(113,-111);
// #RGPP0 @TEXT("l=17.13u w=1u multi=(1)",key="value",size=0.9,halign="start") => @PLACE(113,-118);
// #RGPP0 @TEXT("",key="model");
// #RGPP0_2__dmy0 @SET-SYMBOL $RESISTOR;
// #RGPP0_2__dmy0 @PLACE(135,-114) => @ORIENT("R90");
// #RGPP0_2__dmy0 @TEXT("RGPP0_2__dmy0",key="name",size=1.3,halign="start") => @PLACE(138,-111);
// #RGPP0_2__dmy0 @TEXT("l=17.13u w=1u multi=(1)",key="value",size=0.9,halign="start") => @PLACE(138,-118);
// #RGPP0_2__dmy0 @TEXT("",key="model");
// #RGPP0_3__dmy0 @SET-SYMBOL $RESISTOR;
// #RGPP0_3__dmy0 @PLACE(160,-114) => @ORIENT("R90");
// #RGPP0_3__dmy0 @TEXT("RGPP0_3__dmy0",key="name",size=1.3,halign="start") => @PLACE(163,-111);
// #RGPP0_3__dmy0 @TEXT("l=17.13u w=1u multi=(1)",key="value",size=0.9,halign="start") => @PLACE(163,-118);
// #RGPP0_3__dmy0 @TEXT("",key="model");
// #RGPP0_4__dmy0 @SET-SYMBOL $RESISTOR;
// #RGPP0_4__dmy0 @PLACE(185,-114) => @ORIENT("R90");
// #RGPP0_4__dmy0 @TEXT("RGPP0_4__dmy0",key="name",size=1.3,halign="start") => @PLACE(188,-111);
// #RGPP0_4__dmy0 @TEXT("l=17.13u w=1u multi=(1)",key="value",size=0.9,halign="start") => @PLACE(188,-118);
// #RGPP0_4__dmy0 @TEXT("",key="model");
// #RGPP0_5__dmy0 @SET-SYMBOL $RESISTOR;
// #RGPP0_5__dmy0 @PLACE(210,-114) => @ORIENT("R90");
// #RGPP0_5__dmy0 @TEXT("RGPP0_5__dmy0",key="name",size=1.3,halign="start") => @PLACE(213,-111);
// #RGPP0_5__dmy0 @TEXT("l=17.13u w=1u multi=(1)",key="value",size=0.9,halign="start") => @PLACE(213,-118);
// #RGPP0_5__dmy0 @TEXT("",key="model");
// #RGPP1 @SET-SYMBOL $RESISTOR;
// #RGPP1 @PLACE(235,-114) => @ORIENT("R90");
// #RGPP1 @TEXT("RGPP1",key="name",size=1.3,halign="start") => @PLACE(238,-111);
// #RGPP1 @TEXT("l=17.13u w=1u multi=(1)",key="value",size=0.9,halign="start") => @PLACE(238,-118);
// #RGPP1 @TEXT("",key="model");
// #RGPP1_2__dmy0 @SET-SYMBOL $RESISTOR;
// #RGPP1_2__dmy0 @PLACE(260,-114) => @ORIENT("R90");
// #RGPP1_2__dmy0 @TEXT("RGPP1_2__dmy0",key="name",size=1.3,halign="start") => @PLACE(263,-111);
// #RGPP1_2__dmy0 @TEXT("l=17.13u w=1u multi=(1)",key="value",size=0.9,halign="start") => @PLACE(263,-118);
// #RGPP1_2__dmy0 @TEXT("",key="model");
// #RGPP1_3__dmy0 @SET-SYMBOL $RESISTOR;
// #RGPP1_3__dmy0 @PLACE(285,-114) => @ORIENT("R90");
// #RGPP1_3__dmy0 @TEXT("RGPP1_3__dmy0",key="name",size=1.3,halign="start") => @PLACE(288,-111);
// #RGPP1_3__dmy0 @TEXT("l=17.13u w=1u multi=(1)",key="value",size=0.9,halign="start") => @PLACE(288,-118);
// #RGPP1_3__dmy0 @TEXT("",key="model");
// #RGPP1_4__dmy0 @SET-SYMBOL $RESISTOR;
// #RGPP1_4__dmy0 @PLACE(310,-114) => @ORIENT("R90");
// #RGPP1_4__dmy0 @TEXT("RGPP1_4__dmy0",key="name",size=1.3,halign="start") => @PLACE(313,-111);
// #RGPP1_4__dmy0 @TEXT("l=17.13u w=1u multi=(1)",key="value",size=0.9,halign="start") => @PLACE(313,-118);
// #RGPP1_4__dmy0 @TEXT("",key="model");
// #RGPP1_5__dmy0 @SET-SYMBOL $RESISTOR;
// #RGPP1_5__dmy0 @PLACE(335,-114) => @ORIENT("R90");
// #RGPP1_5__dmy0 @TEXT("RGPP1_5__dmy0",key="name",size=1.3,halign="start") => @PLACE(338,-111);
// #RGPP1_5__dmy0 @TEXT("l=17.13u w=1u multi=(1)",key="value",size=0.9,halign="start") => @PLACE(338,-118);
// #RGPP1_5__dmy0 @TEXT("",key="model");
// (104,-99) @TEXT("GPP / 10 series poly sections",size=0.95,halign="start",textcolor="#223d52");
// &"GNNB" @WIRE(mode="straight",linecolor="#30485d",linewidth=0.16) {#XSTD_GNNCN:1 (61.5,0) (61.5,0) #XSTD_GNNBN:2};
// &"GNNDRV" @WIRE(mode="straight",linecolor="#30485d",linewidth=0.16) {#XSTD_GNNCN:2 (95.5,0) (95.5,0) #RGNN0:1};
// &"GNNA" @WIRE(mode="straight",linecolor="#30485d",linewidth=0.16) {#XSTD_GNNBN:1 (32.5,0) (32.5,0) #XSTD_GNNAN:2};
// &"GNNPRE" @WIRE(mode="straight",linecolor="#30485d",linewidth=0.16) {#XSTD_GNNAN:1 (0.5,0) (0.5,0) #X025:4};
// &"GNPB" @WIRE(mode="straight",linecolor="#30485d",linewidth=0.16) {#XSTD_GNPCN:1 (61.5,-38) (61.5,-38) #XSTD_GNPBN:2};
// &"GNPDRV" @WIRE(mode="straight",linecolor="#30485d",linewidth=0.16) {#XSTD_GNPCN:2 (95.5,-38) (95.5,-38) #RGNP0:1};
// &"GNPA" @WIRE(mode="straight",linecolor="#30485d",linewidth=0.16) {#XSTD_GNPBN:1 (32.5,-38) (32.5,-38) #XSTD_GNPAN:2};
// &"H" @WIRE(mode="straight",linecolor="#30485d",linewidth=0.16) {#XSTD_GNPAN:1 (-6.5,-38) (-6.5,-76) #X008:1};
// &"GPNB" @WIRE(mode="straight",linecolor="#30485d",linewidth=0.16) {#XSTD_GPNCN:1 (61.5,-76) (61.5,-76) #XSTD_GPNBN:2};
// &"GPNDRV" @WIRE(mode="straight",linecolor="#30485d",linewidth=0.16) {#XSTD_GPNCN:2 (95.5,-76) (95.5,-76) #RGPN0:1};
// &"GPNA" @WIRE(mode="straight",linecolor="#30485d",linewidth=0.16) {#XSTD_GPNBN:1 (32.5,-76) (32.5,-76) #XSTD_GPNAN:2};
// &"GPNPRE" @WIRE(mode="straight",linecolor="#30485d",linewidth=0.16) {#XSTD_GPNAN:1 (0.5,-76) (0.5,-76) #X008:4};
// &"GPPB" @WIRE(mode="straight",linecolor="#30485d",linewidth=0.16) {#XSTD_GPPCN:1 (61.5,-114) (61.5,-114) #XSTD_GPPBN:2};
// &"GPPDRV" @WIRE(mode="straight",linecolor="#30485d",linewidth=0.16) {#XSTD_GPPCN:2 (95.5,-114) (95.5,-114) #RGPP0:1};
// &"GPPA" @WIRE(mode="straight",linecolor="#30485d",linewidth=0.16) {#XSTD_GPPBN:1 (32.5,-114) (32.5,-114) #XSTD_GPPAN:2};
// &"GNNRG" @WIRE(mode="straight",linecolor="#30485d",linewidth=0.16) {#RGNN1:1 (222.5,0) (222.5,0) #RGNN0_5__dmy0:2};
// &"RGNN1_1__dmy0" @WIRE(mode="straight",linecolor="#30485d",linewidth=0.16) {#RGNN1:2 (247.5,0) (247.5,0) #RGNN1_2__dmy0:1};
// &"RGNN1_2__dmy0" @WIRE(mode="straight",linecolor="#30485d",linewidth=0.16) {#RGNN1_2__dmy0:2 (272.5,0) (272.5,0) #RGNN1_3__dmy0:1};
// &"RGNN1_3__dmy0" @WIRE(mode="straight",linecolor="#30485d",linewidth=0.16) {#RGNN1_3__dmy0:2 (297.5,0) (297.5,0) #RGNN1_4__dmy0:1};
// &"RGNN1_4__dmy0" @WIRE(mode="straight",linecolor="#30485d",linewidth=0.16) {#RGNN1_4__dmy0:2 (322.5,0) (322.5,0) #RGNN1_5__dmy0:1};
// &"RGNN0_1__dmy0" @WIRE(mode="straight",linecolor="#30485d",linewidth=0.16) {#RGNN0:2 (122.5,0) (122.5,0) #RGNN0_2__dmy0:1};
// &"RGNN0_2__dmy0" @WIRE(mode="straight",linecolor="#30485d",linewidth=0.16) {#RGNN0_2__dmy0:2 (147.5,0) (147.5,0) #RGNN0_3__dmy0:1};
// &"RGNN0_3__dmy0" @WIRE(mode="straight",linecolor="#30485d",linewidth=0.16) {#RGNN0_3__dmy0:2 (172.5,0) (172.5,0) #RGNN0_4__dmy0:1};
// &"RGNN0_4__dmy0" @WIRE(mode="straight",linecolor="#30485d",linewidth=0.16) {#RGNN0_4__dmy0:2 (197.5,0) (197.5,0) #RGNN0_5__dmy0:1};
// &"GNPRG" @WIRE(mode="straight",linecolor="#30485d",linewidth=0.16) {#RGNP1:1 (222.5,-38) (222.5,-38) #RGNP0_5__dmy0:2};
// &"RGNP1_1__dmy0" @WIRE(mode="straight",linecolor="#30485d",linewidth=0.16) {#RGNP1:2 (247.5,-38) (247.5,-38) #RGNP1_2__dmy0:1};
// &"RGNP1_2__dmy0" @WIRE(mode="straight",linecolor="#30485d",linewidth=0.16) {#RGNP1_2__dmy0:2 (272.5,-38) (272.5,-38) #RGNP1_3__dmy0:1};
// &"RGNP1_3__dmy0" @WIRE(mode="straight",linecolor="#30485d",linewidth=0.16) {#RGNP1_3__dmy0:2 (297.5,-38) (297.5,-38) #RGNP1_4__dmy0:1};
// &"RGNP1_4__dmy0" @WIRE(mode="straight",linecolor="#30485d",linewidth=0.16) {#RGNP1_4__dmy0:2 (322.5,-38) (322.5,-38) #RGNP1_5__dmy0:1};
// &"RGNP0_1__dmy0" @WIRE(mode="straight",linecolor="#30485d",linewidth=0.16) {#RGNP0:2 (122.5,-38) (122.5,-38) #RGNP0_2__dmy0:1};
// &"RGNP0_2__dmy0" @WIRE(mode="straight",linecolor="#30485d",linewidth=0.16) {#RGNP0_2__dmy0:2 (147.5,-38) (147.5,-38) #RGNP0_3__dmy0:1};
// &"RGNP0_3__dmy0" @WIRE(mode="straight",linecolor="#30485d",linewidth=0.16) {#RGNP0_3__dmy0:2 (172.5,-38) (172.5,-38) #RGNP0_4__dmy0:1};
// &"RGNP0_4__dmy0" @WIRE(mode="straight",linecolor="#30485d",linewidth=0.16) {#RGNP0_4__dmy0:2 (197.5,-38) (197.5,-38) #RGNP0_5__dmy0:1};
// &"GPNRG" @WIRE(mode="straight",linecolor="#30485d",linewidth=0.16) {#RGPN1:1 (222.5,-76) (222.5,-76) #RGPN0_5__dmy0:2};
// &"RGPN1_1__dmy0" @WIRE(mode="straight",linecolor="#30485d",linewidth=0.16) {#RGPN1:2 (247.5,-76) (247.5,-76) #RGPN1_2__dmy0:1};
// &"RGPN1_2__dmy0" @WIRE(mode="straight",linecolor="#30485d",linewidth=0.16) {#RGPN1_2__dmy0:2 (272.5,-76) (272.5,-76) #RGPN1_3__dmy0:1};
// &"RGPN1_3__dmy0" @WIRE(mode="straight",linecolor="#30485d",linewidth=0.16) {#RGPN1_3__dmy0:2 (297.5,-76) (297.5,-76) #RGPN1_4__dmy0:1};
// &"RGPN1_4__dmy0" @WIRE(mode="straight",linecolor="#30485d",linewidth=0.16) {#RGPN1_4__dmy0:2 (322.5,-76) (322.5,-76) #RGPN1_5__dmy0:1};
// &"RGPN0_1__dmy0" @WIRE(mode="straight",linecolor="#30485d",linewidth=0.16) {#RGPN0:2 (122.5,-76) (122.5,-76) #RGPN0_2__dmy0:1};
// &"RGPN0_2__dmy0" @WIRE(mode="straight",linecolor="#30485d",linewidth=0.16) {#RGPN0_2__dmy0:2 (147.5,-76) (147.5,-76) #RGPN0_3__dmy0:1};
// &"RGPN0_3__dmy0" @WIRE(mode="straight",linecolor="#30485d",linewidth=0.16) {#RGPN0_3__dmy0:2 (172.5,-76) (172.5,-76) #RGPN0_4__dmy0:1};
// &"RGPN0_4__dmy0" @WIRE(mode="straight",linecolor="#30485d",linewidth=0.16) {#RGPN0_4__dmy0:2 (197.5,-76) (197.5,-76) #RGPN0_5__dmy0:1};
// &"GPPRG" @WIRE(mode="straight",linecolor="#30485d",linewidth=0.16) {#RGPP1:1 (222.5,-114) (222.5,-114) #RGPP0_5__dmy0:2};
// &"RGPP1_1__dmy0" @WIRE(mode="straight",linecolor="#30485d",linewidth=0.16) {#RGPP1:2 (247.5,-114) (247.5,-114) #RGPP1_2__dmy0:1};
// &"RGPP1_2__dmy0" @WIRE(mode="straight",linecolor="#30485d",linewidth=0.16) {#RGPP1_2__dmy0:2 (272.5,-114) (272.5,-114) #RGPP1_3__dmy0:1};
// &"RGPP1_3__dmy0" @WIRE(mode="straight",linecolor="#30485d",linewidth=0.16) {#RGPP1_3__dmy0:2 (297.5,-114) (297.5,-114) #RGPP1_4__dmy0:1};
// &"RGPP1_4__dmy0" @WIRE(mode="straight",linecolor="#30485d",linewidth=0.16) {#RGPP1_4__dmy0:2 (322.5,-114) (322.5,-114) #RGPP1_5__dmy0:1};
// &"RGPP0_1__dmy0" @WIRE(mode="straight",linecolor="#30485d",linewidth=0.16) {#RGPP0:2 (122.5,-114) (122.5,-114) #RGPP0_2__dmy0:1};
// &"RGPP0_2__dmy0" @WIRE(mode="straight",linecolor="#30485d",linewidth=0.16) {#RGPP0_2__dmy0:2 (147.5,-114) (147.5,-114) #RGPP0_3__dmy0:1};
// &"RGPP0_3__dmy0" @WIRE(mode="straight",linecolor="#30485d",linewidth=0.16) {#RGPP0_3__dmy0:2 (172.5,-114) (172.5,-114) #RGPP0_4__dmy0:1};
// &"RGPP0_4__dmy0" @WIRE(mode="straight",linecolor="#30485d",linewidth=0.16) {#RGPP0_4__dmy0:2 (197.5,-114) (197.5,-114) #RGPP0_5__dmy0:1};
// (-28,-148) @TEXT("GP and GN chains keep their source polarity, device sizing and series R; no zero-delay abstraction.",size=1,halign="start",textcolor="#223d52");
// &"VDD" @WIRE(mode="straight",linecolor="#30485d",linewidth=0.16) {#XSTD_GNNCN:3 (76,10)};
// (76,10.4) @TEXT("VDD",size=1.1,halign="middle",valign="bottom");
// &"VSS" @WIRE(mode="straight",linecolor="#30485d",linewidth=0.16) {#XSTD_GNNCN:4 (76,-10)};
// (76,-10.4) @TEXT("VSS",size=1.1,halign="middle",valign="top");
// &"VDD" @WIRE(mode="straight",linecolor="#30485d",linewidth=0.16) {#XSTD_GNNBN:3 (47,10)};
// (47,10.4) @TEXT("VDD",size=1.1,halign="middle",valign="bottom");
// &"VSS" @WIRE(mode="straight",linecolor="#30485d",linewidth=0.16) {#XSTD_GNNBN:4 (47,-10)};
// (47,-10.4) @TEXT("VSS",size=1.1,halign="middle",valign="top");
// &"VDD" @WIRE(mode="straight",linecolor="#30485d",linewidth=0.16) {#XSTD_GNNAN:3 (18,10)};
// (18,10.4) @TEXT("VDD",size=1.1,halign="middle",valign="bottom");
// &"VSS" @WIRE(mode="straight",linecolor="#30485d",linewidth=0.16) {#XSTD_GNNAN:4 (18,-10)};
// (18,-10.4) @TEXT("VSS",size=1.1,halign="middle",valign="top");
// &"VDD" @WIRE(mode="straight",linecolor="#30485d",linewidth=0.16) {#XSTD_GNPCN:3 (76,-28)};
// (76,-27.6) @TEXT("VDD",size=1.1,halign="middle",valign="bottom");
// &"VSS" @WIRE(mode="straight",linecolor="#30485d",linewidth=0.16) {#XSTD_GNPCN:4 (76,-48)};
// (76,-48.4) @TEXT("VSS",size=1.1,halign="middle",valign="top");
// &"VDD" @WIRE(mode="straight",linecolor="#30485d",linewidth=0.16) {#XSTD_GNPBN:3 (47,-28)};
// (47,-27.6) @TEXT("VDD",size=1.1,halign="middle",valign="bottom");
// &"VSS" @WIRE(mode="straight",linecolor="#30485d",linewidth=0.16) {#XSTD_GNPBN:4 (47,-48)};
// (47,-48.4) @TEXT("VSS",size=1.1,halign="middle",valign="top");
// &"VDD" @WIRE(mode="straight",linecolor="#30485d",linewidth=0.16) {#XSTD_GNPAN:3 (18,-28)};
// (18,-27.6) @TEXT("VDD",size=1.1,halign="middle",valign="bottom");
// &"VSS" @WIRE(mode="straight",linecolor="#30485d",linewidth=0.16) {#XSTD_GNPAN:4 (18,-48)};
// (18,-48.4) @TEXT("VSS",size=1.1,halign="middle",valign="top");
// &"VDD" @WIRE(mode="straight",linecolor="#30485d",linewidth=0.16) {#XSTD_GPNCN:3 (76,-66)};
// (76,-65.6) @TEXT("VDD",size=1.1,halign="middle",valign="bottom");
// &"VSS" @WIRE(mode="straight",linecolor="#30485d",linewidth=0.16) {#XSTD_GPNCN:4 (76,-86)};
// (76,-86.4) @TEXT("VSS",size=1.1,halign="middle",valign="top");
// &"VDD" @WIRE(mode="straight",linecolor="#30485d",linewidth=0.16) {#XSTD_GPNBN:3 (47,-66)};
// (47,-65.6) @TEXT("VDD",size=1.1,halign="middle",valign="bottom");
// &"VSS" @WIRE(mode="straight",linecolor="#30485d",linewidth=0.16) {#XSTD_GPNBN:4 (47,-86)};
// (47,-86.4) @TEXT("VSS",size=1.1,halign="middle",valign="top");
// &"VDD" @WIRE(mode="straight",linecolor="#30485d",linewidth=0.16) {#XSTD_GPNAN:3 (18,-66)};
// (18,-65.6) @TEXT("VDD",size=1.1,halign="middle",valign="bottom");
// &"VSS" @WIRE(mode="straight",linecolor="#30485d",linewidth=0.16) {#XSTD_GPNAN:4 (18,-86)};
// (18,-86.4) @TEXT("VSS",size=1.1,halign="middle",valign="top");
// &"VDD" @WIRE(mode="straight",linecolor="#30485d",linewidth=0.16) {#XSTD_GPPCN:3 (76,-104)};
// (76,-103.6) @TEXT("VDD",size=1.1,halign="middle",valign="bottom");
// &"VSS" @WIRE(mode="straight",linecolor="#30485d",linewidth=0.16) {#XSTD_GPPCN:4 (76,-124)};
// (76,-124.4) @TEXT("VSS",size=1.1,halign="middle",valign="top");
// &"VDD" @WIRE(mode="straight",linecolor="#30485d",linewidth=0.16) {#XSTD_GPPBN:3 (47,-104)};
// (47,-103.6) @TEXT("VDD",size=1.1,halign="middle",valign="bottom");
// &"VSS" @WIRE(mode="straight",linecolor="#30485d",linewidth=0.16) {#XSTD_GPPBN:4 (47,-124)};
// (47,-124.4) @TEXT("VSS",size=1.1,halign="middle",valign="top");
// &"L" @WIRE(mode="straight",linecolor="#30485d",linewidth=0.16) {#XSTD_GPPAN:1 (8,-114)};
// (7.6,-114) @TEXT("L",size=1.1,halign="end",valign="middle");
// &"VDD" @WIRE(mode="straight",linecolor="#30485d",linewidth=0.16) {#XSTD_GPPAN:3 (18,-104)};
// (18,-103.6) @TEXT("VDD",size=1.1,halign="middle",valign="bottom");
// &"VSS" @WIRE(mode="straight",linecolor="#30485d",linewidth=0.16) {#XSTD_GPPAN:4 (18,-124)};
// (18,-124.4) @TEXT("VSS",size=1.1,halign="middle",valign="top");
// &"GNN" @WIRE(mode="straight",linecolor="#30485d",linewidth=0.16) {#RGNN1_5__dmy0:2 (340,0)};
// (340.4,0) @TEXT("GNN",size=1.1,halign="start",valign="middle");
// &"GNP" @WIRE(mode="straight",linecolor="#30485d",linewidth=0.16) {#RGNP1_5__dmy0:2 (340,-38)};
// (340.4,-38) @TEXT("GNP",size=1.1,halign="start",valign="middle");
// &"GPN" @WIRE(mode="straight",linecolor="#30485d",linewidth=0.16) {#RGPN1_5__dmy0:2 (340,-76)};
// (340.4,-76) @TEXT("GPN",size=1.1,halign="start",valign="middle");
// &"GPP" @WIRE(mode="straight",linecolor="#30485d",linewidth=0.16) {#RGPP1_5__dmy0:2 (340,-114)};
// (340.4,-114) @TEXT("GPP",size=1.1,halign="start",valign="middle");
// &"L" @WIRE(mode="straight",linecolor="#30485d",linewidth=0.16) {#X025:1 (-27,0)};
// (-27.4,0) @TEXT("L",size=1.1,halign="end",valign="middle");
// &"VDD" @WIRE(mode="straight",linecolor="#30485d",linewidth=0.16) {#X025:2 (-17,10)};
// (-17,10.4) @TEXT("VDD",size=1.1,halign="middle",valign="bottom");
// &"VSS" @WIRE(mode="straight",linecolor="#30485d",linewidth=0.16) {#X025:3 (-17,-10)};
// (-17,-10.4) @TEXT("VSS",size=1.1,halign="middle",valign="top");
// &"VDD" @WIRE(mode="straight",linecolor="#30485d",linewidth=0.16) {#X008:2 (-17,-66)};
// (-17,-65.6) @TEXT("VDD",size=1.1,halign="middle",valign="bottom");
// &"VSS" @WIRE(mode="straight",linecolor="#30485d",linewidth=0.16) {#X008:3 (-17,-86)};
// (-17,-86.4) @TEXT("VSS",size=1.1,halign="middle",valign="top");
// }
// END SARADC RNL
ends sar8p_refdrv_b7

subckt sar8p_refword CODE0 CODE1 CODE2 CODE3 CODE4 CODE5 CODE6 CODE7 D0 D1          D2 D3 D4 D5 D6 D7 GNN0 GNN1 GNN2 GNN3 GNN4 GNN5 GNN6 GNN7 GNP0          GNP1 GNP2 GNP3 GNP4 GNP5 GNP6 GNP7 GPN0 GPN1 GPN2 GPN3 GPN4 GPN5          GPN6 GPN7 GPP0 GPP1 GPP2 GPP3 GPP4 GPP5 GPP6 GPP7 PHI_U SAMPLE VDD          VSS
    X002 (FIRST1 VDD VSS FIRST2) sar8p_buf
    X001 (FIRST0 VDD VSS FIRST1) sar8p_buf
    X000 (PHI_U VDD VSS FIRST0) sar8p_buf
    X007 (FIRST2 LATE_CLK VDD VSS CAP_REQ) sar8p_or2
    X003 (SAMPLE ACK VDD VSS REQ_RESET) sar8p_or2
    XREQUEST (REQ_Q REQ_RESET PHI_U VDD VSS) sar8p_sr
    XD_LATE_CLK (REQ_Q VDD VSS LATE_CLK) sar8p_delay_capture
    XD_ACK (LATE_CLK VDD VSS ACK) sar8p_delay_valid
    X008 (CAP_REQ VDD VSS CAP_CLK) sar8p_clkbuf
    XMUX7 (CODE7 D7 PHI_U VDD VSS TARGET7) sar8p_mux2
    XMUX6 (CODE6 D6 PHI_U VDD VSS TARGET6) sar8p_mux2
    XMUX5 (CODE5 D5 PHI_U VDD VSS TARGET5) sar8p_mux2
    XMUX4 (CODE4 D4 PHI_U VDD VSS TARGET4) sar8p_mux2
    XMUX3 (CODE3 D3 PHI_U VDD VSS TARGET3) sar8p_mux2
    XMUX2 (CODE2 D2 PHI_U VDD VSS TARGET2) sar8p_mux2
    XMUX1 (CODE1 D1 PHI_U VDD VSS TARGET1) sar8p_mux2
    XMUX0 (CODE0 D0 PHI_U VDD VSS TARGET0) sar8p_mux2
    X018 (MSB_QN VDD VSS Q7) sar8p_inv
    X017 (TARGET7 VDD VSS MSB_DN) sar8p_inv
    XSTORE7 (CAP_CLK MSB_DN MSB_QN SAMPLE VDD VSS) sar8p_dffr
    XSTORE6 (CAP_CLK TARGET6 Q6 SAMPLE VDD VSS) sar8p_dffr
    XSTORE5 (CAP_CLK TARGET5 Q5 SAMPLE VDD VSS) sar8p_dffr
    XSTORE4 (CAP_CLK TARGET4 Q4 SAMPLE VDD VSS) sar8p_dffr
    XSTORE3 (CAP_CLK TARGET3 Q3 SAMPLE VDD VSS) sar8p_dffr
    XSTORE2 (CAP_CLK TARGET2 Q2 SAMPLE VDD VSS) sar8p_dffr
    XSTORE1 (CAP_CLK TARGET1 Q1 SAMPLE VDD VSS) sar8p_dffr
    XSTORE0 (CAP_CLK TARGET0 Q0 SAMPLE VDD VSS) sar8p_dffr
    XBBM7 (Q7 H7 L7 VDD VSS) sar8p_nonoverlap
    XBBM6 (Q6 H6 L6 VDD VSS) sar8p_nonoverlap
    XBBM5 (Q5 H5 L5 VDD VSS) sar8p_nonoverlap
    XBBM4 (Q4 H4 L4 VDD VSS) sar8p_nonoverlap
    XBBM3 (Q3 H3 L3 VDD VSS) sar8p_nonoverlap
    XBBM2 (Q2 H2 L2 VDD VSS) sar8p_nonoverlap
    XBBM1 (Q1 H1 L1 VDD VSS) sar8p_nonoverlap
    XBBM0 (Q0 H0 L0 VDD VSS) sar8p_nonoverlap
    XDRV0 (GNN0 GNP0 GPN0 GPP0 H0 L0 VDD VSS) sar8p_refdrv_b0
    XDRV1 (GNN1 GNP1 GPN1 GPP1 H1 L1 VDD VSS) sar8p_refdrv_b1
    XDRV2 (GNN2 GNP2 GPN2 GPP2 H2 L2 VDD VSS) sar8p_refdrv_b2
    XDRV3 (GNN3 GNP3 GPN3 GPP3 H3 L3 VDD VSS) sar8p_refdrv_b3
    XDRV4 (GNN4 GNP4 GPN4 GPP4 H4 L4 VDD VSS) sar8p_refdrv_b4
    XDRV5 (GNN5 GNP5 GPN5 GPP5 H5 L5 VDD VSS) sar8p_refdrv_b5
    XDRV6 (GNN6 GNP6 GPN6 GPP6 H6 L6 VDD VSS) sar8p_refdrv_b6
    XDRV7 (GNN7 GNP7 GPN7 GPP7 H7 L7 VDD VSS) sar8p_refdrv_b7
// BEGIN SARADC RNL
// @RNL(author="saradc topology") {
// (-24,205) @TEXT("sar8p_refword / capture, sequential reset, nonoverlap and gate drive",size=1.5,halign="start",textcolor="#223d52");
// (-24,90) @TEXT("Capture request / first and late clocks / acknowledge",size=1.1,halign="start",textcolor="#223d52");
// #X000 @SET-SYMBOL $S_sar8p_buf;
// #X000 @PLACE(0,65) => @ORIENT("R0");
// #X001 @SET-SYMBOL $S_sar8p_buf;
// #X001 @PLACE(43,65) => @ORIENT("R0");
// #X002 @SET-SYMBOL $S_sar8p_buf;
// #X002 @PLACE(86,65) => @ORIENT("R0");
// #X007 @SET-SYMBOL $S_sar8p_or2;
// #X007 @PLACE(171,65) => @ORIENT("R0");
// #X008 @SET-SYMBOL $S_sar8p_clkbuf;
// #X008 @PLACE(214,65) => @ORIENT("R0");
// #X003 @SET-SYMBOL $S_sar8p_or2;
// #X003 @PLACE(0,25) => @ORIENT("R0");
// #XREQUEST @SET-SYMBOL $S_sar8p_sr;
// #XREQUEST @PLACE(43,25) => @ORIENT("R0");
// #XD_LATE_CLK @SET-SYMBOL $S_sar8p_delay_capture;
// #XD_LATE_CLK @PLACE(86,25) => @ORIENT("R0");
// #XD_ACK @SET-SYMBOL $S_sar8p_delay_valid;
// #XD_ACK @PLACE(129,25) => @ORIENT("R0");
// #XMUX7 @SET-SYMBOL $S_sar8p_mux2;
// #XMUX7 @PLACE(0,-25) => @ORIENT("R0");
// #XSTORE7 @SET-SYMBOL $S_sar8p_dffr;
// #XSTORE7 @PLACE(86,-25) => @ORIENT("R0");
// #XBBM7 @SET-SYMBOL $S_sar8p_nonoverlap;
// #XBBM7 @PLACE(155,-25) => @ORIENT("R0");
// #XDRV7 @SET-SYMBOL $S_sar8p_refdrv_b7;
// #XDRV7 @PLACE(218,-25) => @ORIENT("R0");
// (-24,-11) @TEXT("bit 7",size=1,halign="start",textcolor="#223d52");
// #XMUX6 @SET-SYMBOL $S_sar8p_mux2;
// #XMUX6 @PLACE(0,-63) => @ORIENT("R0");
// #XSTORE6 @SET-SYMBOL $S_sar8p_dffr;
// #XSTORE6 @PLACE(86,-63) => @ORIENT("R0");
// #XBBM6 @SET-SYMBOL $S_sar8p_nonoverlap;
// #XBBM6 @PLACE(155,-63) => @ORIENT("R0");
// #XDRV6 @SET-SYMBOL $S_sar8p_refdrv_b6;
// #XDRV6 @PLACE(218,-63) => @ORIENT("R0");
// (-24,-49) @TEXT("bit 6",size=1,halign="start",textcolor="#223d52");
// #XMUX5 @SET-SYMBOL $S_sar8p_mux2;
// #XMUX5 @PLACE(0,-101) => @ORIENT("R0");
// #XSTORE5 @SET-SYMBOL $S_sar8p_dffr;
// #XSTORE5 @PLACE(86,-101) => @ORIENT("R0");
// #XBBM5 @SET-SYMBOL $S_sar8p_nonoverlap;
// #XBBM5 @PLACE(155,-101) => @ORIENT("R0");
// #XDRV5 @SET-SYMBOL $S_sar8p_refdrv_b5;
// #XDRV5 @PLACE(218,-101) => @ORIENT("R0");
// (-24,-87) @TEXT("bit 5",size=1,halign="start",textcolor="#223d52");
// #XMUX4 @SET-SYMBOL $S_sar8p_mux2;
// #XMUX4 @PLACE(0,-139) => @ORIENT("R0");
// #XSTORE4 @SET-SYMBOL $S_sar8p_dffr;
// #XSTORE4 @PLACE(86,-139) => @ORIENT("R0");
// #XBBM4 @SET-SYMBOL $S_sar8p_nonoverlap;
// #XBBM4 @PLACE(155,-139) => @ORIENT("R0");
// #XDRV4 @SET-SYMBOL $S_sar8p_refdrv_b4;
// #XDRV4 @PLACE(218,-139) => @ORIENT("R0");
// (-24,-125) @TEXT("bit 4",size=1,halign="start",textcolor="#223d52");
// #XMUX3 @SET-SYMBOL $S_sar8p_mux2;
// #XMUX3 @PLACE(0,-177) => @ORIENT("R0");
// #XSTORE3 @SET-SYMBOL $S_sar8p_dffr;
// #XSTORE3 @PLACE(86,-177) => @ORIENT("R0");
// #XBBM3 @SET-SYMBOL $S_sar8p_nonoverlap;
// #XBBM3 @PLACE(155,-177) => @ORIENT("R0");
// #XDRV3 @SET-SYMBOL $S_sar8p_refdrv_b3;
// #XDRV3 @PLACE(218,-177) => @ORIENT("R0");
// (-24,-163) @TEXT("bit 3",size=1,halign="start",textcolor="#223d52");
// #XMUX2 @SET-SYMBOL $S_sar8p_mux2;
// #XMUX2 @PLACE(0,-215) => @ORIENT("R0");
// #XSTORE2 @SET-SYMBOL $S_sar8p_dffr;
// #XSTORE2 @PLACE(86,-215) => @ORIENT("R0");
// #XBBM2 @SET-SYMBOL $S_sar8p_nonoverlap;
// #XBBM2 @PLACE(155,-215) => @ORIENT("R0");
// #XDRV2 @SET-SYMBOL $S_sar8p_refdrv_b2;
// #XDRV2 @PLACE(218,-215) => @ORIENT("R0");
// (-24,-201) @TEXT("bit 2",size=1,halign="start",textcolor="#223d52");
// #XMUX1 @SET-SYMBOL $S_sar8p_mux2;
// #XMUX1 @PLACE(0,-253) => @ORIENT("R0");
// #XSTORE1 @SET-SYMBOL $S_sar8p_dffr;
// #XSTORE1 @PLACE(86,-253) => @ORIENT("R0");
// #XBBM1 @SET-SYMBOL $S_sar8p_nonoverlap;
// #XBBM1 @PLACE(155,-253) => @ORIENT("R0");
// #XDRV1 @SET-SYMBOL $S_sar8p_refdrv_b1;
// #XDRV1 @PLACE(218,-253) => @ORIENT("R0");
// (-24,-239) @TEXT("bit 1",size=1,halign="start",textcolor="#223d52");
// #XMUX0 @SET-SYMBOL $S_sar8p_mux2;
// #XMUX0 @PLACE(0,-291) => @ORIENT("R0");
// #XSTORE0 @SET-SYMBOL $S_sar8p_dffr;
// #XSTORE0 @PLACE(86,-291) => @ORIENT("R0");
// #XBBM0 @SET-SYMBOL $S_sar8p_nonoverlap;
// #XBBM0 @PLACE(155,-291) => @ORIENT("R0");
// #XDRV0 @SET-SYMBOL $S_sar8p_refdrv_b0;
// #XDRV0 @PLACE(218,-291) => @ORIENT("R0");
// (-24,-277) @TEXT("bit 0",size=1,halign="start",textcolor="#223d52");
// #X017 @SET-SYMBOL $S_sar8p_inv;
// #X017 @PLACE(43,-25) => @ORIENT("R0");
// #X018 @SET-SYMBOL $S_sar8p_inv;
// #X018 @PLACE(118,-25) => @ORIENT("R0");
// &"FIRST1" @WIRE(mode="straight",linecolor="#30485d",linewidth=0.16) {#X002:1 (64.5,65) (64.5,65) #X001:4};
// &"FIRST0" @WIRE(mode="straight",linecolor="#30485d",linewidth=0.16) {#X001:1 (21.5,65) (21.5,65) #X000:4};
// &"REQ_RESET" @WIRE(mode="straight",linecolor="#30485d",linewidth=0.16) {#X003:5 (18.5,25) (18.5,26.65) #XREQUEST:2};
// &"REQ_Q" @WIRE(mode="straight",linecolor="#30485d",linewidth=0.16) {#XREQUEST:1 (64.5,25) (64.5,25) #XD_LATE_CLK:1};
// &"TARGET7" @WIRE(mode="straight",linecolor="#30485d",linewidth=0.16) {#XMUX7:6 (21.5,-25) (21.5,-25) #X017:1};
// &"MSB_QN" @WIRE(mode="straight",linecolor="#30485d",linewidth=0.16) {#X018:1 (102,-25) (102,-25) #XSTORE7:3};
// &"Q7" @WIRE(mode="straight",linecolor="#30485d",linewidth=0.16) {#X018:4 (133.5,-25) (133.5,-25) #XBBM7:1};
// &"MSB_DN" @WIRE(mode="straight",linecolor="#30485d",linewidth=0.16) {#X017:4 (64.5,-25) (64.5,-25) #XSTORE7:2};
// &"Q6" @WIRE(mode="straight",linecolor="#30485d",linewidth=0.16) {#XSTORE6:3 (117.5,-63) (117.5,-63) #XBBM6:1};
// &"Q5" @WIRE(mode="straight",linecolor="#30485d",linewidth=0.16) {#XSTORE5:3 (117.5,-101) (117.5,-101) #XBBM5:1};
// &"Q4" @WIRE(mode="straight",linecolor="#30485d",linewidth=0.16) {#XSTORE4:3 (117.5,-139) (117.5,-139) #XBBM4:1};
// &"Q3" @WIRE(mode="straight",linecolor="#30485d",linewidth=0.16) {#XSTORE3:3 (117.5,-177) (117.5,-177) #XBBM3:1};
// &"Q2" @WIRE(mode="straight",linecolor="#30485d",linewidth=0.16) {#XSTORE2:3 (117.5,-215) (117.5,-215) #XBBM2:1};
// &"Q1" @WIRE(mode="straight",linecolor="#30485d",linewidth=0.16) {#XSTORE1:3 (117.5,-253) (117.5,-253) #XBBM1:1};
// &"Q0" @WIRE(mode="straight",linecolor="#30485d",linewidth=0.16) {#XSTORE0:3 (117.5,-291) (117.5,-291) #XBBM0:1};
// &"H7" @WIRE(mode="straight",linecolor="#30485d",linewidth=0.16) {#XBBM7:2 (199.5,-23.35) (199.5,-29.95) #XDRV7:5};
// &"L7" @WIRE(mode="straight",linecolor="#30485d",linewidth=0.16) {#XBBM7:3 (199.5,-26.65) (199.5,-33.25) #XDRV7:6};
// &"H6" @WIRE(mode="straight",linecolor="#30485d",linewidth=0.16) {#XBBM6:2 (199.5,-61.35) (199.5,-67.95) #XDRV6:5};
// &"L6" @WIRE(mode="straight",linecolor="#30485d",linewidth=0.16) {#XBBM6:3 (199.5,-64.65) (199.5,-71.25) #XDRV6:6};
// &"H5" @WIRE(mode="straight",linecolor="#30485d",linewidth=0.16) {#XBBM5:2 (199.5,-99.35) (199.5,-105.95) #XDRV5:5};
// &"L5" @WIRE(mode="straight",linecolor="#30485d",linewidth=0.16) {#XBBM5:3 (199.5,-102.65) (199.5,-109.25) #XDRV5:6};
// &"H4" @WIRE(mode="straight",linecolor="#30485d",linewidth=0.16) {#XBBM4:2 (199.5,-137.35) (199.5,-143.95) #XDRV4:5};
// &"L4" @WIRE(mode="straight",linecolor="#30485d",linewidth=0.16) {#XBBM4:3 (199.5,-140.65) (199.5,-147.25) #XDRV4:6};
// &"H3" @WIRE(mode="straight",linecolor="#30485d",linewidth=0.16) {#XBBM3:2 (199.5,-175.35) (199.5,-181.95) #XDRV3:5};
// &"L3" @WIRE(mode="straight",linecolor="#30485d",linewidth=0.16) {#XBBM3:3 (199.5,-178.65) (199.5,-185.25) #XDRV3:6};
// &"H2" @WIRE(mode="straight",linecolor="#30485d",linewidth=0.16) {#XBBM2:2 (199.5,-213.35) (199.5,-219.95) #XDRV2:5};
// &"L2" @WIRE(mode="straight",linecolor="#30485d",linewidth=0.16) {#XBBM2:3 (199.5,-216.65) (199.5,-223.25) #XDRV2:6};
// &"H1" @WIRE(mode="straight",linecolor="#30485d",linewidth=0.16) {#XBBM1:2 (199.5,-251.35) (199.5,-257.95) #XDRV1:5};
// &"L1" @WIRE(mode="straight",linecolor="#30485d",linewidth=0.16) {#XBBM1:3 (199.5,-254.65) (199.5,-261.25) #XDRV1:6};
// &"H0" @WIRE(mode="straight",linecolor="#30485d",linewidth=0.16) {#XBBM0:2 (199.5,-289.35) (199.5,-295.95) #XDRV0:5};
// &"L0" @WIRE(mode="straight",linecolor="#30485d",linewidth=0.16) {#XBBM0:3 (199.5,-292.65) (199.5,-299.25) #XDRV0:6};
// (-24,-318) @TEXT("CODE / D -> MUX -> resettable storage -> break-before-make -> physical GP/GN drivers",size=1.1,halign="start",textcolor="#223d52");
// &"VDD" @WIRE(mode="straight",linecolor="#30485d",linewidth=0.16) {#X002:2 (86,75)};
// (86,75.4) @TEXT("VDD",size=1.1,halign="middle",valign="bottom");
// &"VSS" @WIRE(mode="straight",linecolor="#30485d",linewidth=0.16) {#X002:3 (86,55)};
// (86,54.6) @TEXT("VSS",size=1.1,halign="middle",valign="top");
// &"FIRST2" @WIRE(mode="straight",linecolor="#30485d",linewidth=0.16) {#X002:4 (96,65)};
// (96.4,65) @TEXT("FIRST2",size=1.1,halign="start",valign="middle");
// &"VDD" @WIRE(mode="straight",linecolor="#30485d",linewidth=0.16) {#X001:2 (43,75)};
// (43,75.4) @TEXT("VDD",size=1.1,halign="middle",valign="bottom");
// &"VSS" @WIRE(mode="straight",linecolor="#30485d",linewidth=0.16) {#X001:3 (43,55)};
// (43,54.6) @TEXT("VSS",size=1.1,halign="middle",valign="top");
// &"PHI_U" @WIRE(mode="straight",linecolor="#30485d",linewidth=0.16) {#X000:1 (-10,65)};
// (-10.4,65) @TEXT("PHI_U",size=1.1,halign="end",valign="middle");
// &"VDD" @WIRE(mode="straight",linecolor="#30485d",linewidth=0.16) {#X000:2 (0,75)};
// (0,75.4) @TEXT("VDD",size=1.1,halign="middle",valign="bottom");
// &"VSS" @WIRE(mode="straight",linecolor="#30485d",linewidth=0.16) {#X000:3 (0,55)};
// (0,54.6) @TEXT("VSS",size=1.1,halign="middle",valign="top");
// &"FIRST2" @WIRE(mode="straight",linecolor="#30485d",linewidth=0.16) {#X007:1 (161,66.7)};
// (160.6,66.7) @TEXT("FIRST2",size=1.1,halign="end",valign="middle");
// &"LATE_CLK" @WIRE(mode="straight",linecolor="#30485d",linewidth=0.16) {#X007:2 (161,63.3)};
// (160.6,63.3) @TEXT("LATE_CLK",size=1.1,halign="end",valign="middle");
// &"VDD" @WIRE(mode="straight",linecolor="#30485d",linewidth=0.16) {#X007:3 (171,75)};
// (171,75.4) @TEXT("VDD",size=1.1,halign="middle",valign="bottom");
// &"VSS" @WIRE(mode="straight",linecolor="#30485d",linewidth=0.16) {#X007:4 (171,55)};
// (171,54.6) @TEXT("VSS",size=1.1,halign="middle",valign="top");
// &"CAP_REQ" @WIRE(mode="straight",linecolor="#30485d",linewidth=0.16) {#X007:5 (181,65)};
// (181.4,65) @TEXT("CAP_REQ",size=1.1,halign="start",valign="middle");
// &"SAMPLE" @WIRE(mode="straight",linecolor="#30485d",linewidth=0.16) {#X003:1 (-10,26.7)};
// (-10.4,26.7) @TEXT("SAMPLE",size=1.1,halign="end",valign="middle");
// &"ACK" @WIRE(mode="straight",linecolor="#30485d",linewidth=0.16) {#X003:2 (-10,23.3)};
// (-10.4,23.3) @TEXT("ACK",size=1.1,halign="end",valign="middle");
// &"VDD" @WIRE(mode="straight",linecolor="#30485d",linewidth=0.16) {#X003:3 (0,35)};
// (0,35.4) @TEXT("VDD",size=1.1,halign="middle",valign="bottom");
// &"VSS" @WIRE(mode="straight",linecolor="#30485d",linewidth=0.16) {#X003:4 (0,15)};
// (0,14.6) @TEXT("VSS",size=1.1,halign="middle",valign="top");
// &"PHI_U" @WIRE(mode="straight",linecolor="#30485d",linewidth=0.16) {#XREQUEST:3 (27,23.35)};
// (26.6,23.35) @TEXT("PHI_U",size=1.1,halign="end",valign="middle");
// &"VDD" @WIRE(mode="straight",linecolor="#30485d",linewidth=0.16) {#XREQUEST:4 (43,36)};
// (43,36.4) @TEXT("VDD",size=1.1,halign="middle",valign="bottom");
// &"VSS" @WIRE(mode="straight",linecolor="#30485d",linewidth=0.16) {#XREQUEST:5 (43,14)};
// (43,13.6) @TEXT("VSS",size=1.1,halign="middle",valign="top");
// &"VDD" @WIRE(mode="straight",linecolor="#30485d",linewidth=0.16) {#XD_LATE_CLK:2 (86,36)};
// (86,36.4) @TEXT("VDD",size=1.1,halign="middle",valign="bottom");
// &"VSS" @WIRE(mode="straight",linecolor="#30485d",linewidth=0.16) {#XD_LATE_CLK:3 (86,14)};
// (86,13.6) @TEXT("VSS",size=1.1,halign="middle",valign="top");
// &"LATE_CLK" @WIRE(mode="straight",linecolor="#30485d",linewidth=0.16) {#XD_LATE_CLK:4 (102,25)};
// (102.4,25) @TEXT("LATE_CLK",size=1.1,halign="start",valign="middle");
// &"LATE_CLK" @WIRE(mode="straight",linecolor="#30485d",linewidth=0.16) {#XD_ACK:1 (113,25)};
// (112.6,25) @TEXT("LATE_CLK",size=1.1,halign="end",valign="middle");
// &"VDD" @WIRE(mode="straight",linecolor="#30485d",linewidth=0.16) {#XD_ACK:2 (129,36)};
// (129,36.4) @TEXT("VDD",size=1.1,halign="middle",valign="bottom");
// &"VSS" @WIRE(mode="straight",linecolor="#30485d",linewidth=0.16) {#XD_ACK:3 (129,14)};
// (129,13.6) @TEXT("VSS",size=1.1,halign="middle",valign="top");
// &"ACK" @WIRE(mode="straight",linecolor="#30485d",linewidth=0.16) {#XD_ACK:4 (145,25)};
// (145.4,25) @TEXT("ACK",size=1.1,halign="start",valign="middle");
// &"CAP_REQ" @WIRE(mode="straight",linecolor="#30485d",linewidth=0.16) {#X008:1 (204,65)};
// (203.6,65) @TEXT("CAP_REQ",size=1.1,halign="end",valign="middle");
// &"VDD" @WIRE(mode="straight",linecolor="#30485d",linewidth=0.16) {#X008:2 (214,75)};
// (214,75.4) @TEXT("VDD",size=1.1,halign="middle",valign="bottom");
// &"VSS" @WIRE(mode="straight",linecolor="#30485d",linewidth=0.16) {#X008:3 (214,55)};
// (214,54.6) @TEXT("VSS",size=1.1,halign="middle",valign="top");
// &"CAP_CLK" @WIRE(mode="straight",linecolor="#30485d",linewidth=0.16) {#X008:4 (224,65)};
// (224.4,65) @TEXT("CAP_CLK",size=1.1,halign="start",valign="middle");
// &"CODE7" @WIRE(mode="straight",linecolor="#30485d",linewidth=0.16) {#XMUX7:1 (-10,-21.6)};
// (-10.4,-21.6) @TEXT("CODE7",size=1.1,halign="end",valign="middle");
// &"D7" @WIRE(mode="straight",linecolor="#30485d",linewidth=0.16) {#XMUX7:2 (-10,-25)};
// (-10.4,-25) @TEXT("D7",size=1.1,halign="end",valign="middle");
// &"PHI_U" @WIRE(mode="straight",linecolor="#30485d",linewidth=0.16) {#XMUX7:3 (-10,-28.4)};
// (-10.4,-28.4) @TEXT("PHI_U",size=1.1,halign="end",valign="middle");
// &"VDD" @WIRE(mode="straight",linecolor="#30485d",linewidth=0.16) {#XMUX7:4 (0,-15)};
// (0,-14.6) @TEXT("VDD",size=1.1,halign="middle",valign="bottom");
// &"VSS" @WIRE(mode="straight",linecolor="#30485d",linewidth=0.16) {#XMUX7:5 (0,-35)};
// (0,-35.4) @TEXT("VSS",size=1.1,halign="middle",valign="top");
// &"CODE6" @WIRE(mode="straight",linecolor="#30485d",linewidth=0.16) {#XMUX6:1 (-10,-59.6)};
// (-10.4,-59.6) @TEXT("CODE6",size=1.1,halign="end",valign="middle");
// &"D6" @WIRE(mode="straight",linecolor="#30485d",linewidth=0.16) {#XMUX6:2 (-10,-63)};
// (-10.4,-63) @TEXT("D6",size=1.1,halign="end",valign="middle");
// &"PHI_U" @WIRE(mode="straight",linecolor="#30485d",linewidth=0.16) {#XMUX6:3 (-10,-66.4)};
// (-10.4,-66.4) @TEXT("PHI_U",size=1.1,halign="end",valign="middle");
// &"VDD" @WIRE(mode="straight",linecolor="#30485d",linewidth=0.16) {#XMUX6:4 (0,-53)};
// (0,-52.6) @TEXT("VDD",size=1.1,halign="middle",valign="bottom");
// &"VSS" @WIRE(mode="straight",linecolor="#30485d",linewidth=0.16) {#XMUX6:5 (0,-73)};
// (0,-73.4) @TEXT("VSS",size=1.1,halign="middle",valign="top");
// &"TARGET6" @WIRE(mode="straight",linecolor="#30485d",linewidth=0.16) {#XMUX6:6 (10,-63)};
// (10.4,-63) @TEXT("TARGET6",size=1.1,halign="start",valign="middle");
// &"CODE5" @WIRE(mode="straight",linecolor="#30485d",linewidth=0.16) {#XMUX5:1 (-10,-97.6)};
// (-10.4,-97.6) @TEXT("CODE5",size=1.1,halign="end",valign="middle");
// &"D5" @WIRE(mode="straight",linecolor="#30485d",linewidth=0.16) {#XMUX5:2 (-10,-101)};
// (-10.4,-101) @TEXT("D5",size=1.1,halign="end",valign="middle");
// &"PHI_U" @WIRE(mode="straight",linecolor="#30485d",linewidth=0.16) {#XMUX5:3 (-10,-104.4)};
// (-10.4,-104.4) @TEXT("PHI_U",size=1.1,halign="end",valign="middle");
// &"VDD" @WIRE(mode="straight",linecolor="#30485d",linewidth=0.16) {#XMUX5:4 (0,-91)};
// (0,-90.6) @TEXT("VDD",size=1.1,halign="middle",valign="bottom");
// &"VSS" @WIRE(mode="straight",linecolor="#30485d",linewidth=0.16) {#XMUX5:5 (0,-111)};
// (0,-111.4) @TEXT("VSS",size=1.1,halign="middle",valign="top");
// &"TARGET5" @WIRE(mode="straight",linecolor="#30485d",linewidth=0.16) {#XMUX5:6 (10,-101)};
// (10.4,-101) @TEXT("TARGET5",size=1.1,halign="start",valign="middle");
// &"CODE4" @WIRE(mode="straight",linecolor="#30485d",linewidth=0.16) {#XMUX4:1 (-10,-135.6)};
// (-10.4,-135.6) @TEXT("CODE4",size=1.1,halign="end",valign="middle");
// &"D4" @WIRE(mode="straight",linecolor="#30485d",linewidth=0.16) {#XMUX4:2 (-10,-139)};
// (-10.4,-139) @TEXT("D4",size=1.1,halign="end",valign="middle");
// &"PHI_U" @WIRE(mode="straight",linecolor="#30485d",linewidth=0.16) {#XMUX4:3 (-10,-142.4)};
// (-10.4,-142.4) @TEXT("PHI_U",size=1.1,halign="end",valign="middle");
// &"VDD" @WIRE(mode="straight",linecolor="#30485d",linewidth=0.16) {#XMUX4:4 (0,-129)};
// (0,-128.6) @TEXT("VDD",size=1.1,halign="middle",valign="bottom");
// &"VSS" @WIRE(mode="straight",linecolor="#30485d",linewidth=0.16) {#XMUX4:5 (0,-149)};
// (0,-149.4) @TEXT("VSS",size=1.1,halign="middle",valign="top");
// &"TARGET4" @WIRE(mode="straight",linecolor="#30485d",linewidth=0.16) {#XMUX4:6 (10,-139)};
// (10.4,-139) @TEXT("TARGET4",size=1.1,halign="start",valign="middle");
// &"CODE3" @WIRE(mode="straight",linecolor="#30485d",linewidth=0.16) {#XMUX3:1 (-10,-173.6)};
// (-10.4,-173.6) @TEXT("CODE3",size=1.1,halign="end",valign="middle");
// &"D3" @WIRE(mode="straight",linecolor="#30485d",linewidth=0.16) {#XMUX3:2 (-10,-177)};
// (-10.4,-177) @TEXT("D3",size=1.1,halign="end",valign="middle");
// &"PHI_U" @WIRE(mode="straight",linecolor="#30485d",linewidth=0.16) {#XMUX3:3 (-10,-180.4)};
// (-10.4,-180.4) @TEXT("PHI_U",size=1.1,halign="end",valign="middle");
// &"VDD" @WIRE(mode="straight",linecolor="#30485d",linewidth=0.16) {#XMUX3:4 (0,-167)};
// (0,-166.6) @TEXT("VDD",size=1.1,halign="middle",valign="bottom");
// &"VSS" @WIRE(mode="straight",linecolor="#30485d",linewidth=0.16) {#XMUX3:5 (0,-187)};
// (0,-187.4) @TEXT("VSS",size=1.1,halign="middle",valign="top");
// &"TARGET3" @WIRE(mode="straight",linecolor="#30485d",linewidth=0.16) {#XMUX3:6 (10,-177)};
// (10.4,-177) @TEXT("TARGET3",size=1.1,halign="start",valign="middle");
// &"CODE2" @WIRE(mode="straight",linecolor="#30485d",linewidth=0.16) {#XMUX2:1 (-10,-211.6)};
// (-10.4,-211.6) @TEXT("CODE2",size=1.1,halign="end",valign="middle");
// &"D2" @WIRE(mode="straight",linecolor="#30485d",linewidth=0.16) {#XMUX2:2 (-10,-215)};
// (-10.4,-215) @TEXT("D2",size=1.1,halign="end",valign="middle");
// &"PHI_U" @WIRE(mode="straight",linecolor="#30485d",linewidth=0.16) {#XMUX2:3 (-10,-218.4)};
// (-10.4,-218.4) @TEXT("PHI_U",size=1.1,halign="end",valign="middle");
// &"VDD" @WIRE(mode="straight",linecolor="#30485d",linewidth=0.16) {#XMUX2:4 (0,-205)};
// (0,-204.6) @TEXT("VDD",size=1.1,halign="middle",valign="bottom");
// &"VSS" @WIRE(mode="straight",linecolor="#30485d",linewidth=0.16) {#XMUX2:5 (0,-225)};
// (0,-225.4) @TEXT("VSS",size=1.1,halign="middle",valign="top");
// &"TARGET2" @WIRE(mode="straight",linecolor="#30485d",linewidth=0.16) {#XMUX2:6 (10,-215)};
// (10.4,-215) @TEXT("TARGET2",size=1.1,halign="start",valign="middle");
// &"CODE1" @WIRE(mode="straight",linecolor="#30485d",linewidth=0.16) {#XMUX1:1 (-10,-249.6)};
// (-10.4,-249.6) @TEXT("CODE1",size=1.1,halign="end",valign="middle");
// &"D1" @WIRE(mode="straight",linecolor="#30485d",linewidth=0.16) {#XMUX1:2 (-10,-253)};
// (-10.4,-253) @TEXT("D1",size=1.1,halign="end",valign="middle");
// &"PHI_U" @WIRE(mode="straight",linecolor="#30485d",linewidth=0.16) {#XMUX1:3 (-10,-256.4)};
// (-10.4,-256.4) @TEXT("PHI_U",size=1.1,halign="end",valign="middle");
// &"VDD" @WIRE(mode="straight",linecolor="#30485d",linewidth=0.16) {#XMUX1:4 (0,-243)};
// (0,-242.6) @TEXT("VDD",size=1.1,halign="middle",valign="bottom");
// &"VSS" @WIRE(mode="straight",linecolor="#30485d",linewidth=0.16) {#XMUX1:5 (0,-263)};
// (0,-263.4) @TEXT("VSS",size=1.1,halign="middle",valign="top");
// &"TARGET1" @WIRE(mode="straight",linecolor="#30485d",linewidth=0.16) {#XMUX1:6 (10,-253)};
// (10.4,-253) @TEXT("TARGET1",size=1.1,halign="start",valign="middle");
// &"CODE0" @WIRE(mode="straight",linecolor="#30485d",linewidth=0.16) {#XMUX0:1 (-10,-287.6)};
// (-10.4,-287.6) @TEXT("CODE0",size=1.1,halign="end",valign="middle");
// &"D0" @WIRE(mode="straight",linecolor="#30485d",linewidth=0.16) {#XMUX0:2 (-10,-291)};
// (-10.4,-291) @TEXT("D0",size=1.1,halign="end",valign="middle");
// &"PHI_U" @WIRE(mode="straight",linecolor="#30485d",linewidth=0.16) {#XMUX0:3 (-10,-294.4)};
// (-10.4,-294.4) @TEXT("PHI_U",size=1.1,halign="end",valign="middle");
// &"VDD" @WIRE(mode="straight",linecolor="#30485d",linewidth=0.16) {#XMUX0:4 (0,-281)};
// (0,-280.6) @TEXT("VDD",size=1.1,halign="middle",valign="bottom");
// &"VSS" @WIRE(mode="straight",linecolor="#30485d",linewidth=0.16) {#XMUX0:5 (0,-301)};
// (0,-301.4) @TEXT("VSS",size=1.1,halign="middle",valign="top");
// &"TARGET0" @WIRE(mode="straight",linecolor="#30485d",linewidth=0.16) {#XMUX0:6 (10,-291)};
// (10.4,-291) @TEXT("TARGET0",size=1.1,halign="start",valign="middle");
// &"VDD" @WIRE(mode="straight",linecolor="#30485d",linewidth=0.16) {#X018:2 (118,-15)};
// (118,-14.6) @TEXT("VDD",size=1.1,halign="middle",valign="bottom");
// &"VSS" @WIRE(mode="straight",linecolor="#30485d",linewidth=0.16) {#X018:3 (118,-35)};
// (118,-35.4) @TEXT("VSS",size=1.1,halign="middle",valign="top");
// &"VDD" @WIRE(mode="straight",linecolor="#30485d",linewidth=0.16) {#X017:2 (43,-15)};
// (43,-14.6) @TEXT("VDD",size=1.1,halign="middle",valign="bottom");
// &"VSS" @WIRE(mode="straight",linecolor="#30485d",linewidth=0.16) {#X017:3 (43,-35)};
// (43,-35.4) @TEXT("VSS",size=1.1,halign="middle",valign="top");
// &"CAP_CLK" @WIRE(mode="straight",linecolor="#30485d",linewidth=0.16) {#XSTORE7:1 (76,-21.6)};
// (75.6,-21.6) @TEXT("CAP_CLK",size=1.1,halign="end",valign="middle");
// &"SAMPLE" @WIRE(mode="straight",linecolor="#30485d",linewidth=0.16) {#XSTORE7:4 (76,-28.4)};
// (75.6,-28.4) @TEXT("SAMPLE",size=1.1,halign="end",valign="middle");
// &"VDD" @WIRE(mode="straight",linecolor="#30485d",linewidth=0.16) {#XSTORE7:5 (86,-15)};
// (86,-14.6) @TEXT("VDD",size=1.1,halign="middle",valign="bottom");
// &"VSS" @WIRE(mode="straight",linecolor="#30485d",linewidth=0.16) {#XSTORE7:6 (86,-35)};
// (86,-35.4) @TEXT("VSS",size=1.1,halign="middle",valign="top");
// &"CAP_CLK" @WIRE(mode="straight",linecolor="#30485d",linewidth=0.16) {#XSTORE6:1 (76,-59.6)};
// (75.6,-59.6) @TEXT("CAP_CLK",size=1.1,halign="end",valign="middle");
// &"TARGET6" @WIRE(mode="straight",linecolor="#30485d",linewidth=0.16) {#XSTORE6:2 (76,-63)};
// (75.6,-63) @TEXT("TARGET6",size=1.1,halign="end",valign="middle");
// &"SAMPLE" @WIRE(mode="straight",linecolor="#30485d",linewidth=0.16) {#XSTORE6:4 (76,-66.4)};
// (75.6,-66.4) @TEXT("SAMPLE",size=1.1,halign="end",valign="middle");
// &"VDD" @WIRE(mode="straight",linecolor="#30485d",linewidth=0.16) {#XSTORE6:5 (86,-53)};
// (86,-52.6) @TEXT("VDD",size=1.1,halign="middle",valign="bottom");
// &"VSS" @WIRE(mode="straight",linecolor="#30485d",linewidth=0.16) {#XSTORE6:6 (86,-73)};
// (86,-73.4) @TEXT("VSS",size=1.1,halign="middle",valign="top");
// &"CAP_CLK" @WIRE(mode="straight",linecolor="#30485d",linewidth=0.16) {#XSTORE5:1 (76,-97.6)};
// (75.6,-97.6) @TEXT("CAP_CLK",size=1.1,halign="end",valign="middle");
// &"TARGET5" @WIRE(mode="straight",linecolor="#30485d",linewidth=0.16) {#XSTORE5:2 (76,-101)};
// (75.6,-101) @TEXT("TARGET5",size=1.1,halign="end",valign="middle");
// &"SAMPLE" @WIRE(mode="straight",linecolor="#30485d",linewidth=0.16) {#XSTORE5:4 (76,-104.4)};
// (75.6,-104.4) @TEXT("SAMPLE",size=1.1,halign="end",valign="middle");
// &"VDD" @WIRE(mode="straight",linecolor="#30485d",linewidth=0.16) {#XSTORE5:5 (86,-91)};
// (86,-90.6) @TEXT("VDD",size=1.1,halign="middle",valign="bottom");
// &"VSS" @WIRE(mode="straight",linecolor="#30485d",linewidth=0.16) {#XSTORE5:6 (86,-111)};
// (86,-111.4) @TEXT("VSS",size=1.1,halign="middle",valign="top");
// &"CAP_CLK" @WIRE(mode="straight",linecolor="#30485d",linewidth=0.16) {#XSTORE4:1 (76,-135.6)};
// (75.6,-135.6) @TEXT("CAP_CLK",size=1.1,halign="end",valign="middle");
// &"TARGET4" @WIRE(mode="straight",linecolor="#30485d",linewidth=0.16) {#XSTORE4:2 (76,-139)};
// (75.6,-139) @TEXT("TARGET4",size=1.1,halign="end",valign="middle");
// &"SAMPLE" @WIRE(mode="straight",linecolor="#30485d",linewidth=0.16) {#XSTORE4:4 (76,-142.4)};
// (75.6,-142.4) @TEXT("SAMPLE",size=1.1,halign="end",valign="middle");
// &"VDD" @WIRE(mode="straight",linecolor="#30485d",linewidth=0.16) {#XSTORE4:5 (86,-129)};
// (86,-128.6) @TEXT("VDD",size=1.1,halign="middle",valign="bottom");
// &"VSS" @WIRE(mode="straight",linecolor="#30485d",linewidth=0.16) {#XSTORE4:6 (86,-149)};
// (86,-149.4) @TEXT("VSS",size=1.1,halign="middle",valign="top");
// &"CAP_CLK" @WIRE(mode="straight",linecolor="#30485d",linewidth=0.16) {#XSTORE3:1 (76,-173.6)};
// (75.6,-173.6) @TEXT("CAP_CLK",size=1.1,halign="end",valign="middle");
// &"TARGET3" @WIRE(mode="straight",linecolor="#30485d",linewidth=0.16) {#XSTORE3:2 (76,-177)};
// (75.6,-177) @TEXT("TARGET3",size=1.1,halign="end",valign="middle");
// &"SAMPLE" @WIRE(mode="straight",linecolor="#30485d",linewidth=0.16) {#XSTORE3:4 (76,-180.4)};
// (75.6,-180.4) @TEXT("SAMPLE",size=1.1,halign="end",valign="middle");
// &"VDD" @WIRE(mode="straight",linecolor="#30485d",linewidth=0.16) {#XSTORE3:5 (86,-167)};
// (86,-166.6) @TEXT("VDD",size=1.1,halign="middle",valign="bottom");
// &"VSS" @WIRE(mode="straight",linecolor="#30485d",linewidth=0.16) {#XSTORE3:6 (86,-187)};
// (86,-187.4) @TEXT("VSS",size=1.1,halign="middle",valign="top");
// &"CAP_CLK" @WIRE(mode="straight",linecolor="#30485d",linewidth=0.16) {#XSTORE2:1 (76,-211.6)};
// (75.6,-211.6) @TEXT("CAP_CLK",size=1.1,halign="end",valign="middle");
// &"TARGET2" @WIRE(mode="straight",linecolor="#30485d",linewidth=0.16) {#XSTORE2:2 (76,-215)};
// (75.6,-215) @TEXT("TARGET2",size=1.1,halign="end",valign="middle");
// &"SAMPLE" @WIRE(mode="straight",linecolor="#30485d",linewidth=0.16) {#XSTORE2:4 (76,-218.4)};
// (75.6,-218.4) @TEXT("SAMPLE",size=1.1,halign="end",valign="middle");
// &"VDD" @WIRE(mode="straight",linecolor="#30485d",linewidth=0.16) {#XSTORE2:5 (86,-205)};
// (86,-204.6) @TEXT("VDD",size=1.1,halign="middle",valign="bottom");
// &"VSS" @WIRE(mode="straight",linecolor="#30485d",linewidth=0.16) {#XSTORE2:6 (86,-225)};
// (86,-225.4) @TEXT("VSS",size=1.1,halign="middle",valign="top");
// &"CAP_CLK" @WIRE(mode="straight",linecolor="#30485d",linewidth=0.16) {#XSTORE1:1 (76,-249.6)};
// (75.6,-249.6) @TEXT("CAP_CLK",size=1.1,halign="end",valign="middle");
// &"TARGET1" @WIRE(mode="straight",linecolor="#30485d",linewidth=0.16) {#XSTORE1:2 (76,-253)};
// (75.6,-253) @TEXT("TARGET1",size=1.1,halign="end",valign="middle");
// &"SAMPLE" @WIRE(mode="straight",linecolor="#30485d",linewidth=0.16) {#XSTORE1:4 (76,-256.4)};
// (75.6,-256.4) @TEXT("SAMPLE",size=1.1,halign="end",valign="middle");
// &"VDD" @WIRE(mode="straight",linecolor="#30485d",linewidth=0.16) {#XSTORE1:5 (86,-243)};
// (86,-242.6) @TEXT("VDD",size=1.1,halign="middle",valign="bottom");
// &"VSS" @WIRE(mode="straight",linecolor="#30485d",linewidth=0.16) {#XSTORE1:6 (86,-263)};
// (86,-263.4) @TEXT("VSS",size=1.1,halign="middle",valign="top");
// &"CAP_CLK" @WIRE(mode="straight",linecolor="#30485d",linewidth=0.16) {#XSTORE0:1 (76,-287.6)};
// (75.6,-287.6) @TEXT("CAP_CLK",size=1.1,halign="end",valign="middle");
// &"TARGET0" @WIRE(mode="straight",linecolor="#30485d",linewidth=0.16) {#XSTORE0:2 (76,-291)};
// (75.6,-291) @TEXT("TARGET0",size=1.1,halign="end",valign="middle");
// &"SAMPLE" @WIRE(mode="straight",linecolor="#30485d",linewidth=0.16) {#XSTORE0:4 (76,-294.4)};
// (75.6,-294.4) @TEXT("SAMPLE",size=1.1,halign="end",valign="middle");
// &"VDD" @WIRE(mode="straight",linecolor="#30485d",linewidth=0.16) {#XSTORE0:5 (86,-281)};
// (86,-280.6) @TEXT("VDD",size=1.1,halign="middle",valign="bottom");
// &"VSS" @WIRE(mode="straight",linecolor="#30485d",linewidth=0.16) {#XSTORE0:6 (86,-301)};
// (86,-301.4) @TEXT("VSS",size=1.1,halign="middle",valign="top");
// &"VDD" @WIRE(mode="straight",linecolor="#30485d",linewidth=0.16) {#XBBM7:4 (155,-14)};
// (155,-13.6) @TEXT("VDD",size=1.1,halign="middle",valign="bottom");
// &"VSS" @WIRE(mode="straight",linecolor="#30485d",linewidth=0.16) {#XBBM7:5 (155,-36)};
// (155,-36.4) @TEXT("VSS",size=1.1,halign="middle",valign="top");
// &"VDD" @WIRE(mode="straight",linecolor="#30485d",linewidth=0.16) {#XBBM6:4 (155,-52)};
// (155,-51.6) @TEXT("VDD",size=1.1,halign="middle",valign="bottom");
// &"VSS" @WIRE(mode="straight",linecolor="#30485d",linewidth=0.16) {#XBBM6:5 (155,-74)};
// (155,-74.4) @TEXT("VSS",size=1.1,halign="middle",valign="top");
// &"VDD" @WIRE(mode="straight",linecolor="#30485d",linewidth=0.16) {#XBBM5:4 (155,-90)};
// (155,-89.6) @TEXT("VDD",size=1.1,halign="middle",valign="bottom");
// &"VSS" @WIRE(mode="straight",linecolor="#30485d",linewidth=0.16) {#XBBM5:5 (155,-112)};
// (155,-112.4) @TEXT("VSS",size=1.1,halign="middle",valign="top");
// &"VDD" @WIRE(mode="straight",linecolor="#30485d",linewidth=0.16) {#XBBM4:4 (155,-128)};
// (155,-127.6) @TEXT("VDD",size=1.1,halign="middle",valign="bottom");
// &"VSS" @WIRE(mode="straight",linecolor="#30485d",linewidth=0.16) {#XBBM4:5 (155,-150)};
// (155,-150.4) @TEXT("VSS",size=1.1,halign="middle",valign="top");
// &"VDD" @WIRE(mode="straight",linecolor="#30485d",linewidth=0.16) {#XBBM3:4 (155,-166)};
// (155,-165.6) @TEXT("VDD",size=1.1,halign="middle",valign="bottom");
// &"VSS" @WIRE(mode="straight",linecolor="#30485d",linewidth=0.16) {#XBBM3:5 (155,-188)};
// (155,-188.4) @TEXT("VSS",size=1.1,halign="middle",valign="top");
// &"VDD" @WIRE(mode="straight",linecolor="#30485d",linewidth=0.16) {#XBBM2:4 (155,-204)};
// (155,-203.6) @TEXT("VDD",size=1.1,halign="middle",valign="bottom");
// &"VSS" @WIRE(mode="straight",linecolor="#30485d",linewidth=0.16) {#XBBM2:5 (155,-226)};
// (155,-226.4) @TEXT("VSS",size=1.1,halign="middle",valign="top");
// &"VDD" @WIRE(mode="straight",linecolor="#30485d",linewidth=0.16) {#XBBM1:4 (155,-242)};
// (155,-241.6) @TEXT("VDD",size=1.1,halign="middle",valign="bottom");
// &"VSS" @WIRE(mode="straight",linecolor="#30485d",linewidth=0.16) {#XBBM1:5 (155,-264)};
// (155,-264.4) @TEXT("VSS",size=1.1,halign="middle",valign="top");
// &"VDD" @WIRE(mode="straight",linecolor="#30485d",linewidth=0.16) {#XBBM0:4 (155,-280)};
// (155,-279.6) @TEXT("VDD",size=1.1,halign="middle",valign="bottom");
// &"VSS" @WIRE(mode="straight",linecolor="#30485d",linewidth=0.16) {#XBBM0:5 (155,-302)};
// (155,-302.4) @TEXT("VSS",size=1.1,halign="middle",valign="top");
// &"GNN0" @WIRE(mode="straight",linecolor="#30485d",linewidth=0.16) {#XDRV0:1 (234,-282.75)};
// (234.4,-282.75) @TEXT("GNN0",size=1.1,halign="start",valign="middle");
// &"GNP0" @WIRE(mode="straight",linecolor="#30485d",linewidth=0.16) {#XDRV0:2 (234,-286.05)};
// (234.4,-286.05) @TEXT("GNP0",size=1.1,halign="start",valign="middle");
// &"GPN0" @WIRE(mode="straight",linecolor="#30485d",linewidth=0.16) {#XDRV0:3 (234,-289.35)};
// (234.4,-289.35) @TEXT("GPN0",size=1.1,halign="start",valign="middle");
// &"GPP0" @WIRE(mode="straight",linecolor="#30485d",linewidth=0.16) {#XDRV0:4 (234,-292.65)};
// (234.4,-292.65) @TEXT("GPP0",size=1.1,halign="start",valign="middle");
// &"VDD" @WIRE(mode="straight",linecolor="#30485d",linewidth=0.16) {#XDRV0:7 (218,-274.45)};
// (218,-274.05) @TEXT("VDD",size=1.1,halign="middle",valign="bottom");
// &"VSS" @WIRE(mode="straight",linecolor="#30485d",linewidth=0.16) {#XDRV0:8 (218,-307.55)};
// (218,-307.95) @TEXT("VSS",size=1.1,halign="middle",valign="top");
// &"GNN1" @WIRE(mode="straight",linecolor="#30485d",linewidth=0.16) {#XDRV1:1 (234,-244.75)};
// (234.4,-244.75) @TEXT("GNN1",size=1.1,halign="start",valign="middle");
// &"GNP1" @WIRE(mode="straight",linecolor="#30485d",linewidth=0.16) {#XDRV1:2 (234,-248.05)};
// (234.4,-248.05) @TEXT("GNP1",size=1.1,halign="start",valign="middle");
// &"GPN1" @WIRE(mode="straight",linecolor="#30485d",linewidth=0.16) {#XDRV1:3 (234,-251.35)};
// (234.4,-251.35) @TEXT("GPN1",size=1.1,halign="start",valign="middle");
// &"GPP1" @WIRE(mode="straight",linecolor="#30485d",linewidth=0.16) {#XDRV1:4 (234,-254.65)};
// (234.4,-254.65) @TEXT("GPP1",size=1.1,halign="start",valign="middle");
// &"VDD" @WIRE(mode="straight",linecolor="#30485d",linewidth=0.16) {#XDRV1:7 (218,-236.45)};
// (218,-236.05) @TEXT("VDD",size=1.1,halign="middle",valign="bottom");
// &"VSS" @WIRE(mode="straight",linecolor="#30485d",linewidth=0.16) {#XDRV1:8 (218,-269.55)};
// (218,-269.95) @TEXT("VSS",size=1.1,halign="middle",valign="top");
// &"GNN2" @WIRE(mode="straight",linecolor="#30485d",linewidth=0.16) {#XDRV2:1 (234,-206.75)};
// (234.4,-206.75) @TEXT("GNN2",size=1.1,halign="start",valign="middle");
// &"GNP2" @WIRE(mode="straight",linecolor="#30485d",linewidth=0.16) {#XDRV2:2 (234,-210.05)};
// (234.4,-210.05) @TEXT("GNP2",size=1.1,halign="start",valign="middle");
// &"GPN2" @WIRE(mode="straight",linecolor="#30485d",linewidth=0.16) {#XDRV2:3 (234,-213.35)};
// (234.4,-213.35) @TEXT("GPN2",size=1.1,halign="start",valign="middle");
// &"GPP2" @WIRE(mode="straight",linecolor="#30485d",linewidth=0.16) {#XDRV2:4 (234,-216.65)};
// (234.4,-216.65) @TEXT("GPP2",size=1.1,halign="start",valign="middle");
// &"VDD" @WIRE(mode="straight",linecolor="#30485d",linewidth=0.16) {#XDRV2:7 (218,-198.45)};
// (218,-198.05) @TEXT("VDD",size=1.1,halign="middle",valign="bottom");
// &"VSS" @WIRE(mode="straight",linecolor="#30485d",linewidth=0.16) {#XDRV2:8 (218,-231.55)};
// (218,-231.95) @TEXT("VSS",size=1.1,halign="middle",valign="top");
// &"GNN3" @WIRE(mode="straight",linecolor="#30485d",linewidth=0.16) {#XDRV3:1 (234,-168.75)};
// (234.4,-168.75) @TEXT("GNN3",size=1.1,halign="start",valign="middle");
// &"GNP3" @WIRE(mode="straight",linecolor="#30485d",linewidth=0.16) {#XDRV3:2 (234,-172.05)};
// (234.4,-172.05) @TEXT("GNP3",size=1.1,halign="start",valign="middle");
// &"GPN3" @WIRE(mode="straight",linecolor="#30485d",linewidth=0.16) {#XDRV3:3 (234,-175.35)};
// (234.4,-175.35) @TEXT("GPN3",size=1.1,halign="start",valign="middle");
// &"GPP3" @WIRE(mode="straight",linecolor="#30485d",linewidth=0.16) {#XDRV3:4 (234,-178.65)};
// (234.4,-178.65) @TEXT("GPP3",size=1.1,halign="start",valign="middle");
// &"VDD" @WIRE(mode="straight",linecolor="#30485d",linewidth=0.16) {#XDRV3:7 (218,-160.45)};
// (218,-160.05) @TEXT("VDD",size=1.1,halign="middle",valign="bottom");
// &"VSS" @WIRE(mode="straight",linecolor="#30485d",linewidth=0.16) {#XDRV3:8 (218,-193.55)};
// (218,-193.95) @TEXT("VSS",size=1.1,halign="middle",valign="top");
// &"GNN4" @WIRE(mode="straight",linecolor="#30485d",linewidth=0.16) {#XDRV4:1 (234,-130.75)};
// (234.4,-130.75) @TEXT("GNN4",size=1.1,halign="start",valign="middle");
// &"GNP4" @WIRE(mode="straight",linecolor="#30485d",linewidth=0.16) {#XDRV4:2 (234,-134.05)};
// (234.4,-134.05) @TEXT("GNP4",size=1.1,halign="start",valign="middle");
// &"GPN4" @WIRE(mode="straight",linecolor="#30485d",linewidth=0.16) {#XDRV4:3 (234,-137.35)};
// (234.4,-137.35) @TEXT("GPN4",size=1.1,halign="start",valign="middle");
// &"GPP4" @WIRE(mode="straight",linecolor="#30485d",linewidth=0.16) {#XDRV4:4 (234,-140.65)};
// (234.4,-140.65) @TEXT("GPP4",size=1.1,halign="start",valign="middle");
// &"VDD" @WIRE(mode="straight",linecolor="#30485d",linewidth=0.16) {#XDRV4:7 (218,-122.45)};
// (218,-122.05) @TEXT("VDD",size=1.1,halign="middle",valign="bottom");
// &"VSS" @WIRE(mode="straight",linecolor="#30485d",linewidth=0.16) {#XDRV4:8 (218,-155.55)};
// (218,-155.95) @TEXT("VSS",size=1.1,halign="middle",valign="top");
// &"GNN5" @WIRE(mode="straight",linecolor="#30485d",linewidth=0.16) {#XDRV5:1 (234,-92.75)};
// (234.4,-92.75) @TEXT("GNN5",size=1.1,halign="start",valign="middle");
// &"GNP5" @WIRE(mode="straight",linecolor="#30485d",linewidth=0.16) {#XDRV5:2 (234,-96.05)};
// (234.4,-96.05) @TEXT("GNP5",size=1.1,halign="start",valign="middle");
// &"GPN5" @WIRE(mode="straight",linecolor="#30485d",linewidth=0.16) {#XDRV5:3 (234,-99.35)};
// (234.4,-99.35) @TEXT("GPN5",size=1.1,halign="start",valign="middle");
// &"GPP5" @WIRE(mode="straight",linecolor="#30485d",linewidth=0.16) {#XDRV5:4 (234,-102.65)};
// (234.4,-102.65) @TEXT("GPP5",size=1.1,halign="start",valign="middle");
// &"VDD" @WIRE(mode="straight",linecolor="#30485d",linewidth=0.16) {#XDRV5:7 (218,-84.45)};
// (218,-84.05) @TEXT("VDD",size=1.1,halign="middle",valign="bottom");
// &"VSS" @WIRE(mode="straight",linecolor="#30485d",linewidth=0.16) {#XDRV5:8 (218,-117.55)};
// (218,-117.95) @TEXT("VSS",size=1.1,halign="middle",valign="top");
// &"GNN6" @WIRE(mode="straight",linecolor="#30485d",linewidth=0.16) {#XDRV6:1 (234,-54.75)};
// (234.4,-54.75) @TEXT("GNN6",size=1.1,halign="start",valign="middle");
// &"GNP6" @WIRE(mode="straight",linecolor="#30485d",linewidth=0.16) {#XDRV6:2 (234,-58.05)};
// (234.4,-58.05) @TEXT("GNP6",size=1.1,halign="start",valign="middle");
// &"GPN6" @WIRE(mode="straight",linecolor="#30485d",linewidth=0.16) {#XDRV6:3 (234,-61.35)};
// (234.4,-61.35) @TEXT("GPN6",size=1.1,halign="start",valign="middle");
// &"GPP6" @WIRE(mode="straight",linecolor="#30485d",linewidth=0.16) {#XDRV6:4 (234,-64.65)};
// (234.4,-64.65) @TEXT("GPP6",size=1.1,halign="start",valign="middle");
// &"VDD" @WIRE(mode="straight",linecolor="#30485d",linewidth=0.16) {#XDRV6:7 (218,-46.45)};
// (218,-46.05) @TEXT("VDD",size=1.1,halign="middle",valign="bottom");
// &"VSS" @WIRE(mode="straight",linecolor="#30485d",linewidth=0.16) {#XDRV6:8 (218,-79.55)};
// (218,-79.95) @TEXT("VSS",size=1.1,halign="middle",valign="top");
// &"GNN7" @WIRE(mode="straight",linecolor="#30485d",linewidth=0.16) {#XDRV7:1 (234,-16.75)};
// (234.4,-16.75) @TEXT("GNN7",size=1.1,halign="start",valign="middle");
// &"GNP7" @WIRE(mode="straight",linecolor="#30485d",linewidth=0.16) {#XDRV7:2 (234,-20.05)};
// (234.4,-20.05) @TEXT("GNP7",size=1.1,halign="start",valign="middle");
// &"GPN7" @WIRE(mode="straight",linecolor="#30485d",linewidth=0.16) {#XDRV7:3 (234,-23.35)};
// (234.4,-23.35) @TEXT("GPN7",size=1.1,halign="start",valign="middle");
// &"GPP7" @WIRE(mode="straight",linecolor="#30485d",linewidth=0.16) {#XDRV7:4 (234,-26.65)};
// (234.4,-26.65) @TEXT("GPP7",size=1.1,halign="start",valign="middle");
// &"VDD" @WIRE(mode="straight",linecolor="#30485d",linewidth=0.16) {#XDRV7:7 (218,-8.45)};
// (218,-8.05) @TEXT("VDD",size=1.1,halign="middle",valign="bottom");
// &"VSS" @WIRE(mode="straight",linecolor="#30485d",linewidth=0.16) {#XDRV7:8 (218,-41.55)};
// (218,-41.95) @TEXT("VSS",size=1.1,halign="middle",valign="top");
// }
// END SARADC RNL
ends sar8p_refword

subckt sar8s_refword CODE0 CODE1 CODE2 CODE3 CODE4 CODE5 CODE6 CODE7 D0 D1  D2 D3 D4 D5 D6 D7 GNN0 GNN1 GNN2 GNN3 GNN4 GNN5 GNN6 GNN7 GNP0  GNP1 GNP2 GNP3 GNP4 GNP5 GNP6 GNP7 GPN0 GPN1 GPN2 GPN3 GPN4 GPN5  GPN6 GPN7 GPP0 GPP1 GPP2 GPP3 GPP4 GPP5 GPP6 GPP7 PHI_U SAMPLE VDD  VSS RST_DONE
    XRR7 (SAMPLE SAMPLE VDD VSS RST7) sar8p_and2
    XRSTEP1 (SAMPLE VDD VSS TAP1) sar8s_step
    XRR6 (SAMPLE TAP1 VDD VSS RST6) sar8p_and2
    XRSTEP2 (TAP1 VDD VSS TAP2) sar8s_step
    XRR5 (SAMPLE TAP2 VDD VSS RST5) sar8p_and2
    XRSTEP3 (TAP2 VDD VSS TAP3) sar8s_step
    XRR4 (SAMPLE TAP3 VDD VSS RST4) sar8p_and2
    XRSTEP4 (TAP3 VDD VSS TAP4) sar8s_step
    XRR3 (SAMPLE TAP4 VDD VSS RST3) sar8p_and2
    XRSTEP5 (TAP4 VDD VSS TAP5) sar8s_step
    XRR2 (SAMPLE TAP5 VDD VSS RST2) sar8p_and2
    XRSTEP6 (TAP5 VDD VSS TAP6) sar8s_step
    XRR1 (SAMPLE TAP6 VDD VSS RST1) sar8p_and2
    XRSTEP7 (TAP6 VDD VSS TAP7) sar8s_step
    XRR0 (SAMPLE TAP7 VDD VSS RST0) sar8p_and2
    XRDONE (RST0 VDD VSS RST_DONE) sar8p_buf
    X002 (FIRST1 VDD VSS FIRST2) sar8p_buf
    X001 (FIRST0 VDD VSS FIRST1) sar8p_buf
    X000 (PHI_U VDD VSS FIRST0) sar8p_buf
    X007 (FIRST2 LATE_CLK VDD VSS CAP_REQ) sar8p_or2
    X003 (SAMPLE ACK VDD VSS REQ_RESET) sar8p_or2
    XREQUEST (REQ_Q REQ_RESET PHI_U VDD VSS) sar8p_sr
    XD_LATE_CLK (REQ_Q VDD VSS LATE_CLK) sar8p_delay_capture
    XD_ACK (LATE_CLK VDD VSS ACK) sar8p_delay_valid
    X008 (CAP_REQ VDD VSS CAP_CLK) sar8p_clkbuf
    XMUX7 (CODE7 D7 PHI_U VDD VSS TARGET7) sar8p_mux2
    XMUX6 (CODE6 D6 PHI_U VDD VSS TARGET6) sar8p_mux2
    XMUX5 (CODE5 D5 PHI_U VDD VSS TARGET5) sar8p_mux2
    XMUX4 (CODE4 D4 PHI_U VDD VSS TARGET4) sar8p_mux2
    XMUX3 (CODE3 D3 PHI_U VDD VSS TARGET3) sar8p_mux2
    XMUX2 (CODE2 D2 PHI_U VDD VSS TARGET2) sar8p_mux2
    XMUX1 (CODE1 D1 PHI_U VDD VSS TARGET1) sar8p_mux2
    XMUX0 (CODE0 D0 PHI_U VDD VSS TARGET0) sar8p_mux2
    X018 (MSB_QN VDD VSS Q7) sar8p_inv
    X017 (TARGET7 VDD VSS MSB_DN) sar8p_inv
    XSTORE7 (CAP_CLK MSB_DN MSB_QN RST7 VDD VSS) sar8p_dffr
    XSTORE6 (CAP_CLK TARGET6 Q6 RST6 VDD VSS) sar8p_dffr
    XSTORE5 (CAP_CLK TARGET5 Q5 RST5 VDD VSS) sar8p_dffr
    XSTORE4 (CAP_CLK TARGET4 Q4 RST4 VDD VSS) sar8p_dffr
    XSTORE3 (CAP_CLK TARGET3 Q3 RST3 VDD VSS) sar8p_dffr
    XSTORE2 (CAP_CLK TARGET2 Q2 RST2 VDD VSS) sar8p_dffr
    XSTORE1 (CAP_CLK TARGET1 Q1 RST1 VDD VSS) sar8p_dffr
    XSTORE0 (CAP_CLK TARGET0 Q0 RST0 VDD VSS) sar8p_dffr
    XBBM7 (Q7 H7 L7 VDD VSS) sar8p_nonoverlap
    XBBM6 (Q6 H6 L6 VDD VSS) sar8p_nonoverlap
    XBBM5 (Q5 H5 L5 VDD VSS) sar8p_nonoverlap
    XBBM4 (Q4 H4 L4 VDD VSS) sar8p_nonoverlap
    XBBM3 (Q3 H3 L3 VDD VSS) sar8p_nonoverlap
    XBBM2 (Q2 H2 L2 VDD VSS) sar8p_nonoverlap
    XBBM1 (Q1 H1 L1 VDD VSS) sar8p_nonoverlap
    XBBM0 (Q0 H0 L0 VDD VSS) sar8p_nonoverlap
    XDRV0 (GNN0 GNP0 GPN0 GPP0 H0 L0 VDD VSS) sar8p_refdrv_b0
    XDRV1 (GNN1 GNP1 GPN1 GPP1 H1 L1 VDD VSS) sar8p_refdrv_b1
    XDRV2 (GNN2 GNP2 GPN2 GPP2 H2 L2 VDD VSS) sar8p_refdrv_b2
    XDRV3 (GNN3 GNP3 GPN3 GPP3 H3 L3 VDD VSS) sar8p_refdrv_b3
    XDRV4 (GNN4 GNP4 GPN4 GPP4 H4 L4 VDD VSS) sar8p_refdrv_b4
    XDRV5 (GNN5 GNP5 GPN5 GPP5 H5 L5 VDD VSS) sar8p_refdrv_b5
    XDRV6 (GNN6 GNP6 GPN6 GPP6 H6 L6 VDD VSS) sar8p_refdrv_b6
    XDRV7 (GNN7 GNP7 GPN7 GPP7 H7 L7 VDD VSS) sar8p_refdrv_b7
// BEGIN SARADC RNL
// @RNL(author="saradc topology") {
// (-24,205) @TEXT("sar8s_refword / capture, sequential reset, nonoverlap and gate drive",size=1.5,halign="start",textcolor="#223d52");
// (-24,187) @TEXT("Sequential preset / bit 7 -> bit 0",size=1.1,halign="start",textcolor="#223d52");
// #XRSTEP1 @SET-SYMBOL $S_sar8s_step;
// #XRSTEP1 @PLACE(43,160) => @ORIENT("R0");
// #XRSTEP2 @SET-SYMBOL $S_sar8s_step;
// #XRSTEP2 @PLACE(86,160) => @ORIENT("R0");
// #XRSTEP3 @SET-SYMBOL $S_sar8s_step;
// #XRSTEP3 @PLACE(129,160) => @ORIENT("R0");
// #XRSTEP4 @SET-SYMBOL $S_sar8s_step;
// #XRSTEP4 @PLACE(172,160) => @ORIENT("R0");
// #XRSTEP5 @SET-SYMBOL $S_sar8s_step;
// #XRSTEP5 @PLACE(215,160) => @ORIENT("R0");
// #XRSTEP6 @SET-SYMBOL $S_sar8s_step;
// #XRSTEP6 @PLACE(258,160) => @ORIENT("R0");
// #XRSTEP7 @SET-SYMBOL $S_sar8s_step;
// #XRSTEP7 @PLACE(301,160) => @ORIENT("R0");
// #XRR7 @SET-SYMBOL $S_sar8p_and2;
// #XRR7 @PLACE(0,125) => @ORIENT("R0");
// #XRR6 @SET-SYMBOL $S_sar8p_and2;
// #XRR6 @PLACE(43,125) => @ORIENT("R0");
// #XRR5 @SET-SYMBOL $S_sar8p_and2;
// #XRR5 @PLACE(86,125) => @ORIENT("R0");
// #XRR4 @SET-SYMBOL $S_sar8p_and2;
// #XRR4 @PLACE(129,125) => @ORIENT("R0");
// #XRR3 @SET-SYMBOL $S_sar8p_and2;
// #XRR3 @PLACE(172,125) => @ORIENT("R0");
// #XRR2 @SET-SYMBOL $S_sar8p_and2;
// #XRR2 @PLACE(215,125) => @ORIENT("R0");
// #XRR1 @SET-SYMBOL $S_sar8p_and2;
// #XRR1 @PLACE(258,125) => @ORIENT("R0");
// #XRR0 @SET-SYMBOL $S_sar8p_and2;
// #XRR0 @PLACE(301,125) => @ORIENT("R0");
// #XRDONE @SET-SYMBOL $S_sar8p_buf;
// #XRDONE @PLACE(344,125) => @ORIENT("R0");
// &"TAP1" @WIRE(mode="straight",linecolor="#30485d",linewidth=0.16) {(63,123.3) (63,160)};
// &"TAP1" @WIRE(mode="straight",linecolor="#30485d",linewidth=0.16) {#XRSTEP1:4 (63,160)};
// $JUNCTION @ATTACH (63,160);
// &"TAP1" @WIRE(mode="straight",linecolor="#30485d",linewidth=0.16) {#XRR6:2 (63,123.3)};
// $JUNCTION @ATTACH (63,123.3);
// &"TAP1" @WIRE(mode="straight",linecolor="#30485d",linewidth=0.16) {#XRSTEP2:1 (63,160)};
// $JUNCTION @ATTACH (63,160);
// &"TAP2" @WIRE(mode="straight",linecolor="#30485d",linewidth=0.16) {(106,123.3) (106,160)};
// &"TAP2" @WIRE(mode="straight",linecolor="#30485d",linewidth=0.16) {#XRSTEP2:4 (106,160)};
// $JUNCTION @ATTACH (106,160);
// &"TAP2" @WIRE(mode="straight",linecolor="#30485d",linewidth=0.16) {#XRR5:2 (106,123.3)};
// $JUNCTION @ATTACH (106,123.3);
// &"TAP2" @WIRE(mode="straight",linecolor="#30485d",linewidth=0.16) {#XRSTEP3:1 (106,160)};
// $JUNCTION @ATTACH (106,160);
// &"TAP3" @WIRE(mode="straight",linecolor="#30485d",linewidth=0.16) {(149,123.3) (149,160)};
// &"TAP3" @WIRE(mode="straight",linecolor="#30485d",linewidth=0.16) {#XRSTEP3:4 (149,160)};
// $JUNCTION @ATTACH (149,160);
// &"TAP3" @WIRE(mode="straight",linecolor="#30485d",linewidth=0.16) {#XRR4:2 (149,123.3)};
// $JUNCTION @ATTACH (149,123.3);
// &"TAP3" @WIRE(mode="straight",linecolor="#30485d",linewidth=0.16) {#XRSTEP4:1 (149,160)};
// $JUNCTION @ATTACH (149,160);
// &"TAP4" @WIRE(mode="straight",linecolor="#30485d",linewidth=0.16) {(192,123.3) (192,160)};
// &"TAP4" @WIRE(mode="straight",linecolor="#30485d",linewidth=0.16) {#XRSTEP4:4 (192,160)};
// $JUNCTION @ATTACH (192,160);
// &"TAP4" @WIRE(mode="straight",linecolor="#30485d",linewidth=0.16) {#XRR3:2 (192,123.3)};
// $JUNCTION @ATTACH (192,123.3);
// &"TAP4" @WIRE(mode="straight",linecolor="#30485d",linewidth=0.16) {#XRSTEP5:1 (192,160)};
// $JUNCTION @ATTACH (192,160);
// &"TAP5" @WIRE(mode="straight",linecolor="#30485d",linewidth=0.16) {(235,123.3) (235,160)};
// &"TAP5" @WIRE(mode="straight",linecolor="#30485d",linewidth=0.16) {#XRSTEP5:4 (235,160)};
// $JUNCTION @ATTACH (235,160);
// &"TAP5" @WIRE(mode="straight",linecolor="#30485d",linewidth=0.16) {#XRR2:2 (235,123.3)};
// $JUNCTION @ATTACH (235,123.3);
// &"TAP5" @WIRE(mode="straight",linecolor="#30485d",linewidth=0.16) {#XRSTEP6:1 (235,160)};
// $JUNCTION @ATTACH (235,160);
// &"TAP6" @WIRE(mode="straight",linecolor="#30485d",linewidth=0.16) {(278,123.3) (278,160)};
// &"TAP6" @WIRE(mode="straight",linecolor="#30485d",linewidth=0.16) {#XRSTEP6:4 (278,160)};
// $JUNCTION @ATTACH (278,160);
// &"TAP6" @WIRE(mode="straight",linecolor="#30485d",linewidth=0.16) {#XRR1:2 (278,123.3)};
// $JUNCTION @ATTACH (278,123.3);
// &"TAP6" @WIRE(mode="straight",linecolor="#30485d",linewidth=0.16) {#XRSTEP7:1 (278,160)};
// $JUNCTION @ATTACH (278,160);
// &"TAP7" @WIRE(mode="straight",linecolor="#30485d",linewidth=0.16) {(321,123.3) (321,160)};
// &"TAP7" @WIRE(mode="straight",linecolor="#30485d",linewidth=0.16) {#XRSTEP7:4 (321,160)};
// $JUNCTION @ATTACH (321,160);
// &"TAP7" @WIRE(mode="straight",linecolor="#30485d",linewidth=0.16) {#XRR0:2 (321,123.3)};
// $JUNCTION @ATTACH (321,123.3);
// (-24,90) @TEXT("Capture request / first and late clocks / acknowledge",size=1.1,halign="start",textcolor="#223d52");
// #X000 @SET-SYMBOL $S_sar8p_buf;
// #X000 @PLACE(0,65) => @ORIENT("R0");
// #X001 @SET-SYMBOL $S_sar8p_buf;
// #X001 @PLACE(43,65) => @ORIENT("R0");
// #X002 @SET-SYMBOL $S_sar8p_buf;
// #X002 @PLACE(86,65) => @ORIENT("R0");
// #X007 @SET-SYMBOL $S_sar8p_or2;
// #X007 @PLACE(171,65) => @ORIENT("R0");
// #X008 @SET-SYMBOL $S_sar8p_clkbuf;
// #X008 @PLACE(214,65) => @ORIENT("R0");
// #X003 @SET-SYMBOL $S_sar8p_or2;
// #X003 @PLACE(0,25) => @ORIENT("R0");
// #XREQUEST @SET-SYMBOL $S_sar8p_sr;
// #XREQUEST @PLACE(43,25) => @ORIENT("R0");
// #XD_LATE_CLK @SET-SYMBOL $S_sar8p_delay_capture;
// #XD_LATE_CLK @PLACE(86,25) => @ORIENT("R0");
// #XD_ACK @SET-SYMBOL $S_sar8p_delay_valid;
// #XD_ACK @PLACE(129,25) => @ORIENT("R0");
// #XMUX7 @SET-SYMBOL $S_sar8p_mux2;
// #XMUX7 @PLACE(0,-25) => @ORIENT("R0");
// #XSTORE7 @SET-SYMBOL $S_sar8p_dffr;
// #XSTORE7 @PLACE(86,-25) => @ORIENT("R0");
// #XBBM7 @SET-SYMBOL $S_sar8p_nonoverlap;
// #XBBM7 @PLACE(155,-25) => @ORIENT("R0");
// #XDRV7 @SET-SYMBOL $S_sar8p_refdrv_b7;
// #XDRV7 @PLACE(218,-25) => @ORIENT("R0");
// (-24,-11) @TEXT("bit 7",size=1,halign="start",textcolor="#223d52");
// #XMUX6 @SET-SYMBOL $S_sar8p_mux2;
// #XMUX6 @PLACE(0,-63) => @ORIENT("R0");
// #XSTORE6 @SET-SYMBOL $S_sar8p_dffr;
// #XSTORE6 @PLACE(86,-63) => @ORIENT("R0");
// #XBBM6 @SET-SYMBOL $S_sar8p_nonoverlap;
// #XBBM6 @PLACE(155,-63) => @ORIENT("R0");
// #XDRV6 @SET-SYMBOL $S_sar8p_refdrv_b6;
// #XDRV6 @PLACE(218,-63) => @ORIENT("R0");
// (-24,-49) @TEXT("bit 6",size=1,halign="start",textcolor="#223d52");
// #XMUX5 @SET-SYMBOL $S_sar8p_mux2;
// #XMUX5 @PLACE(0,-101) => @ORIENT("R0");
// #XSTORE5 @SET-SYMBOL $S_sar8p_dffr;
// #XSTORE5 @PLACE(86,-101) => @ORIENT("R0");
// #XBBM5 @SET-SYMBOL $S_sar8p_nonoverlap;
// #XBBM5 @PLACE(155,-101) => @ORIENT("R0");
// #XDRV5 @SET-SYMBOL $S_sar8p_refdrv_b5;
// #XDRV5 @PLACE(218,-101) => @ORIENT("R0");
// (-24,-87) @TEXT("bit 5",size=1,halign="start",textcolor="#223d52");
// #XMUX4 @SET-SYMBOL $S_sar8p_mux2;
// #XMUX4 @PLACE(0,-139) => @ORIENT("R0");
// #XSTORE4 @SET-SYMBOL $S_sar8p_dffr;
// #XSTORE4 @PLACE(86,-139) => @ORIENT("R0");
// #XBBM4 @SET-SYMBOL $S_sar8p_nonoverlap;
// #XBBM4 @PLACE(155,-139) => @ORIENT("R0");
// #XDRV4 @SET-SYMBOL $S_sar8p_refdrv_b4;
// #XDRV4 @PLACE(218,-139) => @ORIENT("R0");
// (-24,-125) @TEXT("bit 4",size=1,halign="start",textcolor="#223d52");
// #XMUX3 @SET-SYMBOL $S_sar8p_mux2;
// #XMUX3 @PLACE(0,-177) => @ORIENT("R0");
// #XSTORE3 @SET-SYMBOL $S_sar8p_dffr;
// #XSTORE3 @PLACE(86,-177) => @ORIENT("R0");
// #XBBM3 @SET-SYMBOL $S_sar8p_nonoverlap;
// #XBBM3 @PLACE(155,-177) => @ORIENT("R0");
// #XDRV3 @SET-SYMBOL $S_sar8p_refdrv_b3;
// #XDRV3 @PLACE(218,-177) => @ORIENT("R0");
// (-24,-163) @TEXT("bit 3",size=1,halign="start",textcolor="#223d52");
// #XMUX2 @SET-SYMBOL $S_sar8p_mux2;
// #XMUX2 @PLACE(0,-215) => @ORIENT("R0");
// #XSTORE2 @SET-SYMBOL $S_sar8p_dffr;
// #XSTORE2 @PLACE(86,-215) => @ORIENT("R0");
// #XBBM2 @SET-SYMBOL $S_sar8p_nonoverlap;
// #XBBM2 @PLACE(155,-215) => @ORIENT("R0");
// #XDRV2 @SET-SYMBOL $S_sar8p_refdrv_b2;
// #XDRV2 @PLACE(218,-215) => @ORIENT("R0");
// (-24,-201) @TEXT("bit 2",size=1,halign="start",textcolor="#223d52");
// #XMUX1 @SET-SYMBOL $S_sar8p_mux2;
// #XMUX1 @PLACE(0,-253) => @ORIENT("R0");
// #XSTORE1 @SET-SYMBOL $S_sar8p_dffr;
// #XSTORE1 @PLACE(86,-253) => @ORIENT("R0");
// #XBBM1 @SET-SYMBOL $S_sar8p_nonoverlap;
// #XBBM1 @PLACE(155,-253) => @ORIENT("R0");
// #XDRV1 @SET-SYMBOL $S_sar8p_refdrv_b1;
// #XDRV1 @PLACE(218,-253) => @ORIENT("R0");
// (-24,-239) @TEXT("bit 1",size=1,halign="start",textcolor="#223d52");
// #XMUX0 @SET-SYMBOL $S_sar8p_mux2;
// #XMUX0 @PLACE(0,-291) => @ORIENT("R0");
// #XSTORE0 @SET-SYMBOL $S_sar8p_dffr;
// #XSTORE0 @PLACE(86,-291) => @ORIENT("R0");
// #XBBM0 @SET-SYMBOL $S_sar8p_nonoverlap;
// #XBBM0 @PLACE(155,-291) => @ORIENT("R0");
// #XDRV0 @SET-SYMBOL $S_sar8p_refdrv_b0;
// #XDRV0 @PLACE(218,-291) => @ORIENT("R0");
// (-24,-277) @TEXT("bit 0",size=1,halign="start",textcolor="#223d52");
// #X017 @SET-SYMBOL $S_sar8p_inv;
// #X017 @PLACE(43,-25) => @ORIENT("R0");
// #X018 @SET-SYMBOL $S_sar8p_inv;
// #X018 @PLACE(118,-25) => @ORIENT("R0");
// &"FIRST1" @WIRE(mode="straight",linecolor="#30485d",linewidth=0.16) {#X002:1 (64.5,65) (64.5,65) #X001:4};
// &"FIRST0" @WIRE(mode="straight",linecolor="#30485d",linewidth=0.16) {#X001:1 (21.5,65) (21.5,65) #X000:4};
// &"REQ_RESET" @WIRE(mode="straight",linecolor="#30485d",linewidth=0.16) {#X003:5 (18.5,25) (18.5,26.65) #XREQUEST:2};
// &"REQ_Q" @WIRE(mode="straight",linecolor="#30485d",linewidth=0.16) {#XREQUEST:1 (64.5,25) (64.5,25) #XD_LATE_CLK:1};
// &"TARGET7" @WIRE(mode="straight",linecolor="#30485d",linewidth=0.16) {#XMUX7:6 (21.5,-25) (21.5,-25) #X017:1};
// &"MSB_QN" @WIRE(mode="straight",linecolor="#30485d",linewidth=0.16) {#X018:1 (102,-25) (102,-25) #XSTORE7:3};
// &"Q7" @WIRE(mode="straight",linecolor="#30485d",linewidth=0.16) {#X018:4 (133.5,-25) (133.5,-25) #XBBM7:1};
// &"MSB_DN" @WIRE(mode="straight",linecolor="#30485d",linewidth=0.16) {#X017:4 (64.5,-25) (64.5,-25) #XSTORE7:2};
// &"Q6" @WIRE(mode="straight",linecolor="#30485d",linewidth=0.16) {#XSTORE6:3 (117.5,-63) (117.5,-63) #XBBM6:1};
// &"Q5" @WIRE(mode="straight",linecolor="#30485d",linewidth=0.16) {#XSTORE5:3 (117.5,-101) (117.5,-101) #XBBM5:1};
// &"Q4" @WIRE(mode="straight",linecolor="#30485d",linewidth=0.16) {#XSTORE4:3 (117.5,-139) (117.5,-139) #XBBM4:1};
// &"Q3" @WIRE(mode="straight",linecolor="#30485d",linewidth=0.16) {#XSTORE3:3 (117.5,-177) (117.5,-177) #XBBM3:1};
// &"Q2" @WIRE(mode="straight",linecolor="#30485d",linewidth=0.16) {#XSTORE2:3 (117.5,-215) (117.5,-215) #XBBM2:1};
// &"Q1" @WIRE(mode="straight",linecolor="#30485d",linewidth=0.16) {#XSTORE1:3 (117.5,-253) (117.5,-253) #XBBM1:1};
// &"Q0" @WIRE(mode="straight",linecolor="#30485d",linewidth=0.16) {#XSTORE0:3 (117.5,-291) (117.5,-291) #XBBM0:1};
// &"H7" @WIRE(mode="straight",linecolor="#30485d",linewidth=0.16) {#XBBM7:2 (199.5,-23.35) (199.5,-29.95) #XDRV7:5};
// &"L7" @WIRE(mode="straight",linecolor="#30485d",linewidth=0.16) {#XBBM7:3 (199.5,-26.65) (199.5,-33.25) #XDRV7:6};
// &"H6" @WIRE(mode="straight",linecolor="#30485d",linewidth=0.16) {#XBBM6:2 (199.5,-61.35) (199.5,-67.95) #XDRV6:5};
// &"L6" @WIRE(mode="straight",linecolor="#30485d",linewidth=0.16) {#XBBM6:3 (199.5,-64.65) (199.5,-71.25) #XDRV6:6};
// &"H5" @WIRE(mode="straight",linecolor="#30485d",linewidth=0.16) {#XBBM5:2 (199.5,-99.35) (199.5,-105.95) #XDRV5:5};
// &"L5" @WIRE(mode="straight",linecolor="#30485d",linewidth=0.16) {#XBBM5:3 (199.5,-102.65) (199.5,-109.25) #XDRV5:6};
// &"H4" @WIRE(mode="straight",linecolor="#30485d",linewidth=0.16) {#XBBM4:2 (199.5,-137.35) (199.5,-143.95) #XDRV4:5};
// &"L4" @WIRE(mode="straight",linecolor="#30485d",linewidth=0.16) {#XBBM4:3 (199.5,-140.65) (199.5,-147.25) #XDRV4:6};
// &"H3" @WIRE(mode="straight",linecolor="#30485d",linewidth=0.16) {#XBBM3:2 (199.5,-175.35) (199.5,-181.95) #XDRV3:5};
// &"L3" @WIRE(mode="straight",linecolor="#30485d",linewidth=0.16) {#XBBM3:3 (199.5,-178.65) (199.5,-185.25) #XDRV3:6};
// &"H2" @WIRE(mode="straight",linecolor="#30485d",linewidth=0.16) {#XBBM2:2 (199.5,-213.35) (199.5,-219.95) #XDRV2:5};
// &"L2" @WIRE(mode="straight",linecolor="#30485d",linewidth=0.16) {#XBBM2:3 (199.5,-216.65) (199.5,-223.25) #XDRV2:6};
// &"H1" @WIRE(mode="straight",linecolor="#30485d",linewidth=0.16) {#XBBM1:2 (199.5,-251.35) (199.5,-257.95) #XDRV1:5};
// &"L1" @WIRE(mode="straight",linecolor="#30485d",linewidth=0.16) {#XBBM1:3 (199.5,-254.65) (199.5,-261.25) #XDRV1:6};
// &"H0" @WIRE(mode="straight",linecolor="#30485d",linewidth=0.16) {#XBBM0:2 (199.5,-289.35) (199.5,-295.95) #XDRV0:5};
// &"L0" @WIRE(mode="straight",linecolor="#30485d",linewidth=0.16) {#XBBM0:3 (199.5,-292.65) (199.5,-299.25) #XDRV0:6};
// (-24,-318) @TEXT("CODE / D -> MUX -> resettable storage -> break-before-make -> physical GP/GN drivers",size=1.1,halign="start",textcolor="#223d52");
// &"SAMPLE" @WIRE(mode="straight",linecolor="#30485d",linewidth=0.16) {#XRR7:1 (-10,126.7)};
// (-10.4,126.7) @TEXT("SAMPLE",size=1.1,halign="end",valign="middle");
// &"SAMPLE" @WIRE(mode="straight",linecolor="#30485d",linewidth=0.16) {#XRR7:2 (-10,123.3)};
// (-10.4,123.3) @TEXT("SAMPLE",size=1.1,halign="end",valign="middle");
// &"VDD" @WIRE(mode="straight",linecolor="#30485d",linewidth=0.16) {#XRR7:3 (0,135)};
// (0,135.4) @TEXT("VDD",size=1.1,halign="middle",valign="bottom");
// &"VSS" @WIRE(mode="straight",linecolor="#30485d",linewidth=0.16) {#XRR7:4 (0,115)};
// (0,114.6) @TEXT("VSS",size=1.1,halign="middle",valign="top");
// &"RST7" @WIRE(mode="straight",linecolor="#30485d",linewidth=0.16) {#XRR7:5 (10,125)};
// (10.4,125) @TEXT("RST7",size=1.1,halign="start",valign="middle");
// &"SAMPLE" @WIRE(mode="straight",linecolor="#30485d",linewidth=0.16) {#XRSTEP1:1 (27,160)};
// (26.6,160) @TEXT("SAMPLE",size=1.1,halign="end",valign="middle");
// &"VDD" @WIRE(mode="straight",linecolor="#30485d",linewidth=0.16) {#XRSTEP1:2 (43,171)};
// (43,171.4) @TEXT("VDD",size=1.1,halign="middle",valign="bottom");
// &"VSS" @WIRE(mode="straight",linecolor="#30485d",linewidth=0.16) {#XRSTEP1:3 (43,149)};
// (43,148.6) @TEXT("VSS",size=1.1,halign="middle",valign="top");
// &"SAMPLE" @WIRE(mode="straight",linecolor="#30485d",linewidth=0.16) {#XRR6:1 (33,126.7)};
// (32.6,126.7) @TEXT("SAMPLE",size=1.1,halign="end",valign="middle");
// &"VDD" @WIRE(mode="straight",linecolor="#30485d",linewidth=0.16) {#XRR6:3 (43,135)};
// (43,135.4) @TEXT("VDD",size=1.1,halign="middle",valign="bottom");
// &"VSS" @WIRE(mode="straight",linecolor="#30485d",linewidth=0.16) {#XRR6:4 (43,115)};
// (43,114.6) @TEXT("VSS",size=1.1,halign="middle",valign="top");
// &"RST6" @WIRE(mode="straight",linecolor="#30485d",linewidth=0.16) {#XRR6:5 (53,125)};
// (53.4,125) @TEXT("RST6",size=1.1,halign="start",valign="middle");
// &"VDD" @WIRE(mode="straight",linecolor="#30485d",linewidth=0.16) {#XRSTEP2:2 (86,171)};
// (86,171.4) @TEXT("VDD",size=1.1,halign="middle",valign="bottom");
// &"VSS" @WIRE(mode="straight",linecolor="#30485d",linewidth=0.16) {#XRSTEP2:3 (86,149)};
// (86,148.6) @TEXT("VSS",size=1.1,halign="middle",valign="top");
// &"SAMPLE" @WIRE(mode="straight",linecolor="#30485d",linewidth=0.16) {#XRR5:1 (76,126.7)};
// (75.6,126.7) @TEXT("SAMPLE",size=1.1,halign="end",valign="middle");
// &"VDD" @WIRE(mode="straight",linecolor="#30485d",linewidth=0.16) {#XRR5:3 (86,135)};
// (86,135.4) @TEXT("VDD",size=1.1,halign="middle",valign="bottom");
// &"VSS" @WIRE(mode="straight",linecolor="#30485d",linewidth=0.16) {#XRR5:4 (86,115)};
// (86,114.6) @TEXT("VSS",size=1.1,halign="middle",valign="top");
// &"RST5" @WIRE(mode="straight",linecolor="#30485d",linewidth=0.16) {#XRR5:5 (96,125)};
// (96.4,125) @TEXT("RST5",size=1.1,halign="start",valign="middle");
// &"VDD" @WIRE(mode="straight",linecolor="#30485d",linewidth=0.16) {#XRSTEP3:2 (129,171)};
// (129,171.4) @TEXT("VDD",size=1.1,halign="middle",valign="bottom");
// &"VSS" @WIRE(mode="straight",linecolor="#30485d",linewidth=0.16) {#XRSTEP3:3 (129,149)};
// (129,148.6) @TEXT("VSS",size=1.1,halign="middle",valign="top");
// &"SAMPLE" @WIRE(mode="straight",linecolor="#30485d",linewidth=0.16) {#XRR4:1 (119,126.7)};
// (118.6,126.7) @TEXT("SAMPLE",size=1.1,halign="end",valign="middle");
// &"VDD" @WIRE(mode="straight",linecolor="#30485d",linewidth=0.16) {#XRR4:3 (129,135)};
// (129,135.4) @TEXT("VDD",size=1.1,halign="middle",valign="bottom");
// &"VSS" @WIRE(mode="straight",linecolor="#30485d",linewidth=0.16) {#XRR4:4 (129,115)};
// (129,114.6) @TEXT("VSS",size=1.1,halign="middle",valign="top");
// &"RST4" @WIRE(mode="straight",linecolor="#30485d",linewidth=0.16) {#XRR4:5 (139,125)};
// (139.4,125) @TEXT("RST4",size=1.1,halign="start",valign="middle");
// &"VDD" @WIRE(mode="straight",linecolor="#30485d",linewidth=0.16) {#XRSTEP4:2 (172,171)};
// (172,171.4) @TEXT("VDD",size=1.1,halign="middle",valign="bottom");
// &"VSS" @WIRE(mode="straight",linecolor="#30485d",linewidth=0.16) {#XRSTEP4:3 (172,149)};
// (172,148.6) @TEXT("VSS",size=1.1,halign="middle",valign="top");
// &"SAMPLE" @WIRE(mode="straight",linecolor="#30485d",linewidth=0.16) {#XRR3:1 (162,126.7)};
// (161.6,126.7) @TEXT("SAMPLE",size=1.1,halign="end",valign="middle");
// &"VDD" @WIRE(mode="straight",linecolor="#30485d",linewidth=0.16) {#XRR3:3 (172,135)};
// (172,135.4) @TEXT("VDD",size=1.1,halign="middle",valign="bottom");
// &"VSS" @WIRE(mode="straight",linecolor="#30485d",linewidth=0.16) {#XRR3:4 (172,115)};
// (172,114.6) @TEXT("VSS",size=1.1,halign="middle",valign="top");
// &"RST3" @WIRE(mode="straight",linecolor="#30485d",linewidth=0.16) {#XRR3:5 (182,125)};
// (182.4,125) @TEXT("RST3",size=1.1,halign="start",valign="middle");
// &"VDD" @WIRE(mode="straight",linecolor="#30485d",linewidth=0.16) {#XRSTEP5:2 (215,171)};
// (215,171.4) @TEXT("VDD",size=1.1,halign="middle",valign="bottom");
// &"VSS" @WIRE(mode="straight",linecolor="#30485d",linewidth=0.16) {#XRSTEP5:3 (215,149)};
// (215,148.6) @TEXT("VSS",size=1.1,halign="middle",valign="top");
// &"SAMPLE" @WIRE(mode="straight",linecolor="#30485d",linewidth=0.16) {#XRR2:1 (205,126.7)};
// (204.6,126.7) @TEXT("SAMPLE",size=1.1,halign="end",valign="middle");
// &"VDD" @WIRE(mode="straight",linecolor="#30485d",linewidth=0.16) {#XRR2:3 (215,135)};
// (215,135.4) @TEXT("VDD",size=1.1,halign="middle",valign="bottom");
// &"VSS" @WIRE(mode="straight",linecolor="#30485d",linewidth=0.16) {#XRR2:4 (215,115)};
// (215,114.6) @TEXT("VSS",size=1.1,halign="middle",valign="top");
// &"RST2" @WIRE(mode="straight",linecolor="#30485d",linewidth=0.16) {#XRR2:5 (225,125)};
// (225.4,125) @TEXT("RST2",size=1.1,halign="start",valign="middle");
// &"VDD" @WIRE(mode="straight",linecolor="#30485d",linewidth=0.16) {#XRSTEP6:2 (258,171)};
// (258,171.4) @TEXT("VDD",size=1.1,halign="middle",valign="bottom");
// &"VSS" @WIRE(mode="straight",linecolor="#30485d",linewidth=0.16) {#XRSTEP6:3 (258,149)};
// (258,148.6) @TEXT("VSS",size=1.1,halign="middle",valign="top");
// &"SAMPLE" @WIRE(mode="straight",linecolor="#30485d",linewidth=0.16) {#XRR1:1 (248,126.7)};
// (247.6,126.7) @TEXT("SAMPLE",size=1.1,halign="end",valign="middle");
// &"VDD" @WIRE(mode="straight",linecolor="#30485d",linewidth=0.16) {#XRR1:3 (258,135)};
// (258,135.4) @TEXT("VDD",size=1.1,halign="middle",valign="bottom");
// &"VSS" @WIRE(mode="straight",linecolor="#30485d",linewidth=0.16) {#XRR1:4 (258,115)};
// (258,114.6) @TEXT("VSS",size=1.1,halign="middle",valign="top");
// &"RST1" @WIRE(mode="straight",linecolor="#30485d",linewidth=0.16) {#XRR1:5 (268,125)};
// (268.4,125) @TEXT("RST1",size=1.1,halign="start",valign="middle");
// &"VDD" @WIRE(mode="straight",linecolor="#30485d",linewidth=0.16) {#XRSTEP7:2 (301,171)};
// (301,171.4) @TEXT("VDD",size=1.1,halign="middle",valign="bottom");
// &"VSS" @WIRE(mode="straight",linecolor="#30485d",linewidth=0.16) {#XRSTEP7:3 (301,149)};
// (301,148.6) @TEXT("VSS",size=1.1,halign="middle",valign="top");
// &"SAMPLE" @WIRE(mode="straight",linecolor="#30485d",linewidth=0.16) {#XRR0:1 (291,126.7)};
// (290.6,126.7) @TEXT("SAMPLE",size=1.1,halign="end",valign="middle");
// &"VDD" @WIRE(mode="straight",linecolor="#30485d",linewidth=0.16) {#XRR0:3 (301,135)};
// (301,135.4) @TEXT("VDD",size=1.1,halign="middle",valign="bottom");
// &"VSS" @WIRE(mode="straight",linecolor="#30485d",linewidth=0.16) {#XRR0:4 (301,115)};
// (301,114.6) @TEXT("VSS",size=1.1,halign="middle",valign="top");
// &"RST0" @WIRE(mode="straight",linecolor="#30485d",linewidth=0.16) {#XRR0:5 (311,125)};
// (311.4,125) @TEXT("RST0",size=1.1,halign="start",valign="middle");
// &"RST0" @WIRE(mode="straight",linecolor="#30485d",linewidth=0.16) {#XRDONE:1 (334,125)};
// (333.6,125) @TEXT("RST0",size=1.1,halign="end",valign="middle");
// &"VDD" @WIRE(mode="straight",linecolor="#30485d",linewidth=0.16) {#XRDONE:2 (344,135)};
// (344,135.4) @TEXT("VDD",size=1.1,halign="middle",valign="bottom");
// &"VSS" @WIRE(mode="straight",linecolor="#30485d",linewidth=0.16) {#XRDONE:3 (344,115)};
// (344,114.6) @TEXT("VSS",size=1.1,halign="middle",valign="top");
// &"RST_DONE" @WIRE(mode="straight",linecolor="#30485d",linewidth=0.16) {#XRDONE:4 (354,125)};
// (354.4,125) @TEXT("RST_DONE",size=1.1,halign="start",valign="middle");
// &"VDD" @WIRE(mode="straight",linecolor="#30485d",linewidth=0.16) {#X002:2 (86,75)};
// (86,75.4) @TEXT("VDD",size=1.1,halign="middle",valign="bottom");
// &"VSS" @WIRE(mode="straight",linecolor="#30485d",linewidth=0.16) {#X002:3 (86,55)};
// (86,54.6) @TEXT("VSS",size=1.1,halign="middle",valign="top");
// &"FIRST2" @WIRE(mode="straight",linecolor="#30485d",linewidth=0.16) {#X002:4 (96,65)};
// (96.4,65) @TEXT("FIRST2",size=1.1,halign="start",valign="middle");
// &"VDD" @WIRE(mode="straight",linecolor="#30485d",linewidth=0.16) {#X001:2 (43,75)};
// (43,75.4) @TEXT("VDD",size=1.1,halign="middle",valign="bottom");
// &"VSS" @WIRE(mode="straight",linecolor="#30485d",linewidth=0.16) {#X001:3 (43,55)};
// (43,54.6) @TEXT("VSS",size=1.1,halign="middle",valign="top");
// &"PHI_U" @WIRE(mode="straight",linecolor="#30485d",linewidth=0.16) {#X000:1 (-10,65)};
// (-10.4,65) @TEXT("PHI_U",size=1.1,halign="end",valign="middle");
// &"VDD" @WIRE(mode="straight",linecolor="#30485d",linewidth=0.16) {#X000:2 (0,75)};
// (0,75.4) @TEXT("VDD",size=1.1,halign="middle",valign="bottom");
// &"VSS" @WIRE(mode="straight",linecolor="#30485d",linewidth=0.16) {#X000:3 (0,55)};
// (0,54.6) @TEXT("VSS",size=1.1,halign="middle",valign="top");
// &"FIRST2" @WIRE(mode="straight",linecolor="#30485d",linewidth=0.16) {#X007:1 (161,66.7)};
// (160.6,66.7) @TEXT("FIRST2",size=1.1,halign="end",valign="middle");
// &"LATE_CLK" @WIRE(mode="straight",linecolor="#30485d",linewidth=0.16) {#X007:2 (161,63.3)};
// (160.6,63.3) @TEXT("LATE_CLK",size=1.1,halign="end",valign="middle");
// &"VDD" @WIRE(mode="straight",linecolor="#30485d",linewidth=0.16) {#X007:3 (171,75)};
// (171,75.4) @TEXT("VDD",size=1.1,halign="middle",valign="bottom");
// &"VSS" @WIRE(mode="straight",linecolor="#30485d",linewidth=0.16) {#X007:4 (171,55)};
// (171,54.6) @TEXT("VSS",size=1.1,halign="middle",valign="top");
// &"CAP_REQ" @WIRE(mode="straight",linecolor="#30485d",linewidth=0.16) {#X007:5 (181,65)};
// (181.4,65) @TEXT("CAP_REQ",size=1.1,halign="start",valign="middle");
// &"SAMPLE" @WIRE(mode="straight",linecolor="#30485d",linewidth=0.16) {#X003:1 (-10,26.7)};
// (-10.4,26.7) @TEXT("SAMPLE",size=1.1,halign="end",valign="middle");
// &"ACK" @WIRE(mode="straight",linecolor="#30485d",linewidth=0.16) {#X003:2 (-10,23.3)};
// (-10.4,23.3) @TEXT("ACK",size=1.1,halign="end",valign="middle");
// &"VDD" @WIRE(mode="straight",linecolor="#30485d",linewidth=0.16) {#X003:3 (0,35)};
// (0,35.4) @TEXT("VDD",size=1.1,halign="middle",valign="bottom");
// &"VSS" @WIRE(mode="straight",linecolor="#30485d",linewidth=0.16) {#X003:4 (0,15)};
// (0,14.6) @TEXT("VSS",size=1.1,halign="middle",valign="top");
// &"PHI_U" @WIRE(mode="straight",linecolor="#30485d",linewidth=0.16) {#XREQUEST:3 (27,23.35)};
// (26.6,23.35) @TEXT("PHI_U",size=1.1,halign="end",valign="middle");
// &"VDD" @WIRE(mode="straight",linecolor="#30485d",linewidth=0.16) {#XREQUEST:4 (43,36)};
// (43,36.4) @TEXT("VDD",size=1.1,halign="middle",valign="bottom");
// &"VSS" @WIRE(mode="straight",linecolor="#30485d",linewidth=0.16) {#XREQUEST:5 (43,14)};
// (43,13.6) @TEXT("VSS",size=1.1,halign="middle",valign="top");
// &"VDD" @WIRE(mode="straight",linecolor="#30485d",linewidth=0.16) {#XD_LATE_CLK:2 (86,36)};
// (86,36.4) @TEXT("VDD",size=1.1,halign="middle",valign="bottom");
// &"VSS" @WIRE(mode="straight",linecolor="#30485d",linewidth=0.16) {#XD_LATE_CLK:3 (86,14)};
// (86,13.6) @TEXT("VSS",size=1.1,halign="middle",valign="top");
// &"LATE_CLK" @WIRE(mode="straight",linecolor="#30485d",linewidth=0.16) {#XD_LATE_CLK:4 (102,25)};
// (102.4,25) @TEXT("LATE_CLK",size=1.1,halign="start",valign="middle");
// &"LATE_CLK" @WIRE(mode="straight",linecolor="#30485d",linewidth=0.16) {#XD_ACK:1 (113,25)};
// (112.6,25) @TEXT("LATE_CLK",size=1.1,halign="end",valign="middle");
// &"VDD" @WIRE(mode="straight",linecolor="#30485d",linewidth=0.16) {#XD_ACK:2 (129,36)};
// (129,36.4) @TEXT("VDD",size=1.1,halign="middle",valign="bottom");
// &"VSS" @WIRE(mode="straight",linecolor="#30485d",linewidth=0.16) {#XD_ACK:3 (129,14)};
// (129,13.6) @TEXT("VSS",size=1.1,halign="middle",valign="top");
// &"ACK" @WIRE(mode="straight",linecolor="#30485d",linewidth=0.16) {#XD_ACK:4 (145,25)};
// (145.4,25) @TEXT("ACK",size=1.1,halign="start",valign="middle");
// &"CAP_REQ" @WIRE(mode="straight",linecolor="#30485d",linewidth=0.16) {#X008:1 (204,65)};
// (203.6,65) @TEXT("CAP_REQ",size=1.1,halign="end",valign="middle");
// &"VDD" @WIRE(mode="straight",linecolor="#30485d",linewidth=0.16) {#X008:2 (214,75)};
// (214,75.4) @TEXT("VDD",size=1.1,halign="middle",valign="bottom");
// &"VSS" @WIRE(mode="straight",linecolor="#30485d",linewidth=0.16) {#X008:3 (214,55)};
// (214,54.6) @TEXT("VSS",size=1.1,halign="middle",valign="top");
// &"CAP_CLK" @WIRE(mode="straight",linecolor="#30485d",linewidth=0.16) {#X008:4 (224,65)};
// (224.4,65) @TEXT("CAP_CLK",size=1.1,halign="start",valign="middle");
// &"CODE7" @WIRE(mode="straight",linecolor="#30485d",linewidth=0.16) {#XMUX7:1 (-10,-21.6)};
// (-10.4,-21.6) @TEXT("CODE7",size=1.1,halign="end",valign="middle");
// &"D7" @WIRE(mode="straight",linecolor="#30485d",linewidth=0.16) {#XMUX7:2 (-10,-25)};
// (-10.4,-25) @TEXT("D7",size=1.1,halign="end",valign="middle");
// &"PHI_U" @WIRE(mode="straight",linecolor="#30485d",linewidth=0.16) {#XMUX7:3 (-10,-28.4)};
// (-10.4,-28.4) @TEXT("PHI_U",size=1.1,halign="end",valign="middle");
// &"VDD" @WIRE(mode="straight",linecolor="#30485d",linewidth=0.16) {#XMUX7:4 (0,-15)};
// (0,-14.6) @TEXT("VDD",size=1.1,halign="middle",valign="bottom");
// &"VSS" @WIRE(mode="straight",linecolor="#30485d",linewidth=0.16) {#XMUX7:5 (0,-35)};
// (0,-35.4) @TEXT("VSS",size=1.1,halign="middle",valign="top");
// &"CODE6" @WIRE(mode="straight",linecolor="#30485d",linewidth=0.16) {#XMUX6:1 (-10,-59.6)};
// (-10.4,-59.6) @TEXT("CODE6",size=1.1,halign="end",valign="middle");
// &"D6" @WIRE(mode="straight",linecolor="#30485d",linewidth=0.16) {#XMUX6:2 (-10,-63)};
// (-10.4,-63) @TEXT("D6",size=1.1,halign="end",valign="middle");
// &"PHI_U" @WIRE(mode="straight",linecolor="#30485d",linewidth=0.16) {#XMUX6:3 (-10,-66.4)};
// (-10.4,-66.4) @TEXT("PHI_U",size=1.1,halign="end",valign="middle");
// &"VDD" @WIRE(mode="straight",linecolor="#30485d",linewidth=0.16) {#XMUX6:4 (0,-53)};
// (0,-52.6) @TEXT("VDD",size=1.1,halign="middle",valign="bottom");
// &"VSS" @WIRE(mode="straight",linecolor="#30485d",linewidth=0.16) {#XMUX6:5 (0,-73)};
// (0,-73.4) @TEXT("VSS",size=1.1,halign="middle",valign="top");
// &"TARGET6" @WIRE(mode="straight",linecolor="#30485d",linewidth=0.16) {#XMUX6:6 (10,-63)};
// (10.4,-63) @TEXT("TARGET6",size=1.1,halign="start",valign="middle");
// &"CODE5" @WIRE(mode="straight",linecolor="#30485d",linewidth=0.16) {#XMUX5:1 (-10,-97.6)};
// (-10.4,-97.6) @TEXT("CODE5",size=1.1,halign="end",valign="middle");
// &"D5" @WIRE(mode="straight",linecolor="#30485d",linewidth=0.16) {#XMUX5:2 (-10,-101)};
// (-10.4,-101) @TEXT("D5",size=1.1,halign="end",valign="middle");
// &"PHI_U" @WIRE(mode="straight",linecolor="#30485d",linewidth=0.16) {#XMUX5:3 (-10,-104.4)};
// (-10.4,-104.4) @TEXT("PHI_U",size=1.1,halign="end",valign="middle");
// &"VDD" @WIRE(mode="straight",linecolor="#30485d",linewidth=0.16) {#XMUX5:4 (0,-91)};
// (0,-90.6) @TEXT("VDD",size=1.1,halign="middle",valign="bottom");
// &"VSS" @WIRE(mode="straight",linecolor="#30485d",linewidth=0.16) {#XMUX5:5 (0,-111)};
// (0,-111.4) @TEXT("VSS",size=1.1,halign="middle",valign="top");
// &"TARGET5" @WIRE(mode="straight",linecolor="#30485d",linewidth=0.16) {#XMUX5:6 (10,-101)};
// (10.4,-101) @TEXT("TARGET5",size=1.1,halign="start",valign="middle");
// &"CODE4" @WIRE(mode="straight",linecolor="#30485d",linewidth=0.16) {#XMUX4:1 (-10,-135.6)};
// (-10.4,-135.6) @TEXT("CODE4",size=1.1,halign="end",valign="middle");
// &"D4" @WIRE(mode="straight",linecolor="#30485d",linewidth=0.16) {#XMUX4:2 (-10,-139)};
// (-10.4,-139) @TEXT("D4",size=1.1,halign="end",valign="middle");
// &"PHI_U" @WIRE(mode="straight",linecolor="#30485d",linewidth=0.16) {#XMUX4:3 (-10,-142.4)};
// (-10.4,-142.4) @TEXT("PHI_U",size=1.1,halign="end",valign="middle");
// &"VDD" @WIRE(mode="straight",linecolor="#30485d",linewidth=0.16) {#XMUX4:4 (0,-129)};
// (0,-128.6) @TEXT("VDD",size=1.1,halign="middle",valign="bottom");
// &"VSS" @WIRE(mode="straight",linecolor="#30485d",linewidth=0.16) {#XMUX4:5 (0,-149)};
// (0,-149.4) @TEXT("VSS",size=1.1,halign="middle",valign="top");
// &"TARGET4" @WIRE(mode="straight",linecolor="#30485d",linewidth=0.16) {#XMUX4:6 (10,-139)};
// (10.4,-139) @TEXT("TARGET4",size=1.1,halign="start",valign="middle");
// &"CODE3" @WIRE(mode="straight",linecolor="#30485d",linewidth=0.16) {#XMUX3:1 (-10,-173.6)};
// (-10.4,-173.6) @TEXT("CODE3",size=1.1,halign="end",valign="middle");
// &"D3" @WIRE(mode="straight",linecolor="#30485d",linewidth=0.16) {#XMUX3:2 (-10,-177)};
// (-10.4,-177) @TEXT("D3",size=1.1,halign="end",valign="middle");
// &"PHI_U" @WIRE(mode="straight",linecolor="#30485d",linewidth=0.16) {#XMUX3:3 (-10,-180.4)};
// (-10.4,-180.4) @TEXT("PHI_U",size=1.1,halign="end",valign="middle");
// &"VDD" @WIRE(mode="straight",linecolor="#30485d",linewidth=0.16) {#XMUX3:4 (0,-167)};
// (0,-166.6) @TEXT("VDD",size=1.1,halign="middle",valign="bottom");
// &"VSS" @WIRE(mode="straight",linecolor="#30485d",linewidth=0.16) {#XMUX3:5 (0,-187)};
// (0,-187.4) @TEXT("VSS",size=1.1,halign="middle",valign="top");
// &"TARGET3" @WIRE(mode="straight",linecolor="#30485d",linewidth=0.16) {#XMUX3:6 (10,-177)};
// (10.4,-177) @TEXT("TARGET3",size=1.1,halign="start",valign="middle");
// &"CODE2" @WIRE(mode="straight",linecolor="#30485d",linewidth=0.16) {#XMUX2:1 (-10,-211.6)};
// (-10.4,-211.6) @TEXT("CODE2",size=1.1,halign="end",valign="middle");
// &"D2" @WIRE(mode="straight",linecolor="#30485d",linewidth=0.16) {#XMUX2:2 (-10,-215)};
// (-10.4,-215) @TEXT("D2",size=1.1,halign="end",valign="middle");
// &"PHI_U" @WIRE(mode="straight",linecolor="#30485d",linewidth=0.16) {#XMUX2:3 (-10,-218.4)};
// (-10.4,-218.4) @TEXT("PHI_U",size=1.1,halign="end",valign="middle");
// &"VDD" @WIRE(mode="straight",linecolor="#30485d",linewidth=0.16) {#XMUX2:4 (0,-205)};
// (0,-204.6) @TEXT("VDD",size=1.1,halign="middle",valign="bottom");
// &"VSS" @WIRE(mode="straight",linecolor="#30485d",linewidth=0.16) {#XMUX2:5 (0,-225)};
// (0,-225.4) @TEXT("VSS",size=1.1,halign="middle",valign="top");
// &"TARGET2" @WIRE(mode="straight",linecolor="#30485d",linewidth=0.16) {#XMUX2:6 (10,-215)};
// (10.4,-215) @TEXT("TARGET2",size=1.1,halign="start",valign="middle");
// &"CODE1" @WIRE(mode="straight",linecolor="#30485d",linewidth=0.16) {#XMUX1:1 (-10,-249.6)};
// (-10.4,-249.6) @TEXT("CODE1",size=1.1,halign="end",valign="middle");
// &"D1" @WIRE(mode="straight",linecolor="#30485d",linewidth=0.16) {#XMUX1:2 (-10,-253)};
// (-10.4,-253) @TEXT("D1",size=1.1,halign="end",valign="middle");
// &"PHI_U" @WIRE(mode="straight",linecolor="#30485d",linewidth=0.16) {#XMUX1:3 (-10,-256.4)};
// (-10.4,-256.4) @TEXT("PHI_U",size=1.1,halign="end",valign="middle");
// &"VDD" @WIRE(mode="straight",linecolor="#30485d",linewidth=0.16) {#XMUX1:4 (0,-243)};
// (0,-242.6) @TEXT("VDD",size=1.1,halign="middle",valign="bottom");
// &"VSS" @WIRE(mode="straight",linecolor="#30485d",linewidth=0.16) {#XMUX1:5 (0,-263)};
// (0,-263.4) @TEXT("VSS",size=1.1,halign="middle",valign="top");
// &"TARGET1" @WIRE(mode="straight",linecolor="#30485d",linewidth=0.16) {#XMUX1:6 (10,-253)};
// (10.4,-253) @TEXT("TARGET1",size=1.1,halign="start",valign="middle");
// &"CODE0" @WIRE(mode="straight",linecolor="#30485d",linewidth=0.16) {#XMUX0:1 (-10,-287.6)};
// (-10.4,-287.6) @TEXT("CODE0",size=1.1,halign="end",valign="middle");
// &"D0" @WIRE(mode="straight",linecolor="#30485d",linewidth=0.16) {#XMUX0:2 (-10,-291)};
// (-10.4,-291) @TEXT("D0",size=1.1,halign="end",valign="middle");
// &"PHI_U" @WIRE(mode="straight",linecolor="#30485d",linewidth=0.16) {#XMUX0:3 (-10,-294.4)};
// (-10.4,-294.4) @TEXT("PHI_U",size=1.1,halign="end",valign="middle");
// &"VDD" @WIRE(mode="straight",linecolor="#30485d",linewidth=0.16) {#XMUX0:4 (0,-281)};
// (0,-280.6) @TEXT("VDD",size=1.1,halign="middle",valign="bottom");
// &"VSS" @WIRE(mode="straight",linecolor="#30485d",linewidth=0.16) {#XMUX0:5 (0,-301)};
// (0,-301.4) @TEXT("VSS",size=1.1,halign="middle",valign="top");
// &"TARGET0" @WIRE(mode="straight",linecolor="#30485d",linewidth=0.16) {#XMUX0:6 (10,-291)};
// (10.4,-291) @TEXT("TARGET0",size=1.1,halign="start",valign="middle");
// &"VDD" @WIRE(mode="straight",linecolor="#30485d",linewidth=0.16) {#X018:2 (118,-15)};
// (118,-14.6) @TEXT("VDD",size=1.1,halign="middle",valign="bottom");
// &"VSS" @WIRE(mode="straight",linecolor="#30485d",linewidth=0.16) {#X018:3 (118,-35)};
// (118,-35.4) @TEXT("VSS",size=1.1,halign="middle",valign="top");
// &"VDD" @WIRE(mode="straight",linecolor="#30485d",linewidth=0.16) {#X017:2 (43,-15)};
// (43,-14.6) @TEXT("VDD",size=1.1,halign="middle",valign="bottom");
// &"VSS" @WIRE(mode="straight",linecolor="#30485d",linewidth=0.16) {#X017:3 (43,-35)};
// (43,-35.4) @TEXT("VSS",size=1.1,halign="middle",valign="top");
// &"CAP_CLK" @WIRE(mode="straight",linecolor="#30485d",linewidth=0.16) {#XSTORE7:1 (76,-21.6)};
// (75.6,-21.6) @TEXT("CAP_CLK",size=1.1,halign="end",valign="middle");
// &"RST7" @WIRE(mode="straight",linecolor="#30485d",linewidth=0.16) {#XSTORE7:4 (76,-28.4)};
// (75.6,-28.4) @TEXT("RST7",size=1.1,halign="end",valign="middle");
// &"VDD" @WIRE(mode="straight",linecolor="#30485d",linewidth=0.16) {#XSTORE7:5 (86,-15)};
// (86,-14.6) @TEXT("VDD",size=1.1,halign="middle",valign="bottom");
// &"VSS" @WIRE(mode="straight",linecolor="#30485d",linewidth=0.16) {#XSTORE7:6 (86,-35)};
// (86,-35.4) @TEXT("VSS",size=1.1,halign="middle",valign="top");
// &"CAP_CLK" @WIRE(mode="straight",linecolor="#30485d",linewidth=0.16) {#XSTORE6:1 (76,-59.6)};
// (75.6,-59.6) @TEXT("CAP_CLK",size=1.1,halign="end",valign="middle");
// &"TARGET6" @WIRE(mode="straight",linecolor="#30485d",linewidth=0.16) {#XSTORE6:2 (76,-63)};
// (75.6,-63) @TEXT("TARGET6",size=1.1,halign="end",valign="middle");
// &"RST6" @WIRE(mode="straight",linecolor="#30485d",linewidth=0.16) {#XSTORE6:4 (76,-66.4)};
// (75.6,-66.4) @TEXT("RST6",size=1.1,halign="end",valign="middle");
// &"VDD" @WIRE(mode="straight",linecolor="#30485d",linewidth=0.16) {#XSTORE6:5 (86,-53)};
// (86,-52.6) @TEXT("VDD",size=1.1,halign="middle",valign="bottom");
// &"VSS" @WIRE(mode="straight",linecolor="#30485d",linewidth=0.16) {#XSTORE6:6 (86,-73)};
// (86,-73.4) @TEXT("VSS",size=1.1,halign="middle",valign="top");
// &"CAP_CLK" @WIRE(mode="straight",linecolor="#30485d",linewidth=0.16) {#XSTORE5:1 (76,-97.6)};
// (75.6,-97.6) @TEXT("CAP_CLK",size=1.1,halign="end",valign="middle");
// &"TARGET5" @WIRE(mode="straight",linecolor="#30485d",linewidth=0.16) {#XSTORE5:2 (76,-101)};
// (75.6,-101) @TEXT("TARGET5",size=1.1,halign="end",valign="middle");
// &"RST5" @WIRE(mode="straight",linecolor="#30485d",linewidth=0.16) {#XSTORE5:4 (76,-104.4)};
// (75.6,-104.4) @TEXT("RST5",size=1.1,halign="end",valign="middle");
// &"VDD" @WIRE(mode="straight",linecolor="#30485d",linewidth=0.16) {#XSTORE5:5 (86,-91)};
// (86,-90.6) @TEXT("VDD",size=1.1,halign="middle",valign="bottom");
// &"VSS" @WIRE(mode="straight",linecolor="#30485d",linewidth=0.16) {#XSTORE5:6 (86,-111)};
// (86,-111.4) @TEXT("VSS",size=1.1,halign="middle",valign="top");
// &"CAP_CLK" @WIRE(mode="straight",linecolor="#30485d",linewidth=0.16) {#XSTORE4:1 (76,-135.6)};
// (75.6,-135.6) @TEXT("CAP_CLK",size=1.1,halign="end",valign="middle");
// &"TARGET4" @WIRE(mode="straight",linecolor="#30485d",linewidth=0.16) {#XSTORE4:2 (76,-139)};
// (75.6,-139) @TEXT("TARGET4",size=1.1,halign="end",valign="middle");
// &"RST4" @WIRE(mode="straight",linecolor="#30485d",linewidth=0.16) {#XSTORE4:4 (76,-142.4)};
// (75.6,-142.4) @TEXT("RST4",size=1.1,halign="end",valign="middle");
// &"VDD" @WIRE(mode="straight",linecolor="#30485d",linewidth=0.16) {#XSTORE4:5 (86,-129)};
// (86,-128.6) @TEXT("VDD",size=1.1,halign="middle",valign="bottom");
// &"VSS" @WIRE(mode="straight",linecolor="#30485d",linewidth=0.16) {#XSTORE4:6 (86,-149)};
// (86,-149.4) @TEXT("VSS",size=1.1,halign="middle",valign="top");
// &"CAP_CLK" @WIRE(mode="straight",linecolor="#30485d",linewidth=0.16) {#XSTORE3:1 (76,-173.6)};
// (75.6,-173.6) @TEXT("CAP_CLK",size=1.1,halign="end",valign="middle");
// &"TARGET3" @WIRE(mode="straight",linecolor="#30485d",linewidth=0.16) {#XSTORE3:2 (76,-177)};
// (75.6,-177) @TEXT("TARGET3",size=1.1,halign="end",valign="middle");
// &"RST3" @WIRE(mode="straight",linecolor="#30485d",linewidth=0.16) {#XSTORE3:4 (76,-180.4)};
// (75.6,-180.4) @TEXT("RST3",size=1.1,halign="end",valign="middle");
// &"VDD" @WIRE(mode="straight",linecolor="#30485d",linewidth=0.16) {#XSTORE3:5 (86,-167)};
// (86,-166.6) @TEXT("VDD",size=1.1,halign="middle",valign="bottom");
// &"VSS" @WIRE(mode="straight",linecolor="#30485d",linewidth=0.16) {#XSTORE3:6 (86,-187)};
// (86,-187.4) @TEXT("VSS",size=1.1,halign="middle",valign="top");
// &"CAP_CLK" @WIRE(mode="straight",linecolor="#30485d",linewidth=0.16) {#XSTORE2:1 (76,-211.6)};
// (75.6,-211.6) @TEXT("CAP_CLK",size=1.1,halign="end",valign="middle");
// &"TARGET2" @WIRE(mode="straight",linecolor="#30485d",linewidth=0.16) {#XSTORE2:2 (76,-215)};
// (75.6,-215) @TEXT("TARGET2",size=1.1,halign="end",valign="middle");
// &"RST2" @WIRE(mode="straight",linecolor="#30485d",linewidth=0.16) {#XSTORE2:4 (76,-218.4)};
// (75.6,-218.4) @TEXT("RST2",size=1.1,halign="end",valign="middle");
// &"VDD" @WIRE(mode="straight",linecolor="#30485d",linewidth=0.16) {#XSTORE2:5 (86,-205)};
// (86,-204.6) @TEXT("VDD",size=1.1,halign="middle",valign="bottom");
// &"VSS" @WIRE(mode="straight",linecolor="#30485d",linewidth=0.16) {#XSTORE2:6 (86,-225)};
// (86,-225.4) @TEXT("VSS",size=1.1,halign="middle",valign="top");
// &"CAP_CLK" @WIRE(mode="straight",linecolor="#30485d",linewidth=0.16) {#XSTORE1:1 (76,-249.6)};
// (75.6,-249.6) @TEXT("CAP_CLK",size=1.1,halign="end",valign="middle");
// &"TARGET1" @WIRE(mode="straight",linecolor="#30485d",linewidth=0.16) {#XSTORE1:2 (76,-253)};
// (75.6,-253) @TEXT("TARGET1",size=1.1,halign="end",valign="middle");
// &"RST1" @WIRE(mode="straight",linecolor="#30485d",linewidth=0.16) {#XSTORE1:4 (76,-256.4)};
// (75.6,-256.4) @TEXT("RST1",size=1.1,halign="end",valign="middle");
// &"VDD" @WIRE(mode="straight",linecolor="#30485d",linewidth=0.16) {#XSTORE1:5 (86,-243)};
// (86,-242.6) @TEXT("VDD",size=1.1,halign="middle",valign="bottom");
// &"VSS" @WIRE(mode="straight",linecolor="#30485d",linewidth=0.16) {#XSTORE1:6 (86,-263)};
// (86,-263.4) @TEXT("VSS",size=1.1,halign="middle",valign="top");
// &"CAP_CLK" @WIRE(mode="straight",linecolor="#30485d",linewidth=0.16) {#XSTORE0:1 (76,-287.6)};
// (75.6,-287.6) @TEXT("CAP_CLK",size=1.1,halign="end",valign="middle");
// &"TARGET0" @WIRE(mode="straight",linecolor="#30485d",linewidth=0.16) {#XSTORE0:2 (76,-291)};
// (75.6,-291) @TEXT("TARGET0",size=1.1,halign="end",valign="middle");
// &"RST0" @WIRE(mode="straight",linecolor="#30485d",linewidth=0.16) {#XSTORE0:4 (76,-294.4)};
// (75.6,-294.4) @TEXT("RST0",size=1.1,halign="end",valign="middle");
// &"VDD" @WIRE(mode="straight",linecolor="#30485d",linewidth=0.16) {#XSTORE0:5 (86,-281)};
// (86,-280.6) @TEXT("VDD",size=1.1,halign="middle",valign="bottom");
// &"VSS" @WIRE(mode="straight",linecolor="#30485d",linewidth=0.16) {#XSTORE0:6 (86,-301)};
// (86,-301.4) @TEXT("VSS",size=1.1,halign="middle",valign="top");
// &"VDD" @WIRE(mode="straight",linecolor="#30485d",linewidth=0.16) {#XBBM7:4 (155,-14)};
// (155,-13.6) @TEXT("VDD",size=1.1,halign="middle",valign="bottom");
// &"VSS" @WIRE(mode="straight",linecolor="#30485d",linewidth=0.16) {#XBBM7:5 (155,-36)};
// (155,-36.4) @TEXT("VSS",size=1.1,halign="middle",valign="top");
// &"VDD" @WIRE(mode="straight",linecolor="#30485d",linewidth=0.16) {#XBBM6:4 (155,-52)};
// (155,-51.6) @TEXT("VDD",size=1.1,halign="middle",valign="bottom");
// &"VSS" @WIRE(mode="straight",linecolor="#30485d",linewidth=0.16) {#XBBM6:5 (155,-74)};
// (155,-74.4) @TEXT("VSS",size=1.1,halign="middle",valign="top");
// &"VDD" @WIRE(mode="straight",linecolor="#30485d",linewidth=0.16) {#XBBM5:4 (155,-90)};
// (155,-89.6) @TEXT("VDD",size=1.1,halign="middle",valign="bottom");
// &"VSS" @WIRE(mode="straight",linecolor="#30485d",linewidth=0.16) {#XBBM5:5 (155,-112)};
// (155,-112.4) @TEXT("VSS",size=1.1,halign="middle",valign="top");
// &"VDD" @WIRE(mode="straight",linecolor="#30485d",linewidth=0.16) {#XBBM4:4 (155,-128)};
// (155,-127.6) @TEXT("VDD",size=1.1,halign="middle",valign="bottom");
// &"VSS" @WIRE(mode="straight",linecolor="#30485d",linewidth=0.16) {#XBBM4:5 (155,-150)};
// (155,-150.4) @TEXT("VSS",size=1.1,halign="middle",valign="top");
// &"VDD" @WIRE(mode="straight",linecolor="#30485d",linewidth=0.16) {#XBBM3:4 (155,-166)};
// (155,-165.6) @TEXT("VDD",size=1.1,halign="middle",valign="bottom");
// &"VSS" @WIRE(mode="straight",linecolor="#30485d",linewidth=0.16) {#XBBM3:5 (155,-188)};
// (155,-188.4) @TEXT("VSS",size=1.1,halign="middle",valign="top");
// &"VDD" @WIRE(mode="straight",linecolor="#30485d",linewidth=0.16) {#XBBM2:4 (155,-204)};
// (155,-203.6) @TEXT("VDD",size=1.1,halign="middle",valign="bottom");
// &"VSS" @WIRE(mode="straight",linecolor="#30485d",linewidth=0.16) {#XBBM2:5 (155,-226)};
// (155,-226.4) @TEXT("VSS",size=1.1,halign="middle",valign="top");
// &"VDD" @WIRE(mode="straight",linecolor="#30485d",linewidth=0.16) {#XBBM1:4 (155,-242)};
// (155,-241.6) @TEXT("VDD",size=1.1,halign="middle",valign="bottom");
// &"VSS" @WIRE(mode="straight",linecolor="#30485d",linewidth=0.16) {#XBBM1:5 (155,-264)};
// (155,-264.4) @TEXT("VSS",size=1.1,halign="middle",valign="top");
// &"VDD" @WIRE(mode="straight",linecolor="#30485d",linewidth=0.16) {#XBBM0:4 (155,-280)};
// (155,-279.6) @TEXT("VDD",size=1.1,halign="middle",valign="bottom");
// &"VSS" @WIRE(mode="straight",linecolor="#30485d",linewidth=0.16) {#XBBM0:5 (155,-302)};
// (155,-302.4) @TEXT("VSS",size=1.1,halign="middle",valign="top");
// &"GNN0" @WIRE(mode="straight",linecolor="#30485d",linewidth=0.16) {#XDRV0:1 (234,-282.75)};
// (234.4,-282.75) @TEXT("GNN0",size=1.1,halign="start",valign="middle");
// &"GNP0" @WIRE(mode="straight",linecolor="#30485d",linewidth=0.16) {#XDRV0:2 (234,-286.05)};
// (234.4,-286.05) @TEXT("GNP0",size=1.1,halign="start",valign="middle");
// &"GPN0" @WIRE(mode="straight",linecolor="#30485d",linewidth=0.16) {#XDRV0:3 (234,-289.35)};
// (234.4,-289.35) @TEXT("GPN0",size=1.1,halign="start",valign="middle");
// &"GPP0" @WIRE(mode="straight",linecolor="#30485d",linewidth=0.16) {#XDRV0:4 (234,-292.65)};
// (234.4,-292.65) @TEXT("GPP0",size=1.1,halign="start",valign="middle");
// &"VDD" @WIRE(mode="straight",linecolor="#30485d",linewidth=0.16) {#XDRV0:7 (218,-274.45)};
// (218,-274.05) @TEXT("VDD",size=1.1,halign="middle",valign="bottom");
// &"VSS" @WIRE(mode="straight",linecolor="#30485d",linewidth=0.16) {#XDRV0:8 (218,-307.55)};
// (218,-307.95) @TEXT("VSS",size=1.1,halign="middle",valign="top");
// &"GNN1" @WIRE(mode="straight",linecolor="#30485d",linewidth=0.16) {#XDRV1:1 (234,-244.75)};
// (234.4,-244.75) @TEXT("GNN1",size=1.1,halign="start",valign="middle");
// &"GNP1" @WIRE(mode="straight",linecolor="#30485d",linewidth=0.16) {#XDRV1:2 (234,-248.05)};
// (234.4,-248.05) @TEXT("GNP1",size=1.1,halign="start",valign="middle");
// &"GPN1" @WIRE(mode="straight",linecolor="#30485d",linewidth=0.16) {#XDRV1:3 (234,-251.35)};
// (234.4,-251.35) @TEXT("GPN1",size=1.1,halign="start",valign="middle");
// &"GPP1" @WIRE(mode="straight",linecolor="#30485d",linewidth=0.16) {#XDRV1:4 (234,-254.65)};
// (234.4,-254.65) @TEXT("GPP1",size=1.1,halign="start",valign="middle");
// &"VDD" @WIRE(mode="straight",linecolor="#30485d",linewidth=0.16) {#XDRV1:7 (218,-236.45)};
// (218,-236.05) @TEXT("VDD",size=1.1,halign="middle",valign="bottom");
// &"VSS" @WIRE(mode="straight",linecolor="#30485d",linewidth=0.16) {#XDRV1:8 (218,-269.55)};
// (218,-269.95) @TEXT("VSS",size=1.1,halign="middle",valign="top");
// &"GNN2" @WIRE(mode="straight",linecolor="#30485d",linewidth=0.16) {#XDRV2:1 (234,-206.75)};
// (234.4,-206.75) @TEXT("GNN2",size=1.1,halign="start",valign="middle");
// &"GNP2" @WIRE(mode="straight",linecolor="#30485d",linewidth=0.16) {#XDRV2:2 (234,-210.05)};
// (234.4,-210.05) @TEXT("GNP2",size=1.1,halign="start",valign="middle");
// &"GPN2" @WIRE(mode="straight",linecolor="#30485d",linewidth=0.16) {#XDRV2:3 (234,-213.35)};
// (234.4,-213.35) @TEXT("GPN2",size=1.1,halign="start",valign="middle");
// &"GPP2" @WIRE(mode="straight",linecolor="#30485d",linewidth=0.16) {#XDRV2:4 (234,-216.65)};
// (234.4,-216.65) @TEXT("GPP2",size=1.1,halign="start",valign="middle");
// &"VDD" @WIRE(mode="straight",linecolor="#30485d",linewidth=0.16) {#XDRV2:7 (218,-198.45)};
// (218,-198.05) @TEXT("VDD",size=1.1,halign="middle",valign="bottom");
// &"VSS" @WIRE(mode="straight",linecolor="#30485d",linewidth=0.16) {#XDRV2:8 (218,-231.55)};
// (218,-231.95) @TEXT("VSS",size=1.1,halign="middle",valign="top");
// &"GNN3" @WIRE(mode="straight",linecolor="#30485d",linewidth=0.16) {#XDRV3:1 (234,-168.75)};
// (234.4,-168.75) @TEXT("GNN3",size=1.1,halign="start",valign="middle");
// &"GNP3" @WIRE(mode="straight",linecolor="#30485d",linewidth=0.16) {#XDRV3:2 (234,-172.05)};
// (234.4,-172.05) @TEXT("GNP3",size=1.1,halign="start",valign="middle");
// &"GPN3" @WIRE(mode="straight",linecolor="#30485d",linewidth=0.16) {#XDRV3:3 (234,-175.35)};
// (234.4,-175.35) @TEXT("GPN3",size=1.1,halign="start",valign="middle");
// &"GPP3" @WIRE(mode="straight",linecolor="#30485d",linewidth=0.16) {#XDRV3:4 (234,-178.65)};
// (234.4,-178.65) @TEXT("GPP3",size=1.1,halign="start",valign="middle");
// &"VDD" @WIRE(mode="straight",linecolor="#30485d",linewidth=0.16) {#XDRV3:7 (218,-160.45)};
// (218,-160.05) @TEXT("VDD",size=1.1,halign="middle",valign="bottom");
// &"VSS" @WIRE(mode="straight",linecolor="#30485d",linewidth=0.16) {#XDRV3:8 (218,-193.55)};
// (218,-193.95) @TEXT("VSS",size=1.1,halign="middle",valign="top");
// &"GNN4" @WIRE(mode="straight",linecolor="#30485d",linewidth=0.16) {#XDRV4:1 (234,-130.75)};
// (234.4,-130.75) @TEXT("GNN4",size=1.1,halign="start",valign="middle");
// &"GNP4" @WIRE(mode="straight",linecolor="#30485d",linewidth=0.16) {#XDRV4:2 (234,-134.05)};
// (234.4,-134.05) @TEXT("GNP4",size=1.1,halign="start",valign="middle");
// &"GPN4" @WIRE(mode="straight",linecolor="#30485d",linewidth=0.16) {#XDRV4:3 (234,-137.35)};
// (234.4,-137.35) @TEXT("GPN4",size=1.1,halign="start",valign="middle");
// &"GPP4" @WIRE(mode="straight",linecolor="#30485d",linewidth=0.16) {#XDRV4:4 (234,-140.65)};
// (234.4,-140.65) @TEXT("GPP4",size=1.1,halign="start",valign="middle");
// &"VDD" @WIRE(mode="straight",linecolor="#30485d",linewidth=0.16) {#XDRV4:7 (218,-122.45)};
// (218,-122.05) @TEXT("VDD",size=1.1,halign="middle",valign="bottom");
// &"VSS" @WIRE(mode="straight",linecolor="#30485d",linewidth=0.16) {#XDRV4:8 (218,-155.55)};
// (218,-155.95) @TEXT("VSS",size=1.1,halign="middle",valign="top");
// &"GNN5" @WIRE(mode="straight",linecolor="#30485d",linewidth=0.16) {#XDRV5:1 (234,-92.75)};
// (234.4,-92.75) @TEXT("GNN5",size=1.1,halign="start",valign="middle");
// &"GNP5" @WIRE(mode="straight",linecolor="#30485d",linewidth=0.16) {#XDRV5:2 (234,-96.05)};
// (234.4,-96.05) @TEXT("GNP5",size=1.1,halign="start",valign="middle");
// &"GPN5" @WIRE(mode="straight",linecolor="#30485d",linewidth=0.16) {#XDRV5:3 (234,-99.35)};
// (234.4,-99.35) @TEXT("GPN5",size=1.1,halign="start",valign="middle");
// &"GPP5" @WIRE(mode="straight",linecolor="#30485d",linewidth=0.16) {#XDRV5:4 (234,-102.65)};
// (234.4,-102.65) @TEXT("GPP5",size=1.1,halign="start",valign="middle");
// &"VDD" @WIRE(mode="straight",linecolor="#30485d",linewidth=0.16) {#XDRV5:7 (218,-84.45)};
// (218,-84.05) @TEXT("VDD",size=1.1,halign="middle",valign="bottom");
// &"VSS" @WIRE(mode="straight",linecolor="#30485d",linewidth=0.16) {#XDRV5:8 (218,-117.55)};
// (218,-117.95) @TEXT("VSS",size=1.1,halign="middle",valign="top");
// &"GNN6" @WIRE(mode="straight",linecolor="#30485d",linewidth=0.16) {#XDRV6:1 (234,-54.75)};
// (234.4,-54.75) @TEXT("GNN6",size=1.1,halign="start",valign="middle");
// &"GNP6" @WIRE(mode="straight",linecolor="#30485d",linewidth=0.16) {#XDRV6:2 (234,-58.05)};
// (234.4,-58.05) @TEXT("GNP6",size=1.1,halign="start",valign="middle");
// &"GPN6" @WIRE(mode="straight",linecolor="#30485d",linewidth=0.16) {#XDRV6:3 (234,-61.35)};
// (234.4,-61.35) @TEXT("GPN6",size=1.1,halign="start",valign="middle");
// &"GPP6" @WIRE(mode="straight",linecolor="#30485d",linewidth=0.16) {#XDRV6:4 (234,-64.65)};
// (234.4,-64.65) @TEXT("GPP6",size=1.1,halign="start",valign="middle");
// &"VDD" @WIRE(mode="straight",linecolor="#30485d",linewidth=0.16) {#XDRV6:7 (218,-46.45)};
// (218,-46.05) @TEXT("VDD",size=1.1,halign="middle",valign="bottom");
// &"VSS" @WIRE(mode="straight",linecolor="#30485d",linewidth=0.16) {#XDRV6:8 (218,-79.55)};
// (218,-79.95) @TEXT("VSS",size=1.1,halign="middle",valign="top");
// &"GNN7" @WIRE(mode="straight",linecolor="#30485d",linewidth=0.16) {#XDRV7:1 (234,-16.75)};
// (234.4,-16.75) @TEXT("GNN7",size=1.1,halign="start",valign="middle");
// &"GNP7" @WIRE(mode="straight",linecolor="#30485d",linewidth=0.16) {#XDRV7:2 (234,-20.05)};
// (234.4,-20.05) @TEXT("GNP7",size=1.1,halign="start",valign="middle");
// &"GPN7" @WIRE(mode="straight",linecolor="#30485d",linewidth=0.16) {#XDRV7:3 (234,-23.35)};
// (234.4,-23.35) @TEXT("GPN7",size=1.1,halign="start",valign="middle");
// &"GPP7" @WIRE(mode="straight",linecolor="#30485d",linewidth=0.16) {#XDRV7:4 (234,-26.65)};
// (234.4,-26.65) @TEXT("GPP7",size=1.1,halign="start",valign="middle");
// &"VDD" @WIRE(mode="straight",linecolor="#30485d",linewidth=0.16) {#XDRV7:7 (218,-8.45)};
// (218,-8.05) @TEXT("VDD",size=1.1,halign="middle",valign="bottom");
// &"VSS" @WIRE(mode="straight",linecolor="#30485d",linewidth=0.16) {#XDRV7:8 (218,-41.55)};
// (218,-41.95) @TEXT("VSS",size=1.1,halign="middle",valign="top");
// }
// END SARADC RNL
ends sar8s_refword

subckt sar8i_refword CODE0 CODE1 CODE2 CODE3 CODE4 CODE5 CODE6 CODE7 D0 D1  D2 D3 D4 D5 D6 D7 GNN0 GNN1 GNN2 GNN3 GNN4 GNN5 GNN6 GNN7 GNP0  GNP1 GNP2 GNP3 GNP4 GNP5 GNP6 GNP7 GPN0 GPN1 GPN2 GPN3 GPN4 GPN5  GPN6 GPN7 GPP0 GPP1 GPP2 GPP3 GPP4 GPP5 GPP6 GPP7 PHI_U SAMPLE VDD  VSS RST_DONE PRESET
    XRR7 (PRESET PRESET VDD VSS RST7) sar8p_and2
    XRSTEP1 (PRESET VDD VSS TAP1) sar8s_step
    XRR6 (PRESET TAP1 VDD VSS RST6) sar8p_and2
    XRSTEP2 (TAP1 VDD VSS TAP2) sar8s_step
    XRR5 (PRESET TAP2 VDD VSS RST5) sar8p_and2
    XRSTEP3 (TAP2 VDD VSS TAP3) sar8s_step
    XRR4 (PRESET TAP3 VDD VSS RST4) sar8p_and2
    XRSTEP4 (TAP3 VDD VSS TAP4) sar8s_step
    XRR3 (PRESET TAP4 VDD VSS RST3) sar8p_and2
    XRSTEP5 (TAP4 VDD VSS TAP5) sar8s_step
    XRR2 (PRESET TAP5 VDD VSS RST2) sar8p_and2
    XRSTEP6 (TAP5 VDD VSS TAP6) sar8s_step
    XRR1 (PRESET TAP6 VDD VSS RST1) sar8p_and2
    XRSTEP7 (TAP6 VDD VSS TAP7) sar8s_step
    XRR0 (PRESET TAP7 VDD VSS RST0) sar8p_and2
    XRDONE (RST0 VDD VSS RST_DONE) sar8p_buf
    X002 (FIRST1 VDD VSS FIRST2) sar8p_buf
    X001 (FIRST0 VDD VSS FIRST1) sar8p_buf
    X000 (PHI_U VDD VSS FIRST0) sar8p_buf
    X007 (FIRST2 LATE_CLK VDD VSS CAP_REQ) sar8p_or2
    X003 (SAMPLE ACK VDD VSS REQ_RESET) sar8p_or2
    XREQUEST (REQ_Q REQ_RESET PHI_U VDD VSS) sar8p_sr
    XD_LATE_CLK (REQ_Q VDD VSS LATE_CLK) sar8p_delay_capture
    XD_ACK (LATE_CLK VDD VSS ACK) sar8p_delay_valid
    X008 (CAP_REQ VDD VSS CAP_CLK) sar8p_clkbuf
    XMUX7 (CODE7 D7 PHI_U VDD VSS TARGET7) sar8p_mux2
    XMUX6 (CODE6 D6 PHI_U VDD VSS TARGET6) sar8p_mux2
    XMUX5 (CODE5 D5 PHI_U VDD VSS TARGET5) sar8p_mux2
    XMUX4 (CODE4 D4 PHI_U VDD VSS TARGET4) sar8p_mux2
    XMUX3 (CODE3 D3 PHI_U VDD VSS TARGET3) sar8p_mux2
    XMUX2 (CODE2 D2 PHI_U VDD VSS TARGET2) sar8p_mux2
    XMUX1 (CODE1 D1 PHI_U VDD VSS TARGET1) sar8p_mux2
    XMUX0 (CODE0 D0 PHI_U VDD VSS TARGET0) sar8p_mux2
    X018 (MSB_QN VDD VSS Q7) sar8p_inv
    X017 (TARGET7 VDD VSS MSB_DN) sar8p_inv
    XSTORE7 (CAP_CLK MSB_DN MSB_QN RST7 VDD VSS) sar8p_dffr
    XSTORE6 (CAP_CLK TARGET6 Q6 RST6 VDD VSS) sar8p_dffr
    XSTORE5 (CAP_CLK TARGET5 Q5 RST5 VDD VSS) sar8p_dffr
    XSTORE4 (CAP_CLK TARGET4 Q4 RST4 VDD VSS) sar8p_dffr
    XSTORE3 (CAP_CLK TARGET3 Q3 RST3 VDD VSS) sar8p_dffr
    XSTORE2 (CAP_CLK TARGET2 Q2 RST2 VDD VSS) sar8p_dffr
    XSTORE1 (CAP_CLK TARGET1 Q1 RST1 VDD VSS) sar8p_dffr
    XSTORE0 (CAP_CLK TARGET0 Q0 RST0 VDD VSS) sar8p_dffr
    XBBM7 (Q7 H7 L7 VDD VSS) sar8p_nonoverlap
    XBBM6 (Q6 H6 L6 VDD VSS) sar8p_nonoverlap
    XBBM5 (Q5 H5 L5 VDD VSS) sar8p_nonoverlap
    XBBM4 (Q4 H4 L4 VDD VSS) sar8p_nonoverlap
    XBBM3 (Q3 H3 L3 VDD VSS) sar8p_nonoverlap
    XBBM2 (Q2 H2 L2 VDD VSS) sar8p_nonoverlap
    XBBM1 (Q1 H1 L1 VDD VSS) sar8p_nonoverlap
    XBBM0 (Q0 H0 L0 VDD VSS) sar8p_nonoverlap
    XDRV0 (GNN0 GNP0 GPN0 GPP0 H0 L0 VDD VSS) sar8p_refdrv_b0
    XDRV1 (GNN1 GNP1 GPN1 GPP1 H1 L1 VDD VSS) sar8p_refdrv_b1
    XDRV2 (GNN2 GNP2 GPN2 GPP2 H2 L2 VDD VSS) sar8p_refdrv_b2
    XDRV3 (GNN3 GNP3 GPN3 GPP3 H3 L3 VDD VSS) sar8p_refdrv_b3
    XDRV4 (GNN4 GNP4 GPN4 GPP4 H4 L4 VDD VSS) sar8p_refdrv_b4
    XDRV5 (GNN5 GNP5 GPN5 GPP5 H5 L5 VDD VSS) sar8p_refdrv_b5
    XDRV6 (GNN6 GNP6 GPN6 GPP6 H6 L6 VDD VSS) sar8p_refdrv_b6
    XDRV7 (GNN7 GNP7 GPN7 GPP7 H7 L7 VDD VSS) sar8p_refdrv_b7
// BEGIN SARADC RNL
// @RNL(author="saradc topology") {
// (-24,205) @TEXT("sar8i_refword / capture, sequential reset, nonoverlap and gate drive",size=1.5,halign="start",textcolor="#223d52");
// (-24,187) @TEXT("Sequential preset / bit 7 -> bit 0",size=1.1,halign="start",textcolor="#223d52");
// #XRSTEP1 @SET-SYMBOL $S_sar8s_step;
// #XRSTEP1 @PLACE(43,160) => @ORIENT("R0");
// #XRSTEP2 @SET-SYMBOL $S_sar8s_step;
// #XRSTEP2 @PLACE(86,160) => @ORIENT("R0");
// #XRSTEP3 @SET-SYMBOL $S_sar8s_step;
// #XRSTEP3 @PLACE(129,160) => @ORIENT("R0");
// #XRSTEP4 @SET-SYMBOL $S_sar8s_step;
// #XRSTEP4 @PLACE(172,160) => @ORIENT("R0");
// #XRSTEP5 @SET-SYMBOL $S_sar8s_step;
// #XRSTEP5 @PLACE(215,160) => @ORIENT("R0");
// #XRSTEP6 @SET-SYMBOL $S_sar8s_step;
// #XRSTEP6 @PLACE(258,160) => @ORIENT("R0");
// #XRSTEP7 @SET-SYMBOL $S_sar8s_step;
// #XRSTEP7 @PLACE(301,160) => @ORIENT("R0");
// #XRR7 @SET-SYMBOL $S_sar8p_and2;
// #XRR7 @PLACE(0,125) => @ORIENT("R0");
// #XRR6 @SET-SYMBOL $S_sar8p_and2;
// #XRR6 @PLACE(43,125) => @ORIENT("R0");
// #XRR5 @SET-SYMBOL $S_sar8p_and2;
// #XRR5 @PLACE(86,125) => @ORIENT("R0");
// #XRR4 @SET-SYMBOL $S_sar8p_and2;
// #XRR4 @PLACE(129,125) => @ORIENT("R0");
// #XRR3 @SET-SYMBOL $S_sar8p_and2;
// #XRR3 @PLACE(172,125) => @ORIENT("R0");
// #XRR2 @SET-SYMBOL $S_sar8p_and2;
// #XRR2 @PLACE(215,125) => @ORIENT("R0");
// #XRR1 @SET-SYMBOL $S_sar8p_and2;
// #XRR1 @PLACE(258,125) => @ORIENT("R0");
// #XRR0 @SET-SYMBOL $S_sar8p_and2;
// #XRR0 @PLACE(301,125) => @ORIENT("R0");
// #XRDONE @SET-SYMBOL $S_sar8p_buf;
// #XRDONE @PLACE(344,125) => @ORIENT("R0");
// &"TAP1" @WIRE(mode="straight",linecolor="#30485d",linewidth=0.16) {(63,123.3) (63,160)};
// &"TAP1" @WIRE(mode="straight",linecolor="#30485d",linewidth=0.16) {#XRSTEP1:4 (63,160)};
// $JUNCTION @ATTACH (63,160);
// &"TAP1" @WIRE(mode="straight",linecolor="#30485d",linewidth=0.16) {#XRR6:2 (63,123.3)};
// $JUNCTION @ATTACH (63,123.3);
// &"TAP1" @WIRE(mode="straight",linecolor="#30485d",linewidth=0.16) {#XRSTEP2:1 (63,160)};
// $JUNCTION @ATTACH (63,160);
// &"TAP2" @WIRE(mode="straight",linecolor="#30485d",linewidth=0.16) {(106,123.3) (106,160)};
// &"TAP2" @WIRE(mode="straight",linecolor="#30485d",linewidth=0.16) {#XRSTEP2:4 (106,160)};
// $JUNCTION @ATTACH (106,160);
// &"TAP2" @WIRE(mode="straight",linecolor="#30485d",linewidth=0.16) {#XRR5:2 (106,123.3)};
// $JUNCTION @ATTACH (106,123.3);
// &"TAP2" @WIRE(mode="straight",linecolor="#30485d",linewidth=0.16) {#XRSTEP3:1 (106,160)};
// $JUNCTION @ATTACH (106,160);
// &"TAP3" @WIRE(mode="straight",linecolor="#30485d",linewidth=0.16) {(149,123.3) (149,160)};
// &"TAP3" @WIRE(mode="straight",linecolor="#30485d",linewidth=0.16) {#XRSTEP3:4 (149,160)};
// $JUNCTION @ATTACH (149,160);
// &"TAP3" @WIRE(mode="straight",linecolor="#30485d",linewidth=0.16) {#XRR4:2 (149,123.3)};
// $JUNCTION @ATTACH (149,123.3);
// &"TAP3" @WIRE(mode="straight",linecolor="#30485d",linewidth=0.16) {#XRSTEP4:1 (149,160)};
// $JUNCTION @ATTACH (149,160);
// &"TAP4" @WIRE(mode="straight",linecolor="#30485d",linewidth=0.16) {(192,123.3) (192,160)};
// &"TAP4" @WIRE(mode="straight",linecolor="#30485d",linewidth=0.16) {#XRSTEP4:4 (192,160)};
// $JUNCTION @ATTACH (192,160);
// &"TAP4" @WIRE(mode="straight",linecolor="#30485d",linewidth=0.16) {#XRR3:2 (192,123.3)};
// $JUNCTION @ATTACH (192,123.3);
// &"TAP4" @WIRE(mode="straight",linecolor="#30485d",linewidth=0.16) {#XRSTEP5:1 (192,160)};
// $JUNCTION @ATTACH (192,160);
// &"TAP5" @WIRE(mode="straight",linecolor="#30485d",linewidth=0.16) {(235,123.3) (235,160)};
// &"TAP5" @WIRE(mode="straight",linecolor="#30485d",linewidth=0.16) {#XRSTEP5:4 (235,160)};
// $JUNCTION @ATTACH (235,160);
// &"TAP5" @WIRE(mode="straight",linecolor="#30485d",linewidth=0.16) {#XRR2:2 (235,123.3)};
// $JUNCTION @ATTACH (235,123.3);
// &"TAP5" @WIRE(mode="straight",linecolor="#30485d",linewidth=0.16) {#XRSTEP6:1 (235,160)};
// $JUNCTION @ATTACH (235,160);
// &"TAP6" @WIRE(mode="straight",linecolor="#30485d",linewidth=0.16) {(278,123.3) (278,160)};
// &"TAP6" @WIRE(mode="straight",linecolor="#30485d",linewidth=0.16) {#XRSTEP6:4 (278,160)};
// $JUNCTION @ATTACH (278,160);
// &"TAP6" @WIRE(mode="straight",linecolor="#30485d",linewidth=0.16) {#XRR1:2 (278,123.3)};
// $JUNCTION @ATTACH (278,123.3);
// &"TAP6" @WIRE(mode="straight",linecolor="#30485d",linewidth=0.16) {#XRSTEP7:1 (278,160)};
// $JUNCTION @ATTACH (278,160);
// &"TAP7" @WIRE(mode="straight",linecolor="#30485d",linewidth=0.16) {(321,123.3) (321,160)};
// &"TAP7" @WIRE(mode="straight",linecolor="#30485d",linewidth=0.16) {#XRSTEP7:4 (321,160)};
// $JUNCTION @ATTACH (321,160);
// &"TAP7" @WIRE(mode="straight",linecolor="#30485d",linewidth=0.16) {#XRR0:2 (321,123.3)};
// $JUNCTION @ATTACH (321,123.3);
// (-24,90) @TEXT("Capture request / first and late clocks / acknowledge",size=1.1,halign="start",textcolor="#223d52");
// #X000 @SET-SYMBOL $S_sar8p_buf;
// #X000 @PLACE(0,65) => @ORIENT("R0");
// #X001 @SET-SYMBOL $S_sar8p_buf;
// #X001 @PLACE(43,65) => @ORIENT("R0");
// #X002 @SET-SYMBOL $S_sar8p_buf;
// #X002 @PLACE(86,65) => @ORIENT("R0");
// #X007 @SET-SYMBOL $S_sar8p_or2;
// #X007 @PLACE(171,65) => @ORIENT("R0");
// #X008 @SET-SYMBOL $S_sar8p_clkbuf;
// #X008 @PLACE(214,65) => @ORIENT("R0");
// #X003 @SET-SYMBOL $S_sar8p_or2;
// #X003 @PLACE(0,25) => @ORIENT("R0");
// #XREQUEST @SET-SYMBOL $S_sar8p_sr;
// #XREQUEST @PLACE(43,25) => @ORIENT("R0");
// #XD_LATE_CLK @SET-SYMBOL $S_sar8p_delay_capture;
// #XD_LATE_CLK @PLACE(86,25) => @ORIENT("R0");
// #XD_ACK @SET-SYMBOL $S_sar8p_delay_valid;
// #XD_ACK @PLACE(129,25) => @ORIENT("R0");
// #XMUX7 @SET-SYMBOL $S_sar8p_mux2;
// #XMUX7 @PLACE(0,-25) => @ORIENT("R0");
// #XSTORE7 @SET-SYMBOL $S_sar8p_dffr;
// #XSTORE7 @PLACE(86,-25) => @ORIENT("R0");
// #XBBM7 @SET-SYMBOL $S_sar8p_nonoverlap;
// #XBBM7 @PLACE(155,-25) => @ORIENT("R0");
// #XDRV7 @SET-SYMBOL $S_sar8p_refdrv_b7;
// #XDRV7 @PLACE(218,-25) => @ORIENT("R0");
// (-24,-11) @TEXT("bit 7",size=1,halign="start",textcolor="#223d52");
// #XMUX6 @SET-SYMBOL $S_sar8p_mux2;
// #XMUX6 @PLACE(0,-63) => @ORIENT("R0");
// #XSTORE6 @SET-SYMBOL $S_sar8p_dffr;
// #XSTORE6 @PLACE(86,-63) => @ORIENT("R0");
// #XBBM6 @SET-SYMBOL $S_sar8p_nonoverlap;
// #XBBM6 @PLACE(155,-63) => @ORIENT("R0");
// #XDRV6 @SET-SYMBOL $S_sar8p_refdrv_b6;
// #XDRV6 @PLACE(218,-63) => @ORIENT("R0");
// (-24,-49) @TEXT("bit 6",size=1,halign="start",textcolor="#223d52");
// #XMUX5 @SET-SYMBOL $S_sar8p_mux2;
// #XMUX5 @PLACE(0,-101) => @ORIENT("R0");
// #XSTORE5 @SET-SYMBOL $S_sar8p_dffr;
// #XSTORE5 @PLACE(86,-101) => @ORIENT("R0");
// #XBBM5 @SET-SYMBOL $S_sar8p_nonoverlap;
// #XBBM5 @PLACE(155,-101) => @ORIENT("R0");
// #XDRV5 @SET-SYMBOL $S_sar8p_refdrv_b5;
// #XDRV5 @PLACE(218,-101) => @ORIENT("R0");
// (-24,-87) @TEXT("bit 5",size=1,halign="start",textcolor="#223d52");
// #XMUX4 @SET-SYMBOL $S_sar8p_mux2;
// #XMUX4 @PLACE(0,-139) => @ORIENT("R0");
// #XSTORE4 @SET-SYMBOL $S_sar8p_dffr;
// #XSTORE4 @PLACE(86,-139) => @ORIENT("R0");
// #XBBM4 @SET-SYMBOL $S_sar8p_nonoverlap;
// #XBBM4 @PLACE(155,-139) => @ORIENT("R0");
// #XDRV4 @SET-SYMBOL $S_sar8p_refdrv_b4;
// #XDRV4 @PLACE(218,-139) => @ORIENT("R0");
// (-24,-125) @TEXT("bit 4",size=1,halign="start",textcolor="#223d52");
// #XMUX3 @SET-SYMBOL $S_sar8p_mux2;
// #XMUX3 @PLACE(0,-177) => @ORIENT("R0");
// #XSTORE3 @SET-SYMBOL $S_sar8p_dffr;
// #XSTORE3 @PLACE(86,-177) => @ORIENT("R0");
// #XBBM3 @SET-SYMBOL $S_sar8p_nonoverlap;
// #XBBM3 @PLACE(155,-177) => @ORIENT("R0");
// #XDRV3 @SET-SYMBOL $S_sar8p_refdrv_b3;
// #XDRV3 @PLACE(218,-177) => @ORIENT("R0");
// (-24,-163) @TEXT("bit 3",size=1,halign="start",textcolor="#223d52");
// #XMUX2 @SET-SYMBOL $S_sar8p_mux2;
// #XMUX2 @PLACE(0,-215) => @ORIENT("R0");
// #XSTORE2 @SET-SYMBOL $S_sar8p_dffr;
// #XSTORE2 @PLACE(86,-215) => @ORIENT("R0");
// #XBBM2 @SET-SYMBOL $S_sar8p_nonoverlap;
// #XBBM2 @PLACE(155,-215) => @ORIENT("R0");
// #XDRV2 @SET-SYMBOL $S_sar8p_refdrv_b2;
// #XDRV2 @PLACE(218,-215) => @ORIENT("R0");
// (-24,-201) @TEXT("bit 2",size=1,halign="start",textcolor="#223d52");
// #XMUX1 @SET-SYMBOL $S_sar8p_mux2;
// #XMUX1 @PLACE(0,-253) => @ORIENT("R0");
// #XSTORE1 @SET-SYMBOL $S_sar8p_dffr;
// #XSTORE1 @PLACE(86,-253) => @ORIENT("R0");
// #XBBM1 @SET-SYMBOL $S_sar8p_nonoverlap;
// #XBBM1 @PLACE(155,-253) => @ORIENT("R0");
// #XDRV1 @SET-SYMBOL $S_sar8p_refdrv_b1;
// #XDRV1 @PLACE(218,-253) => @ORIENT("R0");
// (-24,-239) @TEXT("bit 1",size=1,halign="start",textcolor="#223d52");
// #XMUX0 @SET-SYMBOL $S_sar8p_mux2;
// #XMUX0 @PLACE(0,-291) => @ORIENT("R0");
// #XSTORE0 @SET-SYMBOL $S_sar8p_dffr;
// #XSTORE0 @PLACE(86,-291) => @ORIENT("R0");
// #XBBM0 @SET-SYMBOL $S_sar8p_nonoverlap;
// #XBBM0 @PLACE(155,-291) => @ORIENT("R0");
// #XDRV0 @SET-SYMBOL $S_sar8p_refdrv_b0;
// #XDRV0 @PLACE(218,-291) => @ORIENT("R0");
// (-24,-277) @TEXT("bit 0",size=1,halign="start",textcolor="#223d52");
// #X017 @SET-SYMBOL $S_sar8p_inv;
// #X017 @PLACE(43,-25) => @ORIENT("R0");
// #X018 @SET-SYMBOL $S_sar8p_inv;
// #X018 @PLACE(118,-25) => @ORIENT("R0");
// &"FIRST1" @WIRE(mode="straight",linecolor="#30485d",linewidth=0.16) {#X002:1 (64.5,65) (64.5,65) #X001:4};
// &"FIRST0" @WIRE(mode="straight",linecolor="#30485d",linewidth=0.16) {#X001:1 (21.5,65) (21.5,65) #X000:4};
// &"REQ_RESET" @WIRE(mode="straight",linecolor="#30485d",linewidth=0.16) {#X003:5 (18.5,25) (18.5,26.65) #XREQUEST:2};
// &"REQ_Q" @WIRE(mode="straight",linecolor="#30485d",linewidth=0.16) {#XREQUEST:1 (64.5,25) (64.5,25) #XD_LATE_CLK:1};
// &"TARGET7" @WIRE(mode="straight",linecolor="#30485d",linewidth=0.16) {#XMUX7:6 (21.5,-25) (21.5,-25) #X017:1};
// &"MSB_QN" @WIRE(mode="straight",linecolor="#30485d",linewidth=0.16) {#X018:1 (102,-25) (102,-25) #XSTORE7:3};
// &"Q7" @WIRE(mode="straight",linecolor="#30485d",linewidth=0.16) {#X018:4 (133.5,-25) (133.5,-25) #XBBM7:1};
// &"MSB_DN" @WIRE(mode="straight",linecolor="#30485d",linewidth=0.16) {#X017:4 (64.5,-25) (64.5,-25) #XSTORE7:2};
// &"Q6" @WIRE(mode="straight",linecolor="#30485d",linewidth=0.16) {#XSTORE6:3 (117.5,-63) (117.5,-63) #XBBM6:1};
// &"Q5" @WIRE(mode="straight",linecolor="#30485d",linewidth=0.16) {#XSTORE5:3 (117.5,-101) (117.5,-101) #XBBM5:1};
// &"Q4" @WIRE(mode="straight",linecolor="#30485d",linewidth=0.16) {#XSTORE4:3 (117.5,-139) (117.5,-139) #XBBM4:1};
// &"Q3" @WIRE(mode="straight",linecolor="#30485d",linewidth=0.16) {#XSTORE3:3 (117.5,-177) (117.5,-177) #XBBM3:1};
// &"Q2" @WIRE(mode="straight",linecolor="#30485d",linewidth=0.16) {#XSTORE2:3 (117.5,-215) (117.5,-215) #XBBM2:1};
// &"Q1" @WIRE(mode="straight",linecolor="#30485d",linewidth=0.16) {#XSTORE1:3 (117.5,-253) (117.5,-253) #XBBM1:1};
// &"Q0" @WIRE(mode="straight",linecolor="#30485d",linewidth=0.16) {#XSTORE0:3 (117.5,-291) (117.5,-291) #XBBM0:1};
// &"H7" @WIRE(mode="straight",linecolor="#30485d",linewidth=0.16) {#XBBM7:2 (199.5,-23.35) (199.5,-29.95) #XDRV7:5};
// &"L7" @WIRE(mode="straight",linecolor="#30485d",linewidth=0.16) {#XBBM7:3 (199.5,-26.65) (199.5,-33.25) #XDRV7:6};
// &"H6" @WIRE(mode="straight",linecolor="#30485d",linewidth=0.16) {#XBBM6:2 (199.5,-61.35) (199.5,-67.95) #XDRV6:5};
// &"L6" @WIRE(mode="straight",linecolor="#30485d",linewidth=0.16) {#XBBM6:3 (199.5,-64.65) (199.5,-71.25) #XDRV6:6};
// &"H5" @WIRE(mode="straight",linecolor="#30485d",linewidth=0.16) {#XBBM5:2 (199.5,-99.35) (199.5,-105.95) #XDRV5:5};
// &"L5" @WIRE(mode="straight",linecolor="#30485d",linewidth=0.16) {#XBBM5:3 (199.5,-102.65) (199.5,-109.25) #XDRV5:6};
// &"H4" @WIRE(mode="straight",linecolor="#30485d",linewidth=0.16) {#XBBM4:2 (199.5,-137.35) (199.5,-143.95) #XDRV4:5};
// &"L4" @WIRE(mode="straight",linecolor="#30485d",linewidth=0.16) {#XBBM4:3 (199.5,-140.65) (199.5,-147.25) #XDRV4:6};
// &"H3" @WIRE(mode="straight",linecolor="#30485d",linewidth=0.16) {#XBBM3:2 (199.5,-175.35) (199.5,-181.95) #XDRV3:5};
// &"L3" @WIRE(mode="straight",linecolor="#30485d",linewidth=0.16) {#XBBM3:3 (199.5,-178.65) (199.5,-185.25) #XDRV3:6};
// &"H2" @WIRE(mode="straight",linecolor="#30485d",linewidth=0.16) {#XBBM2:2 (199.5,-213.35) (199.5,-219.95) #XDRV2:5};
// &"L2" @WIRE(mode="straight",linecolor="#30485d",linewidth=0.16) {#XBBM2:3 (199.5,-216.65) (199.5,-223.25) #XDRV2:6};
// &"H1" @WIRE(mode="straight",linecolor="#30485d",linewidth=0.16) {#XBBM1:2 (199.5,-251.35) (199.5,-257.95) #XDRV1:5};
// &"L1" @WIRE(mode="straight",linecolor="#30485d",linewidth=0.16) {#XBBM1:3 (199.5,-254.65) (199.5,-261.25) #XDRV1:6};
// &"H0" @WIRE(mode="straight",linecolor="#30485d",linewidth=0.16) {#XBBM0:2 (199.5,-289.35) (199.5,-295.95) #XDRV0:5};
// &"L0" @WIRE(mode="straight",linecolor="#30485d",linewidth=0.16) {#XBBM0:3 (199.5,-292.65) (199.5,-299.25) #XDRV0:6};
// (-24,-318) @TEXT("CODE / D -> MUX -> resettable storage -> break-before-make -> physical GP/GN drivers",size=1.1,halign="start",textcolor="#223d52");
// &"PRESET" @WIRE(mode="straight",linecolor="#30485d",linewidth=0.16) {#XRR7:1 (-10,126.7)};
// (-10.4,126.7) @TEXT("PRESET",size=1.1,halign="end",valign="middle");
// &"PRESET" @WIRE(mode="straight",linecolor="#30485d",linewidth=0.16) {#XRR7:2 (-10,123.3)};
// (-10.4,123.3) @TEXT("PRESET",size=1.1,halign="end",valign="middle");
// &"VDD" @WIRE(mode="straight",linecolor="#30485d",linewidth=0.16) {#XRR7:3 (0,135)};
// (0,135.4) @TEXT("VDD",size=1.1,halign="middle",valign="bottom");
// &"VSS" @WIRE(mode="straight",linecolor="#30485d",linewidth=0.16) {#XRR7:4 (0,115)};
// (0,114.6) @TEXT("VSS",size=1.1,halign="middle",valign="top");
// &"RST7" @WIRE(mode="straight",linecolor="#30485d",linewidth=0.16) {#XRR7:5 (10,125)};
// (10.4,125) @TEXT("RST7",size=1.1,halign="start",valign="middle");
// &"PRESET" @WIRE(mode="straight",linecolor="#30485d",linewidth=0.16) {#XRSTEP1:1 (27,160)};
// (26.6,160) @TEXT("PRESET",size=1.1,halign="end",valign="middle");
// &"VDD" @WIRE(mode="straight",linecolor="#30485d",linewidth=0.16) {#XRSTEP1:2 (43,171)};
// (43,171.4) @TEXT("VDD",size=1.1,halign="middle",valign="bottom");
// &"VSS" @WIRE(mode="straight",linecolor="#30485d",linewidth=0.16) {#XRSTEP1:3 (43,149)};
// (43,148.6) @TEXT("VSS",size=1.1,halign="middle",valign="top");
// &"PRESET" @WIRE(mode="straight",linecolor="#30485d",linewidth=0.16) {#XRR6:1 (33,126.7)};
// (32.6,126.7) @TEXT("PRESET",size=1.1,halign="end",valign="middle");
// &"VDD" @WIRE(mode="straight",linecolor="#30485d",linewidth=0.16) {#XRR6:3 (43,135)};
// (43,135.4) @TEXT("VDD",size=1.1,halign="middle",valign="bottom");
// &"VSS" @WIRE(mode="straight",linecolor="#30485d",linewidth=0.16) {#XRR6:4 (43,115)};
// (43,114.6) @TEXT("VSS",size=1.1,halign="middle",valign="top");
// &"RST6" @WIRE(mode="straight",linecolor="#30485d",linewidth=0.16) {#XRR6:5 (53,125)};
// (53.4,125) @TEXT("RST6",size=1.1,halign="start",valign="middle");
// &"VDD" @WIRE(mode="straight",linecolor="#30485d",linewidth=0.16) {#XRSTEP2:2 (86,171)};
// (86,171.4) @TEXT("VDD",size=1.1,halign="middle",valign="bottom");
// &"VSS" @WIRE(mode="straight",linecolor="#30485d",linewidth=0.16) {#XRSTEP2:3 (86,149)};
// (86,148.6) @TEXT("VSS",size=1.1,halign="middle",valign="top");
// &"PRESET" @WIRE(mode="straight",linecolor="#30485d",linewidth=0.16) {#XRR5:1 (76,126.7)};
// (75.6,126.7) @TEXT("PRESET",size=1.1,halign="end",valign="middle");
// &"VDD" @WIRE(mode="straight",linecolor="#30485d",linewidth=0.16) {#XRR5:3 (86,135)};
// (86,135.4) @TEXT("VDD",size=1.1,halign="middle",valign="bottom");
// &"VSS" @WIRE(mode="straight",linecolor="#30485d",linewidth=0.16) {#XRR5:4 (86,115)};
// (86,114.6) @TEXT("VSS",size=1.1,halign="middle",valign="top");
// &"RST5" @WIRE(mode="straight",linecolor="#30485d",linewidth=0.16) {#XRR5:5 (96,125)};
// (96.4,125) @TEXT("RST5",size=1.1,halign="start",valign="middle");
// &"VDD" @WIRE(mode="straight",linecolor="#30485d",linewidth=0.16) {#XRSTEP3:2 (129,171)};
// (129,171.4) @TEXT("VDD",size=1.1,halign="middle",valign="bottom");
// &"VSS" @WIRE(mode="straight",linecolor="#30485d",linewidth=0.16) {#XRSTEP3:3 (129,149)};
// (129,148.6) @TEXT("VSS",size=1.1,halign="middle",valign="top");
// &"PRESET" @WIRE(mode="straight",linecolor="#30485d",linewidth=0.16) {#XRR4:1 (119,126.7)};
// (118.6,126.7) @TEXT("PRESET",size=1.1,halign="end",valign="middle");
// &"VDD" @WIRE(mode="straight",linecolor="#30485d",linewidth=0.16) {#XRR4:3 (129,135)};
// (129,135.4) @TEXT("VDD",size=1.1,halign="middle",valign="bottom");
// &"VSS" @WIRE(mode="straight",linecolor="#30485d",linewidth=0.16) {#XRR4:4 (129,115)};
// (129,114.6) @TEXT("VSS",size=1.1,halign="middle",valign="top");
// &"RST4" @WIRE(mode="straight",linecolor="#30485d",linewidth=0.16) {#XRR4:5 (139,125)};
// (139.4,125) @TEXT("RST4",size=1.1,halign="start",valign="middle");
// &"VDD" @WIRE(mode="straight",linecolor="#30485d",linewidth=0.16) {#XRSTEP4:2 (172,171)};
// (172,171.4) @TEXT("VDD",size=1.1,halign="middle",valign="bottom");
// &"VSS" @WIRE(mode="straight",linecolor="#30485d",linewidth=0.16) {#XRSTEP4:3 (172,149)};
// (172,148.6) @TEXT("VSS",size=1.1,halign="middle",valign="top");
// &"PRESET" @WIRE(mode="straight",linecolor="#30485d",linewidth=0.16) {#XRR3:1 (162,126.7)};
// (161.6,126.7) @TEXT("PRESET",size=1.1,halign="end",valign="middle");
// &"VDD" @WIRE(mode="straight",linecolor="#30485d",linewidth=0.16) {#XRR3:3 (172,135)};
// (172,135.4) @TEXT("VDD",size=1.1,halign="middle",valign="bottom");
// &"VSS" @WIRE(mode="straight",linecolor="#30485d",linewidth=0.16) {#XRR3:4 (172,115)};
// (172,114.6) @TEXT("VSS",size=1.1,halign="middle",valign="top");
// &"RST3" @WIRE(mode="straight",linecolor="#30485d",linewidth=0.16) {#XRR3:5 (182,125)};
// (182.4,125) @TEXT("RST3",size=1.1,halign="start",valign="middle");
// &"VDD" @WIRE(mode="straight",linecolor="#30485d",linewidth=0.16) {#XRSTEP5:2 (215,171)};
// (215,171.4) @TEXT("VDD",size=1.1,halign="middle",valign="bottom");
// &"VSS" @WIRE(mode="straight",linecolor="#30485d",linewidth=0.16) {#XRSTEP5:3 (215,149)};
// (215,148.6) @TEXT("VSS",size=1.1,halign="middle",valign="top");
// &"PRESET" @WIRE(mode="straight",linecolor="#30485d",linewidth=0.16) {#XRR2:1 (205,126.7)};
// (204.6,126.7) @TEXT("PRESET",size=1.1,halign="end",valign="middle");
// &"VDD" @WIRE(mode="straight",linecolor="#30485d",linewidth=0.16) {#XRR2:3 (215,135)};
// (215,135.4) @TEXT("VDD",size=1.1,halign="middle",valign="bottom");
// &"VSS" @WIRE(mode="straight",linecolor="#30485d",linewidth=0.16) {#XRR2:4 (215,115)};
// (215,114.6) @TEXT("VSS",size=1.1,halign="middle",valign="top");
// &"RST2" @WIRE(mode="straight",linecolor="#30485d",linewidth=0.16) {#XRR2:5 (225,125)};
// (225.4,125) @TEXT("RST2",size=1.1,halign="start",valign="middle");
// &"VDD" @WIRE(mode="straight",linecolor="#30485d",linewidth=0.16) {#XRSTEP6:2 (258,171)};
// (258,171.4) @TEXT("VDD",size=1.1,halign="middle",valign="bottom");
// &"VSS" @WIRE(mode="straight",linecolor="#30485d",linewidth=0.16) {#XRSTEP6:3 (258,149)};
// (258,148.6) @TEXT("VSS",size=1.1,halign="middle",valign="top");
// &"PRESET" @WIRE(mode="straight",linecolor="#30485d",linewidth=0.16) {#XRR1:1 (248,126.7)};
// (247.6,126.7) @TEXT("PRESET",size=1.1,halign="end",valign="middle");
// &"VDD" @WIRE(mode="straight",linecolor="#30485d",linewidth=0.16) {#XRR1:3 (258,135)};
// (258,135.4) @TEXT("VDD",size=1.1,halign="middle",valign="bottom");
// &"VSS" @WIRE(mode="straight",linecolor="#30485d",linewidth=0.16) {#XRR1:4 (258,115)};
// (258,114.6) @TEXT("VSS",size=1.1,halign="middle",valign="top");
// &"RST1" @WIRE(mode="straight",linecolor="#30485d",linewidth=0.16) {#XRR1:5 (268,125)};
// (268.4,125) @TEXT("RST1",size=1.1,halign="start",valign="middle");
// &"VDD" @WIRE(mode="straight",linecolor="#30485d",linewidth=0.16) {#XRSTEP7:2 (301,171)};
// (301,171.4) @TEXT("VDD",size=1.1,halign="middle",valign="bottom");
// &"VSS" @WIRE(mode="straight",linecolor="#30485d",linewidth=0.16) {#XRSTEP7:3 (301,149)};
// (301,148.6) @TEXT("VSS",size=1.1,halign="middle",valign="top");
// &"PRESET" @WIRE(mode="straight",linecolor="#30485d",linewidth=0.16) {#XRR0:1 (291,126.7)};
// (290.6,126.7) @TEXT("PRESET",size=1.1,halign="end",valign="middle");
// &"VDD" @WIRE(mode="straight",linecolor="#30485d",linewidth=0.16) {#XRR0:3 (301,135)};
// (301,135.4) @TEXT("VDD",size=1.1,halign="middle",valign="bottom");
// &"VSS" @WIRE(mode="straight",linecolor="#30485d",linewidth=0.16) {#XRR0:4 (301,115)};
// (301,114.6) @TEXT("VSS",size=1.1,halign="middle",valign="top");
// &"RST0" @WIRE(mode="straight",linecolor="#30485d",linewidth=0.16) {#XRR0:5 (311,125)};
// (311.4,125) @TEXT("RST0",size=1.1,halign="start",valign="middle");
// &"RST0" @WIRE(mode="straight",linecolor="#30485d",linewidth=0.16) {#XRDONE:1 (334,125)};
// (333.6,125) @TEXT("RST0",size=1.1,halign="end",valign="middle");
// &"VDD" @WIRE(mode="straight",linecolor="#30485d",linewidth=0.16) {#XRDONE:2 (344,135)};
// (344,135.4) @TEXT("VDD",size=1.1,halign="middle",valign="bottom");
// &"VSS" @WIRE(mode="straight",linecolor="#30485d",linewidth=0.16) {#XRDONE:3 (344,115)};
// (344,114.6) @TEXT("VSS",size=1.1,halign="middle",valign="top");
// &"RST_DONE" @WIRE(mode="straight",linecolor="#30485d",linewidth=0.16) {#XRDONE:4 (354,125)};
// (354.4,125) @TEXT("RST_DONE",size=1.1,halign="start",valign="middle");
// &"VDD" @WIRE(mode="straight",linecolor="#30485d",linewidth=0.16) {#X002:2 (86,75)};
// (86,75.4) @TEXT("VDD",size=1.1,halign="middle",valign="bottom");
// &"VSS" @WIRE(mode="straight",linecolor="#30485d",linewidth=0.16) {#X002:3 (86,55)};
// (86,54.6) @TEXT("VSS",size=1.1,halign="middle",valign="top");
// &"FIRST2" @WIRE(mode="straight",linecolor="#30485d",linewidth=0.16) {#X002:4 (96,65)};
// (96.4,65) @TEXT("FIRST2",size=1.1,halign="start",valign="middle");
// &"VDD" @WIRE(mode="straight",linecolor="#30485d",linewidth=0.16) {#X001:2 (43,75)};
// (43,75.4) @TEXT("VDD",size=1.1,halign="middle",valign="bottom");
// &"VSS" @WIRE(mode="straight",linecolor="#30485d",linewidth=0.16) {#X001:3 (43,55)};
// (43,54.6) @TEXT("VSS",size=1.1,halign="middle",valign="top");
// &"PHI_U" @WIRE(mode="straight",linecolor="#30485d",linewidth=0.16) {#X000:1 (-10,65)};
// (-10.4,65) @TEXT("PHI_U",size=1.1,halign="end",valign="middle");
// &"VDD" @WIRE(mode="straight",linecolor="#30485d",linewidth=0.16) {#X000:2 (0,75)};
// (0,75.4) @TEXT("VDD",size=1.1,halign="middle",valign="bottom");
// &"VSS" @WIRE(mode="straight",linecolor="#30485d",linewidth=0.16) {#X000:3 (0,55)};
// (0,54.6) @TEXT("VSS",size=1.1,halign="middle",valign="top");
// &"FIRST2" @WIRE(mode="straight",linecolor="#30485d",linewidth=0.16) {#X007:1 (161,66.7)};
// (160.6,66.7) @TEXT("FIRST2",size=1.1,halign="end",valign="middle");
// &"LATE_CLK" @WIRE(mode="straight",linecolor="#30485d",linewidth=0.16) {#X007:2 (161,63.3)};
// (160.6,63.3) @TEXT("LATE_CLK",size=1.1,halign="end",valign="middle");
// &"VDD" @WIRE(mode="straight",linecolor="#30485d",linewidth=0.16) {#X007:3 (171,75)};
// (171,75.4) @TEXT("VDD",size=1.1,halign="middle",valign="bottom");
// &"VSS" @WIRE(mode="straight",linecolor="#30485d",linewidth=0.16) {#X007:4 (171,55)};
// (171,54.6) @TEXT("VSS",size=1.1,halign="middle",valign="top");
// &"CAP_REQ" @WIRE(mode="straight",linecolor="#30485d",linewidth=0.16) {#X007:5 (181,65)};
// (181.4,65) @TEXT("CAP_REQ",size=1.1,halign="start",valign="middle");
// &"SAMPLE" @WIRE(mode="straight",linecolor="#30485d",linewidth=0.16) {#X003:1 (-10,26.7)};
// (-10.4,26.7) @TEXT("SAMPLE",size=1.1,halign="end",valign="middle");
// &"ACK" @WIRE(mode="straight",linecolor="#30485d",linewidth=0.16) {#X003:2 (-10,23.3)};
// (-10.4,23.3) @TEXT("ACK",size=1.1,halign="end",valign="middle");
// &"VDD" @WIRE(mode="straight",linecolor="#30485d",linewidth=0.16) {#X003:3 (0,35)};
// (0,35.4) @TEXT("VDD",size=1.1,halign="middle",valign="bottom");
// &"VSS" @WIRE(mode="straight",linecolor="#30485d",linewidth=0.16) {#X003:4 (0,15)};
// (0,14.6) @TEXT("VSS",size=1.1,halign="middle",valign="top");
// &"PHI_U" @WIRE(mode="straight",linecolor="#30485d",linewidth=0.16) {#XREQUEST:3 (27,23.35)};
// (26.6,23.35) @TEXT("PHI_U",size=1.1,halign="end",valign="middle");
// &"VDD" @WIRE(mode="straight",linecolor="#30485d",linewidth=0.16) {#XREQUEST:4 (43,36)};
// (43,36.4) @TEXT("VDD",size=1.1,halign="middle",valign="bottom");
// &"VSS" @WIRE(mode="straight",linecolor="#30485d",linewidth=0.16) {#XREQUEST:5 (43,14)};
// (43,13.6) @TEXT("VSS",size=1.1,halign="middle",valign="top");
// &"VDD" @WIRE(mode="straight",linecolor="#30485d",linewidth=0.16) {#XD_LATE_CLK:2 (86,36)};
// (86,36.4) @TEXT("VDD",size=1.1,halign="middle",valign="bottom");
// &"VSS" @WIRE(mode="straight",linecolor="#30485d",linewidth=0.16) {#XD_LATE_CLK:3 (86,14)};
// (86,13.6) @TEXT("VSS",size=1.1,halign="middle",valign="top");
// &"LATE_CLK" @WIRE(mode="straight",linecolor="#30485d",linewidth=0.16) {#XD_LATE_CLK:4 (102,25)};
// (102.4,25) @TEXT("LATE_CLK",size=1.1,halign="start",valign="middle");
// &"LATE_CLK" @WIRE(mode="straight",linecolor="#30485d",linewidth=0.16) {#XD_ACK:1 (113,25)};
// (112.6,25) @TEXT("LATE_CLK",size=1.1,halign="end",valign="middle");
// &"VDD" @WIRE(mode="straight",linecolor="#30485d",linewidth=0.16) {#XD_ACK:2 (129,36)};
// (129,36.4) @TEXT("VDD",size=1.1,halign="middle",valign="bottom");
// &"VSS" @WIRE(mode="straight",linecolor="#30485d",linewidth=0.16) {#XD_ACK:3 (129,14)};
// (129,13.6) @TEXT("VSS",size=1.1,halign="middle",valign="top");
// &"ACK" @WIRE(mode="straight",linecolor="#30485d",linewidth=0.16) {#XD_ACK:4 (145,25)};
// (145.4,25) @TEXT("ACK",size=1.1,halign="start",valign="middle");
// &"CAP_REQ" @WIRE(mode="straight",linecolor="#30485d",linewidth=0.16) {#X008:1 (204,65)};
// (203.6,65) @TEXT("CAP_REQ",size=1.1,halign="end",valign="middle");
// &"VDD" @WIRE(mode="straight",linecolor="#30485d",linewidth=0.16) {#X008:2 (214,75)};
// (214,75.4) @TEXT("VDD",size=1.1,halign="middle",valign="bottom");
// &"VSS" @WIRE(mode="straight",linecolor="#30485d",linewidth=0.16) {#X008:3 (214,55)};
// (214,54.6) @TEXT("VSS",size=1.1,halign="middle",valign="top");
// &"CAP_CLK" @WIRE(mode="straight",linecolor="#30485d",linewidth=0.16) {#X008:4 (224,65)};
// (224.4,65) @TEXT("CAP_CLK",size=1.1,halign="start",valign="middle");
// &"CODE7" @WIRE(mode="straight",linecolor="#30485d",linewidth=0.16) {#XMUX7:1 (-10,-21.6)};
// (-10.4,-21.6) @TEXT("CODE7",size=1.1,halign="end",valign="middle");
// &"D7" @WIRE(mode="straight",linecolor="#30485d",linewidth=0.16) {#XMUX7:2 (-10,-25)};
// (-10.4,-25) @TEXT("D7",size=1.1,halign="end",valign="middle");
// &"PHI_U" @WIRE(mode="straight",linecolor="#30485d",linewidth=0.16) {#XMUX7:3 (-10,-28.4)};
// (-10.4,-28.4) @TEXT("PHI_U",size=1.1,halign="end",valign="middle");
// &"VDD" @WIRE(mode="straight",linecolor="#30485d",linewidth=0.16) {#XMUX7:4 (0,-15)};
// (0,-14.6) @TEXT("VDD",size=1.1,halign="middle",valign="bottom");
// &"VSS" @WIRE(mode="straight",linecolor="#30485d",linewidth=0.16) {#XMUX7:5 (0,-35)};
// (0,-35.4) @TEXT("VSS",size=1.1,halign="middle",valign="top");
// &"CODE6" @WIRE(mode="straight",linecolor="#30485d",linewidth=0.16) {#XMUX6:1 (-10,-59.6)};
// (-10.4,-59.6) @TEXT("CODE6",size=1.1,halign="end",valign="middle");
// &"D6" @WIRE(mode="straight",linecolor="#30485d",linewidth=0.16) {#XMUX6:2 (-10,-63)};
// (-10.4,-63) @TEXT("D6",size=1.1,halign="end",valign="middle");
// &"PHI_U" @WIRE(mode="straight",linecolor="#30485d",linewidth=0.16) {#XMUX6:3 (-10,-66.4)};
// (-10.4,-66.4) @TEXT("PHI_U",size=1.1,halign="end",valign="middle");
// &"VDD" @WIRE(mode="straight",linecolor="#30485d",linewidth=0.16) {#XMUX6:4 (0,-53)};
// (0,-52.6) @TEXT("VDD",size=1.1,halign="middle",valign="bottom");
// &"VSS" @WIRE(mode="straight",linecolor="#30485d",linewidth=0.16) {#XMUX6:5 (0,-73)};
// (0,-73.4) @TEXT("VSS",size=1.1,halign="middle",valign="top");
// &"TARGET6" @WIRE(mode="straight",linecolor="#30485d",linewidth=0.16) {#XMUX6:6 (10,-63)};
// (10.4,-63) @TEXT("TARGET6",size=1.1,halign="start",valign="middle");
// &"CODE5" @WIRE(mode="straight",linecolor="#30485d",linewidth=0.16) {#XMUX5:1 (-10,-97.6)};
// (-10.4,-97.6) @TEXT("CODE5",size=1.1,halign="end",valign="middle");
// &"D5" @WIRE(mode="straight",linecolor="#30485d",linewidth=0.16) {#XMUX5:2 (-10,-101)};
// (-10.4,-101) @TEXT("D5",size=1.1,halign="end",valign="middle");
// &"PHI_U" @WIRE(mode="straight",linecolor="#30485d",linewidth=0.16) {#XMUX5:3 (-10,-104.4)};
// (-10.4,-104.4) @TEXT("PHI_U",size=1.1,halign="end",valign="middle");
// &"VDD" @WIRE(mode="straight",linecolor="#30485d",linewidth=0.16) {#XMUX5:4 (0,-91)};
// (0,-90.6) @TEXT("VDD",size=1.1,halign="middle",valign="bottom");
// &"VSS" @WIRE(mode="straight",linecolor="#30485d",linewidth=0.16) {#XMUX5:5 (0,-111)};
// (0,-111.4) @TEXT("VSS",size=1.1,halign="middle",valign="top");
// &"TARGET5" @WIRE(mode="straight",linecolor="#30485d",linewidth=0.16) {#XMUX5:6 (10,-101)};
// (10.4,-101) @TEXT("TARGET5",size=1.1,halign="start",valign="middle");
// &"CODE4" @WIRE(mode="straight",linecolor="#30485d",linewidth=0.16) {#XMUX4:1 (-10,-135.6)};
// (-10.4,-135.6) @TEXT("CODE4",size=1.1,halign="end",valign="middle");
// &"D4" @WIRE(mode="straight",linecolor="#30485d",linewidth=0.16) {#XMUX4:2 (-10,-139)};
// (-10.4,-139) @TEXT("D4",size=1.1,halign="end",valign="middle");
// &"PHI_U" @WIRE(mode="straight",linecolor="#30485d",linewidth=0.16) {#XMUX4:3 (-10,-142.4)};
// (-10.4,-142.4) @TEXT("PHI_U",size=1.1,halign="end",valign="middle");
// &"VDD" @WIRE(mode="straight",linecolor="#30485d",linewidth=0.16) {#XMUX4:4 (0,-129)};
// (0,-128.6) @TEXT("VDD",size=1.1,halign="middle",valign="bottom");
// &"VSS" @WIRE(mode="straight",linecolor="#30485d",linewidth=0.16) {#XMUX4:5 (0,-149)};
// (0,-149.4) @TEXT("VSS",size=1.1,halign="middle",valign="top");
// &"TARGET4" @WIRE(mode="straight",linecolor="#30485d",linewidth=0.16) {#XMUX4:6 (10,-139)};
// (10.4,-139) @TEXT("TARGET4",size=1.1,halign="start",valign="middle");
// &"CODE3" @WIRE(mode="straight",linecolor="#30485d",linewidth=0.16) {#XMUX3:1 (-10,-173.6)};
// (-10.4,-173.6) @TEXT("CODE3",size=1.1,halign="end",valign="middle");
// &"D3" @WIRE(mode="straight",linecolor="#30485d",linewidth=0.16) {#XMUX3:2 (-10,-177)};
// (-10.4,-177) @TEXT("D3",size=1.1,halign="end",valign="middle");
// &"PHI_U" @WIRE(mode="straight",linecolor="#30485d",linewidth=0.16) {#XMUX3:3 (-10,-180.4)};
// (-10.4,-180.4) @TEXT("PHI_U",size=1.1,halign="end",valign="middle");
// &"VDD" @WIRE(mode="straight",linecolor="#30485d",linewidth=0.16) {#XMUX3:4 (0,-167)};
// (0,-166.6) @TEXT("VDD",size=1.1,halign="middle",valign="bottom");
// &"VSS" @WIRE(mode="straight",linecolor="#30485d",linewidth=0.16) {#XMUX3:5 (0,-187)};
// (0,-187.4) @TEXT("VSS",size=1.1,halign="middle",valign="top");
// &"TARGET3" @WIRE(mode="straight",linecolor="#30485d",linewidth=0.16) {#XMUX3:6 (10,-177)};
// (10.4,-177) @TEXT("TARGET3",size=1.1,halign="start",valign="middle");
// &"CODE2" @WIRE(mode="straight",linecolor="#30485d",linewidth=0.16) {#XMUX2:1 (-10,-211.6)};
// (-10.4,-211.6) @TEXT("CODE2",size=1.1,halign="end",valign="middle");
// &"D2" @WIRE(mode="straight",linecolor="#30485d",linewidth=0.16) {#XMUX2:2 (-10,-215)};
// (-10.4,-215) @TEXT("D2",size=1.1,halign="end",valign="middle");
// &"PHI_U" @WIRE(mode="straight",linecolor="#30485d",linewidth=0.16) {#XMUX2:3 (-10,-218.4)};
// (-10.4,-218.4) @TEXT("PHI_U",size=1.1,halign="end",valign="middle");
// &"VDD" @WIRE(mode="straight",linecolor="#30485d",linewidth=0.16) {#XMUX2:4 (0,-205)};
// (0,-204.6) @TEXT("VDD",size=1.1,halign="middle",valign="bottom");
// &"VSS" @WIRE(mode="straight",linecolor="#30485d",linewidth=0.16) {#XMUX2:5 (0,-225)};
// (0,-225.4) @TEXT("VSS",size=1.1,halign="middle",valign="top");
// &"TARGET2" @WIRE(mode="straight",linecolor="#30485d",linewidth=0.16) {#XMUX2:6 (10,-215)};
// (10.4,-215) @TEXT("TARGET2",size=1.1,halign="start",valign="middle");
// &"CODE1" @WIRE(mode="straight",linecolor="#30485d",linewidth=0.16) {#XMUX1:1 (-10,-249.6)};
// (-10.4,-249.6) @TEXT("CODE1",size=1.1,halign="end",valign="middle");
// &"D1" @WIRE(mode="straight",linecolor="#30485d",linewidth=0.16) {#XMUX1:2 (-10,-253)};
// (-10.4,-253) @TEXT("D1",size=1.1,halign="end",valign="middle");
// &"PHI_U" @WIRE(mode="straight",linecolor="#30485d",linewidth=0.16) {#XMUX1:3 (-10,-256.4)};
// (-10.4,-256.4) @TEXT("PHI_U",size=1.1,halign="end",valign="middle");
// &"VDD" @WIRE(mode="straight",linecolor="#30485d",linewidth=0.16) {#XMUX1:4 (0,-243)};
// (0,-242.6) @TEXT("VDD",size=1.1,halign="middle",valign="bottom");
// &"VSS" @WIRE(mode="straight",linecolor="#30485d",linewidth=0.16) {#XMUX1:5 (0,-263)};
// (0,-263.4) @TEXT("VSS",size=1.1,halign="middle",valign="top");
// &"TARGET1" @WIRE(mode="straight",linecolor="#30485d",linewidth=0.16) {#XMUX1:6 (10,-253)};
// (10.4,-253) @TEXT("TARGET1",size=1.1,halign="start",valign="middle");
// &"CODE0" @WIRE(mode="straight",linecolor="#30485d",linewidth=0.16) {#XMUX0:1 (-10,-287.6)};
// (-10.4,-287.6) @TEXT("CODE0",size=1.1,halign="end",valign="middle");
// &"D0" @WIRE(mode="straight",linecolor="#30485d",linewidth=0.16) {#XMUX0:2 (-10,-291)};
// (-10.4,-291) @TEXT("D0",size=1.1,halign="end",valign="middle");
// &"PHI_U" @WIRE(mode="straight",linecolor="#30485d",linewidth=0.16) {#XMUX0:3 (-10,-294.4)};
// (-10.4,-294.4) @TEXT("PHI_U",size=1.1,halign="end",valign="middle");
// &"VDD" @WIRE(mode="straight",linecolor="#30485d",linewidth=0.16) {#XMUX0:4 (0,-281)};
// (0,-280.6) @TEXT("VDD",size=1.1,halign="middle",valign="bottom");
// &"VSS" @WIRE(mode="straight",linecolor="#30485d",linewidth=0.16) {#XMUX0:5 (0,-301)};
// (0,-301.4) @TEXT("VSS",size=1.1,halign="middle",valign="top");
// &"TARGET0" @WIRE(mode="straight",linecolor="#30485d",linewidth=0.16) {#XMUX0:6 (10,-291)};
// (10.4,-291) @TEXT("TARGET0",size=1.1,halign="start",valign="middle");
// &"VDD" @WIRE(mode="straight",linecolor="#30485d",linewidth=0.16) {#X018:2 (118,-15)};
// (118,-14.6) @TEXT("VDD",size=1.1,halign="middle",valign="bottom");
// &"VSS" @WIRE(mode="straight",linecolor="#30485d",linewidth=0.16) {#X018:3 (118,-35)};
// (118,-35.4) @TEXT("VSS",size=1.1,halign="middle",valign="top");
// &"VDD" @WIRE(mode="straight",linecolor="#30485d",linewidth=0.16) {#X017:2 (43,-15)};
// (43,-14.6) @TEXT("VDD",size=1.1,halign="middle",valign="bottom");
// &"VSS" @WIRE(mode="straight",linecolor="#30485d",linewidth=0.16) {#X017:3 (43,-35)};
// (43,-35.4) @TEXT("VSS",size=1.1,halign="middle",valign="top");
// &"CAP_CLK" @WIRE(mode="straight",linecolor="#30485d",linewidth=0.16) {#XSTORE7:1 (76,-21.6)};
// (75.6,-21.6) @TEXT("CAP_CLK",size=1.1,halign="end",valign="middle");
// &"RST7" @WIRE(mode="straight",linecolor="#30485d",linewidth=0.16) {#XSTORE7:4 (76,-28.4)};
// (75.6,-28.4) @TEXT("RST7",size=1.1,halign="end",valign="middle");
// &"VDD" @WIRE(mode="straight",linecolor="#30485d",linewidth=0.16) {#XSTORE7:5 (86,-15)};
// (86,-14.6) @TEXT("VDD",size=1.1,halign="middle",valign="bottom");
// &"VSS" @WIRE(mode="straight",linecolor="#30485d",linewidth=0.16) {#XSTORE7:6 (86,-35)};
// (86,-35.4) @TEXT("VSS",size=1.1,halign="middle",valign="top");
// &"CAP_CLK" @WIRE(mode="straight",linecolor="#30485d",linewidth=0.16) {#XSTORE6:1 (76,-59.6)};
// (75.6,-59.6) @TEXT("CAP_CLK",size=1.1,halign="end",valign="middle");
// &"TARGET6" @WIRE(mode="straight",linecolor="#30485d",linewidth=0.16) {#XSTORE6:2 (76,-63)};
// (75.6,-63) @TEXT("TARGET6",size=1.1,halign="end",valign="middle");
// &"RST6" @WIRE(mode="straight",linecolor="#30485d",linewidth=0.16) {#XSTORE6:4 (76,-66.4)};
// (75.6,-66.4) @TEXT("RST6",size=1.1,halign="end",valign="middle");
// &"VDD" @WIRE(mode="straight",linecolor="#30485d",linewidth=0.16) {#XSTORE6:5 (86,-53)};
// (86,-52.6) @TEXT("VDD",size=1.1,halign="middle",valign="bottom");
// &"VSS" @WIRE(mode="straight",linecolor="#30485d",linewidth=0.16) {#XSTORE6:6 (86,-73)};
// (86,-73.4) @TEXT("VSS",size=1.1,halign="middle",valign="top");
// &"CAP_CLK" @WIRE(mode="straight",linecolor="#30485d",linewidth=0.16) {#XSTORE5:1 (76,-97.6)};
// (75.6,-97.6) @TEXT("CAP_CLK",size=1.1,halign="end",valign="middle");
// &"TARGET5" @WIRE(mode="straight",linecolor="#30485d",linewidth=0.16) {#XSTORE5:2 (76,-101)};
// (75.6,-101) @TEXT("TARGET5",size=1.1,halign="end",valign="middle");
// &"RST5" @WIRE(mode="straight",linecolor="#30485d",linewidth=0.16) {#XSTORE5:4 (76,-104.4)};
// (75.6,-104.4) @TEXT("RST5",size=1.1,halign="end",valign="middle");
// &"VDD" @WIRE(mode="straight",linecolor="#30485d",linewidth=0.16) {#XSTORE5:5 (86,-91)};
// (86,-90.6) @TEXT("VDD",size=1.1,halign="middle",valign="bottom");
// &"VSS" @WIRE(mode="straight",linecolor="#30485d",linewidth=0.16) {#XSTORE5:6 (86,-111)};
// (86,-111.4) @TEXT("VSS",size=1.1,halign="middle",valign="top");
// &"CAP_CLK" @WIRE(mode="straight",linecolor="#30485d",linewidth=0.16) {#XSTORE4:1 (76,-135.6)};
// (75.6,-135.6) @TEXT("CAP_CLK",size=1.1,halign="end",valign="middle");
// &"TARGET4" @WIRE(mode="straight",linecolor="#30485d",linewidth=0.16) {#XSTORE4:2 (76,-139)};
// (75.6,-139) @TEXT("TARGET4",size=1.1,halign="end",valign="middle");
// &"RST4" @WIRE(mode="straight",linecolor="#30485d",linewidth=0.16) {#XSTORE4:4 (76,-142.4)};
// (75.6,-142.4) @TEXT("RST4",size=1.1,halign="end",valign="middle");
// &"VDD" @WIRE(mode="straight",linecolor="#30485d",linewidth=0.16) {#XSTORE4:5 (86,-129)};
// (86,-128.6) @TEXT("VDD",size=1.1,halign="middle",valign="bottom");
// &"VSS" @WIRE(mode="straight",linecolor="#30485d",linewidth=0.16) {#XSTORE4:6 (86,-149)};
// (86,-149.4) @TEXT("VSS",size=1.1,halign="middle",valign="top");
// &"CAP_CLK" @WIRE(mode="straight",linecolor="#30485d",linewidth=0.16) {#XSTORE3:1 (76,-173.6)};
// (75.6,-173.6) @TEXT("CAP_CLK",size=1.1,halign="end",valign="middle");
// &"TARGET3" @WIRE(mode="straight",linecolor="#30485d",linewidth=0.16) {#XSTORE3:2 (76,-177)};
// (75.6,-177) @TEXT("TARGET3",size=1.1,halign="end",valign="middle");
// &"RST3" @WIRE(mode="straight",linecolor="#30485d",linewidth=0.16) {#XSTORE3:4 (76,-180.4)};
// (75.6,-180.4) @TEXT("RST3",size=1.1,halign="end",valign="middle");
// &"VDD" @WIRE(mode="straight",linecolor="#30485d",linewidth=0.16) {#XSTORE3:5 (86,-167)};
// (86,-166.6) @TEXT("VDD",size=1.1,halign="middle",valign="bottom");
// &"VSS" @WIRE(mode="straight",linecolor="#30485d",linewidth=0.16) {#XSTORE3:6 (86,-187)};
// (86,-187.4) @TEXT("VSS",size=1.1,halign="middle",valign="top");
// &"CAP_CLK" @WIRE(mode="straight",linecolor="#30485d",linewidth=0.16) {#XSTORE2:1 (76,-211.6)};
// (75.6,-211.6) @TEXT("CAP_CLK",size=1.1,halign="end",valign="middle");
// &"TARGET2" @WIRE(mode="straight",linecolor="#30485d",linewidth=0.16) {#XSTORE2:2 (76,-215)};
// (75.6,-215) @TEXT("TARGET2",size=1.1,halign="end",valign="middle");
// &"RST2" @WIRE(mode="straight",linecolor="#30485d",linewidth=0.16) {#XSTORE2:4 (76,-218.4)};
// (75.6,-218.4) @TEXT("RST2",size=1.1,halign="end",valign="middle");
// &"VDD" @WIRE(mode="straight",linecolor="#30485d",linewidth=0.16) {#XSTORE2:5 (86,-205)};
// (86,-204.6) @TEXT("VDD",size=1.1,halign="middle",valign="bottom");
// &"VSS" @WIRE(mode="straight",linecolor="#30485d",linewidth=0.16) {#XSTORE2:6 (86,-225)};
// (86,-225.4) @TEXT("VSS",size=1.1,halign="middle",valign="top");
// &"CAP_CLK" @WIRE(mode="straight",linecolor="#30485d",linewidth=0.16) {#XSTORE1:1 (76,-249.6)};
// (75.6,-249.6) @TEXT("CAP_CLK",size=1.1,halign="end",valign="middle");
// &"TARGET1" @WIRE(mode="straight",linecolor="#30485d",linewidth=0.16) {#XSTORE1:2 (76,-253)};
// (75.6,-253) @TEXT("TARGET1",size=1.1,halign="end",valign="middle");
// &"RST1" @WIRE(mode="straight",linecolor="#30485d",linewidth=0.16) {#XSTORE1:4 (76,-256.4)};
// (75.6,-256.4) @TEXT("RST1",size=1.1,halign="end",valign="middle");
// &"VDD" @WIRE(mode="straight",linecolor="#30485d",linewidth=0.16) {#XSTORE1:5 (86,-243)};
// (86,-242.6) @TEXT("VDD",size=1.1,halign="middle",valign="bottom");
// &"VSS" @WIRE(mode="straight",linecolor="#30485d",linewidth=0.16) {#XSTORE1:6 (86,-263)};
// (86,-263.4) @TEXT("VSS",size=1.1,halign="middle",valign="top");
// &"CAP_CLK" @WIRE(mode="straight",linecolor="#30485d",linewidth=0.16) {#XSTORE0:1 (76,-287.6)};
// (75.6,-287.6) @TEXT("CAP_CLK",size=1.1,halign="end",valign="middle");
// &"TARGET0" @WIRE(mode="straight",linecolor="#30485d",linewidth=0.16) {#XSTORE0:2 (76,-291)};
// (75.6,-291) @TEXT("TARGET0",size=1.1,halign="end",valign="middle");
// &"RST0" @WIRE(mode="straight",linecolor="#30485d",linewidth=0.16) {#XSTORE0:4 (76,-294.4)};
// (75.6,-294.4) @TEXT("RST0",size=1.1,halign="end",valign="middle");
// &"VDD" @WIRE(mode="straight",linecolor="#30485d",linewidth=0.16) {#XSTORE0:5 (86,-281)};
// (86,-280.6) @TEXT("VDD",size=1.1,halign="middle",valign="bottom");
// &"VSS" @WIRE(mode="straight",linecolor="#30485d",linewidth=0.16) {#XSTORE0:6 (86,-301)};
// (86,-301.4) @TEXT("VSS",size=1.1,halign="middle",valign="top");
// &"VDD" @WIRE(mode="straight",linecolor="#30485d",linewidth=0.16) {#XBBM7:4 (155,-14)};
// (155,-13.6) @TEXT("VDD",size=1.1,halign="middle",valign="bottom");
// &"VSS" @WIRE(mode="straight",linecolor="#30485d",linewidth=0.16) {#XBBM7:5 (155,-36)};
// (155,-36.4) @TEXT("VSS",size=1.1,halign="middle",valign="top");
// &"VDD" @WIRE(mode="straight",linecolor="#30485d",linewidth=0.16) {#XBBM6:4 (155,-52)};
// (155,-51.6) @TEXT("VDD",size=1.1,halign="middle",valign="bottom");
// &"VSS" @WIRE(mode="straight",linecolor="#30485d",linewidth=0.16) {#XBBM6:5 (155,-74)};
// (155,-74.4) @TEXT("VSS",size=1.1,halign="middle",valign="top");
// &"VDD" @WIRE(mode="straight",linecolor="#30485d",linewidth=0.16) {#XBBM5:4 (155,-90)};
// (155,-89.6) @TEXT("VDD",size=1.1,halign="middle",valign="bottom");
// &"VSS" @WIRE(mode="straight",linecolor="#30485d",linewidth=0.16) {#XBBM5:5 (155,-112)};
// (155,-112.4) @TEXT("VSS",size=1.1,halign="middle",valign="top");
// &"VDD" @WIRE(mode="straight",linecolor="#30485d",linewidth=0.16) {#XBBM4:4 (155,-128)};
// (155,-127.6) @TEXT("VDD",size=1.1,halign="middle",valign="bottom");
// &"VSS" @WIRE(mode="straight",linecolor="#30485d",linewidth=0.16) {#XBBM4:5 (155,-150)};
// (155,-150.4) @TEXT("VSS",size=1.1,halign="middle",valign="top");
// &"VDD" @WIRE(mode="straight",linecolor="#30485d",linewidth=0.16) {#XBBM3:4 (155,-166)};
// (155,-165.6) @TEXT("VDD",size=1.1,halign="middle",valign="bottom");
// &"VSS" @WIRE(mode="straight",linecolor="#30485d",linewidth=0.16) {#XBBM3:5 (155,-188)};
// (155,-188.4) @TEXT("VSS",size=1.1,halign="middle",valign="top");
// &"VDD" @WIRE(mode="straight",linecolor="#30485d",linewidth=0.16) {#XBBM2:4 (155,-204)};
// (155,-203.6) @TEXT("VDD",size=1.1,halign="middle",valign="bottom");
// &"VSS" @WIRE(mode="straight",linecolor="#30485d",linewidth=0.16) {#XBBM2:5 (155,-226)};
// (155,-226.4) @TEXT("VSS",size=1.1,halign="middle",valign="top");
// &"VDD" @WIRE(mode="straight",linecolor="#30485d",linewidth=0.16) {#XBBM1:4 (155,-242)};
// (155,-241.6) @TEXT("VDD",size=1.1,halign="middle",valign="bottom");
// &"VSS" @WIRE(mode="straight",linecolor="#30485d",linewidth=0.16) {#XBBM1:5 (155,-264)};
// (155,-264.4) @TEXT("VSS",size=1.1,halign="middle",valign="top");
// &"VDD" @WIRE(mode="straight",linecolor="#30485d",linewidth=0.16) {#XBBM0:4 (155,-280)};
// (155,-279.6) @TEXT("VDD",size=1.1,halign="middle",valign="bottom");
// &"VSS" @WIRE(mode="straight",linecolor="#30485d",linewidth=0.16) {#XBBM0:5 (155,-302)};
// (155,-302.4) @TEXT("VSS",size=1.1,halign="middle",valign="top");
// &"GNN0" @WIRE(mode="straight",linecolor="#30485d",linewidth=0.16) {#XDRV0:1 (234,-282.75)};
// (234.4,-282.75) @TEXT("GNN0",size=1.1,halign="start",valign="middle");
// &"GNP0" @WIRE(mode="straight",linecolor="#30485d",linewidth=0.16) {#XDRV0:2 (234,-286.05)};
// (234.4,-286.05) @TEXT("GNP0",size=1.1,halign="start",valign="middle");
// &"GPN0" @WIRE(mode="straight",linecolor="#30485d",linewidth=0.16) {#XDRV0:3 (234,-289.35)};
// (234.4,-289.35) @TEXT("GPN0",size=1.1,halign="start",valign="middle");
// &"GPP0" @WIRE(mode="straight",linecolor="#30485d",linewidth=0.16) {#XDRV0:4 (234,-292.65)};
// (234.4,-292.65) @TEXT("GPP0",size=1.1,halign="start",valign="middle");
// &"VDD" @WIRE(mode="straight",linecolor="#30485d",linewidth=0.16) {#XDRV0:7 (218,-274.45)};
// (218,-274.05) @TEXT("VDD",size=1.1,halign="middle",valign="bottom");
// &"VSS" @WIRE(mode="straight",linecolor="#30485d",linewidth=0.16) {#XDRV0:8 (218,-307.55)};
// (218,-307.95) @TEXT("VSS",size=1.1,halign="middle",valign="top");
// &"GNN1" @WIRE(mode="straight",linecolor="#30485d",linewidth=0.16) {#XDRV1:1 (234,-244.75)};
// (234.4,-244.75) @TEXT("GNN1",size=1.1,halign="start",valign="middle");
// &"GNP1" @WIRE(mode="straight",linecolor="#30485d",linewidth=0.16) {#XDRV1:2 (234,-248.05)};
// (234.4,-248.05) @TEXT("GNP1",size=1.1,halign="start",valign="middle");
// &"GPN1" @WIRE(mode="straight",linecolor="#30485d",linewidth=0.16) {#XDRV1:3 (234,-251.35)};
// (234.4,-251.35) @TEXT("GPN1",size=1.1,halign="start",valign="middle");
// &"GPP1" @WIRE(mode="straight",linecolor="#30485d",linewidth=0.16) {#XDRV1:4 (234,-254.65)};
// (234.4,-254.65) @TEXT("GPP1",size=1.1,halign="start",valign="middle");
// &"VDD" @WIRE(mode="straight",linecolor="#30485d",linewidth=0.16) {#XDRV1:7 (218,-236.45)};
// (218,-236.05) @TEXT("VDD",size=1.1,halign="middle",valign="bottom");
// &"VSS" @WIRE(mode="straight",linecolor="#30485d",linewidth=0.16) {#XDRV1:8 (218,-269.55)};
// (218,-269.95) @TEXT("VSS",size=1.1,halign="middle",valign="top");
// &"GNN2" @WIRE(mode="straight",linecolor="#30485d",linewidth=0.16) {#XDRV2:1 (234,-206.75)};
// (234.4,-206.75) @TEXT("GNN2",size=1.1,halign="start",valign="middle");
// &"GNP2" @WIRE(mode="straight",linecolor="#30485d",linewidth=0.16) {#XDRV2:2 (234,-210.05)};
// (234.4,-210.05) @TEXT("GNP2",size=1.1,halign="start",valign="middle");
// &"GPN2" @WIRE(mode="straight",linecolor="#30485d",linewidth=0.16) {#XDRV2:3 (234,-213.35)};
// (234.4,-213.35) @TEXT("GPN2",size=1.1,halign="start",valign="middle");
// &"GPP2" @WIRE(mode="straight",linecolor="#30485d",linewidth=0.16) {#XDRV2:4 (234,-216.65)};
// (234.4,-216.65) @TEXT("GPP2",size=1.1,halign="start",valign="middle");
// &"VDD" @WIRE(mode="straight",linecolor="#30485d",linewidth=0.16) {#XDRV2:7 (218,-198.45)};
// (218,-198.05) @TEXT("VDD",size=1.1,halign="middle",valign="bottom");
// &"VSS" @WIRE(mode="straight",linecolor="#30485d",linewidth=0.16) {#XDRV2:8 (218,-231.55)};
// (218,-231.95) @TEXT("VSS",size=1.1,halign="middle",valign="top");
// &"GNN3" @WIRE(mode="straight",linecolor="#30485d",linewidth=0.16) {#XDRV3:1 (234,-168.75)};
// (234.4,-168.75) @TEXT("GNN3",size=1.1,halign="start",valign="middle");
// &"GNP3" @WIRE(mode="straight",linecolor="#30485d",linewidth=0.16) {#XDRV3:2 (234,-172.05)};
// (234.4,-172.05) @TEXT("GNP3",size=1.1,halign="start",valign="middle");
// &"GPN3" @WIRE(mode="straight",linecolor="#30485d",linewidth=0.16) {#XDRV3:3 (234,-175.35)};
// (234.4,-175.35) @TEXT("GPN3",size=1.1,halign="start",valign="middle");
// &"GPP3" @WIRE(mode="straight",linecolor="#30485d",linewidth=0.16) {#XDRV3:4 (234,-178.65)};
// (234.4,-178.65) @TEXT("GPP3",size=1.1,halign="start",valign="middle");
// &"VDD" @WIRE(mode="straight",linecolor="#30485d",linewidth=0.16) {#XDRV3:7 (218,-160.45)};
// (218,-160.05) @TEXT("VDD",size=1.1,halign="middle",valign="bottom");
// &"VSS" @WIRE(mode="straight",linecolor="#30485d",linewidth=0.16) {#XDRV3:8 (218,-193.55)};
// (218,-193.95) @TEXT("VSS",size=1.1,halign="middle",valign="top");
// &"GNN4" @WIRE(mode="straight",linecolor="#30485d",linewidth=0.16) {#XDRV4:1 (234,-130.75)};
// (234.4,-130.75) @TEXT("GNN4",size=1.1,halign="start",valign="middle");
// &"GNP4" @WIRE(mode="straight",linecolor="#30485d",linewidth=0.16) {#XDRV4:2 (234,-134.05)};
// (234.4,-134.05) @TEXT("GNP4",size=1.1,halign="start",valign="middle");
// &"GPN4" @WIRE(mode="straight",linecolor="#30485d",linewidth=0.16) {#XDRV4:3 (234,-137.35)};
// (234.4,-137.35) @TEXT("GPN4",size=1.1,halign="start",valign="middle");
// &"GPP4" @WIRE(mode="straight",linecolor="#30485d",linewidth=0.16) {#XDRV4:4 (234,-140.65)};
// (234.4,-140.65) @TEXT("GPP4",size=1.1,halign="start",valign="middle");
// &"VDD" @WIRE(mode="straight",linecolor="#30485d",linewidth=0.16) {#XDRV4:7 (218,-122.45)};
// (218,-122.05) @TEXT("VDD",size=1.1,halign="middle",valign="bottom");
// &"VSS" @WIRE(mode="straight",linecolor="#30485d",linewidth=0.16) {#XDRV4:8 (218,-155.55)};
// (218,-155.95) @TEXT("VSS",size=1.1,halign="middle",valign="top");
// &"GNN5" @WIRE(mode="straight",linecolor="#30485d",linewidth=0.16) {#XDRV5:1 (234,-92.75)};
// (234.4,-92.75) @TEXT("GNN5",size=1.1,halign="start",valign="middle");
// &"GNP5" @WIRE(mode="straight",linecolor="#30485d",linewidth=0.16) {#XDRV5:2 (234,-96.05)};
// (234.4,-96.05) @TEXT("GNP5",size=1.1,halign="start",valign="middle");
// &"GPN5" @WIRE(mode="straight",linecolor="#30485d",linewidth=0.16) {#XDRV5:3 (234,-99.35)};
// (234.4,-99.35) @TEXT("GPN5",size=1.1,halign="start",valign="middle");
// &"GPP5" @WIRE(mode="straight",linecolor="#30485d",linewidth=0.16) {#XDRV5:4 (234,-102.65)};
// (234.4,-102.65) @TEXT("GPP5",size=1.1,halign="start",valign="middle");
// &"VDD" @WIRE(mode="straight",linecolor="#30485d",linewidth=0.16) {#XDRV5:7 (218,-84.45)};
// (218,-84.05) @TEXT("VDD",size=1.1,halign="middle",valign="bottom");
// &"VSS" @WIRE(mode="straight",linecolor="#30485d",linewidth=0.16) {#XDRV5:8 (218,-117.55)};
// (218,-117.95) @TEXT("VSS",size=1.1,halign="middle",valign="top");
// &"GNN6" @WIRE(mode="straight",linecolor="#30485d",linewidth=0.16) {#XDRV6:1 (234,-54.75)};
// (234.4,-54.75) @TEXT("GNN6",size=1.1,halign="start",valign="middle");
// &"GNP6" @WIRE(mode="straight",linecolor="#30485d",linewidth=0.16) {#XDRV6:2 (234,-58.05)};
// (234.4,-58.05) @TEXT("GNP6",size=1.1,halign="start",valign="middle");
// &"GPN6" @WIRE(mode="straight",linecolor="#30485d",linewidth=0.16) {#XDRV6:3 (234,-61.35)};
// (234.4,-61.35) @TEXT("GPN6",size=1.1,halign="start",valign="middle");
// &"GPP6" @WIRE(mode="straight",linecolor="#30485d",linewidth=0.16) {#XDRV6:4 (234,-64.65)};
// (234.4,-64.65) @TEXT("GPP6",size=1.1,halign="start",valign="middle");
// &"VDD" @WIRE(mode="straight",linecolor="#30485d",linewidth=0.16) {#XDRV6:7 (218,-46.45)};
// (218,-46.05) @TEXT("VDD",size=1.1,halign="middle",valign="bottom");
// &"VSS" @WIRE(mode="straight",linecolor="#30485d",linewidth=0.16) {#XDRV6:8 (218,-79.55)};
// (218,-79.95) @TEXT("VSS",size=1.1,halign="middle",valign="top");
// &"GNN7" @WIRE(mode="straight",linecolor="#30485d",linewidth=0.16) {#XDRV7:1 (234,-16.75)};
// (234.4,-16.75) @TEXT("GNN7",size=1.1,halign="start",valign="middle");
// &"GNP7" @WIRE(mode="straight",linecolor="#30485d",linewidth=0.16) {#XDRV7:2 (234,-20.05)};
// (234.4,-20.05) @TEXT("GNP7",size=1.1,halign="start",valign="middle");
// &"GPN7" @WIRE(mode="straight",linecolor="#30485d",linewidth=0.16) {#XDRV7:3 (234,-23.35)};
// (234.4,-23.35) @TEXT("GPN7",size=1.1,halign="start",valign="middle");
// &"GPP7" @WIRE(mode="straight",linecolor="#30485d",linewidth=0.16) {#XDRV7:4 (234,-26.65)};
// (234.4,-26.65) @TEXT("GPP7",size=1.1,halign="start",valign="middle");
// &"VDD" @WIRE(mode="straight",linecolor="#30485d",linewidth=0.16) {#XDRV7:7 (218,-8.45)};
// (218,-8.05) @TEXT("VDD",size=1.1,halign="middle",valign="bottom");
// &"VSS" @WIRE(mode="straight",linecolor="#30485d",linewidth=0.16) {#XDRV7:8 (218,-41.55)};
// (218,-41.95) @TEXT("VSS",size=1.1,halign="middle",valign="top");
// }
// END SARADC RNL
ends sar8i_refword

subckt sar8i_idle ACTIVE SAMPLE VDD VSS PRESET SAMPLE_MATCH
    XN (ACTIVE VDD VSS IDLE) sar8p_inv
    XD (IDLE VDD VSS IDLE_D) sar8i_guard
    XP (SAMPLE IDLE_D VDD VSS PRESET) sar8p_or2
    XA (SAMPLE SAMPLE VDD VSS SAMPLE_AND) sar8p_and2
    XB (SAMPLE_AND VDD VSS SAMPLE_MATCH) sar8p_buf
// BEGIN SARADC RNL
// @RNL(author="saradc topology") {
// #XN @SET-SYMBOL $S_sar8p_inv;
// #XN @PLACE(0,18) => @ORIENT("R0");
// #XD @SET-SYMBOL $S_sar8i_guard;
// #XD @PLACE(42,18) => @ORIENT("R0");
// #XP @SET-SYMBOL $S_sar8p_or2;
// #XP @PLACE(84,18) => @ORIENT("R0");
// #XA @SET-SYMBOL $S_sar8p_and2;
// #XA @PLACE(0,-24) => @ORIENT("R0");
// #XB @SET-SYMBOL $S_sar8p_buf;
// #XB @PLACE(42,-24) => @ORIENT("R0");
// &"IDLE" @WIRE(mode="straight",linecolor="#30485d",linewidth=0.16) {#XN:4 (18,18) (18,18) #XD:1};
// &"IDLE_D" @WIRE(mode="straight",linecolor="#30485d",linewidth=0.16) {#XD:4 (66,18) (66,16.3) #XP:2};
// &"SAMPLE_AND" @WIRE(mode="straight",linecolor="#30485d",linewidth=0.16) {#XA:5 (21,-24) (21,-24) #XB:1};
// &"SAMPLE" @WIRE(mode="straight",linecolor="#30485d",linewidth=0.16) {(-12,-25.7) (-12,-22.3) (-12,19.7)};
// &"SAMPLE" @WIRE(mode="straight",linecolor="#30485d",linewidth=0.16) {#XP:1 (-12,19.7)};
// $JUNCTION @ATTACH (-12,19.7);
// &"SAMPLE" @WIRE(mode="straight",linecolor="#30485d",linewidth=0.16) {#XA:1 (-12,-22.3)};
// $JUNCTION @ATTACH (-12,-22.3);
// &"SAMPLE" @WIRE(mode="straight",linecolor="#30485d",linewidth=0.16) {#XA:2 (-12,-25.7)};
// $JUNCTION @ATTACH (-12,-25.7);
// (-16,46) @TEXT("sar8i_idle / native standard-cell composition",size=1.3,halign="start",textcolor="#223d52");
// &"ACTIVE" @WIRE(mode="straight",linecolor="#30485d",linewidth=0.16) {#XN:1 (-10,18)};
// (-10.4,18) @TEXT("ACTIVE",size=1.1,halign="end",valign="middle");
// &"VDD" @WIRE(mode="straight",linecolor="#30485d",linewidth=0.16) {#XN:2 (0,28)};
// (0,28.4) @TEXT("VDD",size=1.1,halign="middle",valign="bottom");
// &"VSS" @WIRE(mode="straight",linecolor="#30485d",linewidth=0.16) {#XN:3 (0,8)};
// (0,7.6) @TEXT("VSS",size=1.1,halign="middle",valign="top");
// &"VDD" @WIRE(mode="straight",linecolor="#30485d",linewidth=0.16) {#XD:2 (42,29)};
// (42,29.4) @TEXT("VDD",size=1.1,halign="middle",valign="bottom");
// &"VSS" @WIRE(mode="straight",linecolor="#30485d",linewidth=0.16) {#XD:3 (42,7)};
// (42,6.6) @TEXT("VSS",size=1.1,halign="middle",valign="top");
// &"VDD" @WIRE(mode="straight",linecolor="#30485d",linewidth=0.16) {#XP:3 (84,28)};
// (84,28.4) @TEXT("VDD",size=1.1,halign="middle",valign="bottom");
// &"VSS" @WIRE(mode="straight",linecolor="#30485d",linewidth=0.16) {#XP:4 (84,8)};
// (84,7.6) @TEXT("VSS",size=1.1,halign="middle",valign="top");
// &"PRESET" @WIRE(mode="straight",linecolor="#30485d",linewidth=0.16) {#XP:5 (94,18)};
// (94.4,18) @TEXT("PRESET",size=1.1,halign="start",valign="middle");
// &"VDD" @WIRE(mode="straight",linecolor="#30485d",linewidth=0.16) {#XA:3 (0,-14)};
// (0,-13.6) @TEXT("VDD",size=1.1,halign="middle",valign="bottom");
// &"VSS" @WIRE(mode="straight",linecolor="#30485d",linewidth=0.16) {#XA:4 (0,-34)};
// (0,-34.4) @TEXT("VSS",size=1.1,halign="middle",valign="top");
// &"VDD" @WIRE(mode="straight",linecolor="#30485d",linewidth=0.16) {#XB:2 (42,-14)};
// (42,-13.6) @TEXT("VDD",size=1.1,halign="middle",valign="bottom");
// &"VSS" @WIRE(mode="straight",linecolor="#30485d",linewidth=0.16) {#XB:3 (42,-34)};
// (42,-34.4) @TEXT("VSS",size=1.1,halign="middle",valign="top");
// &"SAMPLE_MATCH" @WIRE(mode="straight",linecolor="#30485d",linewidth=0.16) {#XB:4 (52,-24)};
// (52.4,-24) @TEXT("SAMPLE_MATCH",size=1.1,halign="start",valign="middle");
// }
// END SARADC RNL
ends sar8i_idle

subckt sar8p_timing ACTIVE CMP_CLK COMP_N COMP_P DATA PHI_U PHI_W SAMPLE          VDD VSS
    X017 (PHI_U VDD VSS UN) sar8p_inv
    X016 (PHI_W VDD VSS WN) sar8p_inv
    X015 (CMP_CLK VDD VSS CN) sar8p_inv
    X004 (NR VDD VSS NRB) sar8p_inv
    X000 (SAMPLE VDD VSS SN) sar8p_inv
    X022 (QUIET QUIET_D VDD VSS CLOCK_SET) sar8p_and2
    X020 (Q1 LIVE VDD VSS QUIET) sar8p_and2
    X019 (Q0 UN VDD VSS Q1) sar8p_and2
    X018 (CN WN VDD VSS Q0) sar8p_and2
    X014 (UD SN VDD VSS PHI_U) sar8p_and2
    X013 (PHI_W WRITE_D VDD VSS UD) sar8p_and2
    X010 (WD SN VDD VSS WRITE_REQ) sar8p_and2
    X009 (DEC CMP_CLK VDD VSS WD) sar8p_and2
    X008 (RAW RAW_D VDD VSS DEC) sar8p_and2
    X005 (PR NRB VDD VSS DATA) sar8p_and2
    X001 (SN ACTIVE VDD VSS LIVE) sar8p_and2
    X025 (CLOCK_Q VDD VSS CMP_CLK) sar8p_buf
    X003 (COMP_N VDD VSS NR) sar8p_buf
    X002 (COMP_P VDD VSS PR) sar8p_buf
    X006 (PR NR VDD VSS RAW) sar8p_xor2
    XD_RAW_D (RAW VDD VSS RAW_D) sar8p_delay_valid
    X011 (WRITE_REQ VDD VSS PHI_W) sar8p_clkbuf
    XD_WRITE_D (PHI_W VDD VSS WRITE_D) sar8p_delay_write
    XD_QUIET_D (QUIET VDD VSS QUIET_D) sar8p_delay_quiet
    X023 (SAMPLE PHI_U VDD VSS CLOCK_RESET) sar8p_or2
    XCLOCK (CLOCK_Q CLOCK_RESET CLOCK_SET VDD VSS) sar8p_sr
// BEGIN SARADC RNL
// @RNL(author="saradc topology") {
// (-18,73) @TEXT("Asynchronous completion / write / update / quiet / comparator clock",size=1.5,halign="start",textcolor="#223d52");
// #X002 @SET-SYMBOL $S_sar8p_buf;
// #X002 @PLACE(0,36) => @ORIENT("R0");
// #X003 @SET-SYMBOL $S_sar8p_buf;
// #X003 @PLACE(0,0) => @ORIENT("R0");
// #X004 @SET-SYMBOL $S_sar8p_inv;
// #X004 @PLACE(35,0) => @ORIENT("R0");
// #X005 @SET-SYMBOL $S_sar8p_and2;
// #X005 @PLACE(72,36) => @ORIENT("R0");
// #X006 @SET-SYMBOL $S_sar8p_xor2;
// #X006 @PLACE(110,0) => @ORIENT("R0");
// #XD_RAW_D @SET-SYMBOL $S_sar8p_delay_valid;
// #XD_RAW_D @PLACE(151,-21) => @ORIENT("R0");
// #X008 @SET-SYMBOL $S_sar8p_and2;
// #X008 @PLACE(196,0) => @ORIENT("R0");
// #X009 @SET-SYMBOL $S_sar8p_and2;
// #X009 @PLACE(232,0) => @ORIENT("R0");
// #X010 @SET-SYMBOL $S_sar8p_and2;
// #X010 @PLACE(268,0) => @ORIENT("R0");
// #X011 @SET-SYMBOL $S_sar8p_clkbuf;
// #X011 @PLACE(306,0) => @ORIENT("R0");
// #XD_WRITE_D @SET-SYMBOL $S_sar8p_delay_write;
// #XD_WRITE_D @PLACE(349,-21) => @ORIENT("R0");
// #X013 @SET-SYMBOL $S_sar8p_and2;
// #X013 @PLACE(394,0) => @ORIENT("R0");
// #X014 @SET-SYMBOL $S_sar8p_and2;
// #X014 @PLACE(433,0) => @ORIENT("R0");
// #X000 @SET-SYMBOL $S_sar8p_inv;
// #X000 @PLACE(0,-72) => @ORIENT("R0");
// #X001 @SET-SYMBOL $S_sar8p_and2;
// #X001 @PLACE(36,-72) => @ORIENT("R0");
// #X015 @SET-SYMBOL $S_sar8p_inv;
// #X015 @PLACE(80,-72) => @ORIENT("R0");
// #X016 @SET-SYMBOL $S_sar8p_inv;
// #X016 @PLACE(80,-112) => @ORIENT("R0");
// #X017 @SET-SYMBOL $S_sar8p_inv;
// #X017 @PLACE(121,-112) => @ORIENT("R0");
// #X018 @SET-SYMBOL $S_sar8p_and2;
// #X018 @PLACE(121,-72) => @ORIENT("R0");
// #X019 @SET-SYMBOL $S_sar8p_and2;
// #X019 @PLACE(161,-72) => @ORIENT("R0");
// #X020 @SET-SYMBOL $S_sar8p_and2;
// #X020 @PLACE(201,-72) => @ORIENT("R0");
// #XD_QUIET_D @SET-SYMBOL $S_sar8p_delay_quiet;
// #XD_QUIET_D @PLACE(243,-93) => @ORIENT("R0");
// #X022 @SET-SYMBOL $S_sar8p_and2;
// #X022 @PLACE(288,-72) => @ORIENT("R0");
// #X023 @SET-SYMBOL $S_sar8p_or2;
// #X023 @PLACE(329,-112) => @ORIENT("R0");
// #XCLOCK @SET-SYMBOL $S_sar8p_sr;
// #XCLOCK @PLACE(372,-72) => @ORIENT("R0");
// #X025 @SET-SYMBOL $S_sar8p_buf;
// #X025 @PLACE(417,-72) => @ORIENT("R0");
// &"UN" @WIRE(mode="straight",linecolor="#30485d",linewidth=0.16) {#X017:4 (141,-112) (141,-73.7) #X019:2};
// &"WN" @WIRE(mode="straight",linecolor="#30485d",linewidth=0.16) {#X016:4 (100.5,-112) (100.5,-73.7) #X018:2};
// &"CN" @WIRE(mode="straight",linecolor="#30485d",linewidth=0.16) {#X015:4 (100.5,-72) (100.5,-70.3) #X018:1};
// &"NRB" @WIRE(mode="straight",linecolor="#30485d",linewidth=0.16) {#X004:4 (53.5,0) (53.5,34.3) #X005:2};
// &"QUIET_D" @WIRE(mode="straight",linecolor="#30485d",linewidth=0.16) {#X022:2 (268.5,-73.7) (268.5,-93) #XD_QUIET_D:4};
// &"CLOCK_SET" @WIRE(mode="straight",linecolor="#30485d",linewidth=0.16) {#X022:5 (327,-72) (327,-73.65) #XCLOCK:3};
// &"Q1" @WIRE(mode="straight",linecolor="#30485d",linewidth=0.16) {#X020:1 (181,-70.3) (181,-72) #X019:5};
// &"Q0" @WIRE(mode="straight",linecolor="#30485d",linewidth=0.16) {#X019:1 (141,-70.3) (141,-72) #X018:5};
// &"UD" @WIRE(mode="straight",linecolor="#30485d",linewidth=0.16) {#X014:1 (413.5,1.7) (413.5,0) #X013:5};
// &"WRITE_D" @WIRE(mode="straight",linecolor="#30485d",linewidth=0.16) {#X013:2 (374.5,-1.7) (374.5,-21) #XD_WRITE_D:4};
// &"WD" @WIRE(mode="straight",linecolor="#30485d",linewidth=0.16) {#X010:1 (250,1.7) (250,0) #X009:5};
// &"WRITE_REQ" @WIRE(mode="straight",linecolor="#30485d",linewidth=0.16) {#X010:5 (287,0) (287,0) #X011:1};
// &"DEC" @WIRE(mode="straight",linecolor="#30485d",linewidth=0.16) {#X009:1 (214,1.7) (214,0) #X008:5};
// &"RAW_D" @WIRE(mode="straight",linecolor="#30485d",linewidth=0.16) {#X008:2 (176.5,-1.7) (176.5,-21) #XD_RAW_D:4};
// &"CLOCK_Q" @WIRE(mode="straight",linecolor="#30485d",linewidth=0.16) {#X025:1 (397.5,-72) (397.5,-72) #XCLOCK:1};
// &"CLOCK_RESET" @WIRE(mode="straight",linecolor="#30485d",linewidth=0.16) {#X023:5 (347.5,-112) (347.5,-70.35) #XCLOCK:2};
// (109,49) @TEXT("VALID -> WRITE -> UPDATE",size=1.3,halign="start",textcolor="#223d52");
// (78,-46) @TEXT("QUIET detection -> SET / RESET latch -> CMP_CLK",size=1.3,halign="start",textcolor="#223d52");
// (-18,-140) @TEXT("Named inter-row clocks are the same electrical nets. Expand each RC delay or latch to inspect implementation.",size=1,halign="start",textcolor="#223d52");
// &"PHI_U" @WIRE(mode="straight",linecolor="#30485d",linewidth=0.16) {#X017:1 (111,-112)};
// (110.6,-112) @TEXT("PHI_U",size=1.1,halign="end",valign="middle");
// &"VDD" @WIRE(mode="straight",linecolor="#30485d",linewidth=0.16) {#X017:2 (121,-102)};
// (121,-101.6) @TEXT("VDD",size=1.1,halign="middle",valign="bottom");
// &"VSS" @WIRE(mode="straight",linecolor="#30485d",linewidth=0.16) {#X017:3 (121,-122)};
// (121,-122.4) @TEXT("VSS",size=1.1,halign="middle",valign="top");
// &"PHI_W" @WIRE(mode="straight",linecolor="#30485d",linewidth=0.16) {#X016:1 (70,-112)};
// (69.6,-112) @TEXT("PHI_W",size=1.1,halign="end",valign="middle");
// &"VDD" @WIRE(mode="straight",linecolor="#30485d",linewidth=0.16) {#X016:2 (80,-102)};
// (80,-101.6) @TEXT("VDD",size=1.1,halign="middle",valign="bottom");
// &"VSS" @WIRE(mode="straight",linecolor="#30485d",linewidth=0.16) {#X016:3 (80,-122)};
// (80,-122.4) @TEXT("VSS",size=1.1,halign="middle",valign="top");
// &"CMP_CLK" @WIRE(mode="straight",linecolor="#30485d",linewidth=0.16) {#X015:1 (70,-72)};
// (69.6,-72) @TEXT("CMP_CLK",size=1.1,halign="end",valign="middle");
// &"VDD" @WIRE(mode="straight",linecolor="#30485d",linewidth=0.16) {#X015:2 (80,-62)};
// (80,-61.6) @TEXT("VDD",size=1.1,halign="middle",valign="bottom");
// &"VSS" @WIRE(mode="straight",linecolor="#30485d",linewidth=0.16) {#X015:3 (80,-82)};
// (80,-82.4) @TEXT("VSS",size=1.1,halign="middle",valign="top");
// &"NR" @WIRE(mode="straight",linecolor="#30485d",linewidth=0.16) {#X004:1 (25,0)};
// (24.6,0) @TEXT("NR",size=1.1,halign="end",valign="middle");
// &"VDD" @WIRE(mode="straight",linecolor="#30485d",linewidth=0.16) {#X004:2 (35,10)};
// (35,10.4) @TEXT("VDD",size=1.1,halign="middle",valign="bottom");
// &"VSS" @WIRE(mode="straight",linecolor="#30485d",linewidth=0.16) {#X004:3 (35,-10)};
// (35,-10.4) @TEXT("VSS",size=1.1,halign="middle",valign="top");
// &"SAMPLE" @WIRE(mode="straight",linecolor="#30485d",linewidth=0.16) {#X000:1 (-10,-72)};
// (-10.4,-72) @TEXT("SAMPLE",size=1.1,halign="end",valign="middle");
// &"VDD" @WIRE(mode="straight",linecolor="#30485d",linewidth=0.16) {#X000:2 (0,-62)};
// (0,-61.6) @TEXT("VDD",size=1.1,halign="middle",valign="bottom");
// &"VSS" @WIRE(mode="straight",linecolor="#30485d",linewidth=0.16) {#X000:3 (0,-82)};
// (0,-82.4) @TEXT("VSS",size=1.1,halign="middle",valign="top");
// &"SN" @WIRE(mode="straight",linecolor="#30485d",linewidth=0.16) {#X000:4 (10,-72)};
// (10.4,-72) @TEXT("SN",size=1.1,halign="start",valign="middle");
// &"QUIET" @WIRE(mode="straight",linecolor="#30485d",linewidth=0.16) {#X022:1 (278,-70.3)};
// (277.6,-70.3) @TEXT("QUIET",size=1.1,halign="end",valign="middle");
// &"VDD" @WIRE(mode="straight",linecolor="#30485d",linewidth=0.16) {#X022:3 (288,-62)};
// (288,-61.6) @TEXT("VDD",size=1.1,halign="middle",valign="bottom");
// &"VSS" @WIRE(mode="straight",linecolor="#30485d",linewidth=0.16) {#X022:4 (288,-82)};
// (288,-82.4) @TEXT("VSS",size=1.1,halign="middle",valign="top");
// &"LIVE" @WIRE(mode="straight",linecolor="#30485d",linewidth=0.16) {#X020:2 (191,-73.7)};
// (190.6,-73.7) @TEXT("LIVE",size=1.1,halign="end",valign="middle");
// &"VDD" @WIRE(mode="straight",linecolor="#30485d",linewidth=0.16) {#X020:3 (201,-62)};
// (201,-61.6) @TEXT("VDD",size=1.1,halign="middle",valign="bottom");
// &"VSS" @WIRE(mode="straight",linecolor="#30485d",linewidth=0.16) {#X020:4 (201,-82)};
// (201,-82.4) @TEXT("VSS",size=1.1,halign="middle",valign="top");
// &"QUIET" @WIRE(mode="straight",linecolor="#30485d",linewidth=0.16) {#X020:5 (211,-72)};
// (211.4,-72) @TEXT("QUIET",size=1.1,halign="start",valign="middle");
// &"VDD" @WIRE(mode="straight",linecolor="#30485d",linewidth=0.16) {#X019:3 (161,-62)};
// (161,-61.6) @TEXT("VDD",size=1.1,halign="middle",valign="bottom");
// &"VSS" @WIRE(mode="straight",linecolor="#30485d",linewidth=0.16) {#X019:4 (161,-82)};
// (161,-82.4) @TEXT("VSS",size=1.1,halign="middle",valign="top");
// &"VDD" @WIRE(mode="straight",linecolor="#30485d",linewidth=0.16) {#X018:3 (121,-62)};
// (121,-61.6) @TEXT("VDD",size=1.1,halign="middle",valign="bottom");
// &"VSS" @WIRE(mode="straight",linecolor="#30485d",linewidth=0.16) {#X018:4 (121,-82)};
// (121,-82.4) @TEXT("VSS",size=1.1,halign="middle",valign="top");
// &"SN" @WIRE(mode="straight",linecolor="#30485d",linewidth=0.16) {#X014:2 (423,-1.7)};
// (422.6,-1.7) @TEXT("SN",size=1.1,halign="end",valign="middle");
// &"VDD" @WIRE(mode="straight",linecolor="#30485d",linewidth=0.16) {#X014:3 (433,10)};
// (433,10.4) @TEXT("VDD",size=1.1,halign="middle",valign="bottom");
// &"VSS" @WIRE(mode="straight",linecolor="#30485d",linewidth=0.16) {#X014:4 (433,-10)};
// (433,-10.4) @TEXT("VSS",size=1.1,halign="middle",valign="top");
// &"PHI_U" @WIRE(mode="straight",linecolor="#30485d",linewidth=0.16) {#X014:5 (443,0)};
// (443.4,0) @TEXT("PHI_U",size=1.1,halign="start",valign="middle");
// &"PHI_W" @WIRE(mode="straight",linecolor="#30485d",linewidth=0.16) {#X013:1 (384,1.7)};
// (383.6,1.7) @TEXT("PHI_W",size=1.1,halign="end",valign="middle");
// &"VDD" @WIRE(mode="straight",linecolor="#30485d",linewidth=0.16) {#X013:3 (394,10)};
// (394,10.4) @TEXT("VDD",size=1.1,halign="middle",valign="bottom");
// &"VSS" @WIRE(mode="straight",linecolor="#30485d",linewidth=0.16) {#X013:4 (394,-10)};
// (394,-10.4) @TEXT("VSS",size=1.1,halign="middle",valign="top");
// &"SN" @WIRE(mode="straight",linecolor="#30485d",linewidth=0.16) {#X010:2 (258,-1.7)};
// (257.6,-1.7) @TEXT("SN",size=1.1,halign="end",valign="middle");
// &"VDD" @WIRE(mode="straight",linecolor="#30485d",linewidth=0.16) {#X010:3 (268,10)};
// (268,10.4) @TEXT("VDD",size=1.1,halign="middle",valign="bottom");
// &"VSS" @WIRE(mode="straight",linecolor="#30485d",linewidth=0.16) {#X010:4 (268,-10)};
// (268,-10.4) @TEXT("VSS",size=1.1,halign="middle",valign="top");
// &"CMP_CLK" @WIRE(mode="straight",linecolor="#30485d",linewidth=0.16) {#X009:2 (222,-1.7)};
// (221.6,-1.7) @TEXT("CMP_CLK",size=1.1,halign="end",valign="middle");
// &"VDD" @WIRE(mode="straight",linecolor="#30485d",linewidth=0.16) {#X009:3 (232,10)};
// (232,10.4) @TEXT("VDD",size=1.1,halign="middle",valign="bottom");
// &"VSS" @WIRE(mode="straight",linecolor="#30485d",linewidth=0.16) {#X009:4 (232,-10)};
// (232,-10.4) @TEXT("VSS",size=1.1,halign="middle",valign="top");
// &"RAW" @WIRE(mode="straight",linecolor="#30485d",linewidth=0.16) {#X008:1 (186,1.7)};
// (185.6,1.7) @TEXT("RAW",size=1.1,halign="end",valign="middle");
// &"VDD" @WIRE(mode="straight",linecolor="#30485d",linewidth=0.16) {#X008:3 (196,10)};
// (196,10.4) @TEXT("VDD",size=1.1,halign="middle",valign="bottom");
// &"VSS" @WIRE(mode="straight",linecolor="#30485d",linewidth=0.16) {#X008:4 (196,-10)};
// (196,-10.4) @TEXT("VSS",size=1.1,halign="middle",valign="top");
// &"PR" @WIRE(mode="straight",linecolor="#30485d",linewidth=0.16) {#X005:1 (62,37.7)};
// (61.6,37.7) @TEXT("PR",size=1.1,halign="end",valign="middle");
// &"VDD" @WIRE(mode="straight",linecolor="#30485d",linewidth=0.16) {#X005:3 (72,46)};
// (72,46.4) @TEXT("VDD",size=1.1,halign="middle",valign="bottom");
// &"VSS" @WIRE(mode="straight",linecolor="#30485d",linewidth=0.16) {#X005:4 (72,26)};
// (72,25.6) @TEXT("VSS",size=1.1,halign="middle",valign="top");
// &"DATA" @WIRE(mode="straight",linecolor="#30485d",linewidth=0.16) {#X005:5 (82,36)};
// (82.4,36) @TEXT("DATA",size=1.1,halign="start",valign="middle");
// &"SN" @WIRE(mode="straight",linecolor="#30485d",linewidth=0.16) {#X001:1 (26,-70.3)};
// (25.6,-70.3) @TEXT("SN",size=1.1,halign="end",valign="middle");
// &"ACTIVE" @WIRE(mode="straight",linecolor="#30485d",linewidth=0.16) {#X001:2 (26,-73.7)};
// (25.6,-73.7) @TEXT("ACTIVE",size=1.1,halign="end",valign="middle");
// &"VDD" @WIRE(mode="straight",linecolor="#30485d",linewidth=0.16) {#X001:3 (36,-62)};
// (36,-61.6) @TEXT("VDD",size=1.1,halign="middle",valign="bottom");
// &"VSS" @WIRE(mode="straight",linecolor="#30485d",linewidth=0.16) {#X001:4 (36,-82)};
// (36,-82.4) @TEXT("VSS",size=1.1,halign="middle",valign="top");
// &"LIVE" @WIRE(mode="straight",linecolor="#30485d",linewidth=0.16) {#X001:5 (46,-72)};
// (46.4,-72) @TEXT("LIVE",size=1.1,halign="start",valign="middle");
// &"VDD" @WIRE(mode="straight",linecolor="#30485d",linewidth=0.16) {#X025:2 (417,-62)};
// (417,-61.6) @TEXT("VDD",size=1.1,halign="middle",valign="bottom");
// &"VSS" @WIRE(mode="straight",linecolor="#30485d",linewidth=0.16) {#X025:3 (417,-82)};
// (417,-82.4) @TEXT("VSS",size=1.1,halign="middle",valign="top");
// &"CMP_CLK" @WIRE(mode="straight",linecolor="#30485d",linewidth=0.16) {#X025:4 (427,-72)};
// (427.4,-72) @TEXT("CMP_CLK",size=1.1,halign="start",valign="middle");
// &"COMP_N" @WIRE(mode="straight",linecolor="#30485d",linewidth=0.16) {#X003:1 (-10,0)};
// (-10.4,0) @TEXT("COMP_N",size=1.1,halign="end",valign="middle");
// &"VDD" @WIRE(mode="straight",linecolor="#30485d",linewidth=0.16) {#X003:2 (0,10)};
// (0,10.4) @TEXT("VDD",size=1.1,halign="middle",valign="bottom");
// &"VSS" @WIRE(mode="straight",linecolor="#30485d",linewidth=0.16) {#X003:3 (0,-10)};
// (0,-10.4) @TEXT("VSS",size=1.1,halign="middle",valign="top");
// &"NR" @WIRE(mode="straight",linecolor="#30485d",linewidth=0.16) {#X003:4 (10,0)};
// (10.4,0) @TEXT("NR",size=1.1,halign="start",valign="middle");
// &"COMP_P" @WIRE(mode="straight",linecolor="#30485d",linewidth=0.16) {#X002:1 (-10,36)};
// (-10.4,36) @TEXT("COMP_P",size=1.1,halign="end",valign="middle");
// &"VDD" @WIRE(mode="straight",linecolor="#30485d",linewidth=0.16) {#X002:2 (0,46)};
// (0,46.4) @TEXT("VDD",size=1.1,halign="middle",valign="bottom");
// &"VSS" @WIRE(mode="straight",linecolor="#30485d",linewidth=0.16) {#X002:3 (0,26)};
// (0,25.6) @TEXT("VSS",size=1.1,halign="middle",valign="top");
// &"PR" @WIRE(mode="straight",linecolor="#30485d",linewidth=0.16) {#X002:4 (10,36)};
// (10.4,36) @TEXT("PR",size=1.1,halign="start",valign="middle");
// &"PR" @WIRE(mode="straight",linecolor="#30485d",linewidth=0.16) {#X006:1 (100,1.7)};
// (99.6,1.7) @TEXT("PR",size=1.1,halign="end",valign="middle");
// &"NR" @WIRE(mode="straight",linecolor="#30485d",linewidth=0.16) {#X006:2 (100,-1.7)};
// (99.6,-1.7) @TEXT("NR",size=1.1,halign="end",valign="middle");
// &"VDD" @WIRE(mode="straight",linecolor="#30485d",linewidth=0.16) {#X006:3 (110,10)};
// (110,10.4) @TEXT("VDD",size=1.1,halign="middle",valign="bottom");
// &"VSS" @WIRE(mode="straight",linecolor="#30485d",linewidth=0.16) {#X006:4 (110,-10)};
// (110,-10.4) @TEXT("VSS",size=1.1,halign="middle",valign="top");
// &"RAW" @WIRE(mode="straight",linecolor="#30485d",linewidth=0.16) {#X006:5 (120,0)};
// (120.4,0) @TEXT("RAW",size=1.1,halign="start",valign="middle");
// &"RAW" @WIRE(mode="straight",linecolor="#30485d",linewidth=0.16) {#XD_RAW_D:1 (135,-21)};
// (134.6,-21) @TEXT("RAW",size=1.1,halign="end",valign="middle");
// &"VDD" @WIRE(mode="straight",linecolor="#30485d",linewidth=0.16) {#XD_RAW_D:2 (151,-10)};
// (151,-9.6) @TEXT("VDD",size=1.1,halign="middle",valign="bottom");
// &"VSS" @WIRE(mode="straight",linecolor="#30485d",linewidth=0.16) {#XD_RAW_D:3 (151,-32)};
// (151,-32.4) @TEXT("VSS",size=1.1,halign="middle",valign="top");
// &"VDD" @WIRE(mode="straight",linecolor="#30485d",linewidth=0.16) {#X011:2 (306,10)};
// (306,10.4) @TEXT("VDD",size=1.1,halign="middle",valign="bottom");
// &"VSS" @WIRE(mode="straight",linecolor="#30485d",linewidth=0.16) {#X011:3 (306,-10)};
// (306,-10.4) @TEXT("VSS",size=1.1,halign="middle",valign="top");
// &"PHI_W" @WIRE(mode="straight",linecolor="#30485d",linewidth=0.16) {#X011:4 (316,0)};
// (316.4,0) @TEXT("PHI_W",size=1.1,halign="start",valign="middle");
// &"PHI_W" @WIRE(mode="straight",linecolor="#30485d",linewidth=0.16) {#XD_WRITE_D:1 (333,-21)};
// (332.6,-21) @TEXT("PHI_W",size=1.1,halign="end",valign="middle");
// &"VDD" @WIRE(mode="straight",linecolor="#30485d",linewidth=0.16) {#XD_WRITE_D:2 (349,-10)};
// (349,-9.6) @TEXT("VDD",size=1.1,halign="middle",valign="bottom");
// &"VSS" @WIRE(mode="straight",linecolor="#30485d",linewidth=0.16) {#XD_WRITE_D:3 (349,-32)};
// (349,-32.4) @TEXT("VSS",size=1.1,halign="middle",valign="top");
// &"QUIET" @WIRE(mode="straight",linecolor="#30485d",linewidth=0.16) {#XD_QUIET_D:1 (227,-93)};
// (226.6,-93) @TEXT("QUIET",size=1.1,halign="end",valign="middle");
// &"VDD" @WIRE(mode="straight",linecolor="#30485d",linewidth=0.16) {#XD_QUIET_D:2 (243,-82)};
// (243,-81.6) @TEXT("VDD",size=1.1,halign="middle",valign="bottom");
// &"VSS" @WIRE(mode="straight",linecolor="#30485d",linewidth=0.16) {#XD_QUIET_D:3 (243,-104)};
// (243,-104.4) @TEXT("VSS",size=1.1,halign="middle",valign="top");
// &"SAMPLE" @WIRE(mode="straight",linecolor="#30485d",linewidth=0.16) {#X023:1 (319,-110.3)};
// (318.6,-110.3) @TEXT("SAMPLE",size=1.1,halign="end",valign="middle");
// &"PHI_U" @WIRE(mode="straight",linecolor="#30485d",linewidth=0.16) {#X023:2 (319,-113.7)};
// (318.6,-113.7) @TEXT("PHI_U",size=1.1,halign="end",valign="middle");
// &"VDD" @WIRE(mode="straight",linecolor="#30485d",linewidth=0.16) {#X023:3 (329,-102)};
// (329,-101.6) @TEXT("VDD",size=1.1,halign="middle",valign="bottom");
// &"VSS" @WIRE(mode="straight",linecolor="#30485d",linewidth=0.16) {#X023:4 (329,-122)};
// (329,-122.4) @TEXT("VSS",size=1.1,halign="middle",valign="top");
// &"VDD" @WIRE(mode="straight",linecolor="#30485d",linewidth=0.16) {#XCLOCK:4 (372,-61)};
// (372,-60.6) @TEXT("VDD",size=1.1,halign="middle",valign="bottom");
// &"VSS" @WIRE(mode="straight",linecolor="#30485d",linewidth=0.16) {#XCLOCK:5 (372,-83)};
// (372,-83.4) @TEXT("VSS",size=1.1,halign="middle",valign="top");
// }
// END SARADC RNL
ends sar8p_timing

subckt sar8p_bitseq8 PHI_U SAMPLE T0 T1 T2 T3 T4 T5 T6 T7 VDD VSS
    XF0 (PHI_U T1 T0 SAMPLE VDD VSS) sar8p_dffr
    XF1 (PHI_U T2 T1 SAMPLE VDD VSS) sar8p_dffr
    XF2 (PHI_U T3 T2 SAMPLE VDD VSS) sar8p_dffr
    XF3 (PHI_U T4 T3 SAMPLE VDD VSS) sar8p_dffr
    XF4 (PHI_U T5 T4 SAMPLE VDD VSS) sar8p_dffr
    XF5 (PHI_U T6 T5 SAMPLE VDD VSS) sar8p_dffr
    XF6 (PHI_U T7 T6 SAMPLE VDD VSS) sar8p_dffr
    XF7 (PHI_U VDD NT7 SAMPLE VDD VSS) sar8p_dffr
    X001 (NT7 VDD VSS T7) sar8p_inv
// BEGIN SARADC RNL
// @RNL(author="saradc topology") {
// #XF7 @SET-SYMBOL $S_sar8p_dffr;
// #XF7 @PLACE(0,0) => @ORIENT("R0");
// #XF6 @SET-SYMBOL $S_sar8p_dffr;
// #XF6 @PLACE(43,0) => @ORIENT("R0");
// #XF5 @SET-SYMBOL $S_sar8p_dffr;
// #XF5 @PLACE(86,0) => @ORIENT("R0");
// #XF4 @SET-SYMBOL $S_sar8p_dffr;
// #XF4 @PLACE(129,0) => @ORIENT("R0");
// #XF3 @SET-SYMBOL $S_sar8p_dffr;
// #XF3 @PLACE(172,0) => @ORIENT("R0");
// #XF2 @SET-SYMBOL $S_sar8p_dffr;
// #XF2 @PLACE(215,0) => @ORIENT("R0");
// #XF1 @SET-SYMBOL $S_sar8p_dffr;
// #XF1 @PLACE(258,0) => @ORIENT("R0");
// #XF0 @SET-SYMBOL $S_sar8p_dffr;
// #XF0 @PLACE(301,0) => @ORIENT("R0");
// #X001 @SET-SYMBOL $S_sar8p_inv;
// #X001 @PLACE(22,27) => @ORIENT("R0");
// &"T1" @WIRE(mode="straight",linecolor="#30485d",linewidth=0.16) {#XF0:2 (279.5,0) (279.5,0) #XF1:3};
// &"T2" @WIRE(mode="straight",linecolor="#30485d",linewidth=0.16) {#XF1:2 (236.5,0) (236.5,0) #XF2:3};
// &"T3" @WIRE(mode="straight",linecolor="#30485d",linewidth=0.16) {#XF2:2 (193.5,0) (193.5,0) #XF3:3};
// &"T4" @WIRE(mode="straight",linecolor="#30485d",linewidth=0.16) {#XF3:2 (150.5,0) (150.5,0) #XF4:3};
// &"T5" @WIRE(mode="straight",linecolor="#30485d",linewidth=0.16) {#XF4:2 (107.5,0) (107.5,0) #XF5:3};
// &"T6" @WIRE(mode="straight",linecolor="#30485d",linewidth=0.16) {#XF5:2 (64.5,0) (64.5,0) #XF6:3};
// &"T7" @WIRE(mode="straight",linecolor="#30485d",linewidth=0.16) {#XF6:2 (32.5,0) (32.5,27) #X001:4};
// &"NT7" @WIRE(mode="straight",linecolor="#30485d",linewidth=0.16) {#XF7:3 (11,0) (11,27) #X001:1};
// (-16,50) @TEXT("Token shift / bit 7 -> bit 0 / asynchronous reset",size=1.4,halign="start",textcolor="#223d52");
// &"PHI_U" @WIRE(mode="straight",linecolor="#30485d",linewidth=0.16) {#XF0:1 (291,3.4)};
// (290.6,3.4) @TEXT("PHI_U",size=1.1,halign="end",valign="middle");
// &"T0" @WIRE(mode="straight",linecolor="#30485d",linewidth=0.16) {#XF0:3 (311,0)};
// (311.4,0) @TEXT("T0",size=1.1,halign="start",valign="middle");
// &"SAMPLE" @WIRE(mode="straight",linecolor="#30485d",linewidth=0.16) {#XF0:4 (291,-3.4)};
// (290.6,-3.4) @TEXT("SAMPLE",size=1.1,halign="end",valign="middle");
// &"VDD" @WIRE(mode="straight",linecolor="#30485d",linewidth=0.16) {#XF0:5 (301,10)};
// (301,10.4) @TEXT("VDD",size=1.1,halign="middle",valign="bottom");
// &"VSS" @WIRE(mode="straight",linecolor="#30485d",linewidth=0.16) {#XF0:6 (301,-10)};
// (301,-10.4) @TEXT("VSS",size=1.1,halign="middle",valign="top");
// &"PHI_U" @WIRE(mode="straight",linecolor="#30485d",linewidth=0.16) {#XF1:1 (248,3.4)};
// (247.6,3.4) @TEXT("PHI_U",size=1.1,halign="end",valign="middle");
// &"SAMPLE" @WIRE(mode="straight",linecolor="#30485d",linewidth=0.16) {#XF1:4 (248,-3.4)};
// (247.6,-3.4) @TEXT("SAMPLE",size=1.1,halign="end",valign="middle");
// &"VDD" @WIRE(mode="straight",linecolor="#30485d",linewidth=0.16) {#XF1:5 (258,10)};
// (258,10.4) @TEXT("VDD",size=1.1,halign="middle",valign="bottom");
// &"VSS" @WIRE(mode="straight",linecolor="#30485d",linewidth=0.16) {#XF1:6 (258,-10)};
// (258,-10.4) @TEXT("VSS",size=1.1,halign="middle",valign="top");
// &"PHI_U" @WIRE(mode="straight",linecolor="#30485d",linewidth=0.16) {#XF2:1 (205,3.4)};
// (204.6,3.4) @TEXT("PHI_U",size=1.1,halign="end",valign="middle");
// &"SAMPLE" @WIRE(mode="straight",linecolor="#30485d",linewidth=0.16) {#XF2:4 (205,-3.4)};
// (204.6,-3.4) @TEXT("SAMPLE",size=1.1,halign="end",valign="middle");
// &"VDD" @WIRE(mode="straight",linecolor="#30485d",linewidth=0.16) {#XF2:5 (215,10)};
// (215,10.4) @TEXT("VDD",size=1.1,halign="middle",valign="bottom");
// &"VSS" @WIRE(mode="straight",linecolor="#30485d",linewidth=0.16) {#XF2:6 (215,-10)};
// (215,-10.4) @TEXT("VSS",size=1.1,halign="middle",valign="top");
// &"PHI_U" @WIRE(mode="straight",linecolor="#30485d",linewidth=0.16) {#XF3:1 (162,3.4)};
// (161.6,3.4) @TEXT("PHI_U",size=1.1,halign="end",valign="middle");
// &"SAMPLE" @WIRE(mode="straight",linecolor="#30485d",linewidth=0.16) {#XF3:4 (162,-3.4)};
// (161.6,-3.4) @TEXT("SAMPLE",size=1.1,halign="end",valign="middle");
// &"VDD" @WIRE(mode="straight",linecolor="#30485d",linewidth=0.16) {#XF3:5 (172,10)};
// (172,10.4) @TEXT("VDD",size=1.1,halign="middle",valign="bottom");
// &"VSS" @WIRE(mode="straight",linecolor="#30485d",linewidth=0.16) {#XF3:6 (172,-10)};
// (172,-10.4) @TEXT("VSS",size=1.1,halign="middle",valign="top");
// &"PHI_U" @WIRE(mode="straight",linecolor="#30485d",linewidth=0.16) {#XF4:1 (119,3.4)};
// (118.6,3.4) @TEXT("PHI_U",size=1.1,halign="end",valign="middle");
// &"SAMPLE" @WIRE(mode="straight",linecolor="#30485d",linewidth=0.16) {#XF4:4 (119,-3.4)};
// (118.6,-3.4) @TEXT("SAMPLE",size=1.1,halign="end",valign="middle");
// &"VDD" @WIRE(mode="straight",linecolor="#30485d",linewidth=0.16) {#XF4:5 (129,10)};
// (129,10.4) @TEXT("VDD",size=1.1,halign="middle",valign="bottom");
// &"VSS" @WIRE(mode="straight",linecolor="#30485d",linewidth=0.16) {#XF4:6 (129,-10)};
// (129,-10.4) @TEXT("VSS",size=1.1,halign="middle",valign="top");
// &"PHI_U" @WIRE(mode="straight",linecolor="#30485d",linewidth=0.16) {#XF5:1 (76,3.4)};
// (75.6,3.4) @TEXT("PHI_U",size=1.1,halign="end",valign="middle");
// &"SAMPLE" @WIRE(mode="straight",linecolor="#30485d",linewidth=0.16) {#XF5:4 (76,-3.4)};
// (75.6,-3.4) @TEXT("SAMPLE",size=1.1,halign="end",valign="middle");
// &"VDD" @WIRE(mode="straight",linecolor="#30485d",linewidth=0.16) {#XF5:5 (86,10)};
// (86,10.4) @TEXT("VDD",size=1.1,halign="middle",valign="bottom");
// &"VSS" @WIRE(mode="straight",linecolor="#30485d",linewidth=0.16) {#XF5:6 (86,-10)};
// (86,-10.4) @TEXT("VSS",size=1.1,halign="middle",valign="top");
// &"PHI_U" @WIRE(mode="straight",linecolor="#30485d",linewidth=0.16) {#XF6:1 (33,3.4)};
// (32.6,3.4) @TEXT("PHI_U",size=1.1,halign="end",valign="middle");
// &"SAMPLE" @WIRE(mode="straight",linecolor="#30485d",linewidth=0.16) {#XF6:4 (33,-3.4)};
// (32.6,-3.4) @TEXT("SAMPLE",size=1.1,halign="end",valign="middle");
// &"VDD" @WIRE(mode="straight",linecolor="#30485d",linewidth=0.16) {#XF6:5 (43,10)};
// (43,10.4) @TEXT("VDD",size=1.1,halign="middle",valign="bottom");
// &"VSS" @WIRE(mode="straight",linecolor="#30485d",linewidth=0.16) {#XF6:6 (43,-10)};
// (43,-10.4) @TEXT("VSS",size=1.1,halign="middle",valign="top");
// &"PHI_U" @WIRE(mode="straight",linecolor="#30485d",linewidth=0.16) {#XF7:1 (-10,3.4)};
// (-10.4,3.4) @TEXT("PHI_U",size=1.1,halign="end",valign="middle");
// &"VDD" @WIRE(mode="straight",linecolor="#30485d",linewidth=0.16) {#XF7:2 (-10,0)};
// (-10.4,0) @TEXT("VDD",size=1.1,halign="end",valign="middle");
// &"SAMPLE" @WIRE(mode="straight",linecolor="#30485d",linewidth=0.16) {#XF7:4 (-10,-3.4)};
// (-10.4,-3.4) @TEXT("SAMPLE",size=1.1,halign="end",valign="middle");
// &"VDD" @WIRE(mode="straight",linecolor="#30485d",linewidth=0.16) {#XF7:5 (0,10)};
// (0,10.4) @TEXT("VDD",size=1.1,halign="middle",valign="bottom");
// &"VSS" @WIRE(mode="straight",linecolor="#30485d",linewidth=0.16) {#XF7:6 (0,-10)};
// (0,-10.4) @TEXT("VSS",size=1.1,halign="middle",valign="top");
// &"VDD" @WIRE(mode="straight",linecolor="#30485d",linewidth=0.16) {#X001:2 (22,37)};
// (22,37.4) @TEXT("VDD",size=1.1,halign="middle",valign="bottom");
// &"VSS" @WIRE(mode="straight",linecolor="#30485d",linewidth=0.16) {#X001:3 (22,17)};
// (22,16.6) @TEXT("VSS",size=1.1,halign="middle",valign="top");
// }
// END SARADC RNL
ends sar8p_bitseq8

subckt sar8p_bit CODE D DATA PHI_W SAMPLE TOKEN VDD VSS
    XMUX (D DATA TOKEN VDD VSS NEXT_D) sar8p_mux2
    XSTORE (PHI_W NEXT_D D SAMPLE VDD VSS) sar8p_dffr
    X002 (D TOKEN VDD VSS CODE) sar8p_or2
// BEGIN SARADC RNL
// @RNL(author="saradc topology") {
// #XMUX @SET-SYMBOL $S_sar8p_mux2;
// #XMUX @PLACE(0,0) => @ORIENT("R0");
// #XSTORE @SET-SYMBOL $S_sar8p_dffr;
// #XSTORE @PLACE(43,0) => @ORIENT("R0");
// #X002 @SET-SYMBOL $S_sar8p_or2;
// #X002 @PLACE(84,0) => @ORIENT("R0");
// &"TOKEN" @WIRE(mode="straight",linecolor="#30485d",linewidth=0.16) {#XMUX:3 (35,-3.4) (35,-1.7) #X002:2};
// &"NEXT_D" @WIRE(mode="straight",linecolor="#30485d",linewidth=0.16) {#XMUX:6 (21.5,0) (21.5,0) #XSTORE:2};
// &"D" @WIRE(mode="straight",linecolor="#30485d",linewidth=0.16) {(-12,0) (-12,1.7) (-12,3.4)};
// &"D" @WIRE(mode="straight",linecolor="#30485d",linewidth=0.16) {#XMUX:1 (-12,3.4)};
// $JUNCTION @ATTACH (-12,3.4);
// &"D" @WIRE(mode="straight",linecolor="#30485d",linewidth=0.16) {#XSTORE:3 (-12,0)};
// $JUNCTION @ATTACH (-12,0);
// &"D" @WIRE(mode="straight",linecolor="#30485d",linewidth=0.16) {#X002:1 (-12,1.7)};
// $JUNCTION @ATTACH (-12,1.7);
// (-16,46) @TEXT("sar8p_bit / native standard-cell composition",size=1.3,halign="start",textcolor="#223d52");
// &"DATA" @WIRE(mode="straight",linecolor="#30485d",linewidth=0.16) {#XMUX:2 (-10,0)};
// (-10.4,0) @TEXT("DATA",size=1.1,halign="end",valign="middle");
// &"VDD" @WIRE(mode="straight",linecolor="#30485d",linewidth=0.16) {#XMUX:4 (0,10)};
// (0,10.4) @TEXT("VDD",size=1.1,halign="middle",valign="bottom");
// &"VSS" @WIRE(mode="straight",linecolor="#30485d",linewidth=0.16) {#XMUX:5 (0,-10)};
// (0,-10.4) @TEXT("VSS",size=1.1,halign="middle",valign="top");
// &"PHI_W" @WIRE(mode="straight",linecolor="#30485d",linewidth=0.16) {#XSTORE:1 (33,3.4)};
// (32.6,3.4) @TEXT("PHI_W",size=1.1,halign="end",valign="middle");
// &"SAMPLE" @WIRE(mode="straight",linecolor="#30485d",linewidth=0.16) {#XSTORE:4 (33,-3.4)};
// (32.6,-3.4) @TEXT("SAMPLE",size=1.1,halign="end",valign="middle");
// &"VDD" @WIRE(mode="straight",linecolor="#30485d",linewidth=0.16) {#XSTORE:5 (43,10)};
// (43,10.4) @TEXT("VDD",size=1.1,halign="middle",valign="bottom");
// &"VSS" @WIRE(mode="straight",linecolor="#30485d",linewidth=0.16) {#XSTORE:6 (43,-10)};
// (43,-10.4) @TEXT("VSS",size=1.1,halign="middle",valign="top");
// &"VDD" @WIRE(mode="straight",linecolor="#30485d",linewidth=0.16) {#X002:3 (84,10)};
// (84,10.4) @TEXT("VDD",size=1.1,halign="middle",valign="bottom");
// &"VSS" @WIRE(mode="straight",linecolor="#30485d",linewidth=0.16) {#X002:4 (84,-10)};
// (84,-10.4) @TEXT("VSS",size=1.1,halign="middle",valign="top");
// &"CODE" @WIRE(mode="straight",linecolor="#30485d",linewidth=0.16) {#X002:5 (94,0)};
// (94.4,0) @TEXT("CODE",size=1.1,halign="start",valign="middle");
// }
// END SARADC RNL
ends sar8p_bit

subckt sar_logic_8b_physical CMP_CLK CODE0 CODE1 CODE2 CODE3 CODE4 CODE5          CODE6 CODE7 COMP_N COMP_P D0 D1 D2 D3 D4 D5 D6 D7 PHI_U SAMPLE VDD          VSS
    XTIM (ACTIVE CMP_CLK COMP_N COMP_P DATA PHI_U PHI_W SAMPLE VDD VSS)          sar8p_timing
    XSEQ (PHI_U SAMPLE T0 T1 T2 T3 T4 T5 T6 T7 VDD VSS) sar8p_bitseq8
    XBIT7 (CODE7 D7 DATA PHI_W SAMPLE T7 VDD VSS) sar8p_bit
    XBIT6 (CODE6 D6 DATA PHI_W SAMPLE T6 VDD VSS) sar8p_bit
    XBIT5 (CODE5 D5 DATA PHI_W SAMPLE T5 VDD VSS) sar8p_bit
    XBIT4 (CODE4 D4 DATA PHI_W SAMPLE T4 VDD VSS) sar8p_bit
    XBIT3 (CODE3 D3 DATA PHI_W SAMPLE T3 VDD VSS) sar8p_bit
    XBIT2 (CODE2 D2 DATA PHI_W SAMPLE T2 VDD VSS) sar8p_bit
    XBIT1 (CODE1 D1 DATA PHI_W SAMPLE T1 VDD VSS) sar8p_bit
    XBIT0 (CODE0 D0 DATA PHI_W SAMPLE T0 VDD VSS) sar8p_bit
    X018 (A01 A23 VDD VSS ACTIVE) sar8p_or2
    X017 (A2 A3 VDD VSS A23) sar8p_or2
    X016 (A0 A1 VDD VSS A01) sar8p_or2
    X015 (T6 T7 VDD VSS A3) sar8p_or2
    X014 (T4 T5 VDD VSS A2) sar8p_or2
    X013 (T2 T3 VDD VSS A1) sar8p_or2
    X012 (T0 T1 VDD VSS A0) sar8p_or2
// BEGIN SARADC RNL
// @RNL(author="saradc topology") {
// (-23,82) @TEXT("8-bit SAR / one token, eight bit stores, asynchronous handshake",size=1.5,halign="start",textcolor="#223d52");
// #XTIM @SET-SYMBOL $S_sar8p_timing;
// #XTIM @PLACE(0,39) => @ORIENT("R0");
// #XSEQ @SET-SYMBOL $S_sar8p_bitseq8;
// #XSEQ @PLACE(0,-17) => @ORIENT("R0");
// #XBIT7 @SET-SYMBOL $S_sar8p_bit;
// #XBIT7 @PLACE(73,0) => @ORIENT("R0");
// #XBIT6 @SET-SYMBOL $S_sar8p_bit;
// #XBIT6 @PLACE(73,-35) => @ORIENT("R0");
// #XBIT5 @SET-SYMBOL $S_sar8p_bit;
// #XBIT5 @PLACE(73,-70) => @ORIENT("R0");
// #XBIT4 @SET-SYMBOL $S_sar8p_bit;
// #XBIT4 @PLACE(73,-105) => @ORIENT("R0");
// #XBIT3 @SET-SYMBOL $S_sar8p_bit;
// #XBIT3 @PLACE(73,-140) => @ORIENT("R0");
// #XBIT2 @SET-SYMBOL $S_sar8p_bit;
// #XBIT2 @PLACE(73,-175) => @ORIENT("R0");
// #XBIT1 @SET-SYMBOL $S_sar8p_bit;
// #XBIT1 @PLACE(73,-210) => @ORIENT("R0");
// #XBIT0 @SET-SYMBOL $S_sar8p_bit;
// #XBIT0 @PLACE(73,-245) => @ORIENT("R0");
// #X012 @SET-SYMBOL $S_sar8p_or2;
// #X012 @PLACE(142,0) => @ORIENT("R0");
// #X013 @SET-SYMBOL $S_sar8p_or2;
// #X013 @PLACE(142,-70) => @ORIENT("R0");
// #X014 @SET-SYMBOL $S_sar8p_or2;
// #X014 @PLACE(142,-140) => @ORIENT("R0");
// #X015 @SET-SYMBOL $S_sar8p_or2;
// #X015 @PLACE(142,-210) => @ORIENT("R0");
// #X016 @SET-SYMBOL $S_sar8p_or2;
// #X016 @PLACE(184,-35) => @ORIENT("R0");
// #X017 @SET-SYMBOL $S_sar8p_or2;
// #X017 @PLACE(184,-175) => @ORIENT("R0");
// #X018 @SET-SYMBOL $S_sar8p_or2;
// #X018 @PLACE(225,-105) => @ORIENT("R0");
// &"A0" @WIRE(mode="straight",linecolor="#30485d",linewidth=0.16) {(163,-33.3) (163,0)};
// &"A0" @WIRE(mode="straight",linecolor="#30485d",linewidth=0.16) {#X016:1 (163,-33.3)};
// $JUNCTION @ATTACH (163,-33.3);
// &"A0" @WIRE(mode="straight",linecolor="#30485d",linewidth=0.16) {#X012:5 (163,0)};
// $JUNCTION @ATTACH (163,0);
// &"A1" @WIRE(mode="straight",linecolor="#30485d",linewidth=0.16) {(163,-70) (163,-36.7)};
// &"A1" @WIRE(mode="straight",linecolor="#30485d",linewidth=0.16) {#X016:2 (163,-36.7)};
// $JUNCTION @ATTACH (163,-36.7);
// &"A1" @WIRE(mode="straight",linecolor="#30485d",linewidth=0.16) {#X013:5 (163,-70)};
// $JUNCTION @ATTACH (163,-70);
// &"A2" @WIRE(mode="straight",linecolor="#30485d",linewidth=0.16) {(163,-173.3) (163,-140)};
// &"A2" @WIRE(mode="straight",linecolor="#30485d",linewidth=0.16) {#X017:1 (163,-173.3)};
// $JUNCTION @ATTACH (163,-173.3);
// &"A2" @WIRE(mode="straight",linecolor="#30485d",linewidth=0.16) {#X014:5 (163,-140)};
// $JUNCTION @ATTACH (163,-140);
// &"A3" @WIRE(mode="straight",linecolor="#30485d",linewidth=0.16) {(163,-210) (163,-176.7)};
// &"A3" @WIRE(mode="straight",linecolor="#30485d",linewidth=0.16) {#X017:2 (163,-176.7)};
// $JUNCTION @ATTACH (163,-176.7);
// &"A3" @WIRE(mode="straight",linecolor="#30485d",linewidth=0.16) {#X015:5 (163,-210)};
// $JUNCTION @ATTACH (163,-210);
// &"A01" @WIRE(mode="straight",linecolor="#30485d",linewidth=0.16) {(204.5,-103.3) (204.5,-35)};
// &"A01" @WIRE(mode="straight",linecolor="#30485d",linewidth=0.16) {#X018:1 (204.5,-103.3)};
// $JUNCTION @ATTACH (204.5,-103.3);
// &"A01" @WIRE(mode="straight",linecolor="#30485d",linewidth=0.16) {#X016:5 (204.5,-35)};
// $JUNCTION @ATTACH (204.5,-35);
// &"A23" @WIRE(mode="straight",linecolor="#30485d",linewidth=0.16) {(204.5,-175) (204.5,-106.7)};
// &"A23" @WIRE(mode="straight",linecolor="#30485d",linewidth=0.16) {#X018:2 (204.5,-106.7)};
// $JUNCTION @ATTACH (204.5,-106.7);
// &"A23" @WIRE(mode="straight",linecolor="#30485d",linewidth=0.16) {#X017:5 (204.5,-175)};
// $JUNCTION @ATTACH (204.5,-175);
// &"ACTIVE" @WIRE(mode="straight",linecolor="#30485d",linewidth=0.16) {(109.5,-105) (109.5,43.95)};
// &"ACTIVE" @WIRE(mode="straight",linecolor="#30485d",linewidth=0.16) {#XTIM:1 (109.5,43.95)};
// $JUNCTION @ATTACH (109.5,43.95);
// &"ACTIVE" @WIRE(mode="straight",linecolor="#30485d",linewidth=0.16) {#X018:5 (109.5,-105)};
// $JUNCTION @ATTACH (109.5,-105);
// &"DATA" @WIRE(mode="straight",linecolor="#30485d",linewidth=0.16) {(33,-240.05) (33,-205.05) (33,-170.05) (33,-135.05) (33,-100.05) (33,-65.05) (33,-30.05) (33,4.95) (33,40.65)};
// &"DATA" @WIRE(mode="straight",linecolor="#30485d",linewidth=0.16) {#XTIM:5 (33,40.65)};
// $JUNCTION @ATTACH (33,40.65);
// &"DATA" @WIRE(mode="straight",linecolor="#30485d",linewidth=0.16) {#XBIT7:3 (33,4.95)};
// $JUNCTION @ATTACH (33,4.95);
// &"DATA" @WIRE(mode="straight",linecolor="#30485d",linewidth=0.16) {#XBIT6:3 (33,-30.05)};
// $JUNCTION @ATTACH (33,-30.05);
// &"DATA" @WIRE(mode="straight",linecolor="#30485d",linewidth=0.16) {#XBIT5:3 (33,-65.05)};
// $JUNCTION @ATTACH (33,-65.05);
// &"DATA" @WIRE(mode="straight",linecolor="#30485d",linewidth=0.16) {#XBIT4:3 (33,-100.05)};
// $JUNCTION @ATTACH (33,-100.05);
// &"DATA" @WIRE(mode="straight",linecolor="#30485d",linewidth=0.16) {#XBIT3:3 (33,-135.05)};
// $JUNCTION @ATTACH (33,-135.05);
// &"DATA" @WIRE(mode="straight",linecolor="#30485d",linewidth=0.16) {#XBIT2:3 (33,-170.05)};
// $JUNCTION @ATTACH (33,-170.05);
// &"DATA" @WIRE(mode="straight",linecolor="#30485d",linewidth=0.16) {#XBIT1:3 (33,-205.05)};
// $JUNCTION @ATTACH (33,-205.05);
// &"DATA" @WIRE(mode="straight",linecolor="#30485d",linewidth=0.16) {#XBIT0:3 (33,-240.05)};
// $JUNCTION @ATTACH (33,-240.05);
// &"PHI_W" @WIRE(mode="straight",linecolor="#94601a",linewidth=0.16) {(38,-243.35) (38,-208.35) (38,-173.35) (38,-138.35) (38,-103.35) (38,-68.35) (38,-33.35) (38,1.65) (38,34.05)};
// &"PHI_W" @WIRE(mode="straight",linecolor="#94601a",linewidth=0.16) {#XTIM:7 (38,34.05)};
// $JUNCTION @ATTACH (38,34.05);
// &"PHI_W" @WIRE(mode="straight",linecolor="#94601a",linewidth=0.16) {#XBIT7:4 (38,1.65)};
// $JUNCTION @ATTACH (38,1.65);
// &"PHI_W" @WIRE(mode="straight",linecolor="#94601a",linewidth=0.16) {#XBIT6:4 (38,-33.35)};
// $JUNCTION @ATTACH (38,-33.35);
// &"PHI_W" @WIRE(mode="straight",linecolor="#94601a",linewidth=0.16) {#XBIT5:4 (38,-68.35)};
// $JUNCTION @ATTACH (38,-68.35);
// &"PHI_W" @WIRE(mode="straight",linecolor="#94601a",linewidth=0.16) {#XBIT4:4 (38,-103.35)};
// $JUNCTION @ATTACH (38,-103.35);
// &"PHI_W" @WIRE(mode="straight",linecolor="#94601a",linewidth=0.16) {#XBIT3:4 (38,-138.35)};
// $JUNCTION @ATTACH (38,-138.35);
// &"PHI_W" @WIRE(mode="straight",linecolor="#94601a",linewidth=0.16) {#XBIT2:4 (38,-173.35)};
// $JUNCTION @ATTACH (38,-173.35);
// &"PHI_W" @WIRE(mode="straight",linecolor="#94601a",linewidth=0.16) {#XBIT1:4 (38,-208.35)};
// $JUNCTION @ATTACH (38,-208.35);
// &"PHI_W" @WIRE(mode="straight",linecolor="#94601a",linewidth=0.16) {#XBIT0:4 (38,-243.35)};
// $JUNCTION @ATTACH (38,-243.35);
// (121,-246) @TEXT("OR reduction -> ACTIVE",size=1.15,halign="start",textcolor="#223d52");
// (-23,-274) @TEXT("T[7:0] selects one bit; CODE is the trial word and D the stored output. SAMPLE resets the controller.",size=0.95,halign="start",textcolor="#223d52");
// &"CMP_CLK" @WIRE(mode="straight",linecolor="#30485d",linewidth=0.16) {#XTIM:2 (16,43.95)};
// (16.4,43.95) @TEXT("CMP_CLK",size=1.1,halign="start",valign="middle");
// &"COMP_N" @WIRE(mode="straight",linecolor="#30485d",linewidth=0.16) {#XTIM:3 (-16,40.65)};
// (-16.4,40.65) @TEXT("COMP_N",size=1.1,halign="end",valign="middle");
// &"COMP_P" @WIRE(mode="straight",linecolor="#30485d",linewidth=0.16) {#XTIM:4 (-16,37.35)};
// (-16.4,37.35) @TEXT("COMP_P",size=1.1,halign="end",valign="middle");
// &"PHI_U" @WIRE(mode="straight",linecolor="#30485d",linewidth=0.16) {#XTIM:6 (16,37.35)};
// (16.4,37.35) @TEXT("PHI_U",size=1.1,halign="start",valign="middle");
// &"SAMPLE" @WIRE(mode="straight",linecolor="#30485d",linewidth=0.16) {#XTIM:8 (-16,34.05)};
// (-16.4,34.05) @TEXT("SAMPLE",size=1.1,halign="end",valign="middle");
// &"VDD" @WIRE(mode="straight",linecolor="#30485d",linewidth=0.16) {#XTIM:9 (0,52.25)};
// (0,52.65) @TEXT("VDD",size=1.1,halign="middle",valign="bottom");
// &"VSS" @WIRE(mode="straight",linecolor="#30485d",linewidth=0.16) {#XTIM:10 (0,25.75)};
// (0,25.35) @TEXT("VSS",size=1.1,halign="middle",valign="top");
// &"PHI_U" @WIRE(mode="straight",linecolor="#30485d",linewidth=0.16) {#XSEQ:1 (-16,-15.35)};
// (-16.4,-15.35) @TEXT("PHI_U",size=1.1,halign="end",valign="middle");
// &"SAMPLE" @WIRE(mode="straight",linecolor="#30485d",linewidth=0.16) {#XSEQ:2 (-16,-18.65)};
// (-16.4,-18.65) @TEXT("SAMPLE",size=1.1,halign="end",valign="middle");
// {&"T0" &"T1" &"T2" &"T3" &"T4" &"T5" &"T6" &"T7"} @WIRE(mode="straight",linewidth=0.3) {#XSEQ:3 (16,-17)};
// (16.4,-17) @TEXT("T[7:0]",size=1.1,halign="start",valign="middle");
// &"VDD" @WIRE(mode="straight",linecolor="#30485d",linewidth=0.16) {#XSEQ:11 (0,-6)};
// (0,-5.6) @TEXT("VDD",size=1.1,halign="middle",valign="bottom");
// &"VSS" @WIRE(mode="straight",linecolor="#30485d",linewidth=0.16) {#XSEQ:12 (0,-28)};
// (0,-28.4) @TEXT("VSS",size=1.1,halign="middle",valign="top");
// &"CODE7" @WIRE(mode="straight",linecolor="#30485d",linewidth=0.16) {#XBIT7:1 (89,1.65)};
// (89.4,1.65) @TEXT("CODE7",size=1.1,halign="start",valign="middle");
// &"D7" @WIRE(mode="straight",linecolor="#30485d",linewidth=0.16) {#XBIT7:2 (89,-1.65)};
// (89.4,-1.65) @TEXT("D7",size=1.1,halign="start",valign="middle");
// &"SAMPLE" @WIRE(mode="straight",linecolor="#30485d",linewidth=0.16) {#XBIT7:5 (57,-1.65)};
// (56.6,-1.65) @TEXT("SAMPLE",size=1.1,halign="end",valign="middle");
// &"T7" @WIRE(mode="straight",linecolor="#30485d",linewidth=0.16) {#XBIT7:6 (57,-4.95)};
// (56.6,-4.95) @TEXT("T7",size=1.1,halign="end",valign="middle");
// &"VDD" @WIRE(mode="straight",linecolor="#30485d",linewidth=0.16) {#XBIT7:7 (73,13.25)};
// (73,13.65) @TEXT("VDD",size=1.1,halign="middle",valign="bottom");
// &"VSS" @WIRE(mode="straight",linecolor="#30485d",linewidth=0.16) {#XBIT7:8 (73,-13.25)};
// (73,-13.65) @TEXT("VSS",size=1.1,halign="middle",valign="top");
// &"CODE6" @WIRE(mode="straight",linecolor="#30485d",linewidth=0.16) {#XBIT6:1 (89,-33.35)};
// (89.4,-33.35) @TEXT("CODE6",size=1.1,halign="start",valign="middle");
// &"D6" @WIRE(mode="straight",linecolor="#30485d",linewidth=0.16) {#XBIT6:2 (89,-36.65)};
// (89.4,-36.65) @TEXT("D6",size=1.1,halign="start",valign="middle");
// &"SAMPLE" @WIRE(mode="straight",linecolor="#30485d",linewidth=0.16) {#XBIT6:5 (57,-36.65)};
// (56.6,-36.65) @TEXT("SAMPLE",size=1.1,halign="end",valign="middle");
// &"T6" @WIRE(mode="straight",linecolor="#30485d",linewidth=0.16) {#XBIT6:6 (57,-39.95)};
// (56.6,-39.95) @TEXT("T6",size=1.1,halign="end",valign="middle");
// &"VDD" @WIRE(mode="straight",linecolor="#30485d",linewidth=0.16) {#XBIT6:7 (73,-21.75)};
// (73,-21.35) @TEXT("VDD",size=1.1,halign="middle",valign="bottom");
// &"VSS" @WIRE(mode="straight",linecolor="#30485d",linewidth=0.16) {#XBIT6:8 (73,-48.25)};
// (73,-48.65) @TEXT("VSS",size=1.1,halign="middle",valign="top");
// &"CODE5" @WIRE(mode="straight",linecolor="#30485d",linewidth=0.16) {#XBIT5:1 (89,-68.35)};
// (89.4,-68.35) @TEXT("CODE5",size=1.1,halign="start",valign="middle");
// &"D5" @WIRE(mode="straight",linecolor="#30485d",linewidth=0.16) {#XBIT5:2 (89,-71.65)};
// (89.4,-71.65) @TEXT("D5",size=1.1,halign="start",valign="middle");
// &"SAMPLE" @WIRE(mode="straight",linecolor="#30485d",linewidth=0.16) {#XBIT5:5 (57,-71.65)};
// (56.6,-71.65) @TEXT("SAMPLE",size=1.1,halign="end",valign="middle");
// &"T5" @WIRE(mode="straight",linecolor="#30485d",linewidth=0.16) {#XBIT5:6 (57,-74.95)};
// (56.6,-74.95) @TEXT("T5",size=1.1,halign="end",valign="middle");
// &"VDD" @WIRE(mode="straight",linecolor="#30485d",linewidth=0.16) {#XBIT5:7 (73,-56.75)};
// (73,-56.35) @TEXT("VDD",size=1.1,halign="middle",valign="bottom");
// &"VSS" @WIRE(mode="straight",linecolor="#30485d",linewidth=0.16) {#XBIT5:8 (73,-83.25)};
// (73,-83.65) @TEXT("VSS",size=1.1,halign="middle",valign="top");
// &"CODE4" @WIRE(mode="straight",linecolor="#30485d",linewidth=0.16) {#XBIT4:1 (89,-103.35)};
// (89.4,-103.35) @TEXT("CODE4",size=1.1,halign="start",valign="middle");
// &"D4" @WIRE(mode="straight",linecolor="#30485d",linewidth=0.16) {#XBIT4:2 (89,-106.65)};
// (89.4,-106.65) @TEXT("D4",size=1.1,halign="start",valign="middle");
// &"SAMPLE" @WIRE(mode="straight",linecolor="#30485d",linewidth=0.16) {#XBIT4:5 (57,-106.65)};
// (56.6,-106.65) @TEXT("SAMPLE",size=1.1,halign="end",valign="middle");
// &"T4" @WIRE(mode="straight",linecolor="#30485d",linewidth=0.16) {#XBIT4:6 (57,-109.95)};
// (56.6,-109.95) @TEXT("T4",size=1.1,halign="end",valign="middle");
// &"VDD" @WIRE(mode="straight",linecolor="#30485d",linewidth=0.16) {#XBIT4:7 (73,-91.75)};
// (73,-91.35) @TEXT("VDD",size=1.1,halign="middle",valign="bottom");
// &"VSS" @WIRE(mode="straight",linecolor="#30485d",linewidth=0.16) {#XBIT4:8 (73,-118.25)};
// (73,-118.65) @TEXT("VSS",size=1.1,halign="middle",valign="top");
// &"CODE3" @WIRE(mode="straight",linecolor="#30485d",linewidth=0.16) {#XBIT3:1 (89,-138.35)};
// (89.4,-138.35) @TEXT("CODE3",size=1.1,halign="start",valign="middle");
// &"D3" @WIRE(mode="straight",linecolor="#30485d",linewidth=0.16) {#XBIT3:2 (89,-141.65)};
// (89.4,-141.65) @TEXT("D3",size=1.1,halign="start",valign="middle");
// &"SAMPLE" @WIRE(mode="straight",linecolor="#30485d",linewidth=0.16) {#XBIT3:5 (57,-141.65)};
// (56.6,-141.65) @TEXT("SAMPLE",size=1.1,halign="end",valign="middle");
// &"T3" @WIRE(mode="straight",linecolor="#30485d",linewidth=0.16) {#XBIT3:6 (57,-144.95)};
// (56.6,-144.95) @TEXT("T3",size=1.1,halign="end",valign="middle");
// &"VDD" @WIRE(mode="straight",linecolor="#30485d",linewidth=0.16) {#XBIT3:7 (73,-126.75)};
// (73,-126.35) @TEXT("VDD",size=1.1,halign="middle",valign="bottom");
// &"VSS" @WIRE(mode="straight",linecolor="#30485d",linewidth=0.16) {#XBIT3:8 (73,-153.25)};
// (73,-153.65) @TEXT("VSS",size=1.1,halign="middle",valign="top");
// &"CODE2" @WIRE(mode="straight",linecolor="#30485d",linewidth=0.16) {#XBIT2:1 (89,-173.35)};
// (89.4,-173.35) @TEXT("CODE2",size=1.1,halign="start",valign="middle");
// &"D2" @WIRE(mode="straight",linecolor="#30485d",linewidth=0.16) {#XBIT2:2 (89,-176.65)};
// (89.4,-176.65) @TEXT("D2",size=1.1,halign="start",valign="middle");
// &"SAMPLE" @WIRE(mode="straight",linecolor="#30485d",linewidth=0.16) {#XBIT2:5 (57,-176.65)};
// (56.6,-176.65) @TEXT("SAMPLE",size=1.1,halign="end",valign="middle");
// &"T2" @WIRE(mode="straight",linecolor="#30485d",linewidth=0.16) {#XBIT2:6 (57,-179.95)};
// (56.6,-179.95) @TEXT("T2",size=1.1,halign="end",valign="middle");
// &"VDD" @WIRE(mode="straight",linecolor="#30485d",linewidth=0.16) {#XBIT2:7 (73,-161.75)};
// (73,-161.35) @TEXT("VDD",size=1.1,halign="middle",valign="bottom");
// &"VSS" @WIRE(mode="straight",linecolor="#30485d",linewidth=0.16) {#XBIT2:8 (73,-188.25)};
// (73,-188.65) @TEXT("VSS",size=1.1,halign="middle",valign="top");
// &"CODE1" @WIRE(mode="straight",linecolor="#30485d",linewidth=0.16) {#XBIT1:1 (89,-208.35)};
// (89.4,-208.35) @TEXT("CODE1",size=1.1,halign="start",valign="middle");
// &"D1" @WIRE(mode="straight",linecolor="#30485d",linewidth=0.16) {#XBIT1:2 (89,-211.65)};
// (89.4,-211.65) @TEXT("D1",size=1.1,halign="start",valign="middle");
// &"SAMPLE" @WIRE(mode="straight",linecolor="#30485d",linewidth=0.16) {#XBIT1:5 (57,-211.65)};
// (56.6,-211.65) @TEXT("SAMPLE",size=1.1,halign="end",valign="middle");
// &"T1" @WIRE(mode="straight",linecolor="#30485d",linewidth=0.16) {#XBIT1:6 (57,-214.95)};
// (56.6,-214.95) @TEXT("T1",size=1.1,halign="end",valign="middle");
// &"VDD" @WIRE(mode="straight",linecolor="#30485d",linewidth=0.16) {#XBIT1:7 (73,-196.75)};
// (73,-196.35) @TEXT("VDD",size=1.1,halign="middle",valign="bottom");
// &"VSS" @WIRE(mode="straight",linecolor="#30485d",linewidth=0.16) {#XBIT1:8 (73,-223.25)};
// (73,-223.65) @TEXT("VSS",size=1.1,halign="middle",valign="top");
// &"CODE0" @WIRE(mode="straight",linecolor="#30485d",linewidth=0.16) {#XBIT0:1 (89,-243.35)};
// (89.4,-243.35) @TEXT("CODE0",size=1.1,halign="start",valign="middle");
// &"D0" @WIRE(mode="straight",linecolor="#30485d",linewidth=0.16) {#XBIT0:2 (89,-246.65)};
// (89.4,-246.65) @TEXT("D0",size=1.1,halign="start",valign="middle");
// &"SAMPLE" @WIRE(mode="straight",linecolor="#30485d",linewidth=0.16) {#XBIT0:5 (57,-246.65)};
// (56.6,-246.65) @TEXT("SAMPLE",size=1.1,halign="end",valign="middle");
// &"T0" @WIRE(mode="straight",linecolor="#30485d",linewidth=0.16) {#XBIT0:6 (57,-249.95)};
// (56.6,-249.95) @TEXT("T0",size=1.1,halign="end",valign="middle");
// &"VDD" @WIRE(mode="straight",linecolor="#30485d",linewidth=0.16) {#XBIT0:7 (73,-231.75)};
// (73,-231.35) @TEXT("VDD",size=1.1,halign="middle",valign="bottom");
// &"VSS" @WIRE(mode="straight",linecolor="#30485d",linewidth=0.16) {#XBIT0:8 (73,-258.25)};
// (73,-258.65) @TEXT("VSS",size=1.1,halign="middle",valign="top");
// &"VDD" @WIRE(mode="straight",linecolor="#30485d",linewidth=0.16) {#X018:3 (225,-95)};
// (225,-94.6) @TEXT("VDD",size=1.1,halign="middle",valign="bottom");
// &"VSS" @WIRE(mode="straight",linecolor="#30485d",linewidth=0.16) {#X018:4 (225,-115)};
// (225,-115.4) @TEXT("VSS",size=1.1,halign="middle",valign="top");
// &"VDD" @WIRE(mode="straight",linecolor="#30485d",linewidth=0.16) {#X017:3 (184,-165)};
// (184,-164.6) @TEXT("VDD",size=1.1,halign="middle",valign="bottom");
// &"VSS" @WIRE(mode="straight",linecolor="#30485d",linewidth=0.16) {#X017:4 (184,-185)};
// (184,-185.4) @TEXT("VSS",size=1.1,halign="middle",valign="top");
// &"VDD" @WIRE(mode="straight",linecolor="#30485d",linewidth=0.16) {#X016:3 (184,-25)};
// (184,-24.6) @TEXT("VDD",size=1.1,halign="middle",valign="bottom");
// &"VSS" @WIRE(mode="straight",linecolor="#30485d",linewidth=0.16) {#X016:4 (184,-45)};
// (184,-45.4) @TEXT("VSS",size=1.1,halign="middle",valign="top");
// &"T6" @WIRE(mode="straight",linecolor="#30485d",linewidth=0.16) {#X015:1 (132,-208.3)};
// (131.6,-208.3) @TEXT("T6",size=1.1,halign="end",valign="middle");
// &"T7" @WIRE(mode="straight",linecolor="#30485d",linewidth=0.16) {#X015:2 (132,-211.7)};
// (131.6,-211.7) @TEXT("T7",size=1.1,halign="end",valign="middle");
// &"VDD" @WIRE(mode="straight",linecolor="#30485d",linewidth=0.16) {#X015:3 (142,-200)};
// (142,-199.6) @TEXT("VDD",size=1.1,halign="middle",valign="bottom");
// &"VSS" @WIRE(mode="straight",linecolor="#30485d",linewidth=0.16) {#X015:4 (142,-220)};
// (142,-220.4) @TEXT("VSS",size=1.1,halign="middle",valign="top");
// &"T4" @WIRE(mode="straight",linecolor="#30485d",linewidth=0.16) {#X014:1 (132,-138.3)};
// (131.6,-138.3) @TEXT("T4",size=1.1,halign="end",valign="middle");
// &"T5" @WIRE(mode="straight",linecolor="#30485d",linewidth=0.16) {#X014:2 (132,-141.7)};
// (131.6,-141.7) @TEXT("T5",size=1.1,halign="end",valign="middle");
// &"VDD" @WIRE(mode="straight",linecolor="#30485d",linewidth=0.16) {#X014:3 (142,-130)};
// (142,-129.6) @TEXT("VDD",size=1.1,halign="middle",valign="bottom");
// &"VSS" @WIRE(mode="straight",linecolor="#30485d",linewidth=0.16) {#X014:4 (142,-150)};
// (142,-150.4) @TEXT("VSS",size=1.1,halign="middle",valign="top");
// &"T2" @WIRE(mode="straight",linecolor="#30485d",linewidth=0.16) {#X013:1 (132,-68.3)};
// (131.6,-68.3) @TEXT("T2",size=1.1,halign="end",valign="middle");
// &"T3" @WIRE(mode="straight",linecolor="#30485d",linewidth=0.16) {#X013:2 (132,-71.7)};
// (131.6,-71.7) @TEXT("T3",size=1.1,halign="end",valign="middle");
// &"VDD" @WIRE(mode="straight",linecolor="#30485d",linewidth=0.16) {#X013:3 (142,-60)};
// (142,-59.6) @TEXT("VDD",size=1.1,halign="middle",valign="bottom");
// &"VSS" @WIRE(mode="straight",linecolor="#30485d",linewidth=0.16) {#X013:4 (142,-80)};
// (142,-80.4) @TEXT("VSS",size=1.1,halign="middle",valign="top");
// &"T0" @WIRE(mode="straight",linecolor="#30485d",linewidth=0.16) {#X012:1 (132,1.7)};
// (131.6,1.7) @TEXT("T0",size=1.1,halign="end",valign="middle");
// &"T1" @WIRE(mode="straight",linecolor="#30485d",linewidth=0.16) {#X012:2 (132,-1.7)};
// (131.6,-1.7) @TEXT("T1",size=1.1,halign="end",valign="middle");
// &"VDD" @WIRE(mode="straight",linecolor="#30485d",linewidth=0.16) {#X012:3 (142,10)};
// (142,10.4) @TEXT("VDD",size=1.1,halign="middle",valign="bottom");
// &"VSS" @WIRE(mode="straight",linecolor="#30485d",linewidth=0.16) {#X012:4 (142,-10)};
// (142,-10.4) @TEXT("VSS",size=1.1,halign="middle",valign="top");
// }
// END SARADC RNL
ends sar_logic_8b_physical

subckt sar8i_ctrl CMP_CLK CODE0 CODE1 CODE2 CODE3 CODE4 CODE5  CODE6 CODE7 COMP_N COMP_P D0 D1 D2 D3 D4 D5 D6 D7 PHI_U SAMPLE VDD  VSS ACTIVE
    XTIM (ACTIVE CMP_CLK COMP_N COMP_P DATA PHI_U PHI_W SAMPLE VDD VSS)  sar8p_timing
    XSEQ (PHI_U SAMPLE T0 T1 T2 T3 T4 T5 T6 T7 VDD VSS) sar8p_bitseq8
    XBIT7 (CODE7 D7 DATA PHI_W SAMPLE T7 VDD VSS) sar8p_bit
    XBIT6 (CODE6 D6 DATA PHI_W SAMPLE T6 VDD VSS) sar8p_bit
    XBIT5 (CODE5 D5 DATA PHI_W SAMPLE T5 VDD VSS) sar8p_bit
    XBIT4 (CODE4 D4 DATA PHI_W SAMPLE T4 VDD VSS) sar8p_bit
    XBIT3 (CODE3 D3 DATA PHI_W SAMPLE T3 VDD VSS) sar8p_bit
    XBIT2 (CODE2 D2 DATA PHI_W SAMPLE T2 VDD VSS) sar8p_bit
    XBIT1 (CODE1 D1 DATA PHI_W SAMPLE T1 VDD VSS) sar8p_bit
    XBIT0 (CODE0 D0 DATA PHI_W SAMPLE T0 VDD VSS) sar8p_bit
    X018 (A01 A23 VDD VSS ACTIVE) sar8p_or2
    X017 (A2 A3 VDD VSS A23) sar8p_or2
    X016 (A0 A1 VDD VSS A01) sar8p_or2
    X015 (T6 T7 VDD VSS A3) sar8p_or2
    X014 (T4 T5 VDD VSS A2) sar8p_or2
    X013 (T2 T3 VDD VSS A1) sar8p_or2
    X012 (T0 T1 VDD VSS A0) sar8p_or2
// BEGIN SARADC RNL
// @RNL(author="saradc topology") {
// (-23,82) @TEXT("8-bit SAR / one token, eight bit stores, asynchronous handshake",size=1.5,halign="start",textcolor="#223d52");
// #XTIM @SET-SYMBOL $S_sar8p_timing;
// #XTIM @PLACE(0,39) => @ORIENT("R0");
// #XSEQ @SET-SYMBOL $S_sar8p_bitseq8;
// #XSEQ @PLACE(0,-17) => @ORIENT("R0");
// #XBIT7 @SET-SYMBOL $S_sar8p_bit;
// #XBIT7 @PLACE(73,0) => @ORIENT("R0");
// #XBIT6 @SET-SYMBOL $S_sar8p_bit;
// #XBIT6 @PLACE(73,-35) => @ORIENT("R0");
// #XBIT5 @SET-SYMBOL $S_sar8p_bit;
// #XBIT5 @PLACE(73,-70) => @ORIENT("R0");
// #XBIT4 @SET-SYMBOL $S_sar8p_bit;
// #XBIT4 @PLACE(73,-105) => @ORIENT("R0");
// #XBIT3 @SET-SYMBOL $S_sar8p_bit;
// #XBIT3 @PLACE(73,-140) => @ORIENT("R0");
// #XBIT2 @SET-SYMBOL $S_sar8p_bit;
// #XBIT2 @PLACE(73,-175) => @ORIENT("R0");
// #XBIT1 @SET-SYMBOL $S_sar8p_bit;
// #XBIT1 @PLACE(73,-210) => @ORIENT("R0");
// #XBIT0 @SET-SYMBOL $S_sar8p_bit;
// #XBIT0 @PLACE(73,-245) => @ORIENT("R0");
// #X012 @SET-SYMBOL $S_sar8p_or2;
// #X012 @PLACE(142,0) => @ORIENT("R0");
// #X013 @SET-SYMBOL $S_sar8p_or2;
// #X013 @PLACE(142,-70) => @ORIENT("R0");
// #X014 @SET-SYMBOL $S_sar8p_or2;
// #X014 @PLACE(142,-140) => @ORIENT("R0");
// #X015 @SET-SYMBOL $S_sar8p_or2;
// #X015 @PLACE(142,-210) => @ORIENT("R0");
// #X016 @SET-SYMBOL $S_sar8p_or2;
// #X016 @PLACE(184,-35) => @ORIENT("R0");
// #X017 @SET-SYMBOL $S_sar8p_or2;
// #X017 @PLACE(184,-175) => @ORIENT("R0");
// #X018 @SET-SYMBOL $S_sar8p_or2;
// #X018 @PLACE(225,-105) => @ORIENT("R0");
// &"A0" @WIRE(mode="straight",linecolor="#30485d",linewidth=0.16) {(163,-33.3) (163,0)};
// &"A0" @WIRE(mode="straight",linecolor="#30485d",linewidth=0.16) {#X016:1 (163,-33.3)};
// $JUNCTION @ATTACH (163,-33.3);
// &"A0" @WIRE(mode="straight",linecolor="#30485d",linewidth=0.16) {#X012:5 (163,0)};
// $JUNCTION @ATTACH (163,0);
// &"A1" @WIRE(mode="straight",linecolor="#30485d",linewidth=0.16) {(163,-70) (163,-36.7)};
// &"A1" @WIRE(mode="straight",linecolor="#30485d",linewidth=0.16) {#X016:2 (163,-36.7)};
// $JUNCTION @ATTACH (163,-36.7);
// &"A1" @WIRE(mode="straight",linecolor="#30485d",linewidth=0.16) {#X013:5 (163,-70)};
// $JUNCTION @ATTACH (163,-70);
// &"A2" @WIRE(mode="straight",linecolor="#30485d",linewidth=0.16) {(163,-173.3) (163,-140)};
// &"A2" @WIRE(mode="straight",linecolor="#30485d",linewidth=0.16) {#X017:1 (163,-173.3)};
// $JUNCTION @ATTACH (163,-173.3);
// &"A2" @WIRE(mode="straight",linecolor="#30485d",linewidth=0.16) {#X014:5 (163,-140)};
// $JUNCTION @ATTACH (163,-140);
// &"A3" @WIRE(mode="straight",linecolor="#30485d",linewidth=0.16) {(163,-210) (163,-176.7)};
// &"A3" @WIRE(mode="straight",linecolor="#30485d",linewidth=0.16) {#X017:2 (163,-176.7)};
// $JUNCTION @ATTACH (163,-176.7);
// &"A3" @WIRE(mode="straight",linecolor="#30485d",linewidth=0.16) {#X015:5 (163,-210)};
// $JUNCTION @ATTACH (163,-210);
// &"A01" @WIRE(mode="straight",linecolor="#30485d",linewidth=0.16) {(204.5,-103.3) (204.5,-35)};
// &"A01" @WIRE(mode="straight",linecolor="#30485d",linewidth=0.16) {#X018:1 (204.5,-103.3)};
// $JUNCTION @ATTACH (204.5,-103.3);
// &"A01" @WIRE(mode="straight",linecolor="#30485d",linewidth=0.16) {#X016:5 (204.5,-35)};
// $JUNCTION @ATTACH (204.5,-35);
// &"A23" @WIRE(mode="straight",linecolor="#30485d",linewidth=0.16) {(204.5,-175) (204.5,-106.7)};
// &"A23" @WIRE(mode="straight",linecolor="#30485d",linewidth=0.16) {#X018:2 (204.5,-106.7)};
// $JUNCTION @ATTACH (204.5,-106.7);
// &"A23" @WIRE(mode="straight",linecolor="#30485d",linewidth=0.16) {#X017:5 (204.5,-175)};
// $JUNCTION @ATTACH (204.5,-175);
// &"ACTIVE" @WIRE(mode="straight",linecolor="#30485d",linewidth=0.16) {(109.5,-105) (109.5,43.95)};
// &"ACTIVE" @WIRE(mode="straight",linecolor="#30485d",linewidth=0.16) {#XTIM:1 (109.5,43.95)};
// $JUNCTION @ATTACH (109.5,43.95);
// &"ACTIVE" @WIRE(mode="straight",linecolor="#30485d",linewidth=0.16) {#X018:5 (109.5,-105)};
// $JUNCTION @ATTACH (109.5,-105);
// &"DATA" @WIRE(mode="straight",linecolor="#30485d",linewidth=0.16) {(33,-240.05) (33,-205.05) (33,-170.05) (33,-135.05) (33,-100.05) (33,-65.05) (33,-30.05) (33,4.95) (33,40.65)};
// &"DATA" @WIRE(mode="straight",linecolor="#30485d",linewidth=0.16) {#XTIM:5 (33,40.65)};
// $JUNCTION @ATTACH (33,40.65);
// &"DATA" @WIRE(mode="straight",linecolor="#30485d",linewidth=0.16) {#XBIT7:3 (33,4.95)};
// $JUNCTION @ATTACH (33,4.95);
// &"DATA" @WIRE(mode="straight",linecolor="#30485d",linewidth=0.16) {#XBIT6:3 (33,-30.05)};
// $JUNCTION @ATTACH (33,-30.05);
// &"DATA" @WIRE(mode="straight",linecolor="#30485d",linewidth=0.16) {#XBIT5:3 (33,-65.05)};
// $JUNCTION @ATTACH (33,-65.05);
// &"DATA" @WIRE(mode="straight",linecolor="#30485d",linewidth=0.16) {#XBIT4:3 (33,-100.05)};
// $JUNCTION @ATTACH (33,-100.05);
// &"DATA" @WIRE(mode="straight",linecolor="#30485d",linewidth=0.16) {#XBIT3:3 (33,-135.05)};
// $JUNCTION @ATTACH (33,-135.05);
// &"DATA" @WIRE(mode="straight",linecolor="#30485d",linewidth=0.16) {#XBIT2:3 (33,-170.05)};
// $JUNCTION @ATTACH (33,-170.05);
// &"DATA" @WIRE(mode="straight",linecolor="#30485d",linewidth=0.16) {#XBIT1:3 (33,-205.05)};
// $JUNCTION @ATTACH (33,-205.05);
// &"DATA" @WIRE(mode="straight",linecolor="#30485d",linewidth=0.16) {#XBIT0:3 (33,-240.05)};
// $JUNCTION @ATTACH (33,-240.05);
// &"PHI_W" @WIRE(mode="straight",linecolor="#94601a",linewidth=0.16) {(38,-243.35) (38,-208.35) (38,-173.35) (38,-138.35) (38,-103.35) (38,-68.35) (38,-33.35) (38,1.65) (38,34.05)};
// &"PHI_W" @WIRE(mode="straight",linecolor="#94601a",linewidth=0.16) {#XTIM:7 (38,34.05)};
// $JUNCTION @ATTACH (38,34.05);
// &"PHI_W" @WIRE(mode="straight",linecolor="#94601a",linewidth=0.16) {#XBIT7:4 (38,1.65)};
// $JUNCTION @ATTACH (38,1.65);
// &"PHI_W" @WIRE(mode="straight",linecolor="#94601a",linewidth=0.16) {#XBIT6:4 (38,-33.35)};
// $JUNCTION @ATTACH (38,-33.35);
// &"PHI_W" @WIRE(mode="straight",linecolor="#94601a",linewidth=0.16) {#XBIT5:4 (38,-68.35)};
// $JUNCTION @ATTACH (38,-68.35);
// &"PHI_W" @WIRE(mode="straight",linecolor="#94601a",linewidth=0.16) {#XBIT4:4 (38,-103.35)};
// $JUNCTION @ATTACH (38,-103.35);
// &"PHI_W" @WIRE(mode="straight",linecolor="#94601a",linewidth=0.16) {#XBIT3:4 (38,-138.35)};
// $JUNCTION @ATTACH (38,-138.35);
// &"PHI_W" @WIRE(mode="straight",linecolor="#94601a",linewidth=0.16) {#XBIT2:4 (38,-173.35)};
// $JUNCTION @ATTACH (38,-173.35);
// &"PHI_W" @WIRE(mode="straight",linecolor="#94601a",linewidth=0.16) {#XBIT1:4 (38,-208.35)};
// $JUNCTION @ATTACH (38,-208.35);
// &"PHI_W" @WIRE(mode="straight",linecolor="#94601a",linewidth=0.16) {#XBIT0:4 (38,-243.35)};
// $JUNCTION @ATTACH (38,-243.35);
// (121,-246) @TEXT("OR reduction -> ACTIVE",size=1.15,halign="start",textcolor="#223d52");
// (-23,-274) @TEXT("T[7:0] selects one bit; CODE is the trial word and D the stored output. SAMPLE resets the controller.",size=0.95,halign="start",textcolor="#223d52");
// &"CMP_CLK" @WIRE(mode="straight",linecolor="#30485d",linewidth=0.16) {#XTIM:2 (16,43.95)};
// (16.4,43.95) @TEXT("CMP_CLK",size=1.1,halign="start",valign="middle");
// &"COMP_N" @WIRE(mode="straight",linecolor="#30485d",linewidth=0.16) {#XTIM:3 (-16,40.65)};
// (-16.4,40.65) @TEXT("COMP_N",size=1.1,halign="end",valign="middle");
// &"COMP_P" @WIRE(mode="straight",linecolor="#30485d",linewidth=0.16) {#XTIM:4 (-16,37.35)};
// (-16.4,37.35) @TEXT("COMP_P",size=1.1,halign="end",valign="middle");
// &"PHI_U" @WIRE(mode="straight",linecolor="#30485d",linewidth=0.16) {#XTIM:6 (16,37.35)};
// (16.4,37.35) @TEXT("PHI_U",size=1.1,halign="start",valign="middle");
// &"SAMPLE" @WIRE(mode="straight",linecolor="#30485d",linewidth=0.16) {#XTIM:8 (-16,34.05)};
// (-16.4,34.05) @TEXT("SAMPLE",size=1.1,halign="end",valign="middle");
// &"VDD" @WIRE(mode="straight",linecolor="#30485d",linewidth=0.16) {#XTIM:9 (0,52.25)};
// (0,52.65) @TEXT("VDD",size=1.1,halign="middle",valign="bottom");
// &"VSS" @WIRE(mode="straight",linecolor="#30485d",linewidth=0.16) {#XTIM:10 (0,25.75)};
// (0,25.35) @TEXT("VSS",size=1.1,halign="middle",valign="top");
// &"PHI_U" @WIRE(mode="straight",linecolor="#30485d",linewidth=0.16) {#XSEQ:1 (-16,-15.35)};
// (-16.4,-15.35) @TEXT("PHI_U",size=1.1,halign="end",valign="middle");
// &"SAMPLE" @WIRE(mode="straight",linecolor="#30485d",linewidth=0.16) {#XSEQ:2 (-16,-18.65)};
// (-16.4,-18.65) @TEXT("SAMPLE",size=1.1,halign="end",valign="middle");
// {&"T0" &"T1" &"T2" &"T3" &"T4" &"T5" &"T6" &"T7"} @WIRE(mode="straight",linewidth=0.3) {#XSEQ:3 (16,-17)};
// (16.4,-17) @TEXT("T[7:0]",size=1.1,halign="start",valign="middle");
// &"VDD" @WIRE(mode="straight",linecolor="#30485d",linewidth=0.16) {#XSEQ:11 (0,-6)};
// (0,-5.6) @TEXT("VDD",size=1.1,halign="middle",valign="bottom");
// &"VSS" @WIRE(mode="straight",linecolor="#30485d",linewidth=0.16) {#XSEQ:12 (0,-28)};
// (0,-28.4) @TEXT("VSS",size=1.1,halign="middle",valign="top");
// &"CODE7" @WIRE(mode="straight",linecolor="#30485d",linewidth=0.16) {#XBIT7:1 (89,1.65)};
// (89.4,1.65) @TEXT("CODE7",size=1.1,halign="start",valign="middle");
// &"D7" @WIRE(mode="straight",linecolor="#30485d",linewidth=0.16) {#XBIT7:2 (89,-1.65)};
// (89.4,-1.65) @TEXT("D7",size=1.1,halign="start",valign="middle");
// &"SAMPLE" @WIRE(mode="straight",linecolor="#30485d",linewidth=0.16) {#XBIT7:5 (57,-1.65)};
// (56.6,-1.65) @TEXT("SAMPLE",size=1.1,halign="end",valign="middle");
// &"T7" @WIRE(mode="straight",linecolor="#30485d",linewidth=0.16) {#XBIT7:6 (57,-4.95)};
// (56.6,-4.95) @TEXT("T7",size=1.1,halign="end",valign="middle");
// &"VDD" @WIRE(mode="straight",linecolor="#30485d",linewidth=0.16) {#XBIT7:7 (73,13.25)};
// (73,13.65) @TEXT("VDD",size=1.1,halign="middle",valign="bottom");
// &"VSS" @WIRE(mode="straight",linecolor="#30485d",linewidth=0.16) {#XBIT7:8 (73,-13.25)};
// (73,-13.65) @TEXT("VSS",size=1.1,halign="middle",valign="top");
// &"CODE6" @WIRE(mode="straight",linecolor="#30485d",linewidth=0.16) {#XBIT6:1 (89,-33.35)};
// (89.4,-33.35) @TEXT("CODE6",size=1.1,halign="start",valign="middle");
// &"D6" @WIRE(mode="straight",linecolor="#30485d",linewidth=0.16) {#XBIT6:2 (89,-36.65)};
// (89.4,-36.65) @TEXT("D6",size=1.1,halign="start",valign="middle");
// &"SAMPLE" @WIRE(mode="straight",linecolor="#30485d",linewidth=0.16) {#XBIT6:5 (57,-36.65)};
// (56.6,-36.65) @TEXT("SAMPLE",size=1.1,halign="end",valign="middle");
// &"T6" @WIRE(mode="straight",linecolor="#30485d",linewidth=0.16) {#XBIT6:6 (57,-39.95)};
// (56.6,-39.95) @TEXT("T6",size=1.1,halign="end",valign="middle");
// &"VDD" @WIRE(mode="straight",linecolor="#30485d",linewidth=0.16) {#XBIT6:7 (73,-21.75)};
// (73,-21.35) @TEXT("VDD",size=1.1,halign="middle",valign="bottom");
// &"VSS" @WIRE(mode="straight",linecolor="#30485d",linewidth=0.16) {#XBIT6:8 (73,-48.25)};
// (73,-48.65) @TEXT("VSS",size=1.1,halign="middle",valign="top");
// &"CODE5" @WIRE(mode="straight",linecolor="#30485d",linewidth=0.16) {#XBIT5:1 (89,-68.35)};
// (89.4,-68.35) @TEXT("CODE5",size=1.1,halign="start",valign="middle");
// &"D5" @WIRE(mode="straight",linecolor="#30485d",linewidth=0.16) {#XBIT5:2 (89,-71.65)};
// (89.4,-71.65) @TEXT("D5",size=1.1,halign="start",valign="middle");
// &"SAMPLE" @WIRE(mode="straight",linecolor="#30485d",linewidth=0.16) {#XBIT5:5 (57,-71.65)};
// (56.6,-71.65) @TEXT("SAMPLE",size=1.1,halign="end",valign="middle");
// &"T5" @WIRE(mode="straight",linecolor="#30485d",linewidth=0.16) {#XBIT5:6 (57,-74.95)};
// (56.6,-74.95) @TEXT("T5",size=1.1,halign="end",valign="middle");
// &"VDD" @WIRE(mode="straight",linecolor="#30485d",linewidth=0.16) {#XBIT5:7 (73,-56.75)};
// (73,-56.35) @TEXT("VDD",size=1.1,halign="middle",valign="bottom");
// &"VSS" @WIRE(mode="straight",linecolor="#30485d",linewidth=0.16) {#XBIT5:8 (73,-83.25)};
// (73,-83.65) @TEXT("VSS",size=1.1,halign="middle",valign="top");
// &"CODE4" @WIRE(mode="straight",linecolor="#30485d",linewidth=0.16) {#XBIT4:1 (89,-103.35)};
// (89.4,-103.35) @TEXT("CODE4",size=1.1,halign="start",valign="middle");
// &"D4" @WIRE(mode="straight",linecolor="#30485d",linewidth=0.16) {#XBIT4:2 (89,-106.65)};
// (89.4,-106.65) @TEXT("D4",size=1.1,halign="start",valign="middle");
// &"SAMPLE" @WIRE(mode="straight",linecolor="#30485d",linewidth=0.16) {#XBIT4:5 (57,-106.65)};
// (56.6,-106.65) @TEXT("SAMPLE",size=1.1,halign="end",valign="middle");
// &"T4" @WIRE(mode="straight",linecolor="#30485d",linewidth=0.16) {#XBIT4:6 (57,-109.95)};
// (56.6,-109.95) @TEXT("T4",size=1.1,halign="end",valign="middle");
// &"VDD" @WIRE(mode="straight",linecolor="#30485d",linewidth=0.16) {#XBIT4:7 (73,-91.75)};
// (73,-91.35) @TEXT("VDD",size=1.1,halign="middle",valign="bottom");
// &"VSS" @WIRE(mode="straight",linecolor="#30485d",linewidth=0.16) {#XBIT4:8 (73,-118.25)};
// (73,-118.65) @TEXT("VSS",size=1.1,halign="middle",valign="top");
// &"CODE3" @WIRE(mode="straight",linecolor="#30485d",linewidth=0.16) {#XBIT3:1 (89,-138.35)};
// (89.4,-138.35) @TEXT("CODE3",size=1.1,halign="start",valign="middle");
// &"D3" @WIRE(mode="straight",linecolor="#30485d",linewidth=0.16) {#XBIT3:2 (89,-141.65)};
// (89.4,-141.65) @TEXT("D3",size=1.1,halign="start",valign="middle");
// &"SAMPLE" @WIRE(mode="straight",linecolor="#30485d",linewidth=0.16) {#XBIT3:5 (57,-141.65)};
// (56.6,-141.65) @TEXT("SAMPLE",size=1.1,halign="end",valign="middle");
// &"T3" @WIRE(mode="straight",linecolor="#30485d",linewidth=0.16) {#XBIT3:6 (57,-144.95)};
// (56.6,-144.95) @TEXT("T3",size=1.1,halign="end",valign="middle");
// &"VDD" @WIRE(mode="straight",linecolor="#30485d",linewidth=0.16) {#XBIT3:7 (73,-126.75)};
// (73,-126.35) @TEXT("VDD",size=1.1,halign="middle",valign="bottom");
// &"VSS" @WIRE(mode="straight",linecolor="#30485d",linewidth=0.16) {#XBIT3:8 (73,-153.25)};
// (73,-153.65) @TEXT("VSS",size=1.1,halign="middle",valign="top");
// &"CODE2" @WIRE(mode="straight",linecolor="#30485d",linewidth=0.16) {#XBIT2:1 (89,-173.35)};
// (89.4,-173.35) @TEXT("CODE2",size=1.1,halign="start",valign="middle");
// &"D2" @WIRE(mode="straight",linecolor="#30485d",linewidth=0.16) {#XBIT2:2 (89,-176.65)};
// (89.4,-176.65) @TEXT("D2",size=1.1,halign="start",valign="middle");
// &"SAMPLE" @WIRE(mode="straight",linecolor="#30485d",linewidth=0.16) {#XBIT2:5 (57,-176.65)};
// (56.6,-176.65) @TEXT("SAMPLE",size=1.1,halign="end",valign="middle");
// &"T2" @WIRE(mode="straight",linecolor="#30485d",linewidth=0.16) {#XBIT2:6 (57,-179.95)};
// (56.6,-179.95) @TEXT("T2",size=1.1,halign="end",valign="middle");
// &"VDD" @WIRE(mode="straight",linecolor="#30485d",linewidth=0.16) {#XBIT2:7 (73,-161.75)};
// (73,-161.35) @TEXT("VDD",size=1.1,halign="middle",valign="bottom");
// &"VSS" @WIRE(mode="straight",linecolor="#30485d",linewidth=0.16) {#XBIT2:8 (73,-188.25)};
// (73,-188.65) @TEXT("VSS",size=1.1,halign="middle",valign="top");
// &"CODE1" @WIRE(mode="straight",linecolor="#30485d",linewidth=0.16) {#XBIT1:1 (89,-208.35)};
// (89.4,-208.35) @TEXT("CODE1",size=1.1,halign="start",valign="middle");
// &"D1" @WIRE(mode="straight",linecolor="#30485d",linewidth=0.16) {#XBIT1:2 (89,-211.65)};
// (89.4,-211.65) @TEXT("D1",size=1.1,halign="start",valign="middle");
// &"SAMPLE" @WIRE(mode="straight",linecolor="#30485d",linewidth=0.16) {#XBIT1:5 (57,-211.65)};
// (56.6,-211.65) @TEXT("SAMPLE",size=1.1,halign="end",valign="middle");
// &"T1" @WIRE(mode="straight",linecolor="#30485d",linewidth=0.16) {#XBIT1:6 (57,-214.95)};
// (56.6,-214.95) @TEXT("T1",size=1.1,halign="end",valign="middle");
// &"VDD" @WIRE(mode="straight",linecolor="#30485d",linewidth=0.16) {#XBIT1:7 (73,-196.75)};
// (73,-196.35) @TEXT("VDD",size=1.1,halign="middle",valign="bottom");
// &"VSS" @WIRE(mode="straight",linecolor="#30485d",linewidth=0.16) {#XBIT1:8 (73,-223.25)};
// (73,-223.65) @TEXT("VSS",size=1.1,halign="middle",valign="top");
// &"CODE0" @WIRE(mode="straight",linecolor="#30485d",linewidth=0.16) {#XBIT0:1 (89,-243.35)};
// (89.4,-243.35) @TEXT("CODE0",size=1.1,halign="start",valign="middle");
// &"D0" @WIRE(mode="straight",linecolor="#30485d",linewidth=0.16) {#XBIT0:2 (89,-246.65)};
// (89.4,-246.65) @TEXT("D0",size=1.1,halign="start",valign="middle");
// &"SAMPLE" @WIRE(mode="straight",linecolor="#30485d",linewidth=0.16) {#XBIT0:5 (57,-246.65)};
// (56.6,-246.65) @TEXT("SAMPLE",size=1.1,halign="end",valign="middle");
// &"T0" @WIRE(mode="straight",linecolor="#30485d",linewidth=0.16) {#XBIT0:6 (57,-249.95)};
// (56.6,-249.95) @TEXT("T0",size=1.1,halign="end",valign="middle");
// &"VDD" @WIRE(mode="straight",linecolor="#30485d",linewidth=0.16) {#XBIT0:7 (73,-231.75)};
// (73,-231.35) @TEXT("VDD",size=1.1,halign="middle",valign="bottom");
// &"VSS" @WIRE(mode="straight",linecolor="#30485d",linewidth=0.16) {#XBIT0:8 (73,-258.25)};
// (73,-258.65) @TEXT("VSS",size=1.1,halign="middle",valign="top");
// &"VDD" @WIRE(mode="straight",linecolor="#30485d",linewidth=0.16) {#X018:3 (225,-95)};
// (225,-94.6) @TEXT("VDD",size=1.1,halign="middle",valign="bottom");
// &"VSS" @WIRE(mode="straight",linecolor="#30485d",linewidth=0.16) {#X018:4 (225,-115)};
// (225,-115.4) @TEXT("VSS",size=1.1,halign="middle",valign="top");
// &"VDD" @WIRE(mode="straight",linecolor="#30485d",linewidth=0.16) {#X017:3 (184,-165)};
// (184,-164.6) @TEXT("VDD",size=1.1,halign="middle",valign="bottom");
// &"VSS" @WIRE(mode="straight",linecolor="#30485d",linewidth=0.16) {#X017:4 (184,-185)};
// (184,-185.4) @TEXT("VSS",size=1.1,halign="middle",valign="top");
// &"VDD" @WIRE(mode="straight",linecolor="#30485d",linewidth=0.16) {#X016:3 (184,-25)};
// (184,-24.6) @TEXT("VDD",size=1.1,halign="middle",valign="bottom");
// &"VSS" @WIRE(mode="straight",linecolor="#30485d",linewidth=0.16) {#X016:4 (184,-45)};
// (184,-45.4) @TEXT("VSS",size=1.1,halign="middle",valign="top");
// &"T6" @WIRE(mode="straight",linecolor="#30485d",linewidth=0.16) {#X015:1 (132,-208.3)};
// (131.6,-208.3) @TEXT("T6",size=1.1,halign="end",valign="middle");
// &"T7" @WIRE(mode="straight",linecolor="#30485d",linewidth=0.16) {#X015:2 (132,-211.7)};
// (131.6,-211.7) @TEXT("T7",size=1.1,halign="end",valign="middle");
// &"VDD" @WIRE(mode="straight",linecolor="#30485d",linewidth=0.16) {#X015:3 (142,-200)};
// (142,-199.6) @TEXT("VDD",size=1.1,halign="middle",valign="bottom");
// &"VSS" @WIRE(mode="straight",linecolor="#30485d",linewidth=0.16) {#X015:4 (142,-220)};
// (142,-220.4) @TEXT("VSS",size=1.1,halign="middle",valign="top");
// &"T4" @WIRE(mode="straight",linecolor="#30485d",linewidth=0.16) {#X014:1 (132,-138.3)};
// (131.6,-138.3) @TEXT("T4",size=1.1,halign="end",valign="middle");
// &"T5" @WIRE(mode="straight",linecolor="#30485d",linewidth=0.16) {#X014:2 (132,-141.7)};
// (131.6,-141.7) @TEXT("T5",size=1.1,halign="end",valign="middle");
// &"VDD" @WIRE(mode="straight",linecolor="#30485d",linewidth=0.16) {#X014:3 (142,-130)};
// (142,-129.6) @TEXT("VDD",size=1.1,halign="middle",valign="bottom");
// &"VSS" @WIRE(mode="straight",linecolor="#30485d",linewidth=0.16) {#X014:4 (142,-150)};
// (142,-150.4) @TEXT("VSS",size=1.1,halign="middle",valign="top");
// &"T2" @WIRE(mode="straight",linecolor="#30485d",linewidth=0.16) {#X013:1 (132,-68.3)};
// (131.6,-68.3) @TEXT("T2",size=1.1,halign="end",valign="middle");
// &"T3" @WIRE(mode="straight",linecolor="#30485d",linewidth=0.16) {#X013:2 (132,-71.7)};
// (131.6,-71.7) @TEXT("T3",size=1.1,halign="end",valign="middle");
// &"VDD" @WIRE(mode="straight",linecolor="#30485d",linewidth=0.16) {#X013:3 (142,-60)};
// (142,-59.6) @TEXT("VDD",size=1.1,halign="middle",valign="bottom");
// &"VSS" @WIRE(mode="straight",linecolor="#30485d",linewidth=0.16) {#X013:4 (142,-80)};
// (142,-80.4) @TEXT("VSS",size=1.1,halign="middle",valign="top");
// &"T0" @WIRE(mode="straight",linecolor="#30485d",linewidth=0.16) {#X012:1 (132,1.7)};
// (131.6,1.7) @TEXT("T0",size=1.1,halign="end",valign="middle");
// &"T1" @WIRE(mode="straight",linecolor="#30485d",linewidth=0.16) {#X012:2 (132,-1.7)};
// (131.6,-1.7) @TEXT("T1",size=1.1,halign="end",valign="middle");
// &"VDD" @WIRE(mode="straight",linecolor="#30485d",linewidth=0.16) {#X012:3 (142,10)};
// (142,10.4) @TEXT("VDD",size=1.1,halign="middle",valign="bottom");
// &"VSS" @WIRE(mode="straight",linecolor="#30485d",linewidth=0.16) {#X012:4 (142,-10)};
// (142,-10.4) @TEXT("VSS",size=1.1,halign="middle",valign="top");
// }
// END SARADC RNL
ends sar8i_ctrl

subckt tb_cdac
// Isolated CDAC: precharge top plates, release, then single-bit steps and full-scale reversal.
VDPRE (d_pre 0) vsource type=pwl wave=[0 0.9 40n 0.9 40.1n 0]
VDCM (d_cm 0) vsource dc=0.45
XDPN (d_n d_cm d_pre VDD! 0) b_tb_switch
XDPP (d_p d_cm d_pre VDD! 0) b_tb_switch
VDgnn0 (d_gnn0 0) vsource type=pwl wave=[0 0.90000000000000002 5.9900000000000014e-08 0.90000000000000002 6.0000000000000008e-08 0 7.9900000000000007e-08 0 8.0000000000000002e-08 0.90000000000000002 9.9900000000000014e-08 0.90000000000000002 1.0000000000000001e-07 0.90000000000000002 1.1990000000000001e-07 0.90000000000000002 1.2000000000000002e-07 0.90000000000000002 1.399e-07 0.90000000000000002 1.4000000000000001e-07 0.90000000000000002 1.599e-07 0.90000000000000002 1.6e-07 0.90000000000000002 1.7990000000000002e-07 0.90000000000000002 1.8000000000000002e-07 0.90000000000000002 1.9990000000000001e-07 0.90000000000000002 2.0000000000000002e-07 0.90000000000000002 2.199e-07 0.90000000000000002 2.2000000000000001e-07 0 2.3990000000000002e-07 0 2.4000000000000003e-07 0.90000000000000002]
VDgnn1 (d_gnn1 0) vsource type=pwl wave=[0 0.90000000000000002 5.9900000000000014e-08 0.90000000000000002 6.0000000000000008e-08 0.90000000000000002 7.9900000000000007e-08 0.90000000000000002 8.0000000000000002e-08 0 9.9900000000000014e-08 0 1.0000000000000001e-07 0.90000000000000002 1.1990000000000001e-07 0.90000000000000002 1.2000000000000002e-07 0.90000000000000002 1.399e-07 0.90000000000000002 1.4000000000000001e-07 0.90000000000000002 1.599e-07 0.90000000000000002 1.6e-07 0.90000000000000002 1.7990000000000002e-07 0.90000000000000002 1.8000000000000002e-07 0.90000000000000002 1.9990000000000001e-07 0.90000000000000002 2.0000000000000002e-07 0.90000000000000002 2.199e-07 0.90000000000000002 2.2000000000000001e-07 0 2.3990000000000002e-07 0 2.4000000000000003e-07 0.90000000000000002]
VDgnn2 (d_gnn2 0) vsource type=pwl wave=[0 0.90000000000000002 5.9900000000000014e-08 0.90000000000000002 6.0000000000000008e-08 0.90000000000000002 7.9900000000000007e-08 0.90000000000000002 8.0000000000000002e-08 0.90000000000000002 9.9900000000000014e-08 0.90000000000000002 1.0000000000000001e-07 0 1.1990000000000001e-07 0 1.2000000000000002e-07 0.90000000000000002 1.399e-07 0.90000000000000002 1.4000000000000001e-07 0.90000000000000002 1.599e-07 0.90000000000000002 1.6e-07 0.90000000000000002 1.7990000000000002e-07 0.90000000000000002 1.8000000000000002e-07 0.90000000000000002 1.9990000000000001e-07 0.90000000000000002 2.0000000000000002e-07 0.90000000000000002 2.199e-07 0.90000000000000002 2.2000000000000001e-07 0 2.3990000000000002e-07 0 2.4000000000000003e-07 0.90000000000000002]
VDgnn3 (d_gnn3 0) vsource type=pwl wave=[0 0.90000000000000002 5.9900000000000014e-08 0.90000000000000002 6.0000000000000008e-08 0.90000000000000002 7.9900000000000007e-08 0.90000000000000002 8.0000000000000002e-08 0.90000000000000002 9.9900000000000014e-08 0.90000000000000002 1.0000000000000001e-07 0.90000000000000002 1.1990000000000001e-07 0.90000000000000002 1.2000000000000002e-07 0 1.399e-07 0 1.4000000000000001e-07 0.90000000000000002 1.599e-07 0.90000000000000002 1.6e-07 0.90000000000000002 1.7990000000000002e-07 0.90000000000000002 1.8000000000000002e-07 0.90000000000000002 1.9990000000000001e-07 0.90000000000000002 2.0000000000000002e-07 0.90000000000000002 2.199e-07 0.90000000000000002 2.2000000000000001e-07 0 2.3990000000000002e-07 0 2.4000000000000003e-07 0.90000000000000002]
VDgnn4 (d_gnn4 0) vsource type=pwl wave=[0 0.90000000000000002 5.9900000000000014e-08 0.90000000000000002 6.0000000000000008e-08 0.90000000000000002 7.9900000000000007e-08 0.90000000000000002 8.0000000000000002e-08 0.90000000000000002 9.9900000000000014e-08 0.90000000000000002 1.0000000000000001e-07 0.90000000000000002 1.1990000000000001e-07 0.90000000000000002 1.2000000000000002e-07 0.90000000000000002 1.399e-07 0.90000000000000002 1.4000000000000001e-07 0 1.599e-07 0 1.6e-07 0.90000000000000002 1.7990000000000002e-07 0.90000000000000002 1.8000000000000002e-07 0.90000000000000002 1.9990000000000001e-07 0.90000000000000002 2.0000000000000002e-07 0.90000000000000002 2.199e-07 0.90000000000000002 2.2000000000000001e-07 0 2.3990000000000002e-07 0 2.4000000000000003e-07 0.90000000000000002]
VDgnn5 (d_gnn5 0) vsource type=pwl wave=[0 0.90000000000000002 5.9900000000000014e-08 0.90000000000000002 6.0000000000000008e-08 0.90000000000000002 7.9900000000000007e-08 0.90000000000000002 8.0000000000000002e-08 0.90000000000000002 9.9900000000000014e-08 0.90000000000000002 1.0000000000000001e-07 0.90000000000000002 1.1990000000000001e-07 0.90000000000000002 1.2000000000000002e-07 0.90000000000000002 1.399e-07 0.90000000000000002 1.4000000000000001e-07 0.90000000000000002 1.599e-07 0.90000000000000002 1.6e-07 0 1.7990000000000002e-07 0 1.8000000000000002e-07 0.90000000000000002 1.9990000000000001e-07 0.90000000000000002 2.0000000000000002e-07 0.90000000000000002 2.199e-07 0.90000000000000002 2.2000000000000001e-07 0 2.3990000000000002e-07 0 2.4000000000000003e-07 0.90000000000000002]
VDgnn6 (d_gnn6 0) vsource type=pwl wave=[0 0.90000000000000002 5.9900000000000014e-08 0.90000000000000002 6.0000000000000008e-08 0.90000000000000002 7.9900000000000007e-08 0.90000000000000002 8.0000000000000002e-08 0.90000000000000002 9.9900000000000014e-08 0.90000000000000002 1.0000000000000001e-07 0.90000000000000002 1.1990000000000001e-07 0.90000000000000002 1.2000000000000002e-07 0.90000000000000002 1.399e-07 0.90000000000000002 1.4000000000000001e-07 0.90000000000000002 1.599e-07 0.90000000000000002 1.6e-07 0.90000000000000002 1.7990000000000002e-07 0.90000000000000002 1.8000000000000002e-07 0 1.9990000000000001e-07 0 2.0000000000000002e-07 0.90000000000000002 2.199e-07 0.90000000000000002 2.2000000000000001e-07 0 2.3990000000000002e-07 0 2.4000000000000003e-07 0.90000000000000002]
VDgnn7 (d_gnn7 0) vsource type=pwl wave=[0 0.90000000000000002 5.9900000000000014e-08 0.90000000000000002 6.0000000000000008e-08 0.90000000000000002 7.9900000000000007e-08 0.90000000000000002 8.0000000000000002e-08 0.90000000000000002 9.9900000000000014e-08 0.90000000000000002 1.0000000000000001e-07 0.90000000000000002 1.1990000000000001e-07 0.90000000000000002 1.2000000000000002e-07 0.90000000000000002 1.399e-07 0.90000000000000002 1.4000000000000001e-07 0.90000000000000002 1.599e-07 0.90000000000000002 1.6e-07 0.90000000000000002 1.7990000000000002e-07 0.90000000000000002 1.8000000000000002e-07 0.90000000000000002 1.9990000000000001e-07 0.90000000000000002 2.0000000000000002e-07 0 2.199e-07 0 2.2000000000000001e-07 0 2.3990000000000002e-07 0 2.4000000000000003e-07 0.90000000000000002]
VDgnp0 (d_gnp0 0) vsource type=pwl wave=[0 0.90000000000000002 5.9900000000000014e-08 0.90000000000000002 6.0000000000000008e-08 0 7.9900000000000007e-08 0 8.0000000000000002e-08 0.90000000000000002 9.9900000000000014e-08 0.90000000000000002 1.0000000000000001e-07 0.90000000000000002 1.1990000000000001e-07 0.90000000000000002 1.2000000000000002e-07 0.90000000000000002 1.399e-07 0.90000000000000002 1.4000000000000001e-07 0.90000000000000002 1.599e-07 0.90000000000000002 1.6e-07 0.90000000000000002 1.7990000000000002e-07 0.90000000000000002 1.8000000000000002e-07 0.90000000000000002 1.9990000000000001e-07 0.90000000000000002 2.0000000000000002e-07 0.90000000000000002 2.199e-07 0.90000000000000002 2.2000000000000001e-07 0 2.3990000000000002e-07 0 2.4000000000000003e-07 0.90000000000000002]
VDgnp1 (d_gnp1 0) vsource type=pwl wave=[0 0.90000000000000002 5.9900000000000014e-08 0.90000000000000002 6.0000000000000008e-08 0.90000000000000002 7.9900000000000007e-08 0.90000000000000002 8.0000000000000002e-08 0 9.9900000000000014e-08 0 1.0000000000000001e-07 0.90000000000000002 1.1990000000000001e-07 0.90000000000000002 1.2000000000000002e-07 0.90000000000000002 1.399e-07 0.90000000000000002 1.4000000000000001e-07 0.90000000000000002 1.599e-07 0.90000000000000002 1.6e-07 0.90000000000000002 1.7990000000000002e-07 0.90000000000000002 1.8000000000000002e-07 0.90000000000000002 1.9990000000000001e-07 0.90000000000000002 2.0000000000000002e-07 0.90000000000000002 2.199e-07 0.90000000000000002 2.2000000000000001e-07 0 2.3990000000000002e-07 0 2.4000000000000003e-07 0.90000000000000002]
VDgnp2 (d_gnp2 0) vsource type=pwl wave=[0 0.90000000000000002 5.9900000000000014e-08 0.90000000000000002 6.0000000000000008e-08 0.90000000000000002 7.9900000000000007e-08 0.90000000000000002 8.0000000000000002e-08 0.90000000000000002 9.9900000000000014e-08 0.90000000000000002 1.0000000000000001e-07 0 1.1990000000000001e-07 0 1.2000000000000002e-07 0.90000000000000002 1.399e-07 0.90000000000000002 1.4000000000000001e-07 0.90000000000000002 1.599e-07 0.90000000000000002 1.6e-07 0.90000000000000002 1.7990000000000002e-07 0.90000000000000002 1.8000000000000002e-07 0.90000000000000002 1.9990000000000001e-07 0.90000000000000002 2.0000000000000002e-07 0.90000000000000002 2.199e-07 0.90000000000000002 2.2000000000000001e-07 0 2.3990000000000002e-07 0 2.4000000000000003e-07 0.90000000000000002]
VDgnp3 (d_gnp3 0) vsource type=pwl wave=[0 0.90000000000000002 5.9900000000000014e-08 0.90000000000000002 6.0000000000000008e-08 0.90000000000000002 7.9900000000000007e-08 0.90000000000000002 8.0000000000000002e-08 0.90000000000000002 9.9900000000000014e-08 0.90000000000000002 1.0000000000000001e-07 0.90000000000000002 1.1990000000000001e-07 0.90000000000000002 1.2000000000000002e-07 0 1.399e-07 0 1.4000000000000001e-07 0.90000000000000002 1.599e-07 0.90000000000000002 1.6e-07 0.90000000000000002 1.7990000000000002e-07 0.90000000000000002 1.8000000000000002e-07 0.90000000000000002 1.9990000000000001e-07 0.90000000000000002 2.0000000000000002e-07 0.90000000000000002 2.199e-07 0.90000000000000002 2.2000000000000001e-07 0 2.3990000000000002e-07 0 2.4000000000000003e-07 0.90000000000000002]
VDgnp4 (d_gnp4 0) vsource type=pwl wave=[0 0.90000000000000002 5.9900000000000014e-08 0.90000000000000002 6.0000000000000008e-08 0.90000000000000002 7.9900000000000007e-08 0.90000000000000002 8.0000000000000002e-08 0.90000000000000002 9.9900000000000014e-08 0.90000000000000002 1.0000000000000001e-07 0.90000000000000002 1.1990000000000001e-07 0.90000000000000002 1.2000000000000002e-07 0.90000000000000002 1.399e-07 0.90000000000000002 1.4000000000000001e-07 0 1.599e-07 0 1.6e-07 0.90000000000000002 1.7990000000000002e-07 0.90000000000000002 1.8000000000000002e-07 0.90000000000000002 1.9990000000000001e-07 0.90000000000000002 2.0000000000000002e-07 0.90000000000000002 2.199e-07 0.90000000000000002 2.2000000000000001e-07 0 2.3990000000000002e-07 0 2.4000000000000003e-07 0.90000000000000002]
VDgnp5 (d_gnp5 0) vsource type=pwl wave=[0 0.90000000000000002 5.9900000000000014e-08 0.90000000000000002 6.0000000000000008e-08 0.90000000000000002 7.9900000000000007e-08 0.90000000000000002 8.0000000000000002e-08 0.90000000000000002 9.9900000000000014e-08 0.90000000000000002 1.0000000000000001e-07 0.90000000000000002 1.1990000000000001e-07 0.90000000000000002 1.2000000000000002e-07 0.90000000000000002 1.399e-07 0.90000000000000002 1.4000000000000001e-07 0.90000000000000002 1.599e-07 0.90000000000000002 1.6e-07 0 1.7990000000000002e-07 0 1.8000000000000002e-07 0.90000000000000002 1.9990000000000001e-07 0.90000000000000002 2.0000000000000002e-07 0.90000000000000002 2.199e-07 0.90000000000000002 2.2000000000000001e-07 0 2.3990000000000002e-07 0 2.4000000000000003e-07 0.90000000000000002]
VDgnp6 (d_gnp6 0) vsource type=pwl wave=[0 0.90000000000000002 5.9900000000000014e-08 0.90000000000000002 6.0000000000000008e-08 0.90000000000000002 7.9900000000000007e-08 0.90000000000000002 8.0000000000000002e-08 0.90000000000000002 9.9900000000000014e-08 0.90000000000000002 1.0000000000000001e-07 0.90000000000000002 1.1990000000000001e-07 0.90000000000000002 1.2000000000000002e-07 0.90000000000000002 1.399e-07 0.90000000000000002 1.4000000000000001e-07 0.90000000000000002 1.599e-07 0.90000000000000002 1.6e-07 0.90000000000000002 1.7990000000000002e-07 0.90000000000000002 1.8000000000000002e-07 0 1.9990000000000001e-07 0 2.0000000000000002e-07 0.90000000000000002 2.199e-07 0.90000000000000002 2.2000000000000001e-07 0 2.3990000000000002e-07 0 2.4000000000000003e-07 0.90000000000000002]
VDgnp7 (d_gnp7 0) vsource type=pwl wave=[0 0.90000000000000002 5.9900000000000014e-08 0.90000000000000002 6.0000000000000008e-08 0.90000000000000002 7.9900000000000007e-08 0.90000000000000002 8.0000000000000002e-08 0.90000000000000002 9.9900000000000014e-08 0.90000000000000002 1.0000000000000001e-07 0.90000000000000002 1.1990000000000001e-07 0.90000000000000002 1.2000000000000002e-07 0.90000000000000002 1.399e-07 0.90000000000000002 1.4000000000000001e-07 0.90000000000000002 1.599e-07 0.90000000000000002 1.6e-07 0.90000000000000002 1.7990000000000002e-07 0.90000000000000002 1.8000000000000002e-07 0.90000000000000002 1.9990000000000001e-07 0.90000000000000002 2.0000000000000002e-07 0 2.199e-07 0 2.2000000000000001e-07 0 2.3990000000000002e-07 0 2.4000000000000003e-07 0.90000000000000002]
VDgpn0 (d_gpn0 0) vsource type=pwl wave=[0 0 5.9900000000000014e-08 0 6.0000000000000008e-08 0.90000000000000002 7.9900000000000007e-08 0.90000000000000002 8.0000000000000002e-08 0 9.9900000000000014e-08 0 1.0000000000000001e-07 0 1.1990000000000001e-07 0 1.2000000000000002e-07 0 1.399e-07 0 1.4000000000000001e-07 0 1.599e-07 0 1.6e-07 0 1.7990000000000002e-07 0 1.8000000000000002e-07 0 1.9990000000000001e-07 0 2.0000000000000002e-07 0 2.199e-07 0 2.2000000000000001e-07 0.90000000000000002 2.3990000000000002e-07 0.90000000000000002 2.4000000000000003e-07 0]
VDgpn1 (d_gpn1 0) vsource type=pwl wave=[0 0 5.9900000000000014e-08 0 6.0000000000000008e-08 0 7.9900000000000007e-08 0 8.0000000000000002e-08 0.90000000000000002 9.9900000000000014e-08 0.90000000000000002 1.0000000000000001e-07 0 1.1990000000000001e-07 0 1.2000000000000002e-07 0 1.399e-07 0 1.4000000000000001e-07 0 1.599e-07 0 1.6e-07 0 1.7990000000000002e-07 0 1.8000000000000002e-07 0 1.9990000000000001e-07 0 2.0000000000000002e-07 0 2.199e-07 0 2.2000000000000001e-07 0.90000000000000002 2.3990000000000002e-07 0.90000000000000002 2.4000000000000003e-07 0]
VDgpn2 (d_gpn2 0) vsource type=pwl wave=[0 0 5.9900000000000014e-08 0 6.0000000000000008e-08 0 7.9900000000000007e-08 0 8.0000000000000002e-08 0 9.9900000000000014e-08 0 1.0000000000000001e-07 0.90000000000000002 1.1990000000000001e-07 0.90000000000000002 1.2000000000000002e-07 0 1.399e-07 0 1.4000000000000001e-07 0 1.599e-07 0 1.6e-07 0 1.7990000000000002e-07 0 1.8000000000000002e-07 0 1.9990000000000001e-07 0 2.0000000000000002e-07 0 2.199e-07 0 2.2000000000000001e-07 0.90000000000000002 2.3990000000000002e-07 0.90000000000000002 2.4000000000000003e-07 0]
VDgpn3 (d_gpn3 0) vsource type=pwl wave=[0 0 5.9900000000000014e-08 0 6.0000000000000008e-08 0 7.9900000000000007e-08 0 8.0000000000000002e-08 0 9.9900000000000014e-08 0 1.0000000000000001e-07 0 1.1990000000000001e-07 0 1.2000000000000002e-07 0.90000000000000002 1.399e-07 0.90000000000000002 1.4000000000000001e-07 0 1.599e-07 0 1.6e-07 0 1.7990000000000002e-07 0 1.8000000000000002e-07 0 1.9990000000000001e-07 0 2.0000000000000002e-07 0 2.199e-07 0 2.2000000000000001e-07 0.90000000000000002 2.3990000000000002e-07 0.90000000000000002 2.4000000000000003e-07 0]
VDgpn4 (d_gpn4 0) vsource type=pwl wave=[0 0 5.9900000000000014e-08 0 6.0000000000000008e-08 0 7.9900000000000007e-08 0 8.0000000000000002e-08 0 9.9900000000000014e-08 0 1.0000000000000001e-07 0 1.1990000000000001e-07 0 1.2000000000000002e-07 0 1.399e-07 0 1.4000000000000001e-07 0.90000000000000002 1.599e-07 0.90000000000000002 1.6e-07 0 1.7990000000000002e-07 0 1.8000000000000002e-07 0 1.9990000000000001e-07 0 2.0000000000000002e-07 0 2.199e-07 0 2.2000000000000001e-07 0.90000000000000002 2.3990000000000002e-07 0.90000000000000002 2.4000000000000003e-07 0]
VDgpn5 (d_gpn5 0) vsource type=pwl wave=[0 0 5.9900000000000014e-08 0 6.0000000000000008e-08 0 7.9900000000000007e-08 0 8.0000000000000002e-08 0 9.9900000000000014e-08 0 1.0000000000000001e-07 0 1.1990000000000001e-07 0 1.2000000000000002e-07 0 1.399e-07 0 1.4000000000000001e-07 0 1.599e-07 0 1.6e-07 0.90000000000000002 1.7990000000000002e-07 0.90000000000000002 1.8000000000000002e-07 0 1.9990000000000001e-07 0 2.0000000000000002e-07 0 2.199e-07 0 2.2000000000000001e-07 0.90000000000000002 2.3990000000000002e-07 0.90000000000000002 2.4000000000000003e-07 0]
VDgpn6 (d_gpn6 0) vsource type=pwl wave=[0 0 5.9900000000000014e-08 0 6.0000000000000008e-08 0 7.9900000000000007e-08 0 8.0000000000000002e-08 0 9.9900000000000014e-08 0 1.0000000000000001e-07 0 1.1990000000000001e-07 0 1.2000000000000002e-07 0 1.399e-07 0 1.4000000000000001e-07 0 1.599e-07 0 1.6e-07 0 1.7990000000000002e-07 0 1.8000000000000002e-07 0.90000000000000002 1.9990000000000001e-07 0.90000000000000002 2.0000000000000002e-07 0 2.199e-07 0 2.2000000000000001e-07 0.90000000000000002 2.3990000000000002e-07 0.90000000000000002 2.4000000000000003e-07 0]
VDgpn7 (d_gpn7 0) vsource type=pwl wave=[0 0 5.9900000000000014e-08 0 6.0000000000000008e-08 0 7.9900000000000007e-08 0 8.0000000000000002e-08 0 9.9900000000000014e-08 0 1.0000000000000001e-07 0 1.1990000000000001e-07 0 1.2000000000000002e-07 0 1.399e-07 0 1.4000000000000001e-07 0 1.599e-07 0 1.6e-07 0 1.7990000000000002e-07 0 1.8000000000000002e-07 0 1.9990000000000001e-07 0 2.0000000000000002e-07 0.90000000000000002 2.199e-07 0.90000000000000002 2.2000000000000001e-07 0.90000000000000002 2.3990000000000002e-07 0.90000000000000002 2.4000000000000003e-07 0]
VDgpp0 (d_gpp0 0) vsource type=pwl wave=[0 0 5.9900000000000014e-08 0 6.0000000000000008e-08 0.90000000000000002 7.9900000000000007e-08 0.90000000000000002 8.0000000000000002e-08 0 9.9900000000000014e-08 0 1.0000000000000001e-07 0 1.1990000000000001e-07 0 1.2000000000000002e-07 0 1.399e-07 0 1.4000000000000001e-07 0 1.599e-07 0 1.6e-07 0 1.7990000000000002e-07 0 1.8000000000000002e-07 0 1.9990000000000001e-07 0 2.0000000000000002e-07 0 2.199e-07 0 2.2000000000000001e-07 0.90000000000000002 2.3990000000000002e-07 0.90000000000000002 2.4000000000000003e-07 0]
VDgpp1 (d_gpp1 0) vsource type=pwl wave=[0 0 5.9900000000000014e-08 0 6.0000000000000008e-08 0 7.9900000000000007e-08 0 8.0000000000000002e-08 0.90000000000000002 9.9900000000000014e-08 0.90000000000000002 1.0000000000000001e-07 0 1.1990000000000001e-07 0 1.2000000000000002e-07 0 1.399e-07 0 1.4000000000000001e-07 0 1.599e-07 0 1.6e-07 0 1.7990000000000002e-07 0 1.8000000000000002e-07 0 1.9990000000000001e-07 0 2.0000000000000002e-07 0 2.199e-07 0 2.2000000000000001e-07 0.90000000000000002 2.3990000000000002e-07 0.90000000000000002 2.4000000000000003e-07 0]
VDgpp2 (d_gpp2 0) vsource type=pwl wave=[0 0 5.9900000000000014e-08 0 6.0000000000000008e-08 0 7.9900000000000007e-08 0 8.0000000000000002e-08 0 9.9900000000000014e-08 0 1.0000000000000001e-07 0.90000000000000002 1.1990000000000001e-07 0.90000000000000002 1.2000000000000002e-07 0 1.399e-07 0 1.4000000000000001e-07 0 1.599e-07 0 1.6e-07 0 1.7990000000000002e-07 0 1.8000000000000002e-07 0 1.9990000000000001e-07 0 2.0000000000000002e-07 0 2.199e-07 0 2.2000000000000001e-07 0.90000000000000002 2.3990000000000002e-07 0.90000000000000002 2.4000000000000003e-07 0]
VDgpp3 (d_gpp3 0) vsource type=pwl wave=[0 0 5.9900000000000014e-08 0 6.0000000000000008e-08 0 7.9900000000000007e-08 0 8.0000000000000002e-08 0 9.9900000000000014e-08 0 1.0000000000000001e-07 0 1.1990000000000001e-07 0 1.2000000000000002e-07 0.90000000000000002 1.399e-07 0.90000000000000002 1.4000000000000001e-07 0 1.599e-07 0 1.6e-07 0 1.7990000000000002e-07 0 1.8000000000000002e-07 0 1.9990000000000001e-07 0 2.0000000000000002e-07 0 2.199e-07 0 2.2000000000000001e-07 0.90000000000000002 2.3990000000000002e-07 0.90000000000000002 2.4000000000000003e-07 0]
VDgpp4 (d_gpp4 0) vsource type=pwl wave=[0 0 5.9900000000000014e-08 0 6.0000000000000008e-08 0 7.9900000000000007e-08 0 8.0000000000000002e-08 0 9.9900000000000014e-08 0 1.0000000000000001e-07 0 1.1990000000000001e-07 0 1.2000000000000002e-07 0 1.399e-07 0 1.4000000000000001e-07 0.90000000000000002 1.599e-07 0.90000000000000002 1.6e-07 0 1.7990000000000002e-07 0 1.8000000000000002e-07 0 1.9990000000000001e-07 0 2.0000000000000002e-07 0 2.199e-07 0 2.2000000000000001e-07 0.90000000000000002 2.3990000000000002e-07 0.90000000000000002 2.4000000000000003e-07 0]
VDgpp5 (d_gpp5 0) vsource type=pwl wave=[0 0 5.9900000000000014e-08 0 6.0000000000000008e-08 0 7.9900000000000007e-08 0 8.0000000000000002e-08 0 9.9900000000000014e-08 0 1.0000000000000001e-07 0 1.1990000000000001e-07 0 1.2000000000000002e-07 0 1.399e-07 0 1.4000000000000001e-07 0 1.599e-07 0 1.6e-07 0.90000000000000002 1.7990000000000002e-07 0.90000000000000002 1.8000000000000002e-07 0 1.9990000000000001e-07 0 2.0000000000000002e-07 0 2.199e-07 0 2.2000000000000001e-07 0.90000000000000002 2.3990000000000002e-07 0.90000000000000002 2.4000000000000003e-07 0]
VDgpp6 (d_gpp6 0) vsource type=pwl wave=[0 0 5.9900000000000014e-08 0 6.0000000000000008e-08 0 7.9900000000000007e-08 0 8.0000000000000002e-08 0 9.9900000000000014e-08 0 1.0000000000000001e-07 0 1.1990000000000001e-07 0 1.2000000000000002e-07 0 1.399e-07 0 1.4000000000000001e-07 0 1.599e-07 0 1.6e-07 0 1.7990000000000002e-07 0 1.8000000000000002e-07 0.90000000000000002 1.9990000000000001e-07 0.90000000000000002 2.0000000000000002e-07 0 2.199e-07 0 2.2000000000000001e-07 0.90000000000000002 2.3990000000000002e-07 0.90000000000000002 2.4000000000000003e-07 0]
VDgpp7 (d_gpp7 0) vsource type=pwl wave=[0 0 5.9900000000000014e-08 0 6.0000000000000008e-08 0 7.9900000000000007e-08 0 8.0000000000000002e-08 0 9.9900000000000014e-08 0 1.0000000000000001e-07 0 1.1990000000000001e-07 0 1.2000000000000002e-07 0 1.399e-07 0 1.4000000000000001e-07 0 1.599e-07 0 1.6e-07 0 1.7990000000000002e-07 0 1.8000000000000002e-07 0 1.9990000000000001e-07 0 2.0000000000000002e-07 0.90000000000000002 2.199e-07 0.90000000000000002 2.2000000000000001e-07 0.90000000000000002 2.3990000000000002e-07 0.90000000000000002 2.4000000000000003e-07 0]
XDAC (d_gnn0 d_gnn1 d_gnn2 d_gnn3 d_gnn4 d_gnn5 d_gnn6 d_gnn7 d_gnp0 d_gnp1 d_gnp2 d_gnp3 d_gnp4 d_gnp5 d_gnp6 d_gnp7 d_gpn0 d_gpn1 d_gpn2 d_gpn3 d_gpn4 d_gpn5 d_gpn6 d_gpn7 d_gpp0 d_gpp1 d_gpp2 d_gpp3 d_gpp4 d_gpp5 d_gpp6 d_gpp7 d_n d_p VDD! d_rn d_rp 0) sar8j_r1_cdac
VDRN (d_rns 0) vsource dc=0
VDRP (d_rps 0) vsource dc=0.9
RDRN (d_rns d_rn) resistor r=50
RDRP (d_rps d_rp) resistor r=50
CDRN (d_rn 0) capacitor c=4p
CDRP (d_rp 0) capacitor c=4p

// BEGIN SARADC RNL
// @RNL(author="saradc topology") {
// #VDPRE @SET-SYMBOL $VOLTAGE_SOURCE;
// #VDPRE @PLACE(-70,0) => @ORIENT("R0");
// #VDPRE @TEXT("VDPRE",key="name",size=1.3,halign="start") => @PLACE(-67,3);
// #VDPRE @TEXT("",key="value",size=0.9,halign="start") => @PLACE(-67,-4);
// #VDPRE @TEXT("",key="model");
// #VDCM @SET-SYMBOL $VOLTAGE_SOURCE;
// #VDCM @PLACE(-70,-33) => @ORIENT("R0");
// #VDCM @TEXT("VDCM",key="name",size=1.3,halign="start") => @PLACE(-67,-30);
// #VDCM @TEXT("",key="value",size=0.9,halign="start") => @PLACE(-67,-37);
// #VDCM @TEXT("",key="model");
// #VDgnn0 @SET-SYMBOL $VOLTAGE_SOURCE;
// #VDgnn0 @PLACE(-70,-66) => @ORIENT("R0");
// #VDgnn0 @TEXT("VDgnn0",key="name",size=1.3,halign="start") => @PLACE(-67,-63);
// #VDgnn0 @TEXT("",key="value",size=0.9,halign="start") => @PLACE(-67,-70);
// #VDgnn0 @TEXT("",key="model");
// #VDgnn1 @SET-SYMBOL $VOLTAGE_SOURCE;
// #VDgnn1 @PLACE(-70,-99) => @ORIENT("R0");
// #VDgnn1 @TEXT("VDgnn1",key="name",size=1.3,halign="start") => @PLACE(-67,-96);
// #VDgnn1 @TEXT("",key="value",size=0.9,halign="start") => @PLACE(-67,-103);
// #VDgnn1 @TEXT("",key="model");
// #VDgnn2 @SET-SYMBOL $VOLTAGE_SOURCE;
// #VDgnn2 @PLACE(-70,-132) => @ORIENT("R0");
// #VDgnn2 @TEXT("VDgnn2",key="name",size=1.3,halign="start") => @PLACE(-67,-129);
// #VDgnn2 @TEXT("",key="value",size=0.9,halign="start") => @PLACE(-67,-136);
// #VDgnn2 @TEXT("",key="model");
// #VDgnn3 @SET-SYMBOL $VOLTAGE_SOURCE;
// #VDgnn3 @PLACE(-70,-165) => @ORIENT("R0");
// #VDgnn3 @TEXT("VDgnn3",key="name",size=1.3,halign="start") => @PLACE(-67,-162);
// #VDgnn3 @TEXT("",key="value",size=0.9,halign="start") => @PLACE(-67,-169);
// #VDgnn3 @TEXT("",key="model");
// #VDgnn4 @SET-SYMBOL $VOLTAGE_SOURCE;
// #VDgnn4 @PLACE(-70,-198) => @ORIENT("R0");
// #VDgnn4 @TEXT("VDgnn4",key="name",size=1.3,halign="start") => @PLACE(-67,-195);
// #VDgnn4 @TEXT("",key="value",size=0.9,halign="start") => @PLACE(-67,-202);
// #VDgnn4 @TEXT("",key="model");
// #VDgnn5 @SET-SYMBOL $VOLTAGE_SOURCE;
// #VDgnn5 @PLACE(-70,-231) => @ORIENT("R0");
// #VDgnn5 @TEXT("VDgnn5",key="name",size=1.3,halign="start") => @PLACE(-67,-228);
// #VDgnn5 @TEXT("",key="value",size=0.9,halign="start") => @PLACE(-67,-235);
// #VDgnn5 @TEXT("",key="model");
// #VDgnn6 @SET-SYMBOL $VOLTAGE_SOURCE;
// #VDgnn6 @PLACE(-70,-264) => @ORIENT("R0");
// #VDgnn6 @TEXT("VDgnn6",key="name",size=1.3,halign="start") => @PLACE(-67,-261);
// #VDgnn6 @TEXT("",key="value",size=0.9,halign="start") => @PLACE(-67,-268);
// #VDgnn6 @TEXT("",key="model");
// #VDgnn7 @SET-SYMBOL $VOLTAGE_SOURCE;
// #VDgnn7 @PLACE(-70,-297) => @ORIENT("R0");
// #VDgnn7 @TEXT("VDgnn7",key="name",size=1.3,halign="start") => @PLACE(-67,-294);
// #VDgnn7 @TEXT("",key="value",size=0.9,halign="start") => @PLACE(-67,-301);
// #VDgnn7 @TEXT("",key="model");
// #VDgnp0 @SET-SYMBOL $VOLTAGE_SOURCE;
// #VDgnp0 @PLACE(-70,-330) => @ORIENT("R0");
// #VDgnp0 @TEXT("VDgnp0",key="name",size=1.3,halign="start") => @PLACE(-67,-327);
// #VDgnp0 @TEXT("",key="value",size=0.9,halign="start") => @PLACE(-67,-334);
// #VDgnp0 @TEXT("",key="model");
// #VDgnp1 @SET-SYMBOL $VOLTAGE_SOURCE;
// #VDgnp1 @PLACE(-70,-363) => @ORIENT("R0");
// #VDgnp1 @TEXT("VDgnp1",key="name",size=1.3,halign="start") => @PLACE(-67,-360);
// #VDgnp1 @TEXT("",key="value",size=0.9,halign="start") => @PLACE(-67,-367);
// #VDgnp1 @TEXT("",key="model");
// #VDgnp2 @SET-SYMBOL $VOLTAGE_SOURCE;
// #VDgnp2 @PLACE(-15,0) => @ORIENT("R0");
// #VDgnp2 @TEXT("VDgnp2",key="name",size=1.3,halign="start") => @PLACE(-12,3);
// #VDgnp2 @TEXT("",key="value",size=0.9,halign="start") => @PLACE(-12,-4);
// #VDgnp2 @TEXT("",key="model");
// #VDgnp3 @SET-SYMBOL $VOLTAGE_SOURCE;
// #VDgnp3 @PLACE(-15,-33) => @ORIENT("R0");
// #VDgnp3 @TEXT("VDgnp3",key="name",size=1.3,halign="start") => @PLACE(-12,-30);
// #VDgnp3 @TEXT("",key="value",size=0.9,halign="start") => @PLACE(-12,-37);
// #VDgnp3 @TEXT("",key="model");
// #VDgnp4 @SET-SYMBOL $VOLTAGE_SOURCE;
// #VDgnp4 @PLACE(-15,-66) => @ORIENT("R0");
// #VDgnp4 @TEXT("VDgnp4",key="name",size=1.3,halign="start") => @PLACE(-12,-63);
// #VDgnp4 @TEXT("",key="value",size=0.9,halign="start") => @PLACE(-12,-70);
// #VDgnp4 @TEXT("",key="model");
// #VDgnp5 @SET-SYMBOL $VOLTAGE_SOURCE;
// #VDgnp5 @PLACE(-15,-99) => @ORIENT("R0");
// #VDgnp5 @TEXT("VDgnp5",key="name",size=1.3,halign="start") => @PLACE(-12,-96);
// #VDgnp5 @TEXT("",key="value",size=0.9,halign="start") => @PLACE(-12,-103);
// #VDgnp5 @TEXT("",key="model");
// #VDgnp6 @SET-SYMBOL $VOLTAGE_SOURCE;
// #VDgnp6 @PLACE(-15,-132) => @ORIENT("R0");
// #VDgnp6 @TEXT("VDgnp6",key="name",size=1.3,halign="start") => @PLACE(-12,-129);
// #VDgnp6 @TEXT("",key="value",size=0.9,halign="start") => @PLACE(-12,-136);
// #VDgnp6 @TEXT("",key="model");
// #VDgnp7 @SET-SYMBOL $VOLTAGE_SOURCE;
// #VDgnp7 @PLACE(-15,-165) => @ORIENT("R0");
// #VDgnp7 @TEXT("VDgnp7",key="name",size=1.3,halign="start") => @PLACE(-12,-162);
// #VDgnp7 @TEXT("",key="value",size=0.9,halign="start") => @PLACE(-12,-169);
// #VDgnp7 @TEXT("",key="model");
// #VDgpn0 @SET-SYMBOL $VOLTAGE_SOURCE;
// #VDgpn0 @PLACE(-15,-198) => @ORIENT("R0");
// #VDgpn0 @TEXT("VDgpn0",key="name",size=1.3,halign="start") => @PLACE(-12,-195);
// #VDgpn0 @TEXT("",key="value",size=0.9,halign="start") => @PLACE(-12,-202);
// #VDgpn0 @TEXT("",key="model");
// #VDgpn1 @SET-SYMBOL $VOLTAGE_SOURCE;
// #VDgpn1 @PLACE(-15,-231) => @ORIENT("R0");
// #VDgpn1 @TEXT("VDgpn1",key="name",size=1.3,halign="start") => @PLACE(-12,-228);
// #VDgpn1 @TEXT("",key="value",size=0.9,halign="start") => @PLACE(-12,-235);
// #VDgpn1 @TEXT("",key="model");
// #VDgpn2 @SET-SYMBOL $VOLTAGE_SOURCE;
// #VDgpn2 @PLACE(-15,-264) => @ORIENT("R0");
// #VDgpn2 @TEXT("VDgpn2",key="name",size=1.3,halign="start") => @PLACE(-12,-261);
// #VDgpn2 @TEXT("",key="value",size=0.9,halign="start") => @PLACE(-12,-268);
// #VDgpn2 @TEXT("",key="model");
// #VDgpn3 @SET-SYMBOL $VOLTAGE_SOURCE;
// #VDgpn3 @PLACE(-15,-297) => @ORIENT("R0");
// #VDgpn3 @TEXT("VDgpn3",key="name",size=1.3,halign="start") => @PLACE(-12,-294);
// #VDgpn3 @TEXT("",key="value",size=0.9,halign="start") => @PLACE(-12,-301);
// #VDgpn3 @TEXT("",key="model");
// #VDgpn4 @SET-SYMBOL $VOLTAGE_SOURCE;
// #VDgpn4 @PLACE(-15,-330) => @ORIENT("R0");
// #VDgpn4 @TEXT("VDgpn4",key="name",size=1.3,halign="start") => @PLACE(-12,-327);
// #VDgpn4 @TEXT("",key="value",size=0.9,halign="start") => @PLACE(-12,-334);
// #VDgpn4 @TEXT("",key="model");
// #VDgpn5 @SET-SYMBOL $VOLTAGE_SOURCE;
// #VDgpn5 @PLACE(-15,-363) => @ORIENT("R0");
// #VDgpn5 @TEXT("VDgpn5",key="name",size=1.3,halign="start") => @PLACE(-12,-360);
// #VDgpn5 @TEXT("",key="value",size=0.9,halign="start") => @PLACE(-12,-367);
// #VDgpn5 @TEXT("",key="model");
// #VDgpn6 @SET-SYMBOL $VOLTAGE_SOURCE;
// #VDgpn6 @PLACE(40,0) => @ORIENT("R0");
// #VDgpn6 @TEXT("VDgpn6",key="name",size=1.3,halign="start") => @PLACE(43,3);
// #VDgpn6 @TEXT("",key="value",size=0.9,halign="start") => @PLACE(43,-4);
// #VDgpn6 @TEXT("",key="model");
// #VDgpn7 @SET-SYMBOL $VOLTAGE_SOURCE;
// #VDgpn7 @PLACE(40,-33) => @ORIENT("R0");
// #VDgpn7 @TEXT("VDgpn7",key="name",size=1.3,halign="start") => @PLACE(43,-30);
// #VDgpn7 @TEXT("",key="value",size=0.9,halign="start") => @PLACE(43,-37);
// #VDgpn7 @TEXT("",key="model");
// #VDgpp0 @SET-SYMBOL $VOLTAGE_SOURCE;
// #VDgpp0 @PLACE(40,-66) => @ORIENT("R0");
// #VDgpp0 @TEXT("VDgpp0",key="name",size=1.3,halign="start") => @PLACE(43,-63);
// #VDgpp0 @TEXT("",key="value",size=0.9,halign="start") => @PLACE(43,-70);
// #VDgpp0 @TEXT("",key="model");
// #VDgpp1 @SET-SYMBOL $VOLTAGE_SOURCE;
// #VDgpp1 @PLACE(40,-99) => @ORIENT("R0");
// #VDgpp1 @TEXT("VDgpp1",key="name",size=1.3,halign="start") => @PLACE(43,-96);
// #VDgpp1 @TEXT("",key="value",size=0.9,halign="start") => @PLACE(43,-103);
// #VDgpp1 @TEXT("",key="model");
// #VDgpp2 @SET-SYMBOL $VOLTAGE_SOURCE;
// #VDgpp2 @PLACE(40,-132) => @ORIENT("R0");
// #VDgpp2 @TEXT("VDgpp2",key="name",size=1.3,halign="start") => @PLACE(43,-129);
// #VDgpp2 @TEXT("",key="value",size=0.9,halign="start") => @PLACE(43,-136);
// #VDgpp2 @TEXT("",key="model");
// #VDgpp3 @SET-SYMBOL $VOLTAGE_SOURCE;
// #VDgpp3 @PLACE(40,-165) => @ORIENT("R0");
// #VDgpp3 @TEXT("VDgpp3",key="name",size=1.3,halign="start") => @PLACE(43,-162);
// #VDgpp3 @TEXT("",key="value",size=0.9,halign="start") => @PLACE(43,-169);
// #VDgpp3 @TEXT("",key="model");
// #VDgpp4 @SET-SYMBOL $VOLTAGE_SOURCE;
// #VDgpp4 @PLACE(40,-198) => @ORIENT("R0");
// #VDgpp4 @TEXT("VDgpp4",key="name",size=1.3,halign="start") => @PLACE(43,-195);
// #VDgpp4 @TEXT("",key="value",size=0.9,halign="start") => @PLACE(43,-202);
// #VDgpp4 @TEXT("",key="model");
// #VDgpp5 @SET-SYMBOL $VOLTAGE_SOURCE;
// #VDgpp5 @PLACE(40,-231) => @ORIENT("R0");
// #VDgpp5 @TEXT("VDgpp5",key="name",size=1.3,halign="start") => @PLACE(43,-228);
// #VDgpp5 @TEXT("",key="value",size=0.9,halign="start") => @PLACE(43,-235);
// #VDgpp5 @TEXT("",key="model");
// #VDgpp6 @SET-SYMBOL $VOLTAGE_SOURCE;
// #VDgpp6 @PLACE(40,-264) => @ORIENT("R0");
// #VDgpp6 @TEXT("VDgpp6",key="name",size=1.3,halign="start") => @PLACE(43,-261);
// #VDgpp6 @TEXT("",key="value",size=0.9,halign="start") => @PLACE(43,-268);
// #VDgpp6 @TEXT("",key="model");
// #VDgpp7 @SET-SYMBOL $VOLTAGE_SOURCE;
// #VDgpp7 @PLACE(40,-297) => @ORIENT("R0");
// #VDgpp7 @TEXT("VDgpp7",key="name",size=1.3,halign="start") => @PLACE(43,-294);
// #VDgpp7 @TEXT("",key="value",size=0.9,halign="start") => @PLACE(43,-301);
// #VDgpp7 @TEXT("",key="model");
// #VDRN @SET-SYMBOL $VOLTAGE_SOURCE;
// #VDRN @PLACE(40,-330) => @ORIENT("R0");
// #VDRN @TEXT("VDRN",key="name",size=1.3,halign="start") => @PLACE(43,-327);
// #VDRN @TEXT("",key="value",size=0.9,halign="start") => @PLACE(43,-334);
// #VDRN @TEXT("",key="model");
// #VDRP @SET-SYMBOL $VOLTAGE_SOURCE;
// #VDRP @PLACE(40,-363) => @ORIENT("R0");
// #VDRP @TEXT("VDRP",key="name",size=1.3,halign="start") => @PLACE(43,-360);
// #VDRP @TEXT("",key="value",size=0.9,halign="start") => @PLACE(43,-367);
// #VDRP @TEXT("",key="model");
// #XDPN @SET-SYMBOL $S_b_tb_switch;
// #XDPN @PLACE(0,0) => @ORIENT("R0");
// #XDPP @SET-SYMBOL $S_b_tb_switch;
// #XDPP @PLACE(0,-33) => @ORIENT("R0");
// #XDAC @SET-SYMBOL $S_sar8j_r1_cdac;
// #XDAC @PLACE(0,-66) => @ORIENT("R0");
// #RDRN @SET-SYMBOL $RESISTOR;
// #RDRN @PLACE(90,0) => @ORIENT("R0");
// #RDRN @TEXT("RDRN",key="name",size=1.3,halign="start") => @PLACE(93,3);
// #RDRN @TEXT("r=50",key="value",size=0.9,halign="start") => @PLACE(93,-4);
// #RDRN @TEXT("",key="model");
// #RDRP @SET-SYMBOL $RESISTOR;
// #RDRP @PLACE(90,-33) => @ORIENT("R0");
// #RDRP @TEXT("RDRP",key="name",size=1.3,halign="start") => @PLACE(93,-30);
// #RDRP @TEXT("r=50",key="value",size=0.9,halign="start") => @PLACE(93,-37);
// #RDRP @TEXT("",key="model");
// #CDRN @SET-SYMBOL $CAPACITOR;
// #CDRN @PLACE(90,-66) => @ORIENT("R0");
// #CDRN @TEXT("CDRN",key="name",size=1.3,halign="start") => @PLACE(93,-63);
// #CDRN @TEXT("c=4p",key="value",size=0.9,halign="start") => @PLACE(93,-70);
// #CDRN @TEXT("",key="model");
// #CDRP @SET-SYMBOL $CAPACITOR;
// #CDRP @PLACE(90,-99) => @ORIENT("R0");
// #CDRP @TEXT("CDRP",key="name",size=1.3,halign="start") => @PLACE(93,-96);
// #CDRP @TEXT("c=4p",key="value",size=0.9,halign="start") => @PLACE(93,-103);
// #CDRP @TEXT("",key="model");
// &"d_n" @WIRE(mode="straight",linecolor="#30485d",linewidth=0.16) {#XDPN:1 (0,3.3) (0,-64.35) #XDAC:33};
// &"d_p" @WIRE(mode="straight",linecolor="#30485d",linewidth=0.16) {#XDPP:1 (0,-29.7) (0,-67.65) #XDAC:34};
// (-89,30) @TEXT("tb_cdac / source-derived connections",size=1.4,halign="start",textcolor="#223d52");
// &"d_pre" @WIRE(mode="straight",linecolor="#30485d",linewidth=0.16) {#VDPRE:1 (-70,5)};
// (-70,5.4) @TEXT("d_pre",size=1.1,halign="middle",valign="bottom");
// &"0" @WIRE(mode="straight",linecolor="#30485d",linewidth=0.16) {#VDPRE:2 (-70,-5)};
// (-70,-5.4) @TEXT("0",size=1.1,halign="middle",valign="top");
// &"d_cm" @WIRE(mode="straight",linecolor="#30485d",linewidth=0.16) {#VDCM:1 (-70,-28)};
// (-70,-27.6) @TEXT("d_cm",size=1.1,halign="middle",valign="bottom");
// &"0" @WIRE(mode="straight",linecolor="#30485d",linewidth=0.16) {#VDCM:2 (-70,-38)};
// (-70,-38.4) @TEXT("0",size=1.1,halign="middle",valign="top");
// &"d_cm" @WIRE(mode="straight",linecolor="#30485d",linewidth=0.16) {#XDPN:2 (-16,0)};
// (-16.4,0) @TEXT("d_cm",size=1.1,halign="end",valign="middle");
// &"d_pre" @WIRE(mode="straight",linecolor="#30485d",linewidth=0.16) {#XDPN:3 (-16,-3.3)};
// (-16.4,-3.3) @TEXT("d_pre",size=1.1,halign="end",valign="middle");
// &"VDD!" @WIRE(mode="straight",linecolor="#30485d",linewidth=0.16) {#XDPN:4 (0,11.6)};
// (0,12) @TEXT("VDD!",size=1.1,halign="middle",valign="bottom");
// &"0" @WIRE(mode="straight",linecolor="#30485d",linewidth=0.16) {#XDPN:5 (0,-11.6)};
// (0,-12) @TEXT("0",size=1.1,halign="middle",valign="top");
// &"d_cm" @WIRE(mode="straight",linecolor="#30485d",linewidth=0.16) {#XDPP:2 (-16,-33)};
// (-16.4,-33) @TEXT("d_cm",size=1.1,halign="end",valign="middle");
// &"d_pre" @WIRE(mode="straight",linecolor="#30485d",linewidth=0.16) {#XDPP:3 (-16,-36.3)};
// (-16.4,-36.3) @TEXT("d_pre",size=1.1,halign="end",valign="middle");
// &"VDD!" @WIRE(mode="straight",linecolor="#30485d",linewidth=0.16) {#XDPP:4 (0,-21.4)};
// (0,-21) @TEXT("VDD!",size=1.1,halign="middle",valign="bottom");
// &"0" @WIRE(mode="straight",linecolor="#30485d",linewidth=0.16) {#XDPP:5 (0,-44.6)};
// (0,-45) @TEXT("0",size=1.1,halign="middle",valign="top");
// &"d_gnn0" @WIRE(mode="straight",linecolor="#30485d",linewidth=0.16) {#VDgnn0:1 (-70,-61)};
// (-70,-60.6) @TEXT("d_gnn0",size=1.1,halign="middle",valign="bottom");
// &"0" @WIRE(mode="straight",linecolor="#30485d",linewidth=0.16) {#VDgnn0:2 (-70,-71)};
// (-70,-71.4) @TEXT("0",size=1.1,halign="middle",valign="top");
// &"d_gnn1" @WIRE(mode="straight",linecolor="#30485d",linewidth=0.16) {#VDgnn1:1 (-70,-94)};
// (-70,-93.6) @TEXT("d_gnn1",size=1.1,halign="middle",valign="bottom");
// &"0" @WIRE(mode="straight",linecolor="#30485d",linewidth=0.16) {#VDgnn1:2 (-70,-104)};
// (-70,-104.4) @TEXT("0",size=1.1,halign="middle",valign="top");
// &"d_gnn2" @WIRE(mode="straight",linecolor="#30485d",linewidth=0.16) {#VDgnn2:1 (-70,-127)};
// (-70,-126.6) @TEXT("d_gnn2",size=1.1,halign="middle",valign="bottom");
// &"0" @WIRE(mode="straight",linecolor="#30485d",linewidth=0.16) {#VDgnn2:2 (-70,-137)};
// (-70,-137.4) @TEXT("0",size=1.1,halign="middle",valign="top");
// &"d_gnn3" @WIRE(mode="straight",linecolor="#30485d",linewidth=0.16) {#VDgnn3:1 (-70,-160)};
// (-70,-159.6) @TEXT("d_gnn3",size=1.1,halign="middle",valign="bottom");
// &"0" @WIRE(mode="straight",linecolor="#30485d",linewidth=0.16) {#VDgnn3:2 (-70,-170)};
// (-70,-170.4) @TEXT("0",size=1.1,halign="middle",valign="top");
// &"d_gnn4" @WIRE(mode="straight",linecolor="#30485d",linewidth=0.16) {#VDgnn4:1 (-70,-193)};
// (-70,-192.6) @TEXT("d_gnn4",size=1.1,halign="middle",valign="bottom");
// &"0" @WIRE(mode="straight",linecolor="#30485d",linewidth=0.16) {#VDgnn4:2 (-70,-203)};
// (-70,-203.4) @TEXT("0",size=1.1,halign="middle",valign="top");
// &"d_gnn5" @WIRE(mode="straight",linecolor="#30485d",linewidth=0.16) {#VDgnn5:1 (-70,-226)};
// (-70,-225.6) @TEXT("d_gnn5",size=1.1,halign="middle",valign="bottom");
// &"0" @WIRE(mode="straight",linecolor="#30485d",linewidth=0.16) {#VDgnn5:2 (-70,-236)};
// (-70,-236.4) @TEXT("0",size=1.1,halign="middle",valign="top");
// &"d_gnn6" @WIRE(mode="straight",linecolor="#30485d",linewidth=0.16) {#VDgnn6:1 (-70,-259)};
// (-70,-258.6) @TEXT("d_gnn6",size=1.1,halign="middle",valign="bottom");
// &"0" @WIRE(mode="straight",linecolor="#30485d",linewidth=0.16) {#VDgnn6:2 (-70,-269)};
// (-70,-269.4) @TEXT("0",size=1.1,halign="middle",valign="top");
// &"d_gnn7" @WIRE(mode="straight",linecolor="#30485d",linewidth=0.16) {#VDgnn7:1 (-70,-292)};
// (-70,-291.6) @TEXT("d_gnn7",size=1.1,halign="middle",valign="bottom");
// &"0" @WIRE(mode="straight",linecolor="#30485d",linewidth=0.16) {#VDgnn7:2 (-70,-302)};
// (-70,-302.4) @TEXT("0",size=1.1,halign="middle",valign="top");
// &"d_gnp0" @WIRE(mode="straight",linecolor="#30485d",linewidth=0.16) {#VDgnp0:1 (-70,-325)};
// (-70,-324.6) @TEXT("d_gnp0",size=1.1,halign="middle",valign="bottom");
// &"0" @WIRE(mode="straight",linecolor="#30485d",linewidth=0.16) {#VDgnp0:2 (-70,-335)};
// (-70,-335.4) @TEXT("0",size=1.1,halign="middle",valign="top");
// &"d_gnp1" @WIRE(mode="straight",linecolor="#30485d",linewidth=0.16) {#VDgnp1:1 (-70,-358)};
// (-70,-357.6) @TEXT("d_gnp1",size=1.1,halign="middle",valign="bottom");
// &"0" @WIRE(mode="straight",linecolor="#30485d",linewidth=0.16) {#VDgnp1:2 (-70,-368)};
// (-70,-368.4) @TEXT("0",size=1.1,halign="middle",valign="top");
// &"d_gnp2" @WIRE(mode="straight",linecolor="#30485d",linewidth=0.16) {#VDgnp2:1 (-15,5)};
// (-15,5.4) @TEXT("d_gnp2",size=1.1,halign="middle",valign="bottom");
// &"0" @WIRE(mode="straight",linecolor="#30485d",linewidth=0.16) {#VDgnp2:2 (-15,-5)};
// (-15,-5.4) @TEXT("0",size=1.1,halign="middle",valign="top");
// &"d_gnp3" @WIRE(mode="straight",linecolor="#30485d",linewidth=0.16) {#VDgnp3:1 (-15,-28)};
// (-15,-27.6) @TEXT("d_gnp3",size=1.1,halign="middle",valign="bottom");
// &"0" @WIRE(mode="straight",linecolor="#30485d",linewidth=0.16) {#VDgnp3:2 (-15,-38)};
// (-15,-38.4) @TEXT("0",size=1.1,halign="middle",valign="top");
// &"d_gnp4" @WIRE(mode="straight",linecolor="#30485d",linewidth=0.16) {#VDgnp4:1 (-15,-61)};
// (-15,-60.6) @TEXT("d_gnp4",size=1.1,halign="middle",valign="bottom");
// &"0" @WIRE(mode="straight",linecolor="#30485d",linewidth=0.16) {#VDgnp4:2 (-15,-71)};
// (-15,-71.4) @TEXT("0",size=1.1,halign="middle",valign="top");
// &"d_gnp5" @WIRE(mode="straight",linecolor="#30485d",linewidth=0.16) {#VDgnp5:1 (-15,-94)};
// (-15,-93.6) @TEXT("d_gnp5",size=1.1,halign="middle",valign="bottom");
// &"0" @WIRE(mode="straight",linecolor="#30485d",linewidth=0.16) {#VDgnp5:2 (-15,-104)};
// (-15,-104.4) @TEXT("0",size=1.1,halign="middle",valign="top");
// &"d_gnp6" @WIRE(mode="straight",linecolor="#30485d",linewidth=0.16) {#VDgnp6:1 (-15,-127)};
// (-15,-126.6) @TEXT("d_gnp6",size=1.1,halign="middle",valign="bottom");
// &"0" @WIRE(mode="straight",linecolor="#30485d",linewidth=0.16) {#VDgnp6:2 (-15,-137)};
// (-15,-137.4) @TEXT("0",size=1.1,halign="middle",valign="top");
// &"d_gnp7" @WIRE(mode="straight",linecolor="#30485d",linewidth=0.16) {#VDgnp7:1 (-15,-160)};
// (-15,-159.6) @TEXT("d_gnp7",size=1.1,halign="middle",valign="bottom");
// &"0" @WIRE(mode="straight",linecolor="#30485d",linewidth=0.16) {#VDgnp7:2 (-15,-170)};
// (-15,-170.4) @TEXT("0",size=1.1,halign="middle",valign="top");
// &"d_gpn0" @WIRE(mode="straight",linecolor="#30485d",linewidth=0.16) {#VDgpn0:1 (-15,-193)};
// (-15,-192.6) @TEXT("d_gpn0",size=1.1,halign="middle",valign="bottom");
// &"0" @WIRE(mode="straight",linecolor="#30485d",linewidth=0.16) {#VDgpn0:2 (-15,-203)};
// (-15,-203.4) @TEXT("0",size=1.1,halign="middle",valign="top");
// &"d_gpn1" @WIRE(mode="straight",linecolor="#30485d",linewidth=0.16) {#VDgpn1:1 (-15,-226)};
// (-15,-225.6) @TEXT("d_gpn1",size=1.1,halign="middle",valign="bottom");
// &"0" @WIRE(mode="straight",linecolor="#30485d",linewidth=0.16) {#VDgpn1:2 (-15,-236)};
// (-15,-236.4) @TEXT("0",size=1.1,halign="middle",valign="top");
// &"d_gpn2" @WIRE(mode="straight",linecolor="#30485d",linewidth=0.16) {#VDgpn2:1 (-15,-259)};
// (-15,-258.6) @TEXT("d_gpn2",size=1.1,halign="middle",valign="bottom");
// &"0" @WIRE(mode="straight",linecolor="#30485d",linewidth=0.16) {#VDgpn2:2 (-15,-269)};
// (-15,-269.4) @TEXT("0",size=1.1,halign="middle",valign="top");
// &"d_gpn3" @WIRE(mode="straight",linecolor="#30485d",linewidth=0.16) {#VDgpn3:1 (-15,-292)};
// (-15,-291.6) @TEXT("d_gpn3",size=1.1,halign="middle",valign="bottom");
// &"0" @WIRE(mode="straight",linecolor="#30485d",linewidth=0.16) {#VDgpn3:2 (-15,-302)};
// (-15,-302.4) @TEXT("0",size=1.1,halign="middle",valign="top");
// &"d_gpn4" @WIRE(mode="straight",linecolor="#30485d",linewidth=0.16) {#VDgpn4:1 (-15,-325)};
// (-15,-324.6) @TEXT("d_gpn4",size=1.1,halign="middle",valign="bottom");
// &"0" @WIRE(mode="straight",linecolor="#30485d",linewidth=0.16) {#VDgpn4:2 (-15,-335)};
// (-15,-335.4) @TEXT("0",size=1.1,halign="middle",valign="top");
// &"d_gpn5" @WIRE(mode="straight",linecolor="#30485d",linewidth=0.16) {#VDgpn5:1 (-15,-358)};
// (-15,-357.6) @TEXT("d_gpn5",size=1.1,halign="middle",valign="bottom");
// &"0" @WIRE(mode="straight",linecolor="#30485d",linewidth=0.16) {#VDgpn5:2 (-15,-368)};
// (-15,-368.4) @TEXT("0",size=1.1,halign="middle",valign="top");
// &"d_gpn6" @WIRE(mode="straight",linecolor="#30485d",linewidth=0.16) {#VDgpn6:1 (40,5)};
// (40,5.4) @TEXT("d_gpn6",size=1.1,halign="middle",valign="bottom");
// &"0" @WIRE(mode="straight",linecolor="#30485d",linewidth=0.16) {#VDgpn6:2 (40,-5)};
// (40,-5.4) @TEXT("0",size=1.1,halign="middle",valign="top");
// &"d_gpn7" @WIRE(mode="straight",linecolor="#30485d",linewidth=0.16) {#VDgpn7:1 (40,-28)};
// (40,-27.6) @TEXT("d_gpn7",size=1.1,halign="middle",valign="bottom");
// &"0" @WIRE(mode="straight",linecolor="#30485d",linewidth=0.16) {#VDgpn7:2 (40,-38)};
// (40,-38.4) @TEXT("0",size=1.1,halign="middle",valign="top");
// &"d_gpp0" @WIRE(mode="straight",linecolor="#30485d",linewidth=0.16) {#VDgpp0:1 (40,-61)};
// (40,-60.6) @TEXT("d_gpp0",size=1.1,halign="middle",valign="bottom");
// &"0" @WIRE(mode="straight",linecolor="#30485d",linewidth=0.16) {#VDgpp0:2 (40,-71)};
// (40,-71.4) @TEXT("0",size=1.1,halign="middle",valign="top");
// &"d_gpp1" @WIRE(mode="straight",linecolor="#30485d",linewidth=0.16) {#VDgpp1:1 (40,-94)};
// (40,-93.6) @TEXT("d_gpp1",size=1.1,halign="middle",valign="bottom");
// &"0" @WIRE(mode="straight",linecolor="#30485d",linewidth=0.16) {#VDgpp1:2 (40,-104)};
// (40,-104.4) @TEXT("0",size=1.1,halign="middle",valign="top");
// &"d_gpp2" @WIRE(mode="straight",linecolor="#30485d",linewidth=0.16) {#VDgpp2:1 (40,-127)};
// (40,-126.6) @TEXT("d_gpp2",size=1.1,halign="middle",valign="bottom");
// &"0" @WIRE(mode="straight",linecolor="#30485d",linewidth=0.16) {#VDgpp2:2 (40,-137)};
// (40,-137.4) @TEXT("0",size=1.1,halign="middle",valign="top");
// &"d_gpp3" @WIRE(mode="straight",linecolor="#30485d",linewidth=0.16) {#VDgpp3:1 (40,-160)};
// (40,-159.6) @TEXT("d_gpp3",size=1.1,halign="middle",valign="bottom");
// &"0" @WIRE(mode="straight",linecolor="#30485d",linewidth=0.16) {#VDgpp3:2 (40,-170)};
// (40,-170.4) @TEXT("0",size=1.1,halign="middle",valign="top");
// &"d_gpp4" @WIRE(mode="straight",linecolor="#30485d",linewidth=0.16) {#VDgpp4:1 (40,-193)};
// (40,-192.6) @TEXT("d_gpp4",size=1.1,halign="middle",valign="bottom");
// &"0" @WIRE(mode="straight",linecolor="#30485d",linewidth=0.16) {#VDgpp4:2 (40,-203)};
// (40,-203.4) @TEXT("0",size=1.1,halign="middle",valign="top");
// &"d_gpp5" @WIRE(mode="straight",linecolor="#30485d",linewidth=0.16) {#VDgpp5:1 (40,-226)};
// (40,-225.6) @TEXT("d_gpp5",size=1.1,halign="middle",valign="bottom");
// &"0" @WIRE(mode="straight",linecolor="#30485d",linewidth=0.16) {#VDgpp5:2 (40,-236)};
// (40,-236.4) @TEXT("0",size=1.1,halign="middle",valign="top");
// &"d_gpp6" @WIRE(mode="straight",linecolor="#30485d",linewidth=0.16) {#VDgpp6:1 (40,-259)};
// (40,-258.6) @TEXT("d_gpp6",size=1.1,halign="middle",valign="bottom");
// &"0" @WIRE(mode="straight",linecolor="#30485d",linewidth=0.16) {#VDgpp6:2 (40,-269)};
// (40,-269.4) @TEXT("0",size=1.1,halign="middle",valign="top");
// &"d_gpp7" @WIRE(mode="straight",linecolor="#30485d",linewidth=0.16) {#VDgpp7:1 (40,-292)};
// (40,-291.6) @TEXT("d_gpp7",size=1.1,halign="middle",valign="bottom");
// &"0" @WIRE(mode="straight",linecolor="#30485d",linewidth=0.16) {#VDgpp7:2 (40,-302)};
// (40,-302.4) @TEXT("0",size=1.1,halign="middle",valign="top");
// {&"d_gnn0" &"d_gnn1" &"d_gnn2" &"d_gnn3" &"d_gnn4" &"d_gnn5" &"d_gnn6" &"d_gnn7"} @WIRE(mode="straight",linewidth=0.3) {#XDAC:1 (-16,-57.75)};
// (-16.4,-57.75) @TEXT("d_gnn[7:0]",size=1.1,halign="end",valign="middle");
// {&"d_gnp0" &"d_gnp1" &"d_gnp2" &"d_gnp3" &"d_gnp4" &"d_gnp5" &"d_gnp6" &"d_gnp7"} @WIRE(mode="straight",linewidth=0.3) {#XDAC:9 (-16,-61.05)};
// (-16.4,-61.05) @TEXT("d_gnp[7:0]",size=1.1,halign="end",valign="middle");
// {&"d_gpn0" &"d_gpn1" &"d_gpn2" &"d_gpn3" &"d_gpn4" &"d_gpn5" &"d_gpn6" &"d_gpn7"} @WIRE(mode="straight",linewidth=0.3) {#XDAC:17 (-16,-64.35)};
// (-16.4,-64.35) @TEXT("d_gpn[7:0]",size=1.1,halign="end",valign="middle");
// {&"d_gpp0" &"d_gpp1" &"d_gpp2" &"d_gpp3" &"d_gpp4" &"d_gpp5" &"d_gpp6" &"d_gpp7"} @WIRE(mode="straight",linewidth=0.3) {#XDAC:25 (-16,-67.65)};
// (-16.4,-67.65) @TEXT("d_gpp[7:0]",size=1.1,halign="end",valign="middle");
// &"VDD!" @WIRE(mode="straight",linecolor="#30485d",linewidth=0.16) {#XDAC:35 (0,-49.45)};
// (0,-49.05) @TEXT("VDD!",size=1.1,halign="middle",valign="bottom");
// &"d_rn" @WIRE(mode="straight",linecolor="#30485d",linewidth=0.16) {#XDAC:36 (-16,-70.95)};
// (-16.4,-70.95) @TEXT("d_rn",size=1.1,halign="end",valign="middle");
// &"d_rp" @WIRE(mode="straight",linecolor="#30485d",linewidth=0.16) {#XDAC:37 (-16,-74.25)};
// (-16.4,-74.25) @TEXT("d_rp",size=1.1,halign="end",valign="middle");
// &"0" @WIRE(mode="straight",linecolor="#30485d",linewidth=0.16) {#XDAC:38 (0,-82.55)};
// (0,-82.95) @TEXT("0",size=1.1,halign="middle",valign="top");
// &"d_rns" @WIRE(mode="straight",linecolor="#30485d",linewidth=0.16) {#VDRN:1 (40,-325)};
// (40,-324.6) @TEXT("d_rns",size=1.1,halign="middle",valign="bottom");
// &"0" @WIRE(mode="straight",linecolor="#30485d",linewidth=0.16) {#VDRN:2 (40,-335)};
// (40,-335.4) @TEXT("0",size=1.1,halign="middle",valign="top");
// &"d_rps" @WIRE(mode="straight",linecolor="#30485d",linewidth=0.16) {#VDRP:1 (40,-358)};
// (40,-357.6) @TEXT("d_rps",size=1.1,halign="middle",valign="bottom");
// &"0" @WIRE(mode="straight",linecolor="#30485d",linewidth=0.16) {#VDRP:2 (40,-368)};
// (40,-368.4) @TEXT("0",size=1.1,halign="middle",valign="top");
// &"d_rns" @WIRE(mode="straight",linecolor="#30485d",linewidth=0.16) {#RDRN:1 (90,5)};
// (90,5.4) @TEXT("d_rns",size=1.1,halign="middle",valign="bottom");
// &"d_rn" @WIRE(mode="straight",linecolor="#30485d",linewidth=0.16) {#RDRN:2 (90,-5)};
// (90,-5.4) @TEXT("d_rn",size=1.1,halign="middle",valign="top");
// &"d_rps" @WIRE(mode="straight",linecolor="#30485d",linewidth=0.16) {#RDRP:1 (90,-28)};
// (90,-27.6) @TEXT("d_rps",size=1.1,halign="middle",valign="bottom");
// &"d_rp" @WIRE(mode="straight",linecolor="#30485d",linewidth=0.16) {#RDRP:2 (90,-38)};
// (90,-38.4) @TEXT("d_rp",size=1.1,halign="middle",valign="top");
// &"d_rn" @WIRE(mode="straight",linecolor="#30485d",linewidth=0.16) {#CDRN:1 (90,-61)};
// (90,-60.6) @TEXT("d_rn",size=1.1,halign="middle",valign="bottom");
// &"0" @WIRE(mode="straight",linecolor="#30485d",linewidth=0.16) {#CDRN:2 (90,-71)};
// (90,-71.4) @TEXT("0",size=1.1,halign="middle",valign="top");
// &"d_rp" @WIRE(mode="straight",linecolor="#30485d",linewidth=0.16) {#CDRP:1 (90,-94)};
// (90,-93.6) @TEXT("d_rp",size=1.1,halign="middle",valign="bottom");
// &"0" @WIRE(mode="straight",linecolor="#30485d",linewidth=0.16) {#CDRP:2 (90,-104)};
// (90,-104.4) @TEXT("0",size=1.1,halign="middle",valign="top");
// }
// END SARADC RNL
ends tb_cdac

subckt tb_comparator
// Comparator delay/reset at stated differential inputs; native MOM plus receiver gate loads.
VCCLOCK (c_clock 0) vsource type=pulse val0=0 val1=0.9 delay=5n rise=100p fall=100p width=4.9n period=10n
VCN (c_n 0) vsource dc=0.45
VCP (c_p 0) vsource type=pwl wave=[0 0.55000000000000004 9.900000000000001e-09 0.55000000000000004 1e-08 0.34999999999999998 1.99e-08 0.34999999999999998 2e-08 0.47999999999999998 2.9900000000000003e-08 0.47999999999999998 3.0000000000000004e-08 0.42000000000000004 3.99e-08 0.42000000000000004 4.0000000000000001e-08 0.45351562500000003 4.9899999999999997e-08 0.45351562500000003 4.9999999999999998e-08 0.44648437499999999 5.9900000000000014e-08 0.44648437499999999 6.0000000000000008e-08 0.45100000000000001 6.990000000000001e-08 0.45100000000000001 7.0000000000000005e-08 0.44900000000000001 7.9900000000000007e-08 0.44900000000000001 8.0000000000000002e-08 0.4501 8.9900000000000004e-08 0.4501 8.9999999999999999e-08 0.44990000000000002]
XCOMP (c_clock c_outn c_outp VDD! c_n c_p 0) sar_strongarm_t28
CCN (c_outn 0) cfmom_2t nr=8 lr=2.5u w=50n s=50n stm=1 spm=3 multi=2 mismatchflag=1
CCP (c_outp 0) cfmom_2t nr=8 lr=2.5u w=50n s=50n stm=1 spm=3 multi=2 mismatchflag=1
XCRN (c_outn VDD! 0 c_unusedn) sar8p_inv
XCRP (c_outp VDD! 0 c_unusedp) sar8p_inv
// Independent floating-input kickback fixture, same nominal CDAC-side MOM geometry.
VKINIT (k_init 0) vsource type=pwl wave=[0 0.9 10n 0.9 10.1n 0]
VKP (k_sp 0) vsource dc=0.4505
VKN (k_sn 0) vsource dc=0.4495
XKP (k_p k_sp k_init VDD! 0) b_tb_switch
XKN (k_n k_sn k_init VDD! 0) b_tb_switch
CKP (k_p 0) cfmom_2t nr=8 lr=2u w=50n s=50n stm=1 spm=3 multi=256 mismatchflag=1
CKN (k_n 0) cfmom_2t nr=8 lr=2u w=50n s=50n stm=1 spm=3 multi=256 mismatchflag=1
VKC (k_clock 0) vsource type=pulse val0=0 val1=0.9 delay=15n rise=100p fall=100p width=4.9n period=1000n
XKCOMP (k_clock k_outn k_outp VDD! k_n k_p 0) sar_strongarm_t28
CKON (k_outn 0) capacitor c=10f
CKOP (k_outp 0) capacitor c=10f

// BEGIN SARADC RNL
// @RNL(author="saradc topology") {
// #VCCLOCK @SET-SYMBOL $VOLTAGE_SOURCE;
// #VCCLOCK @PLACE(-70,0) => @ORIENT("R0");
// #VCCLOCK @TEXT("VCCLOCK",key="name",size=1.3,halign="start") => @PLACE(-67,3);
// #VCCLOCK @TEXT("",key="value",size=0.9,halign="start") => @PLACE(-67,-4);
// #VCCLOCK @TEXT("",key="model");
// #VCN @SET-SYMBOL $VOLTAGE_SOURCE;
// #VCN @PLACE(-70,-33) => @ORIENT("R0");
// #VCN @TEXT("VCN",key="name",size=1.3,halign="start") => @PLACE(-67,-30);
// #VCN @TEXT("",key="value",size=0.9,halign="start") => @PLACE(-67,-37);
// #VCN @TEXT("",key="model");
// #VCP @SET-SYMBOL $VOLTAGE_SOURCE;
// #VCP @PLACE(-70,-66) => @ORIENT("R0");
// #VCP @TEXT("VCP",key="name",size=1.3,halign="start") => @PLACE(-67,-63);
// #VCP @TEXT("",key="value",size=0.9,halign="start") => @PLACE(-67,-70);
// #VCP @TEXT("",key="model");
// #VKINIT @SET-SYMBOL $VOLTAGE_SOURCE;
// #VKINIT @PLACE(-70,-99) => @ORIENT("R0");
// #VKINIT @TEXT("VKINIT",key="name",size=1.3,halign="start") => @PLACE(-67,-96);
// #VKINIT @TEXT("",key="value",size=0.9,halign="start") => @PLACE(-67,-103);
// #VKINIT @TEXT("",key="model");
// #VKP @SET-SYMBOL $VOLTAGE_SOURCE;
// #VKP @PLACE(-70,-132) => @ORIENT("R0");
// #VKP @TEXT("VKP",key="name",size=1.3,halign="start") => @PLACE(-67,-129);
// #VKP @TEXT("",key="value",size=0.9,halign="start") => @PLACE(-67,-136);
// #VKP @TEXT("",key="model");
// #VKN @SET-SYMBOL $VOLTAGE_SOURCE;
// #VKN @PLACE(-70,-165) => @ORIENT("R0");
// #VKN @TEXT("VKN",key="name",size=1.3,halign="start") => @PLACE(-67,-162);
// #VKN @TEXT("",key="value",size=0.9,halign="start") => @PLACE(-67,-169);
// #VKN @TEXT("",key="model");
// #VKC @SET-SYMBOL $VOLTAGE_SOURCE;
// #VKC @PLACE(-70,-198) => @ORIENT("R0");
// #VKC @TEXT("VKC",key="name",size=1.3,halign="start") => @PLACE(-67,-195);
// #VKC @TEXT("",key="value",size=0.9,halign="start") => @PLACE(-67,-202);
// #VKC @TEXT("",key="model");
// #XCOMP @SET-SYMBOL $S_sar_strongarm_t28;
// #XCOMP @PLACE(0,0) => @ORIENT("R0");
// #XCRN @SET-SYMBOL $S_sar8p_inv;
// #XCRN @PLACE(0,-33) => @ORIENT("R0");
// #XCRP @SET-SYMBOL $S_sar8p_inv;
// #XCRP @PLACE(0,-66) => @ORIENT("R0");
// #XKP @SET-SYMBOL $S_b_tb_switch;
// #XKP @PLACE(0,-99) => @ORIENT("R0");
// #XKN @SET-SYMBOL $S_b_tb_switch;
// #XKN @PLACE(0,-132) => @ORIENT("R0");
// #XKCOMP @SET-SYMBOL $S_sar_strongarm_t28;
// #XKCOMP @PLACE(0,-165) => @ORIENT("R0");
// #CCN @SET-SYMBOL $CAPACITOR;
// #CCN @PLACE(90,0) => @ORIENT("R0");
// #CCN @TEXT("CCN",key="name",size=1.3,halign="start") => @PLACE(93,3);
// #CCN @TEXT("nr=8 lr=2.5u w=50n multi=2",key="value",size=0.9,halign="start") => @PLACE(93,-4);
// #CCN @TEXT("",key="model");
// #CCP @SET-SYMBOL $CAPACITOR;
// #CCP @PLACE(90,-33) => @ORIENT("R0");
// #CCP @TEXT("CCP",key="name",size=1.3,halign="start") => @PLACE(93,-30);
// #CCP @TEXT("nr=8 lr=2.5u w=50n multi=2",key="value",size=0.9,halign="start") => @PLACE(93,-37);
// #CCP @TEXT("",key="model");
// #CKP @SET-SYMBOL $CAPACITOR;
// #CKP @PLACE(90,-66) => @ORIENT("R0");
// #CKP @TEXT("CKP",key="name",size=1.3,halign="start") => @PLACE(93,-63);
// #CKP @TEXT("nr=8 lr=2u w=50n multi=256",key="value",size=0.9,halign="start") => @PLACE(93,-70);
// #CKP @TEXT("",key="model");
// #CKN @SET-SYMBOL $CAPACITOR;
// #CKN @PLACE(90,-99) => @ORIENT("R0");
// #CKN @TEXT("CKN",key="name",size=1.3,halign="start") => @PLACE(93,-96);
// #CKN @TEXT("nr=8 lr=2u w=50n multi=256",key="value",size=0.9,halign="start") => @PLACE(93,-103);
// #CKN @TEXT("",key="model");
// #CKON @SET-SYMBOL $CAPACITOR;
// #CKON @PLACE(90,-132) => @ORIENT("R0");
// #CKON @TEXT("CKON",key="name",size=1.3,halign="start") => @PLACE(93,-129);
// #CKON @TEXT("c=10f",key="value",size=0.9,halign="start") => @PLACE(93,-136);
// #CKON @TEXT("",key="model");
// #CKOP @SET-SYMBOL $CAPACITOR;
// #CKOP @PLACE(90,-165) => @ORIENT("R0");
// #CKOP @TEXT("CKOP",key="name",size=1.3,halign="start") => @PLACE(93,-162);
// #CKOP @TEXT("c=10f",key="value",size=0.9,halign="start") => @PLACE(93,-169);
// #CKOP @TEXT("",key="model");
// &"c_clock" @WIRE(mode="straight",linecolor="#30485d",linewidth=0.16) {#VCCLOCK:1 (-41.5,2) (-41.5,3.3) #XCOMP:1};
// &"c_n" @WIRE(mode="straight",linecolor="#30485d",linewidth=0.16) {#VCN:1 (-41.5,-31) (-41.5,0) #XCOMP:5};
// &"c_p" @WIRE(mode="straight",linecolor="#30485d",linewidth=0.16) {#VCP:1 (-41.5,-64) (-41.5,-3.3) #XCOMP:6};
// &"k_sp" @WIRE(mode="straight",linecolor="#30485d",linewidth=0.16) {#VKP:1 (-41.5,-130) (-41.5,-99) #XKP:2};
// &"k_sn" @WIRE(mode="straight",linecolor="#30485d",linewidth=0.16) {#VKN:1 (-41.5,-163) (-41.5,-132) #XKN:2};
// &"k_clock" @WIRE(mode="straight",linecolor="#30485d",linewidth=0.16) {#VKC:1 (-41.5,-196) (-41.5,-161.7) #XKCOMP:1};
// &"k_outn" @WIRE(mode="straight",linecolor="#30485d",linewidth=0.16) {#XKCOMP:2 (51.5,-163.35) (51.5,-130) #CKON:1};
// &"k_outp" @WIRE(mode="straight",linecolor="#30485d",linewidth=0.16) {#XKCOMP:3 (51.5,-166.65) (51.5,-163) #CKOP:1};
// (-89,30) @TEXT("tb_comparator / source-derived connections",size=1.4,halign="start",textcolor="#223d52");
// &"0" @WIRE(mode="straight",linecolor="#30485d",linewidth=0.16) {#VCCLOCK:2 (-70,-5)};
// (-70,-5.4) @TEXT("0",size=1.1,halign="middle",valign="top");
// &"0" @WIRE(mode="straight",linecolor="#30485d",linewidth=0.16) {#VCN:2 (-70,-38)};
// (-70,-38.4) @TEXT("0",size=1.1,halign="middle",valign="top");
// &"0" @WIRE(mode="straight",linecolor="#30485d",linewidth=0.16) {#VCP:2 (-70,-71)};
// (-70,-71.4) @TEXT("0",size=1.1,halign="middle",valign="top");
// &"c_outn" @WIRE(mode="straight",linecolor="#30485d",linewidth=0.16) {#XCOMP:2 (16,1.65)};
// (16.4,1.65) @TEXT("c_outn",size=1.1,halign="start",valign="middle");
// &"c_outp" @WIRE(mode="straight",linecolor="#30485d",linewidth=0.16) {#XCOMP:3 (16,-1.65)};
// (16.4,-1.65) @TEXT("c_outp",size=1.1,halign="start",valign="middle");
// &"VDD!" @WIRE(mode="straight",linecolor="#30485d",linewidth=0.16) {#XCOMP:4 (0,11.6)};
// (0,12) @TEXT("VDD!",size=1.1,halign="middle",valign="bottom");
// &"0" @WIRE(mode="straight",linecolor="#30485d",linewidth=0.16) {#XCOMP:7 (0,-11.6)};
// (0,-12) @TEXT("0",size=1.1,halign="middle",valign="top");
// &"c_outn" @WIRE(mode="straight",linecolor="#30485d",linewidth=0.16) {#CCN:1 (90,5)};
// (90,5.4) @TEXT("c_outn",size=1.1,halign="middle",valign="bottom");
// &"0" @WIRE(mode="straight",linecolor="#30485d",linewidth=0.16) {#CCN:2 (90,-5)};
// (90,-5.4) @TEXT("0",size=1.1,halign="middle",valign="top");
// &"c_outp" @WIRE(mode="straight",linecolor="#30485d",linewidth=0.16) {#CCP:1 (90,-28)};
// (90,-27.6) @TEXT("c_outp",size=1.1,halign="middle",valign="bottom");
// &"0" @WIRE(mode="straight",linecolor="#30485d",linewidth=0.16) {#CCP:2 (90,-38)};
// (90,-38.4) @TEXT("0",size=1.1,halign="middle",valign="top");
// &"c_outn" @WIRE(mode="straight",linecolor="#30485d",linewidth=0.16) {#XCRN:1 (-10,-33)};
// (-10.4,-33) @TEXT("c_outn",size=1.1,halign="end",valign="middle");
// &"VDD!" @WIRE(mode="straight",linecolor="#30485d",linewidth=0.16) {#XCRN:2 (0,-23)};
// (0,-22.6) @TEXT("VDD!",size=1.1,halign="middle",valign="bottom");
// &"0" @WIRE(mode="straight",linecolor="#30485d",linewidth=0.16) {#XCRN:3 (0,-43)};
// (0,-43.4) @TEXT("0",size=1.1,halign="middle",valign="top");
// &"c_unusedn" @WIRE(mode="straight",linecolor="#30485d",linewidth=0.16) {#XCRN:4 (10,-33)};
// (10.4,-33) @TEXT("c_unusedn",size=1.1,halign="start",valign="middle");
// &"c_outp" @WIRE(mode="straight",linecolor="#30485d",linewidth=0.16) {#XCRP:1 (-10,-66)};
// (-10.4,-66) @TEXT("c_outp",size=1.1,halign="end",valign="middle");
// &"VDD!" @WIRE(mode="straight",linecolor="#30485d",linewidth=0.16) {#XCRP:2 (0,-56)};
// (0,-55.6) @TEXT("VDD!",size=1.1,halign="middle",valign="bottom");
// &"0" @WIRE(mode="straight",linecolor="#30485d",linewidth=0.16) {#XCRP:3 (0,-76)};
// (0,-76.4) @TEXT("0",size=1.1,halign="middle",valign="top");
// &"c_unusedp" @WIRE(mode="straight",linecolor="#30485d",linewidth=0.16) {#XCRP:4 (10,-66)};
// (10.4,-66) @TEXT("c_unusedp",size=1.1,halign="start",valign="middle");
// &"k_init" @WIRE(mode="straight",linecolor="#30485d",linewidth=0.16) {#VKINIT:1 (-70,-94)};
// (-70,-93.6) @TEXT("k_init",size=1.1,halign="middle",valign="bottom");
// &"0" @WIRE(mode="straight",linecolor="#30485d",linewidth=0.16) {#VKINIT:2 (-70,-104)};
// (-70,-104.4) @TEXT("0",size=1.1,halign="middle",valign="top");
// &"0" @WIRE(mode="straight",linecolor="#30485d",linewidth=0.16) {#VKP:2 (-70,-137)};
// (-70,-137.4) @TEXT("0",size=1.1,halign="middle",valign="top");
// &"0" @WIRE(mode="straight",linecolor="#30485d",linewidth=0.16) {#VKN:2 (-70,-170)};
// (-70,-170.4) @TEXT("0",size=1.1,halign="middle",valign="top");
// &"k_p" @WIRE(mode="straight",linecolor="#30485d",linewidth=0.16) {#XKP:1 (-16,-95.7)};
// (-16.4,-95.7) @TEXT("k_p",size=1.1,halign="end",valign="middle");
// &"k_init" @WIRE(mode="straight",linecolor="#30485d",linewidth=0.16) {#XKP:3 (-16,-102.3)};
// (-16.4,-102.3) @TEXT("k_init",size=1.1,halign="end",valign="middle");
// &"VDD!" @WIRE(mode="straight",linecolor="#30485d",linewidth=0.16) {#XKP:4 (0,-87.4)};
// (0,-87) @TEXT("VDD!",size=1.1,halign="middle",valign="bottom");
// &"0" @WIRE(mode="straight",linecolor="#30485d",linewidth=0.16) {#XKP:5 (0,-110.6)};
// (0,-111) @TEXT("0",size=1.1,halign="middle",valign="top");
// &"k_n" @WIRE(mode="straight",linecolor="#30485d",linewidth=0.16) {#XKN:1 (-16,-128.7)};
// (-16.4,-128.7) @TEXT("k_n",size=1.1,halign="end",valign="middle");
// &"k_init" @WIRE(mode="straight",linecolor="#30485d",linewidth=0.16) {#XKN:3 (-16,-135.3)};
// (-16.4,-135.3) @TEXT("k_init",size=1.1,halign="end",valign="middle");
// &"VDD!" @WIRE(mode="straight",linecolor="#30485d",linewidth=0.16) {#XKN:4 (0,-120.4)};
// (0,-120) @TEXT("VDD!",size=1.1,halign="middle",valign="bottom");
// &"0" @WIRE(mode="straight",linecolor="#30485d",linewidth=0.16) {#XKN:5 (0,-143.6)};
// (0,-144) @TEXT("0",size=1.1,halign="middle",valign="top");
// &"k_p" @WIRE(mode="straight",linecolor="#30485d",linewidth=0.16) {#CKP:1 (90,-61)};
// (90,-60.6) @TEXT("k_p",size=1.1,halign="middle",valign="bottom");
// &"0" @WIRE(mode="straight",linecolor="#30485d",linewidth=0.16) {#CKP:2 (90,-71)};
// (90,-71.4) @TEXT("0",size=1.1,halign="middle",valign="top");
// &"k_n" @WIRE(mode="straight",linecolor="#30485d",linewidth=0.16) {#CKN:1 (90,-94)};
// (90,-93.6) @TEXT("k_n",size=1.1,halign="middle",valign="bottom");
// &"0" @WIRE(mode="straight",linecolor="#30485d",linewidth=0.16) {#CKN:2 (90,-104)};
// (90,-104.4) @TEXT("0",size=1.1,halign="middle",valign="top");
// &"0" @WIRE(mode="straight",linecolor="#30485d",linewidth=0.16) {#VKC:2 (-70,-203)};
// (-70,-203.4) @TEXT("0",size=1.1,halign="middle",valign="top");
// &"VDD!" @WIRE(mode="straight",linecolor="#30485d",linewidth=0.16) {#XKCOMP:4 (0,-153.4)};
// (0,-153) @TEXT("VDD!",size=1.1,halign="middle",valign="bottom");
// &"k_n" @WIRE(mode="straight",linecolor="#30485d",linewidth=0.16) {#XKCOMP:5 (-16,-165)};
// (-16.4,-165) @TEXT("k_n",size=1.1,halign="end",valign="middle");
// &"k_p" @WIRE(mode="straight",linecolor="#30485d",linewidth=0.16) {#XKCOMP:6 (-16,-168.3)};
// (-16.4,-168.3) @TEXT("k_p",size=1.1,halign="end",valign="middle");
// &"0" @WIRE(mode="straight",linecolor="#30485d",linewidth=0.16) {#XKCOMP:7 (0,-176.6)};
// (0,-177) @TEXT("0",size=1.1,halign="middle",valign="top");
// &"0" @WIRE(mode="straight",linecolor="#30485d",linewidth=0.16) {#CKON:2 (90,-137)};
// (90,-137.4) @TEXT("0",size=1.1,halign="middle",valign="top");
// &"0" @WIRE(mode="straight",linecolor="#30485d",linewidth=0.16) {#CKOP:2 (90,-170)};
// (90,-170.4) @TEXT("0",size=1.1,halign="middle",valign="top");
// }
// END SARADC RNL
ends tb_comparator

subckt tb_reference
// Reference storage, nonoverlap and gate-drive test with the ACTUAL CDAC as the load.
VRRESET (r_reset 0) vsource type=pwl wave=[0 0.9 20n 0.9 20.1n 0]
VRPHI (r_phi 0) vsource type=pulse val0=0 val1=0.9 delay=50n rise=100p fall=100p width=1.9n period=80n
VRB0 (r_bit0 0) vsource type=pwl wave=[0 0 4.4900000000000005e-08 0 4.5000000000000006e-08 0 1.2490000000000001e-07 0 1.2500000000000002e-07 0 2.0490000000000001e-07 0 2.0500000000000002e-07 0.90000000000000002 2.8490000000000002e-07 0.90000000000000002 2.8500000000000002e-07 0.90000000000000002 3.6489999999999999e-07 0.90000000000000002 3.65e-07 0 4.4490000000000002e-07 0 4.4500000000000003e-07 0]
VRB1 (r_bit1 0) vsource type=pwl wave=[0 0 4.4900000000000005e-08 0 4.5000000000000006e-08 0 1.2490000000000001e-07 0 1.2500000000000002e-07 0 2.0490000000000001e-07 0 2.0500000000000002e-07 0.90000000000000002 2.8490000000000002e-07 0.90000000000000002 2.8500000000000002e-07 0 3.6489999999999999e-07 0 3.65e-07 0.90000000000000002 4.4490000000000002e-07 0.90000000000000002 4.4500000000000003e-07 0]
VRB2 (r_bit2 0) vsource type=pwl wave=[0 0 4.4900000000000005e-08 0 4.5000000000000006e-08 0 1.2490000000000001e-07 0 1.2500000000000002e-07 0 2.0490000000000001e-07 0 2.0500000000000002e-07 0.90000000000000002 2.8490000000000002e-07 0.90000000000000002 2.8500000000000002e-07 0.90000000000000002 3.6489999999999999e-07 0.90000000000000002 3.65e-07 0 4.4490000000000002e-07 0 4.4500000000000003e-07 0]
VRB3 (r_bit3 0) vsource type=pwl wave=[0 0 4.4900000000000005e-08 0 4.5000000000000006e-08 0 1.2490000000000001e-07 0 1.2500000000000002e-07 0 2.0490000000000001e-07 0 2.0500000000000002e-07 0.90000000000000002 2.8490000000000002e-07 0.90000000000000002 2.8500000000000002e-07 0 3.6489999999999999e-07 0 3.65e-07 0.90000000000000002 4.4490000000000002e-07 0.90000000000000002 4.4500000000000003e-07 0]
VRB4 (r_bit4 0) vsource type=pwl wave=[0 0 4.4900000000000005e-08 0 4.5000000000000006e-08 0 1.2490000000000001e-07 0 1.2500000000000002e-07 0 2.0490000000000001e-07 0 2.0500000000000002e-07 0.90000000000000002 2.8490000000000002e-07 0.90000000000000002 2.8500000000000002e-07 0.90000000000000002 3.6489999999999999e-07 0.90000000000000002 3.65e-07 0 4.4490000000000002e-07 0 4.4500000000000003e-07 0]
VRB5 (r_bit5 0) vsource type=pwl wave=[0 0 4.4900000000000005e-08 0 4.5000000000000006e-08 0 1.2490000000000001e-07 0 1.2500000000000002e-07 0 2.0490000000000001e-07 0 2.0500000000000002e-07 0.90000000000000002 2.8490000000000002e-07 0.90000000000000002 2.8500000000000002e-07 0 3.6489999999999999e-07 0 3.65e-07 0.90000000000000002 4.4490000000000002e-07 0.90000000000000002 4.4500000000000003e-07 0]
VRB6 (r_bit6 0) vsource type=pwl wave=[0 0 4.4900000000000005e-08 0 4.5000000000000006e-08 0 1.2490000000000001e-07 0 1.2500000000000002e-07 0 2.0490000000000001e-07 0 2.0500000000000002e-07 0.90000000000000002 2.8490000000000002e-07 0.90000000000000002 2.8500000000000002e-07 0.90000000000000002 3.6489999999999999e-07 0.90000000000000002 3.65e-07 0 4.4490000000000002e-07 0 4.4500000000000003e-07 0]
VRB7 (r_bit7 0) vsource type=pwl wave=[0 0.90000000000000002 4.4900000000000005e-08 0.90000000000000002 4.5000000000000006e-08 0.90000000000000002 1.2490000000000001e-07 0.90000000000000002 1.2500000000000002e-07 0 2.0490000000000001e-07 0 2.0500000000000002e-07 0.90000000000000002 2.8490000000000002e-07 0.90000000000000002 2.8500000000000002e-07 0 3.6489999999999999e-07 0 3.65e-07 0.90000000000000002 4.4490000000000002e-07 0.90000000000000002 4.4500000000000003e-07 0.90000000000000002]
XREF (r_bit0 r_bit1 r_bit2 r_bit3 r_bit4 r_bit5 r_bit6 r_bit7 r_bit0 r_bit1 r_bit2 r_bit3 r_bit4 r_bit5 r_bit6 r_bit7 r_gnn0 r_gnn1 r_gnn2 r_gnn3 r_gnn4 r_gnn5 r_gnn6 r_gnn7 r_gnp0 r_gnp1 r_gnp2 r_gnp3 r_gnp4 r_gnp5 r_gnp6 r_gnp7 r_gpn0 r_gpn1 r_gpn2 r_gpn3 r_gpn4 r_gpn5 r_gpn6 r_gpn7 r_gpp0 r_gpp1 r_gpp2 r_gpp3 r_gpp4 r_gpp5 r_gpp6 r_gpp7 r_phi r_reset VDD! 0 r_done r_reset) sar8i_refword
XRLOAD (r_gnn0 r_gnn1 r_gnn2 r_gnn3 r_gnn4 r_gnn5 r_gnn6 r_gnn7 r_gnp0 r_gnp1 r_gnp2 r_gnp3 r_gnp4 r_gnp5 r_gnp6 r_gnp7 r_gpn0 r_gpn1 r_gpn2 r_gpn3 r_gpn4 r_gpn5 r_gpn6 r_gpn7 r_gpp0 r_gpp1 r_gpp2 r_gpp3 r_gpp4 r_gpp5 r_gpp6 r_gpp7 r_n r_p VDD! r_rn r_rp 0) sar8j_r1_cdac
VRRN (r_rns 0) vsource dc=0
VRRP (r_rps 0) vsource dc=0.9
RRRN (r_rns r_rn) resistor r=50
RRRP (r_rps r_rp) resistor r=50
CRRN (r_rn 0) capacitor c=4p
CRRP (r_rp 0) capacitor c=4p
RRNLEAK (r_n 0) resistor r=1e12
RRPLEAK (r_p 0) resistor r=1e12

// BEGIN SARADC RNL
// @RNL(author="saradc topology") {
// #VRRESET @SET-SYMBOL $VOLTAGE_SOURCE;
// #VRRESET @PLACE(-70,0) => @ORIENT("R0");
// #VRRESET @TEXT("VRRESET",key="name",size=1.3,halign="start") => @PLACE(-67,3);
// #VRRESET @TEXT("",key="value",size=0.9,halign="start") => @PLACE(-67,-4);
// #VRRESET @TEXT("",key="model");
// #VRPHI @SET-SYMBOL $VOLTAGE_SOURCE;
// #VRPHI @PLACE(-70,-33) => @ORIENT("R0");
// #VRPHI @TEXT("VRPHI",key="name",size=1.3,halign="start") => @PLACE(-67,-30);
// #VRPHI @TEXT("",key="value",size=0.9,halign="start") => @PLACE(-67,-37);
// #VRPHI @TEXT("",key="model");
// #VRB0 @SET-SYMBOL $VOLTAGE_SOURCE;
// #VRB0 @PLACE(-70,-66) => @ORIENT("R0");
// #VRB0 @TEXT("VRB0",key="name",size=1.3,halign="start") => @PLACE(-67,-63);
// #VRB0 @TEXT("",key="value",size=0.9,halign="start") => @PLACE(-67,-70);
// #VRB0 @TEXT("",key="model");
// #VRB1 @SET-SYMBOL $VOLTAGE_SOURCE;
// #VRB1 @PLACE(-70,-99) => @ORIENT("R0");
// #VRB1 @TEXT("VRB1",key="name",size=1.3,halign="start") => @PLACE(-67,-96);
// #VRB1 @TEXT("",key="value",size=0.9,halign="start") => @PLACE(-67,-103);
// #VRB1 @TEXT("",key="model");
// #VRB2 @SET-SYMBOL $VOLTAGE_SOURCE;
// #VRB2 @PLACE(-70,-132) => @ORIENT("R0");
// #VRB2 @TEXT("VRB2",key="name",size=1.3,halign="start") => @PLACE(-67,-129);
// #VRB2 @TEXT("",key="value",size=0.9,halign="start") => @PLACE(-67,-136);
// #VRB2 @TEXT("",key="model");
// #VRB3 @SET-SYMBOL $VOLTAGE_SOURCE;
// #VRB3 @PLACE(-70,-165) => @ORIENT("R0");
// #VRB3 @TEXT("VRB3",key="name",size=1.3,halign="start") => @PLACE(-67,-162);
// #VRB3 @TEXT("",key="value",size=0.9,halign="start") => @PLACE(-67,-169);
// #VRB3 @TEXT("",key="model");
// #VRB4 @SET-SYMBOL $VOLTAGE_SOURCE;
// #VRB4 @PLACE(-70,-198) => @ORIENT("R0");
// #VRB4 @TEXT("VRB4",key="name",size=1.3,halign="start") => @PLACE(-67,-195);
// #VRB4 @TEXT("",key="value",size=0.9,halign="start") => @PLACE(-67,-202);
// #VRB4 @TEXT("",key="model");
// #VRB5 @SET-SYMBOL $VOLTAGE_SOURCE;
// #VRB5 @PLACE(-70,-231) => @ORIENT("R0");
// #VRB5 @TEXT("VRB5",key="name",size=1.3,halign="start") => @PLACE(-67,-228);
// #VRB5 @TEXT("",key="value",size=0.9,halign="start") => @PLACE(-67,-235);
// #VRB5 @TEXT("",key="model");
// #VRB6 @SET-SYMBOL $VOLTAGE_SOURCE;
// #VRB6 @PLACE(-70,-264) => @ORIENT("R0");
// #VRB6 @TEXT("VRB6",key="name",size=1.3,halign="start") => @PLACE(-67,-261);
// #VRB6 @TEXT("",key="value",size=0.9,halign="start") => @PLACE(-67,-268);
// #VRB6 @TEXT("",key="model");
// #VRB7 @SET-SYMBOL $VOLTAGE_SOURCE;
// #VRB7 @PLACE(-70,-297) => @ORIENT("R0");
// #VRB7 @TEXT("VRB7",key="name",size=1.3,halign="start") => @PLACE(-67,-294);
// #VRB7 @TEXT("",key="value",size=0.9,halign="start") => @PLACE(-67,-301);
// #VRB7 @TEXT("",key="model");
// #VRRN @SET-SYMBOL $VOLTAGE_SOURCE;
// #VRRN @PLACE(-70,-330) => @ORIENT("R0");
// #VRRN @TEXT("VRRN",key="name",size=1.3,halign="start") => @PLACE(-67,-327);
// #VRRN @TEXT("",key="value",size=0.9,halign="start") => @PLACE(-67,-334);
// #VRRN @TEXT("",key="model");
// #VRRP @SET-SYMBOL $VOLTAGE_SOURCE;
// #VRRP @PLACE(-70,-363) => @ORIENT("R0");
// #VRRP @TEXT("VRRP",key="name",size=1.3,halign="start") => @PLACE(-67,-360);
// #VRRP @TEXT("",key="value",size=0.9,halign="start") => @PLACE(-67,-367);
// #VRRP @TEXT("",key="model");
// #XREF @SET-SYMBOL $S_sar8i_refword;
// #XREF @PLACE(0,0) => @ORIENT("R0");
// #XRLOAD @SET-SYMBOL $S_sar8j_r1_cdac;
// #XRLOAD @PLACE(0,-33) => @ORIENT("R0");
// #RRRN @SET-SYMBOL $RESISTOR;
// #RRRN @PLACE(90,0) => @ORIENT("R0");
// #RRRN @TEXT("RRRN",key="name",size=1.3,halign="start") => @PLACE(93,3);
// #RRRN @TEXT("r=50",key="value",size=0.9,halign="start") => @PLACE(93,-4);
// #RRRN @TEXT("",key="model");
// #RRRP @SET-SYMBOL $RESISTOR;
// #RRRP @PLACE(90,-33) => @ORIENT("R0");
// #RRRP @TEXT("RRRP",key="name",size=1.3,halign="start") => @PLACE(93,-30);
// #RRRP @TEXT("r=50",key="value",size=0.9,halign="start") => @PLACE(93,-37);
// #RRRP @TEXT("",key="model");
// #CRRN @SET-SYMBOL $CAPACITOR;
// #CRRN @PLACE(90,-66) => @ORIENT("R0");
// #CRRN @TEXT("CRRN",key="name",size=1.3,halign="start") => @PLACE(93,-63);
// #CRRN @TEXT("c=4p",key="value",size=0.9,halign="start") => @PLACE(93,-70);
// #CRRN @TEXT("",key="model");
// #CRRP @SET-SYMBOL $CAPACITOR;
// #CRRP @PLACE(90,-99) => @ORIENT("R0");
// #CRRP @TEXT("CRRP",key="name",size=1.3,halign="start") => @PLACE(93,-96);
// #CRRP @TEXT("c=4p",key="value",size=0.9,halign="start") => @PLACE(93,-103);
// #CRRP @TEXT("",key="model");
// #RRNLEAK @SET-SYMBOL $RESISTOR;
// #RRNLEAK @PLACE(90,-132) => @ORIENT("R0");
// #RRNLEAK @TEXT("RRNLEAK",key="name",size=1.3,halign="start") => @PLACE(93,-129);
// #RRNLEAK @TEXT("r=1e12",key="value",size=0.9,halign="start") => @PLACE(93,-136);
// #RRNLEAK @TEXT("",key="model");
// #RRPLEAK @SET-SYMBOL $RESISTOR;
// #RRPLEAK @PLACE(90,-165) => @ORIENT("R0");
// #RRPLEAK @TEXT("RRPLEAK",key="name",size=1.3,halign="start") => @PLACE(93,-162);
// #RRPLEAK @TEXT("r=1e12",key="value",size=0.9,halign="start") => @PLACE(93,-169);
// #RRPLEAK @TEXT("",key="model");
// &"r_phi" @WIRE(mode="straight",linecolor="#30485d",linewidth=0.16) {#VRPHI:1 (-41.5,-31) (-41.5,-1.65) #XREF:49};
// &"r_n" @WIRE(mode="straight",linecolor="#30485d",linewidth=0.16) {#XRLOAD:33 (51.5,-31.35) (51.5,-130) #RRNLEAK:1};
// (-89,30) @TEXT("tb_reference / source-derived connections",size=1.4,halign="start",textcolor="#223d52");
// &"r_reset" @WIRE(mode="straight",linecolor="#30485d",linewidth=0.16) {#VRRESET:1 (-70,5)};
// (-70,5.4) @TEXT("r_reset",size=1.1,halign="middle",valign="bottom");
// &"0" @WIRE(mode="straight",linecolor="#30485d",linewidth=0.16) {#VRRESET:2 (-70,-5)};
// (-70,-5.4) @TEXT("0",size=1.1,halign="middle",valign="top");
// &"0" @WIRE(mode="straight",linecolor="#30485d",linewidth=0.16) {#VRPHI:2 (-70,-38)};
// (-70,-38.4) @TEXT("0",size=1.1,halign="middle",valign="top");
// &"r_bit0" @WIRE(mode="straight",linecolor="#30485d",linewidth=0.16) {#VRB0:1 (-70,-61)};
// (-70,-60.6) @TEXT("r_bit0",size=1.1,halign="middle",valign="bottom");
// &"0" @WIRE(mode="straight",linecolor="#30485d",linewidth=0.16) {#VRB0:2 (-70,-71)};
// (-70,-71.4) @TEXT("0",size=1.1,halign="middle",valign="top");
// &"r_bit1" @WIRE(mode="straight",linecolor="#30485d",linewidth=0.16) {#VRB1:1 (-70,-94)};
// (-70,-93.6) @TEXT("r_bit1",size=1.1,halign="middle",valign="bottom");
// &"0" @WIRE(mode="straight",linecolor="#30485d",linewidth=0.16) {#VRB1:2 (-70,-104)};
// (-70,-104.4) @TEXT("0",size=1.1,halign="middle",valign="top");
// &"r_bit2" @WIRE(mode="straight",linecolor="#30485d",linewidth=0.16) {#VRB2:1 (-70,-127)};
// (-70,-126.6) @TEXT("r_bit2",size=1.1,halign="middle",valign="bottom");
// &"0" @WIRE(mode="straight",linecolor="#30485d",linewidth=0.16) {#VRB2:2 (-70,-137)};
// (-70,-137.4) @TEXT("0",size=1.1,halign="middle",valign="top");
// &"r_bit3" @WIRE(mode="straight",linecolor="#30485d",linewidth=0.16) {#VRB3:1 (-70,-160)};
// (-70,-159.6) @TEXT("r_bit3",size=1.1,halign="middle",valign="bottom");
// &"0" @WIRE(mode="straight",linecolor="#30485d",linewidth=0.16) {#VRB3:2 (-70,-170)};
// (-70,-170.4) @TEXT("0",size=1.1,halign="middle",valign="top");
// &"r_bit4" @WIRE(mode="straight",linecolor="#30485d",linewidth=0.16) {#VRB4:1 (-70,-193)};
// (-70,-192.6) @TEXT("r_bit4",size=1.1,halign="middle",valign="bottom");
// &"0" @WIRE(mode="straight",linecolor="#30485d",linewidth=0.16) {#VRB4:2 (-70,-203)};
// (-70,-203.4) @TEXT("0",size=1.1,halign="middle",valign="top");
// &"r_bit5" @WIRE(mode="straight",linecolor="#30485d",linewidth=0.16) {#VRB5:1 (-70,-226)};
// (-70,-225.6) @TEXT("r_bit5",size=1.1,halign="middle",valign="bottom");
// &"0" @WIRE(mode="straight",linecolor="#30485d",linewidth=0.16) {#VRB5:2 (-70,-236)};
// (-70,-236.4) @TEXT("0",size=1.1,halign="middle",valign="top");
// &"r_bit6" @WIRE(mode="straight",linecolor="#30485d",linewidth=0.16) {#VRB6:1 (-70,-259)};
// (-70,-258.6) @TEXT("r_bit6",size=1.1,halign="middle",valign="bottom");
// &"0" @WIRE(mode="straight",linecolor="#30485d",linewidth=0.16) {#VRB6:2 (-70,-269)};
// (-70,-269.4) @TEXT("0",size=1.1,halign="middle",valign="top");
// &"r_bit7" @WIRE(mode="straight",linecolor="#30485d",linewidth=0.16) {#VRB7:1 (-70,-292)};
// (-70,-291.6) @TEXT("r_bit7",size=1.1,halign="middle",valign="bottom");
// &"0" @WIRE(mode="straight",linecolor="#30485d",linewidth=0.16) {#VRB7:2 (-70,-302)};
// (-70,-302.4) @TEXT("0",size=1.1,halign="middle",valign="top");
// {&"r_bit0" &"r_bit1" &"r_bit2" &"r_bit3" &"r_bit4" &"r_bit5" &"r_bit6" &"r_bit7"} @WIRE(mode="straight",linewidth=0.3) {#XREF:1 (-16,4.95)};
// (-16.4,4.95) @TEXT("r_bit[7:0]",size=1.1,halign="end",valign="middle");
// {&"r_bit0" &"r_bit1" &"r_bit2" &"r_bit3" &"r_bit4" &"r_bit5" &"r_bit6" &"r_bit7"} @WIRE(mode="straight",linewidth=0.3) {#XREF:9 (-16,1.65)};
// (-16.4,1.65) @TEXT("r_bit[7:0]",size=1.1,halign="end",valign="middle");
// {&"r_gnn0" &"r_gnn1" &"r_gnn2" &"r_gnn3" &"r_gnn4" &"r_gnn5" &"r_gnn6" &"r_gnn7"} @WIRE(mode="straight",linewidth=0.3) {#XREF:17 (16,8.25)};
// (16.4,8.25) @TEXT("r_gnn[7:0]",size=1.1,halign="start",valign="middle");
// {&"r_gnp0" &"r_gnp1" &"r_gnp2" &"r_gnp3" &"r_gnp4" &"r_gnp5" &"r_gnp6" &"r_gnp7"} @WIRE(mode="straight",linewidth=0.3) {#XREF:25 (16,4.95)};
// (16.4,4.95) @TEXT("r_gnp[7:0]",size=1.1,halign="start",valign="middle");
// {&"r_gpn0" &"r_gpn1" &"r_gpn2" &"r_gpn3" &"r_gpn4" &"r_gpn5" &"r_gpn6" &"r_gpn7"} @WIRE(mode="straight",linewidth=0.3) {#XREF:33 (16,1.65)};
// (16.4,1.65) @TEXT("r_gpn[7:0]",size=1.1,halign="start",valign="middle");
// {&"r_gpp0" &"r_gpp1" &"r_gpp2" &"r_gpp3" &"r_gpp4" &"r_gpp5" &"r_gpp6" &"r_gpp7"} @WIRE(mode="straight",linewidth=0.3) {#XREF:41 (16,-1.65)};
// (16.4,-1.65) @TEXT("r_gpp[7:0]",size=1.1,halign="start",valign="middle");
// &"r_reset" @WIRE(mode="straight",linecolor="#30485d",linewidth=0.16) {#XREF:50 (-16,-4.95)};
// (-16.4,-4.95) @TEXT("r_reset",size=1.1,halign="end",valign="middle");
// &"VDD!" @WIRE(mode="straight",linecolor="#30485d",linewidth=0.16) {#XREF:51 (0,16.55)};
// (0,16.95) @TEXT("VDD!",size=1.1,halign="middle",valign="bottom");
// &"0" @WIRE(mode="straight",linecolor="#30485d",linewidth=0.16) {#XREF:52 (0,-16.55)};
// (0,-16.95) @TEXT("0",size=1.1,halign="middle",valign="top");
// &"r_done" @WIRE(mode="straight",linecolor="#30485d",linewidth=0.16) {#XREF:53 (16,-4.95)};
// (16.4,-4.95) @TEXT("r_done",size=1.1,halign="start",valign="middle");
// &"r_reset" @WIRE(mode="straight",linecolor="#30485d",linewidth=0.16) {#XREF:54 (16,-8.25)};
// (16.4,-8.25) @TEXT("r_reset",size=1.1,halign="start",valign="middle");
// {&"r_gnn0" &"r_gnn1" &"r_gnn2" &"r_gnn3" &"r_gnn4" &"r_gnn5" &"r_gnn6" &"r_gnn7"} @WIRE(mode="straight",linewidth=0.3) {#XRLOAD:1 (-16,-24.75)};
// (-16.4,-24.75) @TEXT("r_gnn[7:0]",size=1.1,halign="end",valign="middle");
// {&"r_gnp0" &"r_gnp1" &"r_gnp2" &"r_gnp3" &"r_gnp4" &"r_gnp5" &"r_gnp6" &"r_gnp7"} @WIRE(mode="straight",linewidth=0.3) {#XRLOAD:9 (-16,-28.05)};
// (-16.4,-28.05) @TEXT("r_gnp[7:0]",size=1.1,halign="end",valign="middle");
// {&"r_gpn0" &"r_gpn1" &"r_gpn2" &"r_gpn3" &"r_gpn4" &"r_gpn5" &"r_gpn6" &"r_gpn7"} @WIRE(mode="straight",linewidth=0.3) {#XRLOAD:17 (-16,-31.35)};
// (-16.4,-31.35) @TEXT("r_gpn[7:0]",size=1.1,halign="end",valign="middle");
// {&"r_gpp0" &"r_gpp1" &"r_gpp2" &"r_gpp3" &"r_gpp4" &"r_gpp5" &"r_gpp6" &"r_gpp7"} @WIRE(mode="straight",linewidth=0.3) {#XRLOAD:25 (-16,-34.65)};
// (-16.4,-34.65) @TEXT("r_gpp[7:0]",size=1.1,halign="end",valign="middle");
// &"r_p" @WIRE(mode="straight",linecolor="#30485d",linewidth=0.16) {#XRLOAD:34 (16,-34.65)};
// (16.4,-34.65) @TEXT("r_p",size=1.1,halign="start",valign="middle");
// &"VDD!" @WIRE(mode="straight",linecolor="#30485d",linewidth=0.16) {#XRLOAD:35 (0,-16.45)};
// (0,-16.05) @TEXT("VDD!",size=1.1,halign="middle",valign="bottom");
// &"r_rn" @WIRE(mode="straight",linecolor="#30485d",linewidth=0.16) {#XRLOAD:36 (-16,-37.95)};
// (-16.4,-37.95) @TEXT("r_rn",size=1.1,halign="end",valign="middle");
// &"r_rp" @WIRE(mode="straight",linecolor="#30485d",linewidth=0.16) {#XRLOAD:37 (-16,-41.25)};
// (-16.4,-41.25) @TEXT("r_rp",size=1.1,halign="end",valign="middle");
// &"0" @WIRE(mode="straight",linecolor="#30485d",linewidth=0.16) {#XRLOAD:38 (0,-49.55)};
// (0,-49.95) @TEXT("0",size=1.1,halign="middle",valign="top");
// &"r_rns" @WIRE(mode="straight",linecolor="#30485d",linewidth=0.16) {#VRRN:1 (-70,-325)};
// (-70,-324.6) @TEXT("r_rns",size=1.1,halign="middle",valign="bottom");
// &"0" @WIRE(mode="straight",linecolor="#30485d",linewidth=0.16) {#VRRN:2 (-70,-335)};
// (-70,-335.4) @TEXT("0",size=1.1,halign="middle",valign="top");
// &"r_rps" @WIRE(mode="straight",linecolor="#30485d",linewidth=0.16) {#VRRP:1 (-70,-358)};
// (-70,-357.6) @TEXT("r_rps",size=1.1,halign="middle",valign="bottom");
// &"0" @WIRE(mode="straight",linecolor="#30485d",linewidth=0.16) {#VRRP:2 (-70,-368)};
// (-70,-368.4) @TEXT("0",size=1.1,halign="middle",valign="top");
// &"r_rns" @WIRE(mode="straight",linecolor="#30485d",linewidth=0.16) {#RRRN:1 (90,5)};
// (90,5.4) @TEXT("r_rns",size=1.1,halign="middle",valign="bottom");
// &"r_rn" @WIRE(mode="straight",linecolor="#30485d",linewidth=0.16) {#RRRN:2 (90,-5)};
// (90,-5.4) @TEXT("r_rn",size=1.1,halign="middle",valign="top");
// &"r_rps" @WIRE(mode="straight",linecolor="#30485d",linewidth=0.16) {#RRRP:1 (90,-28)};
// (90,-27.6) @TEXT("r_rps",size=1.1,halign="middle",valign="bottom");
// &"r_rp" @WIRE(mode="straight",linecolor="#30485d",linewidth=0.16) {#RRRP:2 (90,-38)};
// (90,-38.4) @TEXT("r_rp",size=1.1,halign="middle",valign="top");
// &"r_rn" @WIRE(mode="straight",linecolor="#30485d",linewidth=0.16) {#CRRN:1 (90,-61)};
// (90,-60.6) @TEXT("r_rn",size=1.1,halign="middle",valign="bottom");
// &"0" @WIRE(mode="straight",linecolor="#30485d",linewidth=0.16) {#CRRN:2 (90,-71)};
// (90,-71.4) @TEXT("0",size=1.1,halign="middle",valign="top");
// &"r_rp" @WIRE(mode="straight",linecolor="#30485d",linewidth=0.16) {#CRRP:1 (90,-94)};
// (90,-93.6) @TEXT("r_rp",size=1.1,halign="middle",valign="bottom");
// &"0" @WIRE(mode="straight",linecolor="#30485d",linewidth=0.16) {#CRRP:2 (90,-104)};
// (90,-104.4) @TEXT("0",size=1.1,halign="middle",valign="top");
// &"0" @WIRE(mode="straight",linecolor="#30485d",linewidth=0.16) {#RRNLEAK:2 (90,-137)};
// (90,-137.4) @TEXT("0",size=1.1,halign="middle",valign="top");
// &"r_p" @WIRE(mode="straight",linecolor="#30485d",linewidth=0.16) {#RRPLEAK:1 (90,-160)};
// (90,-159.6) @TEXT("r_p",size=1.1,halign="middle",valign="bottom");
// &"0" @WIRE(mode="straight",linecolor="#30485d",linewidth=0.16) {#RRPLEAK:2 (90,-170)};
// (90,-170.4) @TEXT("0",size=1.1,halign="middle",valign="top");
// }
// END SARADC RNL
ends tb_reference

subckt tb_sampler
// Standalone sampler: normal initial 60 ns low / 40 ns high, 50 ohm source.
VBCLOCK (b_clock 0) vsource type=pulse val0=0 val1=0.9 delay=60n rise=100p fall=100p width=39.9n period=100n
VBIN (b_source 0) vsource type=pwl wave=[0 0.2 120n 0.2 120.1n 0.8]
RBIN (b_source b_in) resistor r=50
XBOOT (b_clock b_hold b_in) sar_bootstrap_flat_8b_p
CBLOAD (b_hold 0) cfmom_2t nr=8 lr=2u w=50n s=50n stm=1 spm=3 multi=256 mismatchflag=1

// BEGIN SARADC RNL
// @RNL(author="saradc topology") {
// #VBCLOCK @SET-SYMBOL $VOLTAGE_SOURCE;
// #VBCLOCK @PLACE(-70,0) => @ORIENT("R0");
// #VBCLOCK @TEXT("VBCLOCK",key="name",size=1.3,halign="start") => @PLACE(-67,3);
// #VBCLOCK @TEXT("",key="value",size=0.9,halign="start") => @PLACE(-67,-4);
// #VBCLOCK @TEXT("",key="model");
// #VBIN @SET-SYMBOL $VOLTAGE_SOURCE;
// #VBIN @PLACE(-70,-33) => @ORIENT("R0");
// #VBIN @TEXT("VBIN",key="name",size=1.3,halign="start") => @PLACE(-67,-30);
// #VBIN @TEXT("",key="value",size=0.9,halign="start") => @PLACE(-67,-37);
// #VBIN @TEXT("",key="model");
// #XBOOT @SET-SYMBOL $S_sar_bootstrap_flat_8b_p;
// #XBOOT @PLACE(0,0) => @ORIENT("R0");
// #RBIN @SET-SYMBOL $RESISTOR;
// #RBIN @PLACE(90,0) => @ORIENT("R0");
// #RBIN @TEXT("RBIN",key="name",size=1.3,halign="start") => @PLACE(93,3);
// #RBIN @TEXT("r=50",key="value",size=0.9,halign="start") => @PLACE(93,-4);
// #RBIN @TEXT("",key="model");
// #CBLOAD @SET-SYMBOL $CAPACITOR;
// #CBLOAD @PLACE(90,-33) => @ORIENT("R0");
// #CBLOAD @TEXT("CBLOAD",key="name",size=1.3,halign="start") => @PLACE(93,-30);
// #CBLOAD @TEXT("nr=8 lr=2u w=50n multi=256",key="value",size=0.9,halign="start") => @PLACE(93,-37);
// #CBLOAD @TEXT("",key="model");
// &"b_clock" @WIRE(mode="straight",linecolor="#30485d",linewidth=0.16) {#VBCLOCK:1 (-41.5,2) (-41.5,1.65) #XBOOT:1};
// &"b_in" @WIRE(mode="straight",linecolor="#30485d",linewidth=0.16) {#RBIN:2 (38.5,-2) (38.5,-1.65) #XBOOT:3};
// &"b_hold" @WIRE(mode="straight",linecolor="#30485d",linewidth=0.16) {#XBOOT:2 (51.5,0) (51.5,-31) #CBLOAD:1};
// (-89,30) @TEXT("tb_sampler / source-derived connections",size=1.4,halign="start",textcolor="#223d52");
// &"0" @WIRE(mode="straight",linecolor="#30485d",linewidth=0.16) {#VBCLOCK:2 (-70,-5)};
// (-70,-5.4) @TEXT("0",size=1.1,halign="middle",valign="top");
// &"b_source" @WIRE(mode="straight",linecolor="#30485d",linewidth=0.16) {#VBIN:1 (-70,-28)};
// (-70,-27.6) @TEXT("b_source",size=1.1,halign="middle",valign="bottom");
// &"0" @WIRE(mode="straight",linecolor="#30485d",linewidth=0.16) {#VBIN:2 (-70,-38)};
// (-70,-38.4) @TEXT("0",size=1.1,halign="middle",valign="top");
// &"b_source" @WIRE(mode="straight",linecolor="#30485d",linewidth=0.16) {#RBIN:1 (90,5)};
// (90,5.4) @TEXT("b_source",size=1.1,halign="middle",valign="bottom");
// &"0" @WIRE(mode="straight",linecolor="#30485d",linewidth=0.16) {#CBLOAD:2 (90,-38)};
// (90,-38.4) @TEXT("0",size=1.1,halign="middle",valign="top");
// }
// END SARADC RNL
ends tb_sampler

subckt tb_sar
// Native SAR and native delays; electrical VA sampler/CDAC/reference/comparator provide the environment.
VSCLOCK (s_clock 0) vsource type=pulse val0=0 val1=0.9 delay=60n rise=100p fall=100p width=39.9n period=100n
VSs_ps (s_ps 0) vsource type=pwl wave=[0 0.0017578125000000111 1.5980000000000001e-07 0.0017578125000000111 1.5990000000000002e-07 0.0439453125 2.5979999999999998e-07 0.0439453125 2.5989999999999999e-07 0.4482421875 3.5979999999999998e-07 0.4482421875 3.5989999999999999e-07 0.45175781250000002 4.5979999999999997e-07 0.45175781250000002 4.5989999999999998e-07 0.85605468750000002 5.5980000000000002e-07 0.85605468750000002 5.5990000000000003e-07 0.89824218750000007]
VSs_ns (s_ns 0) vsource type=pwl wave=[0 0.89824218749999996 1.5980000000000001e-07 0.89824218749999996 1.5990000000000002e-07 0.85605468750000002 2.5979999999999998e-07 0.85605468750000002 2.5989999999999999e-07 0.45175781250000002 3.5979999999999998e-07 0.45175781250000002 3.5989999999999999e-07 0.4482421875 4.5979999999999997e-07 0.4482421875 4.5989999999999998e-07 0.0439453125 5.5980000000000002e-07 0.0439453125 5.5990000000000003e-07 0.0017578124999999556]
XSAR (s_d0 s_d1 s_d2 s_d3 s_d4 s_d5 s_d6 s_d7 s_clock VDD! s_n s_p s_rn s_rp 0) tb_sar_top
RSIN (s_ns s_n) resistor r=50
RSIP (s_ps s_p) resistor r=50
VSRN (s_rns 0) vsource dc=0
VSRP (s_rps 0) vsource dc=0.9
RSRN (s_rns s_rn) resistor r=50
RSRP (s_rps s_rp) resistor r=50
CSRN (s_rn 0) capacitor c=4p
CSRP (s_rp 0) capacitor c=4p
XSPROBE (s_d0 s_d1 s_d2 s_d3 s_d4 s_d5 s_d6 s_d7 s_clock VDD! 0) b_behavior_observer model_id=901
CSL0 (s_d0 0) capacitor c=5f
CSL1 (s_d1 0) capacitor c=5f
CSL2 (s_d2 0) capacitor c=5f
CSL3 (s_d3 0) capacitor c=5f
CSL4 (s_d4 0) capacitor c=5f
CSL5 (s_d5 0) capacitor c=5f
CSL6 (s_d6 0) capacitor c=5f
CSL7 (s_d7 0) capacitor c=5f
// A second real SAR receives no comparator response. A new acquisition must
// clear it without a false write/update; this adds no watchdog to the design.
XSTALLED (f_d0 f_d1 f_d2 f_d3 f_d4 f_d5 f_d6 f_d7 s_clock VDD! f_n f_p f_rn f_rp 0) tb_sar_stalled_top
RFIN (s_ns f_n) resistor r=50
RFIP (s_ps f_p) resistor r=50
VFRN (f_rns 0) vsource dc=0
VFRP (f_rps 0) vsource dc=0.9
RFRN (f_rns f_rn) resistor r=50
RFRP (f_rps f_rp) resistor r=50
CFRN (f_rn 0) capacitor c=4p
CFRP (f_rp 0) capacitor c=4p
CFL0 (f_d0 0) capacitor c=5f
CFL1 (f_d1 0) capacitor c=5f
CFL2 (f_d2 0) capacitor c=5f
CFL3 (f_d3 0) capacitor c=5f
CFL4 (f_d4 0) capacitor c=5f
CFL5 (f_d5 0) capacitor c=5f
CFL6 (f_d6 0) capacitor c=5f
CFL7 (f_d7 0) capacitor c=5f

// BEGIN SARADC RNL
// @RNL(author="saradc topology") {
// #VSCLOCK @SET-SYMBOL $VOLTAGE_SOURCE;
// #VSCLOCK @PLACE(-70,0) => @ORIENT("R0");
// #VSCLOCK @TEXT("VSCLOCK",key="name",size=1.3,halign="start") => @PLACE(-67,3);
// #VSCLOCK @TEXT("",key="value",size=0.9,halign="start") => @PLACE(-67,-4);
// #VSCLOCK @TEXT("",key="model");
// #VSs_ps @SET-SYMBOL $VOLTAGE_SOURCE;
// #VSs_ps @PLACE(-70,-33) => @ORIENT("R0");
// #VSs_ps @TEXT("VSs_ps",key="name",size=1.3,halign="start") => @PLACE(-67,-30);
// #VSs_ps @TEXT("",key="value",size=0.9,halign="start") => @PLACE(-67,-37);
// #VSs_ps @TEXT("",key="model");
// #VSs_ns @SET-SYMBOL $VOLTAGE_SOURCE;
// #VSs_ns @PLACE(-70,-66) => @ORIENT("R0");
// #VSs_ns @TEXT("VSs_ns",key="name",size=1.3,halign="start") => @PLACE(-67,-63);
// #VSs_ns @TEXT("",key="value",size=0.9,halign="start") => @PLACE(-67,-70);
// #VSs_ns @TEXT("",key="model");
// #VSRN @SET-SYMBOL $VOLTAGE_SOURCE;
// #VSRN @PLACE(-70,-99) => @ORIENT("R0");
// #VSRN @TEXT("VSRN",key="name",size=1.3,halign="start") => @PLACE(-67,-96);
// #VSRN @TEXT("",key="value",size=0.9,halign="start") => @PLACE(-67,-103);
// #VSRN @TEXT("",key="model");
// #VSRP @SET-SYMBOL $VOLTAGE_SOURCE;
// #VSRP @PLACE(-70,-132) => @ORIENT("R0");
// #VSRP @TEXT("VSRP",key="name",size=1.3,halign="start") => @PLACE(-67,-129);
// #VSRP @TEXT("",key="value",size=0.9,halign="start") => @PLACE(-67,-136);
// #VSRP @TEXT("",key="model");
// #VFRN @SET-SYMBOL $VOLTAGE_SOURCE;
// #VFRN @PLACE(-70,-165) => @ORIENT("R0");
// #VFRN @TEXT("VFRN",key="name",size=1.3,halign="start") => @PLACE(-67,-162);
// #VFRN @TEXT("",key="value",size=0.9,halign="start") => @PLACE(-67,-169);
// #VFRN @TEXT("",key="model");
// #VFRP @SET-SYMBOL $VOLTAGE_SOURCE;
// #VFRP @PLACE(-70,-198) => @ORIENT("R0");
// #VFRP @TEXT("VFRP",key="name",size=1.3,halign="start") => @PLACE(-67,-195);
// #VFRP @TEXT("",key="value",size=0.9,halign="start") => @PLACE(-67,-202);
// #VFRP @TEXT("",key="model");
// #XSAR @SET-SYMBOL $S_tb_sar_top;
// #XSAR @PLACE(0,0) => @ORIENT("R0");
// #XSPROBE @SET-SYMBOL $S_b_behavior_observer;
// #XSPROBE @PLACE(0,-33) => @ORIENT("R0");
// #XSTALLED @SET-SYMBOL $S_tb_sar_stalled_top;
// #XSTALLED @PLACE(0,-66) => @ORIENT("R0");
// #RSIN @SET-SYMBOL $RESISTOR;
// #RSIN @PLACE(90,0) => @ORIENT("R0");
// #RSIN @TEXT("RSIN",key="name",size=1.3,halign="start") => @PLACE(93,3);
// #RSIN @TEXT("r=50",key="value",size=0.9,halign="start") => @PLACE(93,-4);
// #RSIN @TEXT("",key="model");
// #RSIP @SET-SYMBOL $RESISTOR;
// #RSIP @PLACE(90,-33) => @ORIENT("R0");
// #RSIP @TEXT("RSIP",key="name",size=1.3,halign="start") => @PLACE(93,-30);
// #RSIP @TEXT("r=50",key="value",size=0.9,halign="start") => @PLACE(93,-37);
// #RSIP @TEXT("",key="model");
// #RSRN @SET-SYMBOL $RESISTOR;
// #RSRN @PLACE(90,-66) => @ORIENT("R0");
// #RSRN @TEXT("RSRN",key="name",size=1.3,halign="start") => @PLACE(93,-63);
// #RSRN @TEXT("r=50",key="value",size=0.9,halign="start") => @PLACE(93,-70);
// #RSRN @TEXT("",key="model");
// #RSRP @SET-SYMBOL $RESISTOR;
// #RSRP @PLACE(90,-99) => @ORIENT("R0");
// #RSRP @TEXT("RSRP",key="name",size=1.3,halign="start") => @PLACE(93,-96);
// #RSRP @TEXT("r=50",key="value",size=0.9,halign="start") => @PLACE(93,-103);
// #RSRP @TEXT("",key="model");
// #CSRN @SET-SYMBOL $CAPACITOR;
// #CSRN @PLACE(90,-132) => @ORIENT("R0");
// #CSRN @TEXT("CSRN",key="name",size=1.3,halign="start") => @PLACE(93,-129);
// #CSRN @TEXT("c=4p",key="value",size=0.9,halign="start") => @PLACE(93,-136);
// #CSRN @TEXT("",key="model");
// #CSRP @SET-SYMBOL $CAPACITOR;
// #CSRP @PLACE(90,-165) => @ORIENT("R0");
// #CSRP @TEXT("CSRP",key="name",size=1.3,halign="start") => @PLACE(93,-162);
// #CSRP @TEXT("c=4p",key="value",size=0.9,halign="start") => @PLACE(93,-169);
// #CSRP @TEXT("",key="model");
// #CSL0 @SET-SYMBOL $CAPACITOR;
// #CSL0 @PLACE(90,-198) => @ORIENT("R0");
// #CSL0 @TEXT("CSL0",key="name",size=1.3,halign="start") => @PLACE(93,-195);
// #CSL0 @TEXT("c=5f",key="value",size=0.9,halign="start") => @PLACE(93,-202);
// #CSL0 @TEXT("",key="model");
// #CSL1 @SET-SYMBOL $CAPACITOR;
// #CSL1 @PLACE(90,-231) => @ORIENT("R0");
// #CSL1 @TEXT("CSL1",key="name",size=1.3,halign="start") => @PLACE(93,-228);
// #CSL1 @TEXT("c=5f",key="value",size=0.9,halign="start") => @PLACE(93,-235);
// #CSL1 @TEXT("",key="model");
// #CSL2 @SET-SYMBOL $CAPACITOR;
// #CSL2 @PLACE(90,-264) => @ORIENT("R0");
// #CSL2 @TEXT("CSL2",key="name",size=1.3,halign="start") => @PLACE(93,-261);
// #CSL2 @TEXT("c=5f",key="value",size=0.9,halign="start") => @PLACE(93,-268);
// #CSL2 @TEXT("",key="model");
// #CSL3 @SET-SYMBOL $CAPACITOR;
// #CSL3 @PLACE(90,-297) => @ORIENT("R0");
// #CSL3 @TEXT("CSL3",key="name",size=1.3,halign="start") => @PLACE(93,-294);
// #CSL3 @TEXT("c=5f",key="value",size=0.9,halign="start") => @PLACE(93,-301);
// #CSL3 @TEXT("",key="model");
// #CSL4 @SET-SYMBOL $CAPACITOR;
// #CSL4 @PLACE(90,-330) => @ORIENT("R0");
// #CSL4 @TEXT("CSL4",key="name",size=1.3,halign="start") => @PLACE(93,-327);
// #CSL4 @TEXT("c=5f",key="value",size=0.9,halign="start") => @PLACE(93,-334);
// #CSL4 @TEXT("",key="model");
// #CSL5 @SET-SYMBOL $CAPACITOR;
// #CSL5 @PLACE(90,-363) => @ORIENT("R0");
// #CSL5 @TEXT("CSL5",key="name",size=1.3,halign="start") => @PLACE(93,-360);
// #CSL5 @TEXT("c=5f",key="value",size=0.9,halign="start") => @PLACE(93,-367);
// #CSL5 @TEXT("",key="model");
// #CSL6 @SET-SYMBOL $CAPACITOR;
// #CSL6 @PLACE(145,0) => @ORIENT("R0");
// #CSL6 @TEXT("CSL6",key="name",size=1.3,halign="start") => @PLACE(148,3);
// #CSL6 @TEXT("c=5f",key="value",size=0.9,halign="start") => @PLACE(148,-4);
// #CSL6 @TEXT("",key="model");
// #CSL7 @SET-SYMBOL $CAPACITOR;
// #CSL7 @PLACE(145,-33) => @ORIENT("R0");
// #CSL7 @TEXT("CSL7",key="name",size=1.3,halign="start") => @PLACE(148,-30);
// #CSL7 @TEXT("c=5f",key="value",size=0.9,halign="start") => @PLACE(148,-37);
// #CSL7 @TEXT("",key="model");
// #RFIN @SET-SYMBOL $RESISTOR;
// #RFIN @PLACE(145,-66) => @ORIENT("R0");
// #RFIN @TEXT("RFIN",key="name",size=1.3,halign="start") => @PLACE(148,-63);
// #RFIN @TEXT("r=50",key="value",size=0.9,halign="start") => @PLACE(148,-70);
// #RFIN @TEXT("",key="model");
// #RFIP @SET-SYMBOL $RESISTOR;
// #RFIP @PLACE(145,-99) => @ORIENT("R0");
// #RFIP @TEXT("RFIP",key="name",size=1.3,halign="start") => @PLACE(148,-96);
// #RFIP @TEXT("r=50",key="value",size=0.9,halign="start") => @PLACE(148,-103);
// #RFIP @TEXT("",key="model");
// #RFRN @SET-SYMBOL $RESISTOR;
// #RFRN @PLACE(145,-132) => @ORIENT("R0");
// #RFRN @TEXT("RFRN",key="name",size=1.3,halign="start") => @PLACE(148,-129);
// #RFRN @TEXT("r=50",key="value",size=0.9,halign="start") => @PLACE(148,-136);
// #RFRN @TEXT("",key="model");
// #RFRP @SET-SYMBOL $RESISTOR;
// #RFRP @PLACE(145,-165) => @ORIENT("R0");
// #RFRP @TEXT("RFRP",key="name",size=1.3,halign="start") => @PLACE(148,-162);
// #RFRP @TEXT("r=50",key="value",size=0.9,halign="start") => @PLACE(148,-169);
// #RFRP @TEXT("",key="model");
// #CFRN @SET-SYMBOL $CAPACITOR;
// #CFRN @PLACE(145,-198) => @ORIENT("R0");
// #CFRN @TEXT("CFRN",key="name",size=1.3,halign="start") => @PLACE(148,-195);
// #CFRN @TEXT("c=4p",key="value",size=0.9,halign="start") => @PLACE(148,-202);
// #CFRN @TEXT("",key="model");
// #CFRP @SET-SYMBOL $CAPACITOR;
// #CFRP @PLACE(145,-231) => @ORIENT("R0");
// #CFRP @TEXT("CFRP",key="name",size=1.3,halign="start") => @PLACE(148,-228);
// #CFRP @TEXT("c=4p",key="value",size=0.9,halign="start") => @PLACE(148,-235);
// #CFRP @TEXT("",key="model");
// #CFL0 @SET-SYMBOL $CAPACITOR;
// #CFL0 @PLACE(145,-264) => @ORIENT("R0");
// #CFL0 @TEXT("CFL0",key="name",size=1.3,halign="start") => @PLACE(148,-261);
// #CFL0 @TEXT("c=5f",key="value",size=0.9,halign="start") => @PLACE(148,-268);
// #CFL0 @TEXT("",key="model");
// #CFL1 @SET-SYMBOL $CAPACITOR;
// #CFL1 @PLACE(145,-297) => @ORIENT("R0");
// #CFL1 @TEXT("CFL1",key="name",size=1.3,halign="start") => @PLACE(148,-294);
// #CFL1 @TEXT("c=5f",key="value",size=0.9,halign="start") => @PLACE(148,-301);
// #CFL1 @TEXT("",key="model");
// #CFL2 @SET-SYMBOL $CAPACITOR;
// #CFL2 @PLACE(145,-330) => @ORIENT("R0");
// #CFL2 @TEXT("CFL2",key="name",size=1.3,halign="start") => @PLACE(148,-327);
// #CFL2 @TEXT("c=5f",key="value",size=0.9,halign="start") => @PLACE(148,-334);
// #CFL2 @TEXT("",key="model");
// #CFL3 @SET-SYMBOL $CAPACITOR;
// #CFL3 @PLACE(145,-363) => @ORIENT("R0");
// #CFL3 @TEXT("CFL3",key="name",size=1.3,halign="start") => @PLACE(148,-360);
// #CFL3 @TEXT("c=5f",key="value",size=0.9,halign="start") => @PLACE(148,-367);
// #CFL3 @TEXT("",key="model");
// #CFL4 @SET-SYMBOL $CAPACITOR;
// #CFL4 @PLACE(200,0) => @ORIENT("R0");
// #CFL4 @TEXT("CFL4",key="name",size=1.3,halign="start") => @PLACE(203,3);
// #CFL4 @TEXT("c=5f",key="value",size=0.9,halign="start") => @PLACE(203,-4);
// #CFL4 @TEXT("",key="model");
// #CFL5 @SET-SYMBOL $CAPACITOR;
// #CFL5 @PLACE(200,-33) => @ORIENT("R0");
// #CFL5 @TEXT("CFL5",key="name",size=1.3,halign="start") => @PLACE(203,-30);
// #CFL5 @TEXT("c=5f",key="value",size=0.9,halign="start") => @PLACE(203,-37);
// #CFL5 @TEXT("",key="model");
// #CFL6 @SET-SYMBOL $CAPACITOR;
// #CFL6 @PLACE(200,-66) => @ORIENT("R0");
// #CFL6 @TEXT("CFL6",key="name",size=1.3,halign="start") => @PLACE(203,-63);
// #CFL6 @TEXT("c=5f",key="value",size=0.9,halign="start") => @PLACE(203,-70);
// #CFL6 @TEXT("",key="model");
// #CFL7 @SET-SYMBOL $CAPACITOR;
// #CFL7 @PLACE(200,-99) => @ORIENT("R0");
// #CFL7 @TEXT("CFL7",key="name",size=1.3,halign="start") => @PLACE(203,-96);
// #CFL7 @TEXT("c=5f",key="value",size=0.9,halign="start") => @PLACE(203,-103);
// #CFL7 @TEXT("",key="model");
// &"s_n" @WIRE(mode="straight",linecolor="#30485d",linewidth=0.16) {#XSAR:11 (38.5,3.3) (38.5,-2) #RSIN:2};
// &"s_p" @WIRE(mode="straight",linecolor="#30485d",linewidth=0.16) {#XSAR:12 (38.5,0) (38.5,-35) #RSIP:2};
// (-89,30) @TEXT("tb_sar / source-derived connections",size=1.4,halign="start",textcolor="#223d52");
// &"s_clock" @WIRE(mode="straight",linecolor="#30485d",linewidth=0.16) {#VSCLOCK:1 (-70,5)};
// (-70,5.4) @TEXT("s_clock",size=1.1,halign="middle",valign="bottom");
// &"0" @WIRE(mode="straight",linecolor="#30485d",linewidth=0.16) {#VSCLOCK:2 (-70,-5)};
// (-70,-5.4) @TEXT("0",size=1.1,halign="middle",valign="top");
// &"s_ps" @WIRE(mode="straight",linecolor="#30485d",linewidth=0.16) {#VSs_ps:1 (-70,-28)};
// (-70,-27.6) @TEXT("s_ps",size=1.1,halign="middle",valign="bottom");
// &"0" @WIRE(mode="straight",linecolor="#30485d",linewidth=0.16) {#VSs_ps:2 (-70,-38)};
// (-70,-38.4) @TEXT("0",size=1.1,halign="middle",valign="top");
// &"s_ns" @WIRE(mode="straight",linecolor="#30485d",linewidth=0.16) {#VSs_ns:1 (-70,-61)};
// (-70,-60.6) @TEXT("s_ns",size=1.1,halign="middle",valign="bottom");
// &"0" @WIRE(mode="straight",linecolor="#30485d",linewidth=0.16) {#VSs_ns:2 (-70,-71)};
// (-70,-71.4) @TEXT("0",size=1.1,halign="middle",valign="top");
// {&"s_d0" &"s_d1" &"s_d2" &"s_d3" &"s_d4" &"s_d5" &"s_d6" &"s_d7"} @WIRE(mode="straight",linewidth=0.3) {#XSAR:1 (16,0)};
// (16.4,0) @TEXT("s_d[7:0]",size=1.1,halign="start",valign="middle");
// &"s_clock" @WIRE(mode="straight",linecolor="#30485d",linewidth=0.16) {#XSAR:9 (-16,6.6)};
// (-16.4,6.6) @TEXT("s_clock",size=1.1,halign="end",valign="middle");
// &"VDD!" @WIRE(mode="straight",linecolor="#30485d",linewidth=0.16) {#XSAR:10 (0,14.9)};
// (0,15.3) @TEXT("VDD!",size=1.1,halign="middle",valign="bottom");
// &"s_rn" @WIRE(mode="straight",linecolor="#30485d",linewidth=0.16) {#XSAR:13 (-16,-3.3)};
// (-16.4,-3.3) @TEXT("s_rn",size=1.1,halign="end",valign="middle");
// &"s_rp" @WIRE(mode="straight",linecolor="#30485d",linewidth=0.16) {#XSAR:14 (-16,-6.6)};
// (-16.4,-6.6) @TEXT("s_rp",size=1.1,halign="end",valign="middle");
// &"0" @WIRE(mode="straight",linecolor="#30485d",linewidth=0.16) {#XSAR:15 (0,-14.9)};
// (0,-15.3) @TEXT("0",size=1.1,halign="middle",valign="top");
// &"s_ns" @WIRE(mode="straight",linecolor="#30485d",linewidth=0.16) {#RSIN:1 (90,5)};
// (90,5.4) @TEXT("s_ns",size=1.1,halign="middle",valign="bottom");
// &"s_ps" @WIRE(mode="straight",linecolor="#30485d",linewidth=0.16) {#RSIP:1 (90,-28)};
// (90,-27.6) @TEXT("s_ps",size=1.1,halign="middle",valign="bottom");
// &"s_rns" @WIRE(mode="straight",linecolor="#30485d",linewidth=0.16) {#VSRN:1 (-70,-94)};
// (-70,-93.6) @TEXT("s_rns",size=1.1,halign="middle",valign="bottom");
// &"0" @WIRE(mode="straight",linecolor="#30485d",linewidth=0.16) {#VSRN:2 (-70,-104)};
// (-70,-104.4) @TEXT("0",size=1.1,halign="middle",valign="top");
// &"s_rps" @WIRE(mode="straight",linecolor="#30485d",linewidth=0.16) {#VSRP:1 (-70,-127)};
// (-70,-126.6) @TEXT("s_rps",size=1.1,halign="middle",valign="bottom");
// &"0" @WIRE(mode="straight",linecolor="#30485d",linewidth=0.16) {#VSRP:2 (-70,-137)};
// (-70,-137.4) @TEXT("0",size=1.1,halign="middle",valign="top");
// &"s_rns" @WIRE(mode="straight",linecolor="#30485d",linewidth=0.16) {#RSRN:1 (90,-61)};
// (90,-60.6) @TEXT("s_rns",size=1.1,halign="middle",valign="bottom");
// &"s_rn" @WIRE(mode="straight",linecolor="#30485d",linewidth=0.16) {#RSRN:2 (90,-71)};
// (90,-71.4) @TEXT("s_rn",size=1.1,halign="middle",valign="top");
// &"s_rps" @WIRE(mode="straight",linecolor="#30485d",linewidth=0.16) {#RSRP:1 (90,-94)};
// (90,-93.6) @TEXT("s_rps",size=1.1,halign="middle",valign="bottom");
// &"s_rp" @WIRE(mode="straight",linecolor="#30485d",linewidth=0.16) {#RSRP:2 (90,-104)};
// (90,-104.4) @TEXT("s_rp",size=1.1,halign="middle",valign="top");
// &"s_rn" @WIRE(mode="straight",linecolor="#30485d",linewidth=0.16) {#CSRN:1 (90,-127)};
// (90,-126.6) @TEXT("s_rn",size=1.1,halign="middle",valign="bottom");
// &"0" @WIRE(mode="straight",linecolor="#30485d",linewidth=0.16) {#CSRN:2 (90,-137)};
// (90,-137.4) @TEXT("0",size=1.1,halign="middle",valign="top");
// &"s_rp" @WIRE(mode="straight",linecolor="#30485d",linewidth=0.16) {#CSRP:1 (90,-160)};
// (90,-159.6) @TEXT("s_rp",size=1.1,halign="middle",valign="bottom");
// &"0" @WIRE(mode="straight",linecolor="#30485d",linewidth=0.16) {#CSRP:2 (90,-170)};
// (90,-170.4) @TEXT("0",size=1.1,halign="middle",valign="top");
// {&"s_d0" &"s_d1" &"s_d2" &"s_d3" &"s_d4" &"s_d5" &"s_d6" &"s_d7"} @WIRE(mode="straight",linewidth=0.3) {#XSPROBE:1 (16,-33)};
// (16.4,-33) @TEXT("s_d[7:0]",size=1.1,halign="start",valign="middle");
// &"s_clock" @WIRE(mode="straight",linecolor="#30485d",linewidth=0.16) {#XSPROBE:9 (-16,-33)};
// (-16.4,-33) @TEXT("s_clock",size=1.1,halign="end",valign="middle");
// &"VDD!" @WIRE(mode="straight",linecolor="#30485d",linewidth=0.16) {#XSPROBE:10 (0,-22)};
// (0,-21.6) @TEXT("VDD!",size=1.1,halign="middle",valign="bottom");
// &"0" @WIRE(mode="straight",linecolor="#30485d",linewidth=0.16) {#XSPROBE:11 (0,-44)};
// (0,-44.4) @TEXT("0",size=1.1,halign="middle",valign="top");
// &"s_d0" @WIRE(mode="straight",linecolor="#30485d",linewidth=0.16) {#CSL0:1 (90,-193)};
// (90,-192.6) @TEXT("s_d0",size=1.1,halign="middle",valign="bottom");
// &"0" @WIRE(mode="straight",linecolor="#30485d",linewidth=0.16) {#CSL0:2 (90,-203)};
// (90,-203.4) @TEXT("0",size=1.1,halign="middle",valign="top");
// &"s_d1" @WIRE(mode="straight",linecolor="#30485d",linewidth=0.16) {#CSL1:1 (90,-226)};
// (90,-225.6) @TEXT("s_d1",size=1.1,halign="middle",valign="bottom");
// &"0" @WIRE(mode="straight",linecolor="#30485d",linewidth=0.16) {#CSL1:2 (90,-236)};
// (90,-236.4) @TEXT("0",size=1.1,halign="middle",valign="top");
// &"s_d2" @WIRE(mode="straight",linecolor="#30485d",linewidth=0.16) {#CSL2:1 (90,-259)};
// (90,-258.6) @TEXT("s_d2",size=1.1,halign="middle",valign="bottom");
// &"0" @WIRE(mode="straight",linecolor="#30485d",linewidth=0.16) {#CSL2:2 (90,-269)};
// (90,-269.4) @TEXT("0",size=1.1,halign="middle",valign="top");
// &"s_d3" @WIRE(mode="straight",linecolor="#30485d",linewidth=0.16) {#CSL3:1 (90,-292)};
// (90,-291.6) @TEXT("s_d3",size=1.1,halign="middle",valign="bottom");
// &"0" @WIRE(mode="straight",linecolor="#30485d",linewidth=0.16) {#CSL3:2 (90,-302)};
// (90,-302.4) @TEXT("0",size=1.1,halign="middle",valign="top");
// &"s_d4" @WIRE(mode="straight",linecolor="#30485d",linewidth=0.16) {#CSL4:1 (90,-325)};
// (90,-324.6) @TEXT("s_d4",size=1.1,halign="middle",valign="bottom");
// &"0" @WIRE(mode="straight",linecolor="#30485d",linewidth=0.16) {#CSL4:2 (90,-335)};
// (90,-335.4) @TEXT("0",size=1.1,halign="middle",valign="top");
// &"s_d5" @WIRE(mode="straight",linecolor="#30485d",linewidth=0.16) {#CSL5:1 (90,-358)};
// (90,-357.6) @TEXT("s_d5",size=1.1,halign="middle",valign="bottom");
// &"0" @WIRE(mode="straight",linecolor="#30485d",linewidth=0.16) {#CSL5:2 (90,-368)};
// (90,-368.4) @TEXT("0",size=1.1,halign="middle",valign="top");
// &"s_d6" @WIRE(mode="straight",linecolor="#30485d",linewidth=0.16) {#CSL6:1 (145,5)};
// (145,5.4) @TEXT("s_d6",size=1.1,halign="middle",valign="bottom");
// &"0" @WIRE(mode="straight",linecolor="#30485d",linewidth=0.16) {#CSL6:2 (145,-5)};
// (145,-5.4) @TEXT("0",size=1.1,halign="middle",valign="top");
// &"s_d7" @WIRE(mode="straight",linecolor="#30485d",linewidth=0.16) {#CSL7:1 (145,-28)};
// (145,-27.6) @TEXT("s_d7",size=1.1,halign="middle",valign="bottom");
// &"0" @WIRE(mode="straight",linecolor="#30485d",linewidth=0.16) {#CSL7:2 (145,-38)};
// (145,-38.4) @TEXT("0",size=1.1,halign="middle",valign="top");
// {&"f_d0" &"f_d1" &"f_d2" &"f_d3" &"f_d4" &"f_d5" &"f_d6" &"f_d7"} @WIRE(mode="straight",linewidth=0.3) {#XSTALLED:1 (16,-66)};
// (16.4,-66) @TEXT("f_d[7:0]",size=1.1,halign="start",valign="middle");
// &"s_clock" @WIRE(mode="straight",linecolor="#30485d",linewidth=0.16) {#XSTALLED:9 (-16,-59.4)};
// (-16.4,-59.4) @TEXT("s_clock",size=1.1,halign="end",valign="middle");
// &"VDD!" @WIRE(mode="straight",linecolor="#30485d",linewidth=0.16) {#XSTALLED:10 (0,-51.1)};
// (0,-50.7) @TEXT("VDD!",size=1.1,halign="middle",valign="bottom");
// &"f_n" @WIRE(mode="straight",linecolor="#30485d",linewidth=0.16) {#XSTALLED:11 (-16,-62.7)};
// (-16.4,-62.7) @TEXT("f_n",size=1.1,halign="end",valign="middle");
// &"f_p" @WIRE(mode="straight",linecolor="#30485d",linewidth=0.16) {#XSTALLED:12 (-16,-66)};
// (-16.4,-66) @TEXT("f_p",size=1.1,halign="end",valign="middle");
// &"f_rn" @WIRE(mode="straight",linecolor="#30485d",linewidth=0.16) {#XSTALLED:13 (-16,-69.3)};
// (-16.4,-69.3) @TEXT("f_rn",size=1.1,halign="end",valign="middle");
// &"f_rp" @WIRE(mode="straight",linecolor="#30485d",linewidth=0.16) {#XSTALLED:14 (-16,-72.6)};
// (-16.4,-72.6) @TEXT("f_rp",size=1.1,halign="end",valign="middle");
// &"0" @WIRE(mode="straight",linecolor="#30485d",linewidth=0.16) {#XSTALLED:15 (0,-80.9)};
// (0,-81.3) @TEXT("0",size=1.1,halign="middle",valign="top");
// &"s_ns" @WIRE(mode="straight",linecolor="#30485d",linewidth=0.16) {#RFIN:1 (145,-61)};
// (145,-60.6) @TEXT("s_ns",size=1.1,halign="middle",valign="bottom");
// &"f_n" @WIRE(mode="straight",linecolor="#30485d",linewidth=0.16) {#RFIN:2 (145,-71)};
// (145,-71.4) @TEXT("f_n",size=1.1,halign="middle",valign="top");
// &"s_ps" @WIRE(mode="straight",linecolor="#30485d",linewidth=0.16) {#RFIP:1 (145,-94)};
// (145,-93.6) @TEXT("s_ps",size=1.1,halign="middle",valign="bottom");
// &"f_p" @WIRE(mode="straight",linecolor="#30485d",linewidth=0.16) {#RFIP:2 (145,-104)};
// (145,-104.4) @TEXT("f_p",size=1.1,halign="middle",valign="top");
// &"f_rns" @WIRE(mode="straight",linecolor="#30485d",linewidth=0.16) {#VFRN:1 (-70,-160)};
// (-70,-159.6) @TEXT("f_rns",size=1.1,halign="middle",valign="bottom");
// &"0" @WIRE(mode="straight",linecolor="#30485d",linewidth=0.16) {#VFRN:2 (-70,-170)};
// (-70,-170.4) @TEXT("0",size=1.1,halign="middle",valign="top");
// &"f_rps" @WIRE(mode="straight",linecolor="#30485d",linewidth=0.16) {#VFRP:1 (-70,-193)};
// (-70,-192.6) @TEXT("f_rps",size=1.1,halign="middle",valign="bottom");
// &"0" @WIRE(mode="straight",linecolor="#30485d",linewidth=0.16) {#VFRP:2 (-70,-203)};
// (-70,-203.4) @TEXT("0",size=1.1,halign="middle",valign="top");
// &"f_rns" @WIRE(mode="straight",linecolor="#30485d",linewidth=0.16) {#RFRN:1 (145,-127)};
// (145,-126.6) @TEXT("f_rns",size=1.1,halign="middle",valign="bottom");
// &"f_rn" @WIRE(mode="straight",linecolor="#30485d",linewidth=0.16) {#RFRN:2 (145,-137)};
// (145,-137.4) @TEXT("f_rn",size=1.1,halign="middle",valign="top");
// &"f_rps" @WIRE(mode="straight",linecolor="#30485d",linewidth=0.16) {#RFRP:1 (145,-160)};
// (145,-159.6) @TEXT("f_rps",size=1.1,halign="middle",valign="bottom");
// &"f_rp" @WIRE(mode="straight",linecolor="#30485d",linewidth=0.16) {#RFRP:2 (145,-170)};
// (145,-170.4) @TEXT("f_rp",size=1.1,halign="middle",valign="top");
// &"f_rn" @WIRE(mode="straight",linecolor="#30485d",linewidth=0.16) {#CFRN:1 (145,-193)};
// (145,-192.6) @TEXT("f_rn",size=1.1,halign="middle",valign="bottom");
// &"0" @WIRE(mode="straight",linecolor="#30485d",linewidth=0.16) {#CFRN:2 (145,-203)};
// (145,-203.4) @TEXT("0",size=1.1,halign="middle",valign="top");
// &"f_rp" @WIRE(mode="straight",linecolor="#30485d",linewidth=0.16) {#CFRP:1 (145,-226)};
// (145,-225.6) @TEXT("f_rp",size=1.1,halign="middle",valign="bottom");
// &"0" @WIRE(mode="straight",linecolor="#30485d",linewidth=0.16) {#CFRP:2 (145,-236)};
// (145,-236.4) @TEXT("0",size=1.1,halign="middle",valign="top");
// &"f_d0" @WIRE(mode="straight",linecolor="#30485d",linewidth=0.16) {#CFL0:1 (145,-259)};
// (145,-258.6) @TEXT("f_d0",size=1.1,halign="middle",valign="bottom");
// &"0" @WIRE(mode="straight",linecolor="#30485d",linewidth=0.16) {#CFL0:2 (145,-269)};
// (145,-269.4) @TEXT("0",size=1.1,halign="middle",valign="top");
// &"f_d1" @WIRE(mode="straight",linecolor="#30485d",linewidth=0.16) {#CFL1:1 (145,-292)};
// (145,-291.6) @TEXT("f_d1",size=1.1,halign="middle",valign="bottom");
// &"0" @WIRE(mode="straight",linecolor="#30485d",linewidth=0.16) {#CFL1:2 (145,-302)};
// (145,-302.4) @TEXT("0",size=1.1,halign="middle",valign="top");
// &"f_d2" @WIRE(mode="straight",linecolor="#30485d",linewidth=0.16) {#CFL2:1 (145,-325)};
// (145,-324.6) @TEXT("f_d2",size=1.1,halign="middle",valign="bottom");
// &"0" @WIRE(mode="straight",linecolor="#30485d",linewidth=0.16) {#CFL2:2 (145,-335)};
// (145,-335.4) @TEXT("0",size=1.1,halign="middle",valign="top");
// &"f_d3" @WIRE(mode="straight",linecolor="#30485d",linewidth=0.16) {#CFL3:1 (145,-358)};
// (145,-357.6) @TEXT("f_d3",size=1.1,halign="middle",valign="bottom");
// &"0" @WIRE(mode="straight",linecolor="#30485d",linewidth=0.16) {#CFL3:2 (145,-368)};
// (145,-368.4) @TEXT("0",size=1.1,halign="middle",valign="top");
// &"f_d4" @WIRE(mode="straight",linecolor="#30485d",linewidth=0.16) {#CFL4:1 (200,5)};
// (200,5.4) @TEXT("f_d4",size=1.1,halign="middle",valign="bottom");
// &"0" @WIRE(mode="straight",linecolor="#30485d",linewidth=0.16) {#CFL4:2 (200,-5)};
// (200,-5.4) @TEXT("0",size=1.1,halign="middle",valign="top");
// &"f_d5" @WIRE(mode="straight",linecolor="#30485d",linewidth=0.16) {#CFL5:1 (200,-28)};
// (200,-27.6) @TEXT("f_d5",size=1.1,halign="middle",valign="bottom");
// &"0" @WIRE(mode="straight",linecolor="#30485d",linewidth=0.16) {#CFL5:2 (200,-38)};
// (200,-38.4) @TEXT("0",size=1.1,halign="middle",valign="top");
// &"f_d6" @WIRE(mode="straight",linecolor="#30485d",linewidth=0.16) {#CFL6:1 (200,-61)};
// (200,-60.6) @TEXT("f_d6",size=1.1,halign="middle",valign="bottom");
// &"0" @WIRE(mode="straight",linecolor="#30485d",linewidth=0.16) {#CFL6:2 (200,-71)};
// (200,-71.4) @TEXT("0",size=1.1,halign="middle",valign="top");
// &"f_d7" @WIRE(mode="straight",linecolor="#30485d",linewidth=0.16) {#CFL7:1 (200,-94)};
// (200,-93.6) @TEXT("f_d7",size=1.1,halign="middle",valign="bottom");
// &"0" @WIRE(mode="straight",linecolor="#30485d",linewidth=0.16) {#CFL7:2 (200,-104)};
// (200,-104.4) @TEXT("0",size=1.1,halign="middle",valign="top");
// }
// END SARADC RNL
ends tb_sar

subckt tb_timing
// Every exported delay/edge helper, loaded by a native standard-cell input.
VTCLOCK (t_clock 0) vsource type=pulse val0=0 val1=0.9 delay=60n rise=100p fall=100p width=39.9n period=100n
XT0 (t_clock VDD! 0 t_out0) sar8p_delay_valid
XTL0 (t_out0 VDD! 0 t_unused0) sar8p_inv
XT1 (t_clock VDD! 0 t_out1) sar8p_delay_write
XTL1 (t_out1 VDD! 0 t_unused1) sar8p_inv
XT2 (t_clock VDD! 0 t_out2) sar8p_delay_quiet
XTL2 (t_out2 VDD! 0 t_unused2) sar8p_inv
XT3 (t_clock VDD! 0 t_out3) sar8p_delay_capture
XTL3 (t_out3 VDD! 0 t_unused3) sar8p_inv
XT4 (t_clock VDD! 0 t_out4) sar8p_delay_bbm
XTL4 (t_out4 VDD! 0 t_unused4) sar8p_inv
XT5 (t_clock VDD! 0 t_out5) sar8r_delay
XTL5 (t_out5 VDD! 0 t_unused5) sar8p_inv
XT6 (t_clock VDD! 0 t_out6) sar8s_step
XTL6 (t_out6 VDD! 0 t_unused6) sar8p_inv
XT7 (t_clock VDD! 0 t_out7) sar8i_guard
XTL7 (t_out7 VDD! 0 t_unused7) sar8p_inv
XT8 (t_clock VDD! 0 t_out8) sar8r_edge
XTL8 (t_out8 VDD! 0 t_unused8) sar8p_inv
XT9 (t_clock VDD! 0 t_out9) sar8p_clkbuf
XTL9 (t_out9 VDD! 0 t_unused9) sar8p_inv

// BEGIN SARADC RNL
// @RNL(author="saradc topology") {
// #VTCLOCK @SET-SYMBOL $VOLTAGE_SOURCE;
// #VTCLOCK @PLACE(-70,0) => @ORIENT("R0");
// #VTCLOCK @TEXT("VTCLOCK",key="name",size=1.3,halign="start") => @PLACE(-67,3);
// #VTCLOCK @TEXT("",key="value",size=0.9,halign="start") => @PLACE(-67,-4);
// #VTCLOCK @TEXT("",key="model");
// #XT0 @SET-SYMBOL $S_sar8p_delay_valid;
// #XT0 @PLACE(0,0) => @ORIENT("R0");
// #XTL0 @SET-SYMBOL $S_sar8p_inv;
// #XTL0 @PLACE(0,-33) => @ORIENT("R0");
// #XT1 @SET-SYMBOL $S_sar8p_delay_write;
// #XT1 @PLACE(0,-66) => @ORIENT("R0");
// #XTL1 @SET-SYMBOL $S_sar8p_inv;
// #XTL1 @PLACE(0,-99) => @ORIENT("R0");
// #XT2 @SET-SYMBOL $S_sar8p_delay_quiet;
// #XT2 @PLACE(0,-132) => @ORIENT("R0");
// #XTL2 @SET-SYMBOL $S_sar8p_inv;
// #XTL2 @PLACE(0,-165) => @ORIENT("R0");
// #XT3 @SET-SYMBOL $S_sar8p_delay_capture;
// #XT3 @PLACE(0,-198) => @ORIENT("R0");
// #XTL3 @SET-SYMBOL $S_sar8p_inv;
// #XTL3 @PLACE(0,-231) => @ORIENT("R0");
// #XT4 @SET-SYMBOL $S_sar8p_delay_bbm;
// #XT4 @PLACE(0,-264) => @ORIENT("R0");
// #XTL4 @SET-SYMBOL $S_sar8p_inv;
// #XTL4 @PLACE(0,-297) => @ORIENT("R0");
// #XT5 @SET-SYMBOL $S_sar8r_delay;
// #XT5 @PLACE(0,-330) => @ORIENT("R0");
// #XTL5 @SET-SYMBOL $S_sar8p_inv;
// #XTL5 @PLACE(0,-363) => @ORIENT("R0");
// #XT6 @SET-SYMBOL $S_sar8s_step;
// #XT6 @PLACE(55,0) => @ORIENT("R0");
// #XTL6 @SET-SYMBOL $S_sar8p_inv;
// #XTL6 @PLACE(55,-33) => @ORIENT("R0");
// #XT7 @SET-SYMBOL $S_sar8i_guard;
// #XT7 @PLACE(55,-66) => @ORIENT("R0");
// #XTL7 @SET-SYMBOL $S_sar8p_inv;
// #XTL7 @PLACE(55,-99) => @ORIENT("R0");
// #XT8 @SET-SYMBOL $S_sar8r_edge;
// #XT8 @PLACE(55,-132) => @ORIENT("R0");
// #XTL8 @SET-SYMBOL $S_sar8p_inv;
// #XTL8 @PLACE(55,-165) => @ORIENT("R0");
// #XT9 @SET-SYMBOL $S_sar8p_clkbuf;
// #XT9 @PLACE(55,-198) => @ORIENT("R0");
// #XTL9 @SET-SYMBOL $S_sar8p_inv;
// #XTL9 @PLACE(55,-231) => @ORIENT("R0");
// &"t_out0" @WIRE(mode="straight",linecolor="#30485d",linewidth=0.16) {#XT0:4 (3,0) (3,-33) #XTL0:1};
// &"t_out1" @WIRE(mode="straight",linecolor="#30485d",linewidth=0.16) {#XT1:4 (3,-66) (3,-99) #XTL1:1};
// &"t_out2" @WIRE(mode="straight",linecolor="#30485d",linewidth=0.16) {#XT2:4 (3,-132) (3,-165) #XTL2:1};
// &"t_out3" @WIRE(mode="straight",linecolor="#30485d",linewidth=0.16) {#XT3:4 (3,-198) (3,-231) #XTL3:1};
// &"t_out4" @WIRE(mode="straight",linecolor="#30485d",linewidth=0.16) {#XT4:4 (3,-264) (3,-297) #XTL4:1};
// &"t_out5" @WIRE(mode="straight",linecolor="#30485d",linewidth=0.16) {#XT5:4 (3,-330) (3,-363) #XTL5:1};
// &"t_out6" @WIRE(mode="straight",linecolor="#30485d",linewidth=0.16) {#XT6:4 (58,0) (58,-33) #XTL6:1};
// &"t_out7" @WIRE(mode="straight",linecolor="#30485d",linewidth=0.16) {#XT7:4 (58,-66) (58,-99) #XTL7:1};
// &"t_out8" @WIRE(mode="straight",linecolor="#30485d",linewidth=0.16) {#XT8:4 (58,-132) (58,-165) #XTL8:1};
// &"t_out9" @WIRE(mode="straight",linecolor="#30485d",linewidth=0.16) {#XT9:4 (55,-198) (55,-231) #XTL9:1};
// (-89,30) @TEXT("tb_timing / source-derived connections",size=1.4,halign="start",textcolor="#223d52");
// &"t_clock" @WIRE(mode="straight",linecolor="#30485d",linewidth=0.16) {#VTCLOCK:1 (-70,5)};
// (-70,5.4) @TEXT("t_clock",size=1.1,halign="middle",valign="bottom");
// &"0" @WIRE(mode="straight",linecolor="#30485d",linewidth=0.16) {#VTCLOCK:2 (-70,-5)};
// (-70,-5.4) @TEXT("0",size=1.1,halign="middle",valign="top");
// &"t_clock" @WIRE(mode="straight",linecolor="#30485d",linewidth=0.16) {#XT0:1 (-16,0)};
// (-16.4,0) @TEXT("t_clock",size=1.1,halign="end",valign="middle");
// &"VDD!" @WIRE(mode="straight",linecolor="#30485d",linewidth=0.16) {#XT0:2 (0,11)};
// (0,11.4) @TEXT("VDD!",size=1.1,halign="middle",valign="bottom");
// &"0" @WIRE(mode="straight",linecolor="#30485d",linewidth=0.16) {#XT0:3 (0,-11)};
// (0,-11.4) @TEXT("0",size=1.1,halign="middle",valign="top");
// &"VDD!" @WIRE(mode="straight",linecolor="#30485d",linewidth=0.16) {#XTL0:2 (0,-23)};
// (0,-22.6) @TEXT("VDD!",size=1.1,halign="middle",valign="bottom");
// &"0" @WIRE(mode="straight",linecolor="#30485d",linewidth=0.16) {#XTL0:3 (0,-43)};
// (0,-43.4) @TEXT("0",size=1.1,halign="middle",valign="top");
// &"t_unused0" @WIRE(mode="straight",linecolor="#30485d",linewidth=0.16) {#XTL0:4 (10,-33)};
// (10.4,-33) @TEXT("t_unused0",size=1.1,halign="start",valign="middle");
// &"t_clock" @WIRE(mode="straight",linecolor="#30485d",linewidth=0.16) {#XT1:1 (-16,-66)};
// (-16.4,-66) @TEXT("t_clock",size=1.1,halign="end",valign="middle");
// &"VDD!" @WIRE(mode="straight",linecolor="#30485d",linewidth=0.16) {#XT1:2 (0,-55)};
// (0,-54.6) @TEXT("VDD!",size=1.1,halign="middle",valign="bottom");
// &"0" @WIRE(mode="straight",linecolor="#30485d",linewidth=0.16) {#XT1:3 (0,-77)};
// (0,-77.4) @TEXT("0",size=1.1,halign="middle",valign="top");
// &"VDD!" @WIRE(mode="straight",linecolor="#30485d",linewidth=0.16) {#XTL1:2 (0,-89)};
// (0,-88.6) @TEXT("VDD!",size=1.1,halign="middle",valign="bottom");
// &"0" @WIRE(mode="straight",linecolor="#30485d",linewidth=0.16) {#XTL1:3 (0,-109)};
// (0,-109.4) @TEXT("0",size=1.1,halign="middle",valign="top");
// &"t_unused1" @WIRE(mode="straight",linecolor="#30485d",linewidth=0.16) {#XTL1:4 (10,-99)};
// (10.4,-99) @TEXT("t_unused1",size=1.1,halign="start",valign="middle");
// &"t_clock" @WIRE(mode="straight",linecolor="#30485d",linewidth=0.16) {#XT2:1 (-16,-132)};
// (-16.4,-132) @TEXT("t_clock",size=1.1,halign="end",valign="middle");
// &"VDD!" @WIRE(mode="straight",linecolor="#30485d",linewidth=0.16) {#XT2:2 (0,-121)};
// (0,-120.6) @TEXT("VDD!",size=1.1,halign="middle",valign="bottom");
// &"0" @WIRE(mode="straight",linecolor="#30485d",linewidth=0.16) {#XT2:3 (0,-143)};
// (0,-143.4) @TEXT("0",size=1.1,halign="middle",valign="top");
// &"VDD!" @WIRE(mode="straight",linecolor="#30485d",linewidth=0.16) {#XTL2:2 (0,-155)};
// (0,-154.6) @TEXT("VDD!",size=1.1,halign="middle",valign="bottom");
// &"0" @WIRE(mode="straight",linecolor="#30485d",linewidth=0.16) {#XTL2:3 (0,-175)};
// (0,-175.4) @TEXT("0",size=1.1,halign="middle",valign="top");
// &"t_unused2" @WIRE(mode="straight",linecolor="#30485d",linewidth=0.16) {#XTL2:4 (10,-165)};
// (10.4,-165) @TEXT("t_unused2",size=1.1,halign="start",valign="middle");
// &"t_clock" @WIRE(mode="straight",linecolor="#30485d",linewidth=0.16) {#XT3:1 (-16,-198)};
// (-16.4,-198) @TEXT("t_clock",size=1.1,halign="end",valign="middle");
// &"VDD!" @WIRE(mode="straight",linecolor="#30485d",linewidth=0.16) {#XT3:2 (0,-187)};
// (0,-186.6) @TEXT("VDD!",size=1.1,halign="middle",valign="bottom");
// &"0" @WIRE(mode="straight",linecolor="#30485d",linewidth=0.16) {#XT3:3 (0,-209)};
// (0,-209.4) @TEXT("0",size=1.1,halign="middle",valign="top");
// &"VDD!" @WIRE(mode="straight",linecolor="#30485d",linewidth=0.16) {#XTL3:2 (0,-221)};
// (0,-220.6) @TEXT("VDD!",size=1.1,halign="middle",valign="bottom");
// &"0" @WIRE(mode="straight",linecolor="#30485d",linewidth=0.16) {#XTL3:3 (0,-241)};
// (0,-241.4) @TEXT("0",size=1.1,halign="middle",valign="top");
// &"t_unused3" @WIRE(mode="straight",linecolor="#30485d",linewidth=0.16) {#XTL3:4 (10,-231)};
// (10.4,-231) @TEXT("t_unused3",size=1.1,halign="start",valign="middle");
// &"t_clock" @WIRE(mode="straight",linecolor="#30485d",linewidth=0.16) {#XT4:1 (-16,-264)};
// (-16.4,-264) @TEXT("t_clock",size=1.1,halign="end",valign="middle");
// &"VDD!" @WIRE(mode="straight",linecolor="#30485d",linewidth=0.16) {#XT4:2 (0,-253)};
// (0,-252.6) @TEXT("VDD!",size=1.1,halign="middle",valign="bottom");
// &"0" @WIRE(mode="straight",linecolor="#30485d",linewidth=0.16) {#XT4:3 (0,-275)};
// (0,-275.4) @TEXT("0",size=1.1,halign="middle",valign="top");
// &"VDD!" @WIRE(mode="straight",linecolor="#30485d",linewidth=0.16) {#XTL4:2 (0,-287)};
// (0,-286.6) @TEXT("VDD!",size=1.1,halign="middle",valign="bottom");
// &"0" @WIRE(mode="straight",linecolor="#30485d",linewidth=0.16) {#XTL4:3 (0,-307)};
// (0,-307.4) @TEXT("0",size=1.1,halign="middle",valign="top");
// &"t_unused4" @WIRE(mode="straight",linecolor="#30485d",linewidth=0.16) {#XTL4:4 (10,-297)};
// (10.4,-297) @TEXT("t_unused4",size=1.1,halign="start",valign="middle");
// &"t_clock" @WIRE(mode="straight",linecolor="#30485d",linewidth=0.16) {#XT5:1 (-16,-330)};
// (-16.4,-330) @TEXT("t_clock",size=1.1,halign="end",valign="middle");
// &"VDD!" @WIRE(mode="straight",linecolor="#30485d",linewidth=0.16) {#XT5:2 (0,-319)};
// (0,-318.6) @TEXT("VDD!",size=1.1,halign="middle",valign="bottom");
// &"0" @WIRE(mode="straight",linecolor="#30485d",linewidth=0.16) {#XT5:3 (0,-341)};
// (0,-341.4) @TEXT("0",size=1.1,halign="middle",valign="top");
// &"VDD!" @WIRE(mode="straight",linecolor="#30485d",linewidth=0.16) {#XTL5:2 (0,-353)};
// (0,-352.6) @TEXT("VDD!",size=1.1,halign="middle",valign="bottom");
// &"0" @WIRE(mode="straight",linecolor="#30485d",linewidth=0.16) {#XTL5:3 (0,-373)};
// (0,-373.4) @TEXT("0",size=1.1,halign="middle",valign="top");
// &"t_unused5" @WIRE(mode="straight",linecolor="#30485d",linewidth=0.16) {#XTL5:4 (10,-363)};
// (10.4,-363) @TEXT("t_unused5",size=1.1,halign="start",valign="middle");
// &"t_clock" @WIRE(mode="straight",linecolor="#30485d",linewidth=0.16) {#XT6:1 (39,0)};
// (38.6,0) @TEXT("t_clock",size=1.1,halign="end",valign="middle");
// &"VDD!" @WIRE(mode="straight",linecolor="#30485d",linewidth=0.16) {#XT6:2 (55,11)};
// (55,11.4) @TEXT("VDD!",size=1.1,halign="middle",valign="bottom");
// &"0" @WIRE(mode="straight",linecolor="#30485d",linewidth=0.16) {#XT6:3 (55,-11)};
// (55,-11.4) @TEXT("0",size=1.1,halign="middle",valign="top");
// &"VDD!" @WIRE(mode="straight",linecolor="#30485d",linewidth=0.16) {#XTL6:2 (55,-23)};
// (55,-22.6) @TEXT("VDD!",size=1.1,halign="middle",valign="bottom");
// &"0" @WIRE(mode="straight",linecolor="#30485d",linewidth=0.16) {#XTL6:3 (55,-43)};
// (55,-43.4) @TEXT("0",size=1.1,halign="middle",valign="top");
// &"t_unused6" @WIRE(mode="straight",linecolor="#30485d",linewidth=0.16) {#XTL6:4 (65,-33)};
// (65.4,-33) @TEXT("t_unused6",size=1.1,halign="start",valign="middle");
// &"t_clock" @WIRE(mode="straight",linecolor="#30485d",linewidth=0.16) {#XT7:1 (39,-66)};
// (38.6,-66) @TEXT("t_clock",size=1.1,halign="end",valign="middle");
// &"VDD!" @WIRE(mode="straight",linecolor="#30485d",linewidth=0.16) {#XT7:2 (55,-55)};
// (55,-54.6) @TEXT("VDD!",size=1.1,halign="middle",valign="bottom");
// &"0" @WIRE(mode="straight",linecolor="#30485d",linewidth=0.16) {#XT7:3 (55,-77)};
// (55,-77.4) @TEXT("0",size=1.1,halign="middle",valign="top");
// &"VDD!" @WIRE(mode="straight",linecolor="#30485d",linewidth=0.16) {#XTL7:2 (55,-89)};
// (55,-88.6) @TEXT("VDD!",size=1.1,halign="middle",valign="bottom");
// &"0" @WIRE(mode="straight",linecolor="#30485d",linewidth=0.16) {#XTL7:3 (55,-109)};
// (55,-109.4) @TEXT("0",size=1.1,halign="middle",valign="top");
// &"t_unused7" @WIRE(mode="straight",linecolor="#30485d",linewidth=0.16) {#XTL7:4 (65,-99)};
// (65.4,-99) @TEXT("t_unused7",size=1.1,halign="start",valign="middle");
// &"t_clock" @WIRE(mode="straight",linecolor="#30485d",linewidth=0.16) {#XT8:1 (39,-132)};
// (38.6,-132) @TEXT("t_clock",size=1.1,halign="end",valign="middle");
// &"VDD!" @WIRE(mode="straight",linecolor="#30485d",linewidth=0.16) {#XT8:2 (55,-121)};
// (55,-120.6) @TEXT("VDD!",size=1.1,halign="middle",valign="bottom");
// &"0" @WIRE(mode="straight",linecolor="#30485d",linewidth=0.16) {#XT8:3 (55,-143)};
// (55,-143.4) @TEXT("0",size=1.1,halign="middle",valign="top");
// &"VDD!" @WIRE(mode="straight",linecolor="#30485d",linewidth=0.16) {#XTL8:2 (55,-155)};
// (55,-154.6) @TEXT("VDD!",size=1.1,halign="middle",valign="bottom");
// &"0" @WIRE(mode="straight",linecolor="#30485d",linewidth=0.16) {#XTL8:3 (55,-175)};
// (55,-175.4) @TEXT("0",size=1.1,halign="middle",valign="top");
// &"t_unused8" @WIRE(mode="straight",linecolor="#30485d",linewidth=0.16) {#XTL8:4 (65,-165)};
// (65.4,-165) @TEXT("t_unused8",size=1.1,halign="start",valign="middle");
// &"t_clock" @WIRE(mode="straight",linecolor="#30485d",linewidth=0.16) {#XT9:1 (45,-198)};
// (44.6,-198) @TEXT("t_clock",size=1.1,halign="end",valign="middle");
// &"VDD!" @WIRE(mode="straight",linecolor="#30485d",linewidth=0.16) {#XT9:2 (55,-188)};
// (55,-187.6) @TEXT("VDD!",size=1.1,halign="middle",valign="bottom");
// &"0" @WIRE(mode="straight",linecolor="#30485d",linewidth=0.16) {#XT9:3 (55,-208)};
// (55,-208.4) @TEXT("0",size=1.1,halign="middle",valign="top");
// &"VDD!" @WIRE(mode="straight",linecolor="#30485d",linewidth=0.16) {#XTL9:2 (55,-221)};
// (55,-220.6) @TEXT("VDD!",size=1.1,halign="middle",valign="bottom");
// &"0" @WIRE(mode="straight",linecolor="#30485d",linewidth=0.16) {#XTL9:3 (55,-241)};
// (55,-241.4) @TEXT("0",size=1.1,halign="middle",valign="top");
// &"t_unused9" @WIRE(mode="straight",linecolor="#30485d",linewidth=0.16) {#XTL9:4 (65,-231)};
// (65.4,-231) @TEXT("t_unused9",size=1.1,halign="start",valign="middle");
// }
// END SARADC RNL
ends tb_timing

subckt tb_sar_top D0 D1 D2 D3 D4 D5 D6 D7 SAMPLE VDD! VINN VINP  VREFN VREFP 0
    XSEQ (SAMPLE_MATCH VDD! 0 SEQ_SAMPLE) sar8r_edge
    XIDLE (ACTIVE SAMPLE_INT VDD! 0 PRESET SAMPLE_MATCH) b_idle
    XSAMPLE (SAMPLE VDD! 0 SAMPLE_INT) sar8p_clkbuf
    XBOOTN (SEQ_SAMPLE TOPN VINN) b_sampler_bridge
    XBOOTP (SEQ_SAMPLE TOPP VINP) b_sampler_bridge
    XCDAC (GNN0 GNN1 GNN2 GNN3 GNN4 GNN5 GNN6 GNN7 GNP0 GNP1 GNP2 GNP3  GNP4 GNP5 GNP6 GNP7 GPN0 GPN1 GPN2 GPN3 GPN4 GPN5 GPN6 GPN7 GPP0  GPP1 GPP2 GPP3 GPP4 GPP5 GPP6 GPP7 TOPN TOPP VDD! VREFN VREFP 0)  b_cdac
    XCTRL (CMP_CLK CODE0 CODE1 CODE2 CODE3 CODE4 CODE5 CODE6 CODE7 COMP_N  COMP_P D0 D1 D2 D3 D4 D5 D6 D7 PHI_U SAMPLE_INT VDD! 0 ACTIVE)  sar8i_ctrl
    XREF (CODE0 CODE1 CODE2 CODE3 CODE4 CODE5 CODE6 CODE7 D0 D1 D2 D3 D4  D5 D6 D7 GNN0 GNN1 GNN2 GNN3 GNN4 GNN5 GNN6 GNN7 GNP0 GNP1 GNP2  GNP3 GNP4 GNP5 GNP6 GNP7 GPN0 GPN1 GPN2 GPN3 GPN4 GPN5 GPN6 GPN7  GPP0 GPP1 GPP2 GPP3 GPP4 GPP5 GPP6 GPP7 PHI_U SAMPLE_INT VDD! 0 RST_DONE PRESET)  b_reference
    XCOMP (CMP_CLK COMP_N COMP_P VDD! TOPN TOPP 0) b_comparator
    CL_COMP_N (COMP_N 0) cfmom_2t nr=8 lr=2.5u w=50n s=50n stm=1 spm=3  multi=2 mismatchflag=1
    CL_COMP_P (COMP_P 0) cfmom_2t nr=8 lr=2.5u w=50n s=50n stm=1 spm=3  multi=2 mismatchflag=1
    CL_CMP_CLK (CMP_CLK 0) cfmom_2t nr=8 lr=2.5u w=50n s=50n stm=1 spm=3  multi=2 mismatchflag=1
// BEGIN SARADC RNL
// @RNL(author="saradc topology") {
// #XSEQ @SET-SYMBOL $S_sar8r_edge;
// #XSEQ @PLACE(0,0) => @ORIENT("R0");
// #XIDLE @SET-SYMBOL $S_b_idle;
// #XIDLE @PLACE(0,-33) => @ORIENT("R0");
// #XSAMPLE @SET-SYMBOL $S_sar8p_clkbuf;
// #XSAMPLE @PLACE(0,-66) => @ORIENT("R0");
// #XBOOTN @SET-SYMBOL $S_b_sampler_bridge;
// #XBOOTN @PLACE(0,-99) => @ORIENT("R0");
// #XBOOTP @SET-SYMBOL $S_b_sampler_bridge;
// #XBOOTP @PLACE(0,-132) => @ORIENT("R0");
// #XCDAC @SET-SYMBOL $S_b_cdac;
// #XCDAC @PLACE(0,-165) => @ORIENT("R0");
// #XCTRL @SET-SYMBOL $S_sar8i_ctrl;
// #XCTRL @PLACE(0,-198) => @ORIENT("R0");
// #XREF @SET-SYMBOL $S_b_reference;
// #XREF @PLACE(0,-231) => @ORIENT("R0");
// #XCOMP @SET-SYMBOL $S_b_comparator;
// #XCOMP @PLACE(0,-264) => @ORIENT("R0");
// #CL_COMP_N @SET-SYMBOL $CAPACITOR;
// #CL_COMP_N @PLACE(90,0) => @ORIENT("R0");
// #CL_COMP_N @TEXT("CL_COMP_N",key="name",size=1.3,halign="start") => @PLACE(93,3);
// #CL_COMP_N @TEXT("nr=8 lr=2.5u w=50n multi=2",key="value",size=0.9,halign="start") => @PLACE(93,-4);
// #CL_COMP_N @TEXT("",key="model");
// #CL_COMP_P @SET-SYMBOL $CAPACITOR;
// #CL_COMP_P @PLACE(90,-33) => @ORIENT("R0");
// #CL_COMP_P @TEXT("CL_COMP_P",key="name",size=1.3,halign="start") => @PLACE(93,-30);
// #CL_COMP_P @TEXT("nr=8 lr=2.5u w=50n multi=2",key="value",size=0.9,halign="start") => @PLACE(93,-37);
// #CL_COMP_P @TEXT("",key="model");
// #CL_CMP_CLK @SET-SYMBOL $CAPACITOR;
// #CL_CMP_CLK @PLACE(90,-66) => @ORIENT("R0");
// #CL_CMP_CLK @TEXT("CL_CMP_CLK",key="name",size=1.3,halign="start") => @PLACE(93,-63);
// #CL_CMP_CLK @TEXT("nr=8 lr=2.5u w=50n multi=2",key="value",size=0.9,halign="start") => @PLACE(93,-70);
// #CL_CMP_CLK @TEXT("",key="model");
// &"SAMPLE_MATCH" @WIRE(mode="straight",linecolor="#30485d",linewidth=0.16) {#XSEQ:1 (0,0) (0,-36.3) #XIDLE:6};
// &"PHI_U" @WIRE(mode="straight",linecolor="#30485d",linewidth=0.16) {#XCTRL:20 (0,-201.3) (0,-232.65) #XREF:49};
// (-89,30) @TEXT("tb_sar_top / source-derived connections",size=1.4,halign="start",textcolor="#223d52");
// &"VDD!" @WIRE(mode="straight",linecolor="#30485d",linewidth=0.16) {#XSEQ:2 (0,11)};
// (0,11.4) @TEXT("VDD!",size=1.1,halign="middle",valign="bottom");
// &"0" @WIRE(mode="straight",linecolor="#30485d",linewidth=0.16) {#XSEQ:3 (0,-11)};
// (0,-11.4) @TEXT("0",size=1.1,halign="middle",valign="top");
// &"SEQ_SAMPLE" @WIRE(mode="straight",linecolor="#30485d",linewidth=0.16) {#XSEQ:4 (16,0)};
// (16.4,0) @TEXT("SEQ_SAMPLE",size=1.1,halign="start",valign="middle");
// &"ACTIVE" @WIRE(mode="straight",linecolor="#30485d",linewidth=0.16) {#XIDLE:1 (16,-29.7)};
// (16.4,-29.7) @TEXT("ACTIVE",size=1.1,halign="start",valign="middle");
// &"SAMPLE_INT" @WIRE(mode="straight",linecolor="#30485d",linewidth=0.16) {#XIDLE:2 (-16,-33)};
// (-16.4,-33) @TEXT("SAMPLE_INT",size=1.1,halign="end",valign="middle");
// &"VDD!" @WIRE(mode="straight",linecolor="#30485d",linewidth=0.16) {#XIDLE:3 (0,-21.4)};
// (0,-21) @TEXT("VDD!",size=1.1,halign="middle",valign="bottom");
// &"0" @WIRE(mode="straight",linecolor="#30485d",linewidth=0.16) {#XIDLE:4 (0,-44.6)};
// (0,-45) @TEXT("0",size=1.1,halign="middle",valign="top");
// &"PRESET" @WIRE(mode="straight",linecolor="#30485d",linewidth=0.16) {#XIDLE:5 (16,-33)};
// (16.4,-33) @TEXT("PRESET",size=1.1,halign="start",valign="middle");
// &"SAMPLE" @WIRE(mode="straight",linecolor="#30485d",linewidth=0.16) {#XSAMPLE:1 (-10,-66)};
// (-10.4,-66) @TEXT("SAMPLE",size=1.1,halign="end",valign="middle");
// &"VDD!" @WIRE(mode="straight",linecolor="#30485d",linewidth=0.16) {#XSAMPLE:2 (0,-56)};
// (0,-55.6) @TEXT("VDD!",size=1.1,halign="middle",valign="bottom");
// &"0" @WIRE(mode="straight",linecolor="#30485d",linewidth=0.16) {#XSAMPLE:3 (0,-76)};
// (0,-76.4) @TEXT("0",size=1.1,halign="middle",valign="top");
// &"SAMPLE_INT" @WIRE(mode="straight",linecolor="#30485d",linewidth=0.16) {#XSAMPLE:4 (10,-66)};
// (10.4,-66) @TEXT("SAMPLE_INT",size=1.1,halign="start",valign="middle");
// &"SEQ_SAMPLE" @WIRE(mode="straight",linecolor="#30485d",linewidth=0.16) {#XBOOTN:1 (-16,-97.35)};
// (-16.4,-97.35) @TEXT("SEQ_SAMPLE",size=1.1,halign="end",valign="middle");
// &"TOPN" @WIRE(mode="straight",linecolor="#30485d",linewidth=0.16) {#XBOOTN:2 (16,-99)};
// (16.4,-99) @TEXT("TOPN",size=1.1,halign="start",valign="middle");
// &"VINN" @WIRE(mode="straight",linecolor="#30485d",linewidth=0.16) {#XBOOTN:3 (-16,-100.65)};
// (-16.4,-100.65) @TEXT("VINN",size=1.1,halign="end",valign="middle");
// &"SEQ_SAMPLE" @WIRE(mode="straight",linecolor="#30485d",linewidth=0.16) {#XBOOTP:1 (-16,-130.35)};
// (-16.4,-130.35) @TEXT("SEQ_SAMPLE",size=1.1,halign="end",valign="middle");
// &"TOPP" @WIRE(mode="straight",linecolor="#30485d",linewidth=0.16) {#XBOOTP:2 (16,-132)};
// (16.4,-132) @TEXT("TOPP",size=1.1,halign="start",valign="middle");
// &"VINP" @WIRE(mode="straight",linecolor="#30485d",linewidth=0.16) {#XBOOTP:3 (-16,-133.65)};
// (-16.4,-133.65) @TEXT("VINP",size=1.1,halign="end",valign="middle");
// {&"GNN0" &"GNN1" &"GNN2" &"GNN3" &"GNN4" &"GNN5" &"GNN6" &"GNN7"} @WIRE(mode="straight",linewidth=0.3) {#XCDAC:1 (-16,-156.75)};
// (-16.4,-156.75) @TEXT("GNN[7:0]",size=1.1,halign="end",valign="middle");
// {&"GNP0" &"GNP1" &"GNP2" &"GNP3" &"GNP4" &"GNP5" &"GNP6" &"GNP7"} @WIRE(mode="straight",linewidth=0.3) {#XCDAC:9 (-16,-160.05)};
// (-16.4,-160.05) @TEXT("GNP[7:0]",size=1.1,halign="end",valign="middle");
// {&"GPN0" &"GPN1" &"GPN2" &"GPN3" &"GPN4" &"GPN5" &"GPN6" &"GPN7"} @WIRE(mode="straight",linewidth=0.3) {#XCDAC:17 (-16,-163.35)};
// (-16.4,-163.35) @TEXT("GPN[7:0]",size=1.1,halign="end",valign="middle");
// {&"GPP0" &"GPP1" &"GPP2" &"GPP3" &"GPP4" &"GPP5" &"GPP6" &"GPP7"} @WIRE(mode="straight",linewidth=0.3) {#XCDAC:25 (-16,-166.65)};
// (-16.4,-166.65) @TEXT("GPP[7:0]",size=1.1,halign="end",valign="middle");
// &"TOPN" @WIRE(mode="straight",linecolor="#30485d",linewidth=0.16) {#XCDAC:33 (16,-163.35)};
// (16.4,-163.35) @TEXT("TOPN",size=1.1,halign="start",valign="middle");
// &"TOPP" @WIRE(mode="straight",linecolor="#30485d",linewidth=0.16) {#XCDAC:34 (16,-166.65)};
// (16.4,-166.65) @TEXT("TOPP",size=1.1,halign="start",valign="middle");
// &"VDD!" @WIRE(mode="straight",linecolor="#30485d",linewidth=0.16) {#XCDAC:35 (0,-148.45)};
// (0,-148.05) @TEXT("VDD!",size=1.1,halign="middle",valign="bottom");
// &"VREFN" @WIRE(mode="straight",linecolor="#30485d",linewidth=0.16) {#XCDAC:36 (-16,-169.95)};
// (-16.4,-169.95) @TEXT("VREFN",size=1.1,halign="end",valign="middle");
// &"VREFP" @WIRE(mode="straight",linecolor="#30485d",linewidth=0.16) {#XCDAC:37 (-16,-173.25)};
// (-16.4,-173.25) @TEXT("VREFP",size=1.1,halign="end",valign="middle");
// &"0" @WIRE(mode="straight",linecolor="#30485d",linewidth=0.16) {#XCDAC:38 (0,-181.55)};
// (0,-181.95) @TEXT("0",size=1.1,halign="middle",valign="top");
// &"CMP_CLK" @WIRE(mode="straight",linecolor="#30485d",linewidth=0.16) {#XCTRL:1 (16,-191.4)};
// (16.4,-191.4) @TEXT("CMP_CLK",size=1.1,halign="start",valign="middle");
// {&"CODE0" &"CODE1" &"CODE2" &"CODE3" &"CODE4" &"CODE5" &"CODE6" &"CODE7"} @WIRE(mode="straight",linewidth=0.3) {#XCTRL:2 (16,-194.7)};
// (16.4,-194.7) @TEXT("CODE[7:0]",size=1.1,halign="start",valign="middle");
// &"COMP_N" @WIRE(mode="straight",linecolor="#30485d",linewidth=0.16) {#XCTRL:10 (-16,-194.7)};
// (-16.4,-194.7) @TEXT("COMP_N",size=1.1,halign="end",valign="middle");
// &"COMP_P" @WIRE(mode="straight",linecolor="#30485d",linewidth=0.16) {#XCTRL:11 (-16,-198)};
// (-16.4,-198) @TEXT("COMP_P",size=1.1,halign="end",valign="middle");
// {&"D0" &"D1" &"D2" &"D3" &"D4" &"D5" &"D6" &"D7"} @WIRE(mode="straight",linewidth=0.3) {#XCTRL:12 (16,-198)};
// (16.4,-198) @TEXT("D[7:0]",size=1.1,halign="start",valign="middle");
// &"SAMPLE_INT" @WIRE(mode="straight",linecolor="#30485d",linewidth=0.16) {#XCTRL:21 (-16,-201.3)};
// (-16.4,-201.3) @TEXT("SAMPLE_INT",size=1.1,halign="end",valign="middle");
// &"VDD!" @WIRE(mode="straight",linecolor="#30485d",linewidth=0.16) {#XCTRL:22 (0,-183.1)};
// (0,-182.7) @TEXT("VDD!",size=1.1,halign="middle",valign="bottom");
// &"0" @WIRE(mode="straight",linecolor="#30485d",linewidth=0.16) {#XCTRL:23 (0,-212.9)};
// (0,-213.3) @TEXT("0",size=1.1,halign="middle",valign="top");
// &"ACTIVE" @WIRE(mode="straight",linecolor="#30485d",linewidth=0.16) {#XCTRL:24 (16,-204.6)};
// (16.4,-204.6) @TEXT("ACTIVE",size=1.1,halign="start",valign="middle");
// {&"CODE0" &"CODE1" &"CODE2" &"CODE3" &"CODE4" &"CODE5" &"CODE6" &"CODE7"} @WIRE(mode="straight",linewidth=0.3) {#XREF:1 (-16,-226.05)};
// (-16.4,-226.05) @TEXT("CODE[7:0]",size=1.1,halign="end",valign="middle");
// {&"D0" &"D1" &"D2" &"D3" &"D4" &"D5" &"D6" &"D7"} @WIRE(mode="straight",linewidth=0.3) {#XREF:9 (-16,-229.35)};
// (-16.4,-229.35) @TEXT("D[7:0]",size=1.1,halign="end",valign="middle");
// {&"GNN0" &"GNN1" &"GNN2" &"GNN3" &"GNN4" &"GNN5" &"GNN6" &"GNN7"} @WIRE(mode="straight",linewidth=0.3) {#XREF:17 (16,-222.75)};
// (16.4,-222.75) @TEXT("GNN[7:0]",size=1.1,halign="start",valign="middle");
// {&"GNP0" &"GNP1" &"GNP2" &"GNP3" &"GNP4" &"GNP5" &"GNP6" &"GNP7"} @WIRE(mode="straight",linewidth=0.3) {#XREF:25 (16,-226.05)};
// (16.4,-226.05) @TEXT("GNP[7:0]",size=1.1,halign="start",valign="middle");
// {&"GPN0" &"GPN1" &"GPN2" &"GPN3" &"GPN4" &"GPN5" &"GPN6" &"GPN7"} @WIRE(mode="straight",linewidth=0.3) {#XREF:33 (16,-229.35)};
// (16.4,-229.35) @TEXT("GPN[7:0]",size=1.1,halign="start",valign="middle");
// {&"GPP0" &"GPP1" &"GPP2" &"GPP3" &"GPP4" &"GPP5" &"GPP6" &"GPP7"} @WIRE(mode="straight",linewidth=0.3) {#XREF:41 (16,-232.65)};
// (16.4,-232.65) @TEXT("GPP[7:0]",size=1.1,halign="start",valign="middle");
// &"SAMPLE_INT" @WIRE(mode="straight",linecolor="#30485d",linewidth=0.16) {#XREF:50 (-16,-235.95)};
// (-16.4,-235.95) @TEXT("SAMPLE_INT",size=1.1,halign="end",valign="middle");
// &"VDD!" @WIRE(mode="straight",linecolor="#30485d",linewidth=0.16) {#XREF:51 (0,-214.45)};
// (0,-214.05) @TEXT("VDD!",size=1.1,halign="middle",valign="bottom");
// &"0" @WIRE(mode="straight",linecolor="#30485d",linewidth=0.16) {#XREF:52 (0,-247.55)};
// (0,-247.95) @TEXT("0",size=1.1,halign="middle",valign="top");
// &"RST_DONE" @WIRE(mode="straight",linecolor="#30485d",linewidth=0.16) {#XREF:53 (16,-235.95)};
// (16.4,-235.95) @TEXT("RST_DONE",size=1.1,halign="start",valign="middle");
// &"PRESET" @WIRE(mode="straight",linecolor="#30485d",linewidth=0.16) {#XREF:54 (16,-239.25)};
// (16.4,-239.25) @TEXT("PRESET",size=1.1,halign="start",valign="middle");
// &"CMP_CLK" @WIRE(mode="straight",linecolor="#30485d",linewidth=0.16) {#XCOMP:1 (-16,-260.7)};
// (-16.4,-260.7) @TEXT("CMP_CLK",size=1.1,halign="end",valign="middle");
// &"COMP_N" @WIRE(mode="straight",linecolor="#30485d",linewidth=0.16) {#XCOMP:2 (16,-262.35)};
// (16.4,-262.35) @TEXT("COMP_N",size=1.1,halign="start",valign="middle");
// &"COMP_P" @WIRE(mode="straight",linecolor="#30485d",linewidth=0.16) {#XCOMP:3 (16,-265.65)};
// (16.4,-265.65) @TEXT("COMP_P",size=1.1,halign="start",valign="middle");
// &"VDD!" @WIRE(mode="straight",linecolor="#30485d",linewidth=0.16) {#XCOMP:4 (0,-252.4)};
// (0,-252) @TEXT("VDD!",size=1.1,halign="middle",valign="bottom");
// &"TOPN" @WIRE(mode="straight",linecolor="#30485d",linewidth=0.16) {#XCOMP:5 (-16,-264)};
// (-16.4,-264) @TEXT("TOPN",size=1.1,halign="end",valign="middle");
// &"TOPP" @WIRE(mode="straight",linecolor="#30485d",linewidth=0.16) {#XCOMP:6 (-16,-267.3)};
// (-16.4,-267.3) @TEXT("TOPP",size=1.1,halign="end",valign="middle");
// &"0" @WIRE(mode="straight",linecolor="#30485d",linewidth=0.16) {#XCOMP:7 (0,-275.6)};
// (0,-276) @TEXT("0",size=1.1,halign="middle",valign="top");
// &"COMP_N" @WIRE(mode="straight",linecolor="#30485d",linewidth=0.16) {#CL_COMP_N:1 (90,5)};
// (90,5.4) @TEXT("COMP_N",size=1.1,halign="middle",valign="bottom");
// &"0" @WIRE(mode="straight",linecolor="#30485d",linewidth=0.16) {#CL_COMP_N:2 (90,-5)};
// (90,-5.4) @TEXT("0",size=1.1,halign="middle",valign="top");
// &"COMP_P" @WIRE(mode="straight",linecolor="#30485d",linewidth=0.16) {#CL_COMP_P:1 (90,-28)};
// (90,-27.6) @TEXT("COMP_P",size=1.1,halign="middle",valign="bottom");
// &"0" @WIRE(mode="straight",linecolor="#30485d",linewidth=0.16) {#CL_COMP_P:2 (90,-38)};
// (90,-38.4) @TEXT("0",size=1.1,halign="middle",valign="top");
// &"CMP_CLK" @WIRE(mode="straight",linecolor="#30485d",linewidth=0.16) {#CL_CMP_CLK:1 (90,-61)};
// (90,-60.6) @TEXT("CMP_CLK",size=1.1,halign="middle",valign="bottom");
// &"0" @WIRE(mode="straight",linecolor="#30485d",linewidth=0.16) {#CL_CMP_CLK:2 (90,-71)};
// (90,-71.4) @TEXT("0",size=1.1,halign="middle",valign="top");
// }
// END SARADC RNL
ends tb_sar_top

subckt tb_sar_stalled_top D0 D1 D2 D3 D4 D5 D6 D7 SAMPLE VDD! VINN VINP  VREFN VREFP 0
    XSEQ (SAMPLE_MATCH VDD! 0 SEQ_SAMPLE) sar8r_edge
    XIDLE (ACTIVE SAMPLE_INT VDD! 0 PRESET SAMPLE_MATCH) b_idle
    XSAMPLE (SAMPLE VDD! 0 SAMPLE_INT) sar8p_clkbuf
    XBOOTN (SEQ_SAMPLE TOPN VINN) b_sampler_bridge
    XBOOTP (SEQ_SAMPLE TOPP VINP) b_sampler_bridge
    XCDAC (GNN0 GNN1 GNN2 GNN3 GNN4 GNN5 GNN6 GNN7 GNP0 GNP1 GNP2 GNP3  GNP4 GNP5 GNP6 GNP7 GPN0 GPN1 GPN2 GPN3 GPN4 GPN5 GPN6 GPN7 GPP0  GPP1 GPP2 GPP3 GPP4 GPP5 GPP6 GPP7 TOPN TOPP VDD! VREFN VREFP 0)  b_cdac
    XCTRL (CMP_CLK CODE0 CODE1 CODE2 CODE3 CODE4 CODE5 CODE6 CODE7 COMP_N  COMP_P D0 D1 D2 D3 D4 D5 D6 D7 PHI_U SAMPLE_INT VDD! 0 ACTIVE)  sar8i_ctrl
    XREF (CODE0 CODE1 CODE2 CODE3 CODE4 CODE5 CODE6 CODE7 D0 D1 D2 D3 D4  D5 D6 D7 GNN0 GNN1 GNN2 GNN3 GNN4 GNN5 GNN6 GNN7 GNP0 GNP1 GNP2  GNP3 GNP4 GNP5 GNP6 GNP7 GPN0 GPN1 GPN2 GPN3 GPN4 GPN5 GPN6 GPN7  GPP0 GPP1 GPP2 GPP3 GPP4 GPP5 GPP6 GPP7 PHI_U SAMPLE_INT VDD! 0 RST_DONE PRESET)  b_reference
    XCOMP (CMP_CLK COMP_N COMP_P VDD! TOPN TOPP 0) b_comparator force_stuck=1
    CL_COMP_N (COMP_N 0) cfmom_2t nr=8 lr=2.5u w=50n s=50n stm=1 spm=3  multi=2 mismatchflag=1
    CL_COMP_P (COMP_P 0) cfmom_2t nr=8 lr=2.5u w=50n s=50n stm=1 spm=3  multi=2 mismatchflag=1
    CL_CMP_CLK (CMP_CLK 0) cfmom_2t nr=8 lr=2.5u w=50n s=50n stm=1 spm=3  multi=2 mismatchflag=1
// BEGIN SARADC RNL
// @RNL(author="saradc topology") {
// #XSEQ @SET-SYMBOL $S_sar8r_edge;
// #XSEQ @PLACE(0,0) => @ORIENT("R0");
// #XIDLE @SET-SYMBOL $S_b_idle;
// #XIDLE @PLACE(0,-33) => @ORIENT("R0");
// #XSAMPLE @SET-SYMBOL $S_sar8p_clkbuf;
// #XSAMPLE @PLACE(0,-66) => @ORIENT("R0");
// #XBOOTN @SET-SYMBOL $S_b_sampler_bridge;
// #XBOOTN @PLACE(0,-99) => @ORIENT("R0");
// #XBOOTP @SET-SYMBOL $S_b_sampler_bridge;
// #XBOOTP @PLACE(0,-132) => @ORIENT("R0");
// #XCDAC @SET-SYMBOL $S_b_cdac;
// #XCDAC @PLACE(0,-165) => @ORIENT("R0");
// #XCTRL @SET-SYMBOL $S_sar8i_ctrl;
// #XCTRL @PLACE(0,-198) => @ORIENT("R0");
// #XREF @SET-SYMBOL $S_b_reference;
// #XREF @PLACE(0,-231) => @ORIENT("R0");
// #XCOMP @SET-SYMBOL $S_b_comparator;
// #XCOMP @PLACE(0,-264) => @ORIENT("R0");
// #CL_COMP_N @SET-SYMBOL $CAPACITOR;
// #CL_COMP_N @PLACE(90,0) => @ORIENT("R0");
// #CL_COMP_N @TEXT("CL_COMP_N",key="name",size=1.3,halign="start") => @PLACE(93,3);
// #CL_COMP_N @TEXT("nr=8 lr=2.5u w=50n multi=2",key="value",size=0.9,halign="start") => @PLACE(93,-4);
// #CL_COMP_N @TEXT("",key="model");
// #CL_COMP_P @SET-SYMBOL $CAPACITOR;
// #CL_COMP_P @PLACE(90,-33) => @ORIENT("R0");
// #CL_COMP_P @TEXT("CL_COMP_P",key="name",size=1.3,halign="start") => @PLACE(93,-30);
// #CL_COMP_P @TEXT("nr=8 lr=2.5u w=50n multi=2",key="value",size=0.9,halign="start") => @PLACE(93,-37);
// #CL_COMP_P @TEXT("",key="model");
// #CL_CMP_CLK @SET-SYMBOL $CAPACITOR;
// #CL_CMP_CLK @PLACE(90,-66) => @ORIENT("R0");
// #CL_CMP_CLK @TEXT("CL_CMP_CLK",key="name",size=1.3,halign="start") => @PLACE(93,-63);
// #CL_CMP_CLK @TEXT("nr=8 lr=2.5u w=50n multi=2",key="value",size=0.9,halign="start") => @PLACE(93,-70);
// #CL_CMP_CLK @TEXT("",key="model");
// &"SAMPLE_MATCH" @WIRE(mode="straight",linecolor="#30485d",linewidth=0.16) {#XSEQ:1 (0,0) (0,-36.3) #XIDLE:6};
// &"PHI_U" @WIRE(mode="straight",linecolor="#30485d",linewidth=0.16) {#XCTRL:20 (0,-201.3) (0,-232.65) #XREF:49};
// (-89,30) @TEXT("tb_sar_stalled_top / source-derived connections",size=1.4,halign="start",textcolor="#223d52");
// &"VDD!" @WIRE(mode="straight",linecolor="#30485d",linewidth=0.16) {#XSEQ:2 (0,11)};
// (0,11.4) @TEXT("VDD!",size=1.1,halign="middle",valign="bottom");
// &"0" @WIRE(mode="straight",linecolor="#30485d",linewidth=0.16) {#XSEQ:3 (0,-11)};
// (0,-11.4) @TEXT("0",size=1.1,halign="middle",valign="top");
// &"SEQ_SAMPLE" @WIRE(mode="straight",linecolor="#30485d",linewidth=0.16) {#XSEQ:4 (16,0)};
// (16.4,0) @TEXT("SEQ_SAMPLE",size=1.1,halign="start",valign="middle");
// &"ACTIVE" @WIRE(mode="straight",linecolor="#30485d",linewidth=0.16) {#XIDLE:1 (16,-29.7)};
// (16.4,-29.7) @TEXT("ACTIVE",size=1.1,halign="start",valign="middle");
// &"SAMPLE_INT" @WIRE(mode="straight",linecolor="#30485d",linewidth=0.16) {#XIDLE:2 (-16,-33)};
// (-16.4,-33) @TEXT("SAMPLE_INT",size=1.1,halign="end",valign="middle");
// &"VDD!" @WIRE(mode="straight",linecolor="#30485d",linewidth=0.16) {#XIDLE:3 (0,-21.4)};
// (0,-21) @TEXT("VDD!",size=1.1,halign="middle",valign="bottom");
// &"0" @WIRE(mode="straight",linecolor="#30485d",linewidth=0.16) {#XIDLE:4 (0,-44.6)};
// (0,-45) @TEXT("0",size=1.1,halign="middle",valign="top");
// &"PRESET" @WIRE(mode="straight",linecolor="#30485d",linewidth=0.16) {#XIDLE:5 (16,-33)};
// (16.4,-33) @TEXT("PRESET",size=1.1,halign="start",valign="middle");
// &"SAMPLE" @WIRE(mode="straight",linecolor="#30485d",linewidth=0.16) {#XSAMPLE:1 (-10,-66)};
// (-10.4,-66) @TEXT("SAMPLE",size=1.1,halign="end",valign="middle");
// &"VDD!" @WIRE(mode="straight",linecolor="#30485d",linewidth=0.16) {#XSAMPLE:2 (0,-56)};
// (0,-55.6) @TEXT("VDD!",size=1.1,halign="middle",valign="bottom");
// &"0" @WIRE(mode="straight",linecolor="#30485d",linewidth=0.16) {#XSAMPLE:3 (0,-76)};
// (0,-76.4) @TEXT("0",size=1.1,halign="middle",valign="top");
// &"SAMPLE_INT" @WIRE(mode="straight",linecolor="#30485d",linewidth=0.16) {#XSAMPLE:4 (10,-66)};
// (10.4,-66) @TEXT("SAMPLE_INT",size=1.1,halign="start",valign="middle");
// &"SEQ_SAMPLE" @WIRE(mode="straight",linecolor="#30485d",linewidth=0.16) {#XBOOTN:1 (-16,-97.35)};
// (-16.4,-97.35) @TEXT("SEQ_SAMPLE",size=1.1,halign="end",valign="middle");
// &"TOPN" @WIRE(mode="straight",linecolor="#30485d",linewidth=0.16) {#XBOOTN:2 (16,-99)};
// (16.4,-99) @TEXT("TOPN",size=1.1,halign="start",valign="middle");
// &"VINN" @WIRE(mode="straight",linecolor="#30485d",linewidth=0.16) {#XBOOTN:3 (-16,-100.65)};
// (-16.4,-100.65) @TEXT("VINN",size=1.1,halign="end",valign="middle");
// &"SEQ_SAMPLE" @WIRE(mode="straight",linecolor="#30485d",linewidth=0.16) {#XBOOTP:1 (-16,-130.35)};
// (-16.4,-130.35) @TEXT("SEQ_SAMPLE",size=1.1,halign="end",valign="middle");
// &"TOPP" @WIRE(mode="straight",linecolor="#30485d",linewidth=0.16) {#XBOOTP:2 (16,-132)};
// (16.4,-132) @TEXT("TOPP",size=1.1,halign="start",valign="middle");
// &"VINP" @WIRE(mode="straight",linecolor="#30485d",linewidth=0.16) {#XBOOTP:3 (-16,-133.65)};
// (-16.4,-133.65) @TEXT("VINP",size=1.1,halign="end",valign="middle");
// {&"GNN0" &"GNN1" &"GNN2" &"GNN3" &"GNN4" &"GNN5" &"GNN6" &"GNN7"} @WIRE(mode="straight",linewidth=0.3) {#XCDAC:1 (-16,-156.75)};
// (-16.4,-156.75) @TEXT("GNN[7:0]",size=1.1,halign="end",valign="middle");
// {&"GNP0" &"GNP1" &"GNP2" &"GNP3" &"GNP4" &"GNP5" &"GNP6" &"GNP7"} @WIRE(mode="straight",linewidth=0.3) {#XCDAC:9 (-16,-160.05)};
// (-16.4,-160.05) @TEXT("GNP[7:0]",size=1.1,halign="end",valign="middle");
// {&"GPN0" &"GPN1" &"GPN2" &"GPN3" &"GPN4" &"GPN5" &"GPN6" &"GPN7"} @WIRE(mode="straight",linewidth=0.3) {#XCDAC:17 (-16,-163.35)};
// (-16.4,-163.35) @TEXT("GPN[7:0]",size=1.1,halign="end",valign="middle");
// {&"GPP0" &"GPP1" &"GPP2" &"GPP3" &"GPP4" &"GPP5" &"GPP6" &"GPP7"} @WIRE(mode="straight",linewidth=0.3) {#XCDAC:25 (-16,-166.65)};
// (-16.4,-166.65) @TEXT("GPP[7:0]",size=1.1,halign="end",valign="middle");
// &"TOPN" @WIRE(mode="straight",linecolor="#30485d",linewidth=0.16) {#XCDAC:33 (16,-163.35)};
// (16.4,-163.35) @TEXT("TOPN",size=1.1,halign="start",valign="middle");
// &"TOPP" @WIRE(mode="straight",linecolor="#30485d",linewidth=0.16) {#XCDAC:34 (16,-166.65)};
// (16.4,-166.65) @TEXT("TOPP",size=1.1,halign="start",valign="middle");
// &"VDD!" @WIRE(mode="straight",linecolor="#30485d",linewidth=0.16) {#XCDAC:35 (0,-148.45)};
// (0,-148.05) @TEXT("VDD!",size=1.1,halign="middle",valign="bottom");
// &"VREFN" @WIRE(mode="straight",linecolor="#30485d",linewidth=0.16) {#XCDAC:36 (-16,-169.95)};
// (-16.4,-169.95) @TEXT("VREFN",size=1.1,halign="end",valign="middle");
// &"VREFP" @WIRE(mode="straight",linecolor="#30485d",linewidth=0.16) {#XCDAC:37 (-16,-173.25)};
// (-16.4,-173.25) @TEXT("VREFP",size=1.1,halign="end",valign="middle");
// &"0" @WIRE(mode="straight",linecolor="#30485d",linewidth=0.16) {#XCDAC:38 (0,-181.55)};
// (0,-181.95) @TEXT("0",size=1.1,halign="middle",valign="top");
// &"CMP_CLK" @WIRE(mode="straight",linecolor="#30485d",linewidth=0.16) {#XCTRL:1 (16,-191.4)};
// (16.4,-191.4) @TEXT("CMP_CLK",size=1.1,halign="start",valign="middle");
// {&"CODE0" &"CODE1" &"CODE2" &"CODE3" &"CODE4" &"CODE5" &"CODE6" &"CODE7"} @WIRE(mode="straight",linewidth=0.3) {#XCTRL:2 (16,-194.7)};
// (16.4,-194.7) @TEXT("CODE[7:0]",size=1.1,halign="start",valign="middle");
// &"COMP_N" @WIRE(mode="straight",linecolor="#30485d",linewidth=0.16) {#XCTRL:10 (-16,-194.7)};
// (-16.4,-194.7) @TEXT("COMP_N",size=1.1,halign="end",valign="middle");
// &"COMP_P" @WIRE(mode="straight",linecolor="#30485d",linewidth=0.16) {#XCTRL:11 (-16,-198)};
// (-16.4,-198) @TEXT("COMP_P",size=1.1,halign="end",valign="middle");
// {&"D0" &"D1" &"D2" &"D3" &"D4" &"D5" &"D6" &"D7"} @WIRE(mode="straight",linewidth=0.3) {#XCTRL:12 (16,-198)};
// (16.4,-198) @TEXT("D[7:0]",size=1.1,halign="start",valign="middle");
// &"SAMPLE_INT" @WIRE(mode="straight",linecolor="#30485d",linewidth=0.16) {#XCTRL:21 (-16,-201.3)};
// (-16.4,-201.3) @TEXT("SAMPLE_INT",size=1.1,halign="end",valign="middle");
// &"VDD!" @WIRE(mode="straight",linecolor="#30485d",linewidth=0.16) {#XCTRL:22 (0,-183.1)};
// (0,-182.7) @TEXT("VDD!",size=1.1,halign="middle",valign="bottom");
// &"0" @WIRE(mode="straight",linecolor="#30485d",linewidth=0.16) {#XCTRL:23 (0,-212.9)};
// (0,-213.3) @TEXT("0",size=1.1,halign="middle",valign="top");
// &"ACTIVE" @WIRE(mode="straight",linecolor="#30485d",linewidth=0.16) {#XCTRL:24 (16,-204.6)};
// (16.4,-204.6) @TEXT("ACTIVE",size=1.1,halign="start",valign="middle");
// {&"CODE0" &"CODE1" &"CODE2" &"CODE3" &"CODE4" &"CODE5" &"CODE6" &"CODE7"} @WIRE(mode="straight",linewidth=0.3) {#XREF:1 (-16,-226.05)};
// (-16.4,-226.05) @TEXT("CODE[7:0]",size=1.1,halign="end",valign="middle");
// {&"D0" &"D1" &"D2" &"D3" &"D4" &"D5" &"D6" &"D7"} @WIRE(mode="straight",linewidth=0.3) {#XREF:9 (-16,-229.35)};
// (-16.4,-229.35) @TEXT("D[7:0]",size=1.1,halign="end",valign="middle");
// {&"GNN0" &"GNN1" &"GNN2" &"GNN3" &"GNN4" &"GNN5" &"GNN6" &"GNN7"} @WIRE(mode="straight",linewidth=0.3) {#XREF:17 (16,-222.75)};
// (16.4,-222.75) @TEXT("GNN[7:0]",size=1.1,halign="start",valign="middle");
// {&"GNP0" &"GNP1" &"GNP2" &"GNP3" &"GNP4" &"GNP5" &"GNP6" &"GNP7"} @WIRE(mode="straight",linewidth=0.3) {#XREF:25 (16,-226.05)};
// (16.4,-226.05) @TEXT("GNP[7:0]",size=1.1,halign="start",valign="middle");
// {&"GPN0" &"GPN1" &"GPN2" &"GPN3" &"GPN4" &"GPN5" &"GPN6" &"GPN7"} @WIRE(mode="straight",linewidth=0.3) {#XREF:33 (16,-229.35)};
// (16.4,-229.35) @TEXT("GPN[7:0]",size=1.1,halign="start",valign="middle");
// {&"GPP0" &"GPP1" &"GPP2" &"GPP3" &"GPP4" &"GPP5" &"GPP6" &"GPP7"} @WIRE(mode="straight",linewidth=0.3) {#XREF:41 (16,-232.65)};
// (16.4,-232.65) @TEXT("GPP[7:0]",size=1.1,halign="start",valign="middle");
// &"SAMPLE_INT" @WIRE(mode="straight",linecolor="#30485d",linewidth=0.16) {#XREF:50 (-16,-235.95)};
// (-16.4,-235.95) @TEXT("SAMPLE_INT",size=1.1,halign="end",valign="middle");
// &"VDD!" @WIRE(mode="straight",linecolor="#30485d",linewidth=0.16) {#XREF:51 (0,-214.45)};
// (0,-214.05) @TEXT("VDD!",size=1.1,halign="middle",valign="bottom");
// &"0" @WIRE(mode="straight",linecolor="#30485d",linewidth=0.16) {#XREF:52 (0,-247.55)};
// (0,-247.95) @TEXT("0",size=1.1,halign="middle",valign="top");
// &"RST_DONE" @WIRE(mode="straight",linecolor="#30485d",linewidth=0.16) {#XREF:53 (16,-235.95)};
// (16.4,-235.95) @TEXT("RST_DONE",size=1.1,halign="start",valign="middle");
// &"PRESET" @WIRE(mode="straight",linecolor="#30485d",linewidth=0.16) {#XREF:54 (16,-239.25)};
// (16.4,-239.25) @TEXT("PRESET",size=1.1,halign="start",valign="middle");
// &"CMP_CLK" @WIRE(mode="straight",linecolor="#30485d",linewidth=0.16) {#XCOMP:1 (-16,-260.7)};
// (-16.4,-260.7) @TEXT("CMP_CLK",size=1.1,halign="end",valign="middle");
// &"COMP_N" @WIRE(mode="straight",linecolor="#30485d",linewidth=0.16) {#XCOMP:2 (16,-262.35)};
// (16.4,-262.35) @TEXT("COMP_N",size=1.1,halign="start",valign="middle");
// &"COMP_P" @WIRE(mode="straight",linecolor="#30485d",linewidth=0.16) {#XCOMP:3 (16,-265.65)};
// (16.4,-265.65) @TEXT("COMP_P",size=1.1,halign="start",valign="middle");
// &"VDD!" @WIRE(mode="straight",linecolor="#30485d",linewidth=0.16) {#XCOMP:4 (0,-252.4)};
// (0,-252) @TEXT("VDD!",size=1.1,halign="middle",valign="bottom");
// &"TOPN" @WIRE(mode="straight",linecolor="#30485d",linewidth=0.16) {#XCOMP:5 (-16,-264)};
// (-16.4,-264) @TEXT("TOPN",size=1.1,halign="end",valign="middle");
// &"TOPP" @WIRE(mode="straight",linecolor="#30485d",linewidth=0.16) {#XCOMP:6 (-16,-267.3)};
// (-16.4,-267.3) @TEXT("TOPP",size=1.1,halign="end",valign="middle");
// &"0" @WIRE(mode="straight",linecolor="#30485d",linewidth=0.16) {#XCOMP:7 (0,-275.6)};
// (0,-276) @TEXT("0",size=1.1,halign="middle",valign="top");
// &"COMP_N" @WIRE(mode="straight",linecolor="#30485d",linewidth=0.16) {#CL_COMP_N:1 (90,5)};
// (90,5.4) @TEXT("COMP_N",size=1.1,halign="middle",valign="bottom");
// &"0" @WIRE(mode="straight",linecolor="#30485d",linewidth=0.16) {#CL_COMP_N:2 (90,-5)};
// (90,-5.4) @TEXT("0",size=1.1,halign="middle",valign="top");
// &"COMP_P" @WIRE(mode="straight",linecolor="#30485d",linewidth=0.16) {#CL_COMP_P:1 (90,-28)};
// (90,-27.6) @TEXT("COMP_P",size=1.1,halign="middle",valign="bottom");
// &"0" @WIRE(mode="straight",linecolor="#30485d",linewidth=0.16) {#CL_COMP_P:2 (90,-38)};
// (90,-38.4) @TEXT("0",size=1.1,halign="middle",valign="top");
// &"CMP_CLK" @WIRE(mode="straight",linecolor="#30485d",linewidth=0.16) {#CL_CMP_CLK:1 (90,-61)};
// (90,-60.6) @TEXT("CMP_CLK",size=1.1,halign="middle",valign="bottom");
// &"0" @WIRE(mode="straight",linecolor="#30485d",linewidth=0.16) {#CL_CMP_CLK:2 (90,-71)};
// (90,-71.4) @TEXT("0",size=1.1,halign="middle",valign="top");
// }
// END SARADC RNL
ends tb_sar_stalled_top

subckt INVD1BWP12T30P140 A Y VDD VSS
// BEGIN SARADC RNL
// @RNL(author="saradc topology") {
// (-89,30) @TEXT("INVD1BWP12T30P140 / source-derived connections",size=1.4,halign="start",textcolor="#223d52");
// (-20,5) @TEXT("Interface view only - no transistor body is distributed here.",size=1.2,halign="start",textcolor="#223d52");
// (-20,-2) @TEXT("Ports: A, Y, VDD, VSS",size=0.9,halign="start",textcolor="#223d52");
// }
// END SARADC RNL
ends INVD1BWP12T30P140

subckt ND2D1BWP12T30P140 A B Y VDD VSS
// BEGIN SARADC RNL
// @RNL(author="saradc topology") {
// (-89,30) @TEXT("ND2D1BWP12T30P140 / source-derived connections",size=1.4,halign="start",textcolor="#223d52");
// (-20,5) @TEXT("Interface view only - no transistor body is distributed here.",size=1.2,halign="start",textcolor="#223d52");
// (-20,-2) @TEXT("Ports: A, B, Y, VDD, VSS",size=0.9,halign="start",textcolor="#223d52");
// }
// END SARADC RNL
ends ND2D1BWP12T30P140

subckt DFCNQD1BWP12T30P140 D CK RN Q VDD VSS
// BEGIN SARADC RNL
// @RNL(author="saradc topology") {
// (-89,30) @TEXT("DFCNQD1BWP12T30P140 / source-derived connections",size=1.4,halign="start",textcolor="#223d52");
// (-20,5) @TEXT("Interface view only - no transistor body is distributed here.",size=1.2,halign="start",textcolor="#223d52");
// (-20,-2) @TEXT("Ports: D, CK, RN, Q, VDD, VSS",size=0.9,halign="start",textcolor="#223d52");
// }
// END SARADC RNL
ends DFCNQD1BWP12T30P140

subckt b_cdac GNN0 GNN1 GNN2 GNN3 GNN4 GNN5 GNN6 GNN7 GNP0 GNP1 GNP2 GNP3 GNP4 GNP5 GNP6 GNP7 GPN0 GPN1 GPN2 GPN3 GPN4 GPN5 GPN6 GPN7 GPP0 GPP1 GPP2 GPP3 GPP4 GPP5 GPP6 GPP7 TOPN TOPP VDD VREFN VREFP VSS
// BEGIN SARADC RNL
// @RNL(author="saradc topology") {
// (-89,30) @TEXT("b_cdac / source-derived connections",size=1.4,halign="start",textcolor="#223d52");
// (-20,5) @TEXT("Interface view only - no transistor body is distributed here.",size=1.2,halign="start",textcolor="#223d52");
// (-20,-2) @TEXT("Ports: GNN0, GNN1, GNN2, GNN3, GNN4, GNN5, GNN6, GNN7, GNP0, GNP1, GNP2, GNP3, GNP4, GNP5, GNP6, GNP7, GPN0, GPN1, GPN2, GPN3, GPN4, GPN5, GPN6, GPN7, GPP0, GPP1, GPP2, GPP3, GPP4, GPP5, GPP6, GPP7, TOPN, TOPP, VDD, VREFN, VREFP, VSS",size=0.9,halign="start",textcolor="#223d52");
// }
// END SARADC RNL
ends b_cdac

subckt b_cdac_bit GNN GNP GPN GPP TOPN TOPP VREFN VREFP VDD VSS
// BEGIN SARADC RNL
// @RNL(author="saradc topology") {
// (-89,30) @TEXT("b_cdac_bit / source-derived connections",size=1.4,halign="start",textcolor="#223d52");
// (-20,5) @TEXT("Interface view only - no transistor body is distributed here.",size=1.2,halign="start",textcolor="#223d52");
// (-20,-2) @TEXT("Ports: GNN, GNP, GPN, GPP, TOPN, TOPP, VREFN, VREFP, VDD, VSS",size=0.9,halign="start",textcolor="#223d52");
// }
// END SARADC RNL
ends b_cdac_bit

subckt b_comparator CLK OUTN OUTP VDD VINN VINP VSS
// BEGIN SARADC RNL
// @RNL(author="saradc topology") {
// (-89,30) @TEXT("b_comparator / source-derived connections",size=1.4,halign="start",textcolor="#223d52");
// (-20,5) @TEXT("Interface view only - no transistor body is distributed here.",size=1.2,halign="start",textcolor="#223d52");
// (-20,-2) @TEXT("Ports: CLK, OUTN, OUTP, VDD, VINN, VINP, VSS",size=0.9,halign="start",textcolor="#223d52");
// }
// END SARADC RNL
ends b_comparator

subckt b_reference CODE0 CODE1 CODE2 CODE3 CODE4 CODE5 CODE6 CODE7 D0 D1 D2 D3 D4 D5 D6 D7 GNN0 GNN1 GNN2 GNN3 GNN4 GNN5 GNN6 GNN7 GNP0 GNP1 GNP2 GNP3 GNP4 GNP5 GNP6 GNP7 GPN0 GPN1 GPN2 GPN3 GPN4 GPN5 GPN6 GPN7 GPP0 GPP1 GPP2 GPP3 GPP4 GPP5 GPP6 GPP7 PHI_U SAMPLE VDD VSS RST_DONE PRESET
// BEGIN SARADC RNL
// @RNL(author="saradc topology") {
// (-89,30) @TEXT("b_reference / source-derived connections",size=1.4,halign="start",textcolor="#223d52");
// (-20,5) @TEXT("Interface view only - no transistor body is distributed here.",size=1.2,halign="start",textcolor="#223d52");
// (-20,-2) @TEXT("Ports: CODE0, CODE1, CODE2, CODE3, CODE4, CODE5, CODE6, CODE7, D0, D1, D2, D3, D4, D5, D6, D7, GNN0, GNN1, GNN2, GNN3, GNN4, GNN5, GNN6, GNN7, GNP0, GNP1, GNP2, GNP3, GNP4, GNP5, GNP6, GNP7, GPN0, GPN1, GPN2, GPN3, GPN4, GPN5, GPN6, GPN7, GPP0, GPP1, GPP2, GPP3, GPP4, GPP5, GPP6, GPP7, PHI_U, SAMPLE, VDD, VSS, RST_DONE, PRESET",size=0.9,halign="start",textcolor="#223d52");
// }
// END SARADC RNL
ends b_reference

subckt b_edge A VDD VSS Y
// BEGIN SARADC RNL
// @RNL(author="saradc topology") {
// (-89,30) @TEXT("b_edge / source-derived connections",size=1.4,halign="start",textcolor="#223d52");
// (-20,5) @TEXT("Interface view only - no transistor body is distributed here.",size=1.2,halign="start",textcolor="#223d52");
// (-20,-2) @TEXT("Ports: A, VDD, VSS, Y",size=0.9,halign="start",textcolor="#223d52");
// }
// END SARADC RNL
ends b_edge

subckt b_idle ACTIVE SAMPLE VDD VSS PRESET SAMPLE_MATCH
// BEGIN SARADC RNL
// @RNL(author="saradc topology") {
// (-89,30) @TEXT("b_idle / source-derived connections",size=1.4,halign="start",textcolor="#223d52");
// (-20,5) @TEXT("Interface view only - no transistor body is distributed here.",size=1.2,halign="start",textcolor="#223d52");
// (-20,-2) @TEXT("Ports: ACTIVE, SAMPLE, VDD, VSS, PRESET, SAMPLE_MATCH",size=0.9,halign="start",textcolor="#223d52");
// }
// END SARADC RNL
ends b_idle

subckt b_sampler CLKS VOUT VIN VDD VSS
// BEGIN SARADC RNL
// @RNL(author="saradc topology") {
// (-89,30) @TEXT("b_sampler / source-derived connections",size=1.4,halign="start",textcolor="#223d52");
// (-20,5) @TEXT("Interface view only - no transistor body is distributed here.",size=1.2,halign="start",textcolor="#223d52");
// (-20,-2) @TEXT("Ports: CLKS, VOUT, VIN, VDD, VSS",size=0.9,halign="start",textcolor="#223d52");
// }
// END SARADC RNL
ends b_sampler

subckt b_sar CMP_CLK CODE0 CODE1 CODE2 CODE3 CODE4 CODE5 CODE6 CODE7 COMP_N COMP_P D0 D1 D2 D3 D4 D5 D6 D7 PHI_U SAMPLE VDD VSS ACTIVE
// BEGIN SARADC RNL
// @RNL(author="saradc topology") {
// (-89,30) @TEXT("b_sar / source-derived connections",size=1.4,halign="start",textcolor="#223d52");
// (-20,5) @TEXT("Interface view only - no transistor body is distributed here.",size=1.2,halign="start",textcolor="#223d52");
// (-20,-2) @TEXT("Ports: CMP_CLK, CODE0, CODE1, CODE2, CODE3, CODE4, CODE5, CODE6, CODE7, COMP_N, COMP_P, D0, D1, D2, D3, D4, D5, D6, D7, PHI_U, SAMPLE, VDD, VSS, ACTIVE",size=0.9,halign="start",textcolor="#223d52");
// }
// END SARADC RNL
ends b_sar

subckt sar_adc_b D0 D1 D2 D3 D4 D5 D6 D7 SAMPLE VDD VINN VINP VREFN VREFP VSS
// BEGIN SARADC RNL
// @RNL(author="saradc topology") {
// (-89,30) @TEXT("sar_adc_b / source-derived connections",size=1.4,halign="start",textcolor="#223d52");
// (-20,5) @TEXT("Interface view only - no transistor body is distributed here.",size=1.2,halign="start",textcolor="#223d52");
// (-20,-2) @TEXT("Ports: D0, D1, D2, D3, D4, D5, D6, D7, SAMPLE, VDD, VINN, VINP, VREFN, VREFP, VSS",size=0.9,halign="start",textcolor="#223d52");
// }
// END SARADC RNL
ends sar_adc_b

subckt b_delay A VDD VSS Y
// BEGIN SARADC RNL
// @RNL(author="saradc topology") {
// (-89,30) @TEXT("b_delay / source-derived connections",size=1.4,halign="start",textcolor="#223d52");
// (-20,5) @TEXT("Interface view only - no transistor body is distributed here.",size=1.2,halign="start",textcolor="#223d52");
// (-20,-2) @TEXT("Ports: A, VDD, VSS, Y",size=0.9,halign="start",textcolor="#223d52");
// }
// END SARADC RNL
ends b_delay

subckt b_behavior_observer D0 D1 D2 D3 D4 D5 D6 D7 SAMPLE VDD VSS
// BEGIN SARADC RNL
// @RNL(author="saradc topology") {
// (-89,30) @TEXT("b_behavior_observer / source-derived connections",size=1.4,halign="start",textcolor="#223d52");
// (-20,5) @TEXT("Interface view only - no transistor body is distributed here.",size=1.2,halign="start",textcolor="#223d52");
// (-20,-2) @TEXT("Ports: D0, D1, D2, D3, D4, D5, D6, D7, SAMPLE, VDD, VSS",size=0.9,halign="start",textcolor="#223d52");
// }
// END SARADC RNL
ends b_behavior_observer

subckt b_tb_switch A B EN VDD VSS
// BEGIN SARADC RNL
// @RNL(author="saradc topology") {
// (-89,30) @TEXT("b_tb_switch / source-derived connections",size=1.4,halign="start",textcolor="#223d52");
// (-20,5) @TEXT("Interface view only - no transistor body is distributed here.",size=1.2,halign="start",textcolor="#223d52");
// (-20,-2) @TEXT("Ports: A, B, EN, VDD, VSS",size=0.9,halign="start",textcolor="#223d52");
// }
// END SARADC RNL
ends b_tb_switch

subckt b_sampler_bridge CLKS VOUT Vin
// BEGIN SARADC RNL
// @RNL(author="saradc topology") {
// (-89,30) @TEXT("b_sampler_bridge / source-derived connections",size=1.4,halign="start",textcolor="#223d52");
// (-20,5) @TEXT("Interface view only - no transistor body is distributed here.",size=1.2,halign="start",textcolor="#223d52");
// (-20,-2) @TEXT("Ports: CLKS, VOUT, Vin",size=0.9,halign="start",textcolor="#223d52");
// }
// END SARADC RNL
ends b_sampler_bridge

subckt b_sar8p_delay_valid A VDD VSS Y
// BEGIN SARADC RNL
// @RNL(author="saradc topology") {
// (-89,30) @TEXT("b_sar8p_delay_valid / source-derived connections",size=1.4,halign="start",textcolor="#223d52");
// (-20,5) @TEXT("Interface view only - no transistor body is distributed here.",size=1.2,halign="start",textcolor="#223d52");
// (-20,-2) @TEXT("Ports: A, VDD, VSS, Y",size=0.9,halign="start",textcolor="#223d52");
// }
// END SARADC RNL
ends b_sar8p_delay_valid

subckt b_sar8p_delay_write A VDD VSS Y
// BEGIN SARADC RNL
// @RNL(author="saradc topology") {
// (-89,30) @TEXT("b_sar8p_delay_write / source-derived connections",size=1.4,halign="start",textcolor="#223d52");
// (-20,5) @TEXT("Interface view only - no transistor body is distributed here.",size=1.2,halign="start",textcolor="#223d52");
// (-20,-2) @TEXT("Ports: A, VDD, VSS, Y",size=0.9,halign="start",textcolor="#223d52");
// }
// END SARADC RNL
ends b_sar8p_delay_write

subckt b_sar8p_delay_quiet A VDD VSS Y
// BEGIN SARADC RNL
// @RNL(author="saradc topology") {
// (-89,30) @TEXT("b_sar8p_delay_quiet / source-derived connections",size=1.4,halign="start",textcolor="#223d52");
// (-20,5) @TEXT("Interface view only - no transistor body is distributed here.",size=1.2,halign="start",textcolor="#223d52");
// (-20,-2) @TEXT("Ports: A, VDD, VSS, Y",size=0.9,halign="start",textcolor="#223d52");
// }
// END SARADC RNL
ends b_sar8p_delay_quiet

subckt b_sar8p_delay_capture A VDD VSS Y
// BEGIN SARADC RNL
// @RNL(author="saradc topology") {
// (-89,30) @TEXT("b_sar8p_delay_capture / source-derived connections",size=1.4,halign="start",textcolor="#223d52");
// (-20,5) @TEXT("Interface view only - no transistor body is distributed here.",size=1.2,halign="start",textcolor="#223d52");
// (-20,-2) @TEXT("Ports: A, VDD, VSS, Y",size=0.9,halign="start",textcolor="#223d52");
// }
// END SARADC RNL
ends b_sar8p_delay_capture

subckt b_sar8p_delay_bbm A VDD VSS Y
// BEGIN SARADC RNL
// @RNL(author="saradc topology") {
// (-89,30) @TEXT("b_sar8p_delay_bbm / source-derived connections",size=1.4,halign="start",textcolor="#223d52");
// (-20,5) @TEXT("Interface view only - no transistor body is distributed here.",size=1.2,halign="start",textcolor="#223d52");
// (-20,-2) @TEXT("Ports: A, VDD, VSS, Y",size=0.9,halign="start",textcolor="#223d52");
// }
// END SARADC RNL
ends b_sar8p_delay_bbm

subckt b_sar8r_delay A VDD VSS Y
// BEGIN SARADC RNL
// @RNL(author="saradc topology") {
// (-89,30) @TEXT("b_sar8r_delay / source-derived connections",size=1.4,halign="start",textcolor="#223d52");
// (-20,5) @TEXT("Interface view only - no transistor body is distributed here.",size=1.2,halign="start",textcolor="#223d52");
// (-20,-2) @TEXT("Ports: A, VDD, VSS, Y",size=0.9,halign="start",textcolor="#223d52");
// }
// END SARADC RNL
ends b_sar8r_delay

subckt b_sar8s_step A VDD VSS Y
// BEGIN SARADC RNL
// @RNL(author="saradc topology") {
// (-89,30) @TEXT("b_sar8s_step / source-derived connections",size=1.4,halign="start",textcolor="#223d52");
// (-20,5) @TEXT("Interface view only - no transistor body is distributed here.",size=1.2,halign="start",textcolor="#223d52");
// (-20,-2) @TEXT("Ports: A, VDD, VSS, Y",size=0.9,halign="start",textcolor="#223d52");
// }
// END SARADC RNL
ends b_sar8s_step

subckt b_sar8i_guard A VDD VSS Y
// BEGIN SARADC RNL
// @RNL(author="saradc topology") {
// (-89,30) @TEXT("b_sar8i_guard / source-derived connections",size=1.4,halign="start",textcolor="#223d52");
// (-20,5) @TEXT("Interface view only - no transistor body is distributed here.",size=1.2,halign="start",textcolor="#223d52");
// (-20,-2) @TEXT("Ports: A, VDD, VSS, Y",size=0.9,halign="start",textcolor="#223d52");
// }
// END SARADC RNL
ends b_sar8i_guard

subckt b_sar8r_edge A VDD VSS Y
// BEGIN SARADC RNL
// @RNL(author="saradc topology") {
// (-89,30) @TEXT("b_sar8r_edge / source-derived connections",size=1.4,halign="start",textcolor="#223d52");
// (-20,5) @TEXT("Interface view only - no transistor body is distributed here.",size=1.2,halign="start",textcolor="#223d52");
// (-20,-2) @TEXT("Ports: A, VDD, VSS, Y",size=0.9,halign="start",textcolor="#223d52");
// }
// END SARADC RNL
ends b_sar8r_edge

subckt b_sar8p_clkbuf A VDD VSS Y
// BEGIN SARADC RNL
// @RNL(author="saradc topology") {
// (-89,30) @TEXT("b_sar8p_clkbuf / source-derived connections",size=1.4,halign="start",textcolor="#223d52");
// (-20,5) @TEXT("Interface view only - no transistor body is distributed here.",size=1.2,halign="start",textcolor="#223d52");
// (-20,-2) @TEXT("Ports: A, VDD, VSS, Y",size=0.9,halign="start",textcolor="#223d52");
// }
// END SARADC RNL
ends b_sar8p_clkbuf
