// Display-only self-contained RNL export. Use design/dut.scs for simulation.

// BEGIN SARADC RNL
// @RNL(type="header") { @VERSION("0.3"); @USE-PACKAGE(name="rnl-std-fill") {};
// @DEVICE(name="*",model="nch*",terminals=["d","g","s","b"]);
// @DEVICE(name="*",model="pch*",terminals=["d","g","s","b"]);
// @USE-PACKAGE(name="sar8",version="0.1") {
//
// $S_sar_adc8_join_r4 = @DEFINE-SYMBOL {
// @LINE {(-11,9.9) (11,9.9) (11,-9.9) (-11,-9.9) (-11,9.9)};
// (-13,6.6) @PIN(terminal=9,direction="left");
// @LINE {(-13,6.6) (-11,6.6)};
// (-10.5,6.6) @TEXT("SAMPLE",size=1.1,halign="start",valign="middle");
// (-13,3.3) @PIN(terminal=11,direction="left");
// @LINE {(-13,3.3) (-11,3.3)};
// (-10.5,3.3) @TEXT("VINN",size=1.1,halign="start",valign="middle");
// (-13,0) @PIN(terminal=12,direction="left");
// @LINE {(-13,0) (-11,0)};
// (-10.5,0) @TEXT("VINP",size=1.1,halign="start",valign="middle");
// (-13,-3.3) @PIN(terminal=13,direction="left");
// @LINE {(-13,-3.3) (-11,-3.3)};
// (-10.5,-3.3) @TEXT("VREFN",size=1.1,halign="start",valign="middle");
// (-13,-6.6) @PIN(terminal=14,direction="left");
// @LINE {(-13,-6.6) (-11,-6.6)};
// (-10.5,-6.6) @TEXT("VREFP",size=1.1,halign="start",valign="middle");
// (13,0) @PIN(terminal=[1, 2, 3, 4, 5, 6, 7, 8],direction="right");
// @LINE {(13,0) (11,0)};
// (10.5,0) @TEXT("D[7:0]",size=1.1,halign="end",valign="middle");
// (0,11.9) @PIN(terminal=10,direction="up");
// @LINE {(0,11.9) (0,9.9)};
// (0,9.1) @TEXT("VDD!",size=1.1,halign="middle",valign="middle");
// (0,-11.9) @PIN(terminal=15,direction="down");
// @LINE {(0,-11.9) (0,-9.9)};
// (0,-9.1) @TEXT("0",size=1.1,halign="middle",valign="middle");
// ? @TEXT("${name}",key="name",size=1.6,halign="middle") => @PLACE(0,13.4);
// ? @TEXT("${model}",key="model",size=0.85,halign="middle") => @PLACE(0,-13.9);
// };
// # @SELECT-INSTANCE(model="sar_adc8_join_r4") => @SET-SYMBOL $S_sar_adc8_join_r4;
// $S_sar_bootstrap_flat_8b_p = @DEFINE-SYMBOL {
// @LINE(fill="fillcolor",fillcolor="#eaf5ef") {(-13,6) (13,6) (13,-6) (-13,-6) (-13,6)};
// (-15,1.65) @PIN(terminal=1,direction="left");
// @LINE {(-15,1.65) (-13,1.65)};
// (-12.5,1.65) @TEXT("CLKS",size=1.1,halign="start",valign="middle");
// (-15,-1.65) @PIN(terminal=3,direction="left");
// @LINE {(-15,-1.65) (-13,-1.65)};
// (-12.5,-1.65) @TEXT("Vin",size=1.1,halign="start",valign="middle");
// (15,0) @PIN(terminal=2,direction="right");
// @LINE {(15,0) (13,0)};
// (12.5,0) @TEXT("VOUT",size=1.1,halign="end",valign="middle");
// ? @TEXT("${name}",key="name",size=1.6,halign="middle") => @PLACE(0,9.5);
// ? @TEXT("${model}",key="model",size=0.85,halign="middle") => @PLACE(0,-10);
// };
// # @SELECT-INSTANCE(model="sar_bootstrap_flat_8b_p") => @SET-SYMBOL $S_sar_bootstrap_flat_8b_p;
// $S_sar8j_r1_sw_b0 = @DEFINE-SYMBOL {
// @LINE {(-9,7) (9,7) (9,-7) (-9,-7) (-9,7)};
// (0,12) @PIN(terminal=1,direction="up");
// @LINE {(0,12) (0,7)};
// (0,6.2) @TEXT("BOT",size=0.65,halign="middle",valign="middle");
// (-3,-12) @PIN(terminal=2,direction="down");
// @LINE {(-3,-12) (-3,-7)};
// (-3,-6.2) @TEXT("SEL",size=0.65,halign="middle",valign="middle");
// (-11,-4) @PIN(terminal=4,direction="left");
// @LINE {(-11,-4) (-9,-4)};
// (-8,-4) @TEXT("VREFN",size=0.65,halign="start",valign="middle");
// (-11,4) @PIN(terminal=5,direction="left");
// @LINE {(-11,4) (-9,4)};
// (-8,4) @TEXT("VREFP",size=0.65,halign="start",valign="middle");
// (6,12) @PIN(terminal=3,direction="up");
// @LINE {(6,12) (6,7)};
// (6,6.2) @TEXT("VDD",size=0.65,halign="middle",valign="middle");
// (6,-12) @PIN(terminal=6,direction="down");
// @LINE {(6,-12) (6,-7)};
// (6,-6.2) @TEXT("VSS",size=0.65,halign="middle",valign="middle");
// ? @TEXT("${name}",key="name",size=1.6,halign="middle") => @PLACE(0,10.5);
// ? @TEXT("",key="model",size=0.85,halign="middle") => @PLACE(0,-11);
// };
// # @SELECT-INSTANCE(model="sar8j_r1_sw_b0") => @SET-SYMBOL $S_sar8j_r1_sw_b0;
// $S_sar8j_r1_sw_b1 = @DEFINE-SYMBOL {
// @LINE {(-9,7) (9,7) (9,-7) (-9,-7) (-9,7)};
// (0,12) @PIN(terminal=1,direction="up");
// @LINE {(0,12) (0,7)};
// (0,6.2) @TEXT("BOT",size=0.65,halign="middle",valign="middle");
// (-3,-12) @PIN(terminal=2,direction="down");
// @LINE {(-3,-12) (-3,-7)};
// (-3,-6.2) @TEXT("SEL",size=0.65,halign="middle",valign="middle");
// (-11,-4) @PIN(terminal=4,direction="left");
// @LINE {(-11,-4) (-9,-4)};
// (-8,-4) @TEXT("VREFN",size=0.65,halign="start",valign="middle");
// (-11,4) @PIN(terminal=5,direction="left");
// @LINE {(-11,4) (-9,4)};
// (-8,4) @TEXT("VREFP",size=0.65,halign="start",valign="middle");
// (6,12) @PIN(terminal=3,direction="up");
// @LINE {(6,12) (6,7)};
// (6,6.2) @TEXT("VDD",size=0.65,halign="middle",valign="middle");
// (6,-12) @PIN(terminal=6,direction="down");
// @LINE {(6,-12) (6,-7)};
// (6,-6.2) @TEXT("VSS",size=0.65,halign="middle",valign="middle");
// ? @TEXT("${name}",key="name",size=1.6,halign="middle") => @PLACE(0,10.5);
// ? @TEXT("",key="model",size=0.85,halign="middle") => @PLACE(0,-11);
// };
// # @SELECT-INSTANCE(model="sar8j_r1_sw_b1") => @SET-SYMBOL $S_sar8j_r1_sw_b1;
// $S_sar8j_r1_sw_b2 = @DEFINE-SYMBOL {
// @LINE {(-9,7) (9,7) (9,-7) (-9,-7) (-9,7)};
// (0,12) @PIN(terminal=1,direction="up");
// @LINE {(0,12) (0,7)};
// (0,6.2) @TEXT("BOT",size=0.65,halign="middle",valign="middle");
// (-3,-12) @PIN(terminal=2,direction="down");
// @LINE {(-3,-12) (-3,-7)};
// (-3,-6.2) @TEXT("SEL",size=0.65,halign="middle",valign="middle");
// (-11,-4) @PIN(terminal=4,direction="left");
// @LINE {(-11,-4) (-9,-4)};
// (-8,-4) @TEXT("VREFN",size=0.65,halign="start",valign="middle");
// (-11,4) @PIN(terminal=5,direction="left");
// @LINE {(-11,4) (-9,4)};
// (-8,4) @TEXT("VREFP",size=0.65,halign="start",valign="middle");
// (6,12) @PIN(terminal=3,direction="up");
// @LINE {(6,12) (6,7)};
// (6,6.2) @TEXT("VDD",size=0.65,halign="middle",valign="middle");
// (6,-12) @PIN(terminal=6,direction="down");
// @LINE {(6,-12) (6,-7)};
// (6,-6.2) @TEXT("VSS",size=0.65,halign="middle",valign="middle");
// ? @TEXT("${name}",key="name",size=1.6,halign="middle") => @PLACE(0,10.5);
// ? @TEXT("",key="model",size=0.85,halign="middle") => @PLACE(0,-11);
// };
// # @SELECT-INSTANCE(model="sar8j_r1_sw_b2") => @SET-SYMBOL $S_sar8j_r1_sw_b2;
// $S_sar8j_r1_sw_b3 = @DEFINE-SYMBOL {
// @LINE {(-9,7) (9,7) (9,-7) (-9,-7) (-9,7)};
// (0,12) @PIN(terminal=1,direction="up");
// @LINE {(0,12) (0,7)};
// (0,6.2) @TEXT("BOT",size=0.65,halign="middle",valign="middle");
// (-3,-12) @PIN(terminal=2,direction="down");
// @LINE {(-3,-12) (-3,-7)};
// (-3,-6.2) @TEXT("SEL",size=0.65,halign="middle",valign="middle");
// (-11,-4) @PIN(terminal=4,direction="left");
// @LINE {(-11,-4) (-9,-4)};
// (-8,-4) @TEXT("VREFN",size=0.65,halign="start",valign="middle");
// (-11,4) @PIN(terminal=5,direction="left");
// @LINE {(-11,4) (-9,4)};
// (-8,4) @TEXT("VREFP",size=0.65,halign="start",valign="middle");
// (6,12) @PIN(terminal=3,direction="up");
// @LINE {(6,12) (6,7)};
// (6,6.2) @TEXT("VDD",size=0.65,halign="middle",valign="middle");
// (6,-12) @PIN(terminal=6,direction="down");
// @LINE {(6,-12) (6,-7)};
// (6,-6.2) @TEXT("VSS",size=0.65,halign="middle",valign="middle");
// ? @TEXT("${name}",key="name",size=1.6,halign="middle") => @PLACE(0,10.5);
// ? @TEXT("",key="model",size=0.85,halign="middle") => @PLACE(0,-11);
// };
// # @SELECT-INSTANCE(model="sar8j_r1_sw_b3") => @SET-SYMBOL $S_sar8j_r1_sw_b3;
// $S_sar8j_r1_sw_b4 = @DEFINE-SYMBOL {
// @LINE {(-9,7) (9,7) (9,-7) (-9,-7) (-9,7)};
// (0,12) @PIN(terminal=1,direction="up");
// @LINE {(0,12) (0,7)};
// (0,6.2) @TEXT("BOT",size=0.65,halign="middle",valign="middle");
// (-3,-12) @PIN(terminal=2,direction="down");
// @LINE {(-3,-12) (-3,-7)};
// (-3,-6.2) @TEXT("SEL",size=0.65,halign="middle",valign="middle");
// (-11,-4) @PIN(terminal=4,direction="left");
// @LINE {(-11,-4) (-9,-4)};
// (-8,-4) @TEXT("VREFN",size=0.65,halign="start",valign="middle");
// (-11,4) @PIN(terminal=5,direction="left");
// @LINE {(-11,4) (-9,4)};
// (-8,4) @TEXT("VREFP",size=0.65,halign="start",valign="middle");
// (6,12) @PIN(terminal=3,direction="up");
// @LINE {(6,12) (6,7)};
// (6,6.2) @TEXT("VDD",size=0.65,halign="middle",valign="middle");
// (6,-12) @PIN(terminal=6,direction="down");
// @LINE {(6,-12) (6,-7)};
// (6,-6.2) @TEXT("VSS",size=0.65,halign="middle",valign="middle");
// ? @TEXT("${name}",key="name",size=1.6,halign="middle") => @PLACE(0,10.5);
// ? @TEXT("",key="model",size=0.85,halign="middle") => @PLACE(0,-11);
// };
// # @SELECT-INSTANCE(model="sar8j_r1_sw_b4") => @SET-SYMBOL $S_sar8j_r1_sw_b4;
// $S_sar8j_r1_sw_b5 = @DEFINE-SYMBOL {
// @LINE {(-9,7) (9,7) (9,-7) (-9,-7) (-9,7)};
// (0,12) @PIN(terminal=1,direction="up");
// @LINE {(0,12) (0,7)};
// (0,6.2) @TEXT("BOT",size=0.65,halign="middle",valign="middle");
// (-3,-12) @PIN(terminal=2,direction="down");
// @LINE {(-3,-12) (-3,-7)};
// (-3,-6.2) @TEXT("SEL",size=0.65,halign="middle",valign="middle");
// (-11,-4) @PIN(terminal=4,direction="left");
// @LINE {(-11,-4) (-9,-4)};
// (-8,-4) @TEXT("VREFN",size=0.65,halign="start",valign="middle");
// (-11,4) @PIN(terminal=5,direction="left");
// @LINE {(-11,4) (-9,4)};
// (-8,4) @TEXT("VREFP",size=0.65,halign="start",valign="middle");
// (6,12) @PIN(terminal=3,direction="up");
// @LINE {(6,12) (6,7)};
// (6,6.2) @TEXT("VDD",size=0.65,halign="middle",valign="middle");
// (6,-12) @PIN(terminal=6,direction="down");
// @LINE {(6,-12) (6,-7)};
// (6,-6.2) @TEXT("VSS",size=0.65,halign="middle",valign="middle");
// ? @TEXT("${name}",key="name",size=1.6,halign="middle") => @PLACE(0,10.5);
// ? @TEXT("",key="model",size=0.85,halign="middle") => @PLACE(0,-11);
// };
// # @SELECT-INSTANCE(model="sar8j_r1_sw_b5") => @SET-SYMBOL $S_sar8j_r1_sw_b5;
// $S_sar8j_r1_sw_b6 = @DEFINE-SYMBOL {
// @LINE {(-9,7) (9,7) (9,-7) (-9,-7) (-9,7)};
// (0,12) @PIN(terminal=1,direction="up");
// @LINE {(0,12) (0,7)};
// (0,6.2) @TEXT("BOT",size=0.65,halign="middle",valign="middle");
// (-3,-12) @PIN(terminal=2,direction="down");
// @LINE {(-3,-12) (-3,-7)};
// (-3,-6.2) @TEXT("SEL",size=0.65,halign="middle",valign="middle");
// (-11,-4) @PIN(terminal=4,direction="left");
// @LINE {(-11,-4) (-9,-4)};
// (-8,-4) @TEXT("VREFN",size=0.65,halign="start",valign="middle");
// (-11,4) @PIN(terminal=5,direction="left");
// @LINE {(-11,4) (-9,4)};
// (-8,4) @TEXT("VREFP",size=0.65,halign="start",valign="middle");
// (6,12) @PIN(terminal=3,direction="up");
// @LINE {(6,12) (6,7)};
// (6,6.2) @TEXT("VDD",size=0.65,halign="middle",valign="middle");
// (6,-12) @PIN(terminal=6,direction="down");
// @LINE {(6,-12) (6,-7)};
// (6,-6.2) @TEXT("VSS",size=0.65,halign="middle",valign="middle");
// ? @TEXT("${name}",key="name",size=1.6,halign="middle") => @PLACE(0,10.5);
// ? @TEXT("",key="model",size=0.85,halign="middle") => @PLACE(0,-11);
// };
// # @SELECT-INSTANCE(model="sar8j_r1_sw_b6") => @SET-SYMBOL $S_sar8j_r1_sw_b6;
// $S_sar8j_r1_sw_b7 = @DEFINE-SYMBOL {
// @LINE {(-9,7) (9,7) (9,-7) (-9,-7) (-9,7)};
// (0,12) @PIN(terminal=1,direction="up");
// @LINE {(0,12) (0,7)};
// (0,6.2) @TEXT("BOT",size=0.65,halign="middle",valign="middle");
// (-3,-12) @PIN(terminal=2,direction="down");
// @LINE {(-3,-12) (-3,-7)};
// (-3,-6.2) @TEXT("SEL",size=0.65,halign="middle",valign="middle");
// (-11,-4) @PIN(terminal=4,direction="left");
// @LINE {(-11,-4) (-9,-4)};
// (-8,-4) @TEXT("VREFN",size=0.65,halign="start",valign="middle");
// (-11,4) @PIN(terminal=5,direction="left");
// @LINE {(-11,4) (-9,4)};
// (-8,4) @TEXT("VREFP",size=0.65,halign="start",valign="middle");
// (6,12) @PIN(terminal=3,direction="up");
// @LINE {(6,12) (6,7)};
// (6,6.2) @TEXT("VDD",size=0.65,halign="middle",valign="middle");
// (6,-12) @PIN(terminal=6,direction="down");
// @LINE {(6,-12) (6,-7)};
// (6,-6.2) @TEXT("VSS",size=0.65,halign="middle",valign="middle");
// ? @TEXT("${name}",key="name",size=1.6,halign="middle") => @PLACE(0,10.5);
// ? @TEXT("",key="model",size=0.85,halign="middle") => @PLACE(0,-11);
// };
// # @SELECT-INSTANCE(model="sar8j_r1_sw_b7") => @SET-SYMBOL $S_sar8j_r1_sw_b7;
// $S_sar8j_r1_cdac = @DEFINE-SYMBOL {
// @LINE(fill="fillcolor",fillcolor="#eef4e3") {(-13,6) (13,6) (13,-6) (-13,-6) (-13,6)};
// (-15,1.65) @PIN(terminal=21,direction="left");
// @LINE {(-15,1.65) (-13,1.65)};
// (-12.5,1.65) @TEXT("VREFP",size=1.2,halign="start",valign="middle");
// (-15,-1.65) @PIN(terminal=20,direction="left");
// @LINE {(-15,-1.65) (-13,-1.65)};
// (-12.5,-1.65) @TEXT("VREFN",size=1.2,halign="start",valign="middle");
// (-8,8) @PIN(terminal=18,direction="up");
// @LINE {(-8,8) (-8,6)};
// (-8,5.2) @TEXT("TOPP",size=1.2,halign="middle",valign="middle");
// (0,8) @PIN(terminal=19,direction="up");
// @LINE {(0,8) (0,6)};
// (0,5.2) @TEXT("VDD",size=1.2,halign="middle",valign="middle");
// (8,8) @PIN(terminal=17,direction="up");
// @LINE {(8,8) (8,6)};
// (8,5.2) @TEXT("TOPN",size=1.2,halign="middle",valign="middle");
// (-8,-8) @PIN(terminal=[1, 2, 3, 4, 5, 6, 7, 8],direction="down");
// @LINE {(-8,-8) (-8,-6)};
// (-8,-5.2) @TEXT("REFSEL_N[7:0]",size=1.2,halign="middle",valign="middle");
// (0,-8) @PIN(terminal=22,direction="down");
// @LINE {(0,-8) (0,-6)};
// (0,-5.2) @TEXT("VSS",size=1.2,halign="middle",valign="middle");
// (8,-8) @PIN(terminal=[9, 10, 11, 12, 13, 14, 15, 16],direction="down");
// @LINE {(8,-8) (8,-6)};
// (8,-5.2) @TEXT("REFSEL_P[7:0]",size=1.2,halign="middle",valign="middle");
// ? @TEXT("${name}",key="name",size=1.6,halign="middle") => @PLACE(0,9.5);
// ? @TEXT("${model}",key="model",size=0.85,halign="middle") => @PLACE(0,-10);
// };
// # @SELECT-INSTANCE(model="sar8j_r1_cdac") => @SET-SYMBOL $S_sar8j_r1_cdac;
// $S_sar_strongarm_t28 = @DEFINE-SYMBOL {
// @LINE(fill="fillcolor",fillcolor="#eaf2fa") {(-13,6) (13,6) (13,-6) (-13,-6) (-13,6)};
// (-15,1.65) @PIN(terminal=6,direction="left");
// @LINE {(-15,1.65) (-13,1.65)};
// (-12.5,1.65) @TEXT("VINP",size=1.2,halign="start",valign="middle");
// (-15,-1.65) @PIN(terminal=5,direction="left");
// @LINE {(-15,-1.65) (-13,-1.65)};
// (-12.5,-1.65) @TEXT("VINN",size=1.2,halign="start",valign="middle");
// (15,1.65) @PIN(terminal=3,direction="right");
// @LINE {(15,1.65) (13,1.65)};
// (12.5,1.65) @TEXT("OUTP",size=1.2,halign="end",valign="middle");
// (15,-1.65) @PIN(terminal=2,direction="right");
// @LINE {(15,-1.65) (13,-1.65)};
// (12.5,-1.65) @TEXT("OUTN",size=1.2,halign="end",valign="middle");
// (-4,8) @PIN(terminal=1,direction="up");
// @LINE {(-4,8) (-4,6)};
// (-4,5.2) @TEXT("CLK",size=1.2,halign="middle",valign="middle");
// (4,8) @PIN(terminal=4,direction="up");
// @LINE {(4,8) (4,6)};
// (4,5.2) @TEXT("VDD",size=1.2,halign="middle",valign="middle");
// (0,-8) @PIN(terminal=7,direction="down");
// @LINE {(0,-8) (0,-6)};
// (0,-5.2) @TEXT("VSS",size=1.2,halign="middle",valign="middle");
// ? @TEXT("${name}",key="name",size=1.6,halign="middle") => @PLACE(0,9.5);
// ? @TEXT("${model}",key="model",size=0.85,halign="middle") => @PLACE(0,-10);
// };
// # @SELECT-INSTANCE(model="sar_strongarm_t28") => @SET-SYMBOL $S_sar_strongarm_t28;
// $S_sar8i_refword = @DEFINE-SYMBOL {
// @LINE(fill="fillcolor",fillcolor="#f6f0e5") {(-13,6) (13,6) (13,-6) (-13,-6) (-13,6)};
// (-15,0) @PIN(terminal=27,direction="left");
// @LINE {(-15,0) (-13,0)};
// (-12.5,0) @TEXT("PRESET",size=1.2,halign="start",valign="middle");
// (15,0) @PIN(terminal=[1, 2, 3, 4, 5, 6, 7, 8],direction="right");
// @LINE {(15,0) (13,0)};
// (12.5,0) @TEXT("CODE[7:0]",size=1.2,halign="end",valign="middle");
// (-8,8) @PIN(terminal=[9, 10, 11, 12, 13, 14, 15, 16],direction="up");
// @LINE {(-8,8) (-8,6)};
// (-8,5.2) @TEXT("REFSEL_N[7:0]",size=1.2,halign="middle",valign="middle");
// (0,8) @PIN(terminal=25,direction="up");
// @LINE {(0,8) (0,6)};
// (0,5.2) @TEXT("VDD",size=1.2,halign="middle",valign="middle");
// (8,8) @PIN(terminal=[17, 18, 19, 20, 21, 22, 23, 24],direction="up");
// @LINE {(8,8) (8,6)};
// (8,5.2) @TEXT("REFSEL_P[7:0]",size=1.2,halign="middle",valign="middle");
// (0,-8) @PIN(terminal=26,direction="down");
// @LINE {(0,-8) (0,-6)};
// (0,-5.2) @TEXT("VSS",size=1.2,halign="middle",valign="middle");
// ? @TEXT("${name}",key="name",size=1.6,halign="middle") => @PLACE(0,9.5);
// ? @TEXT("${model}",key="model",size=0.85,halign="middle") => @PLACE(0,-10);
// };
// # @SELECT-INSTANCE(model="sar8i_refword") => @SET-SYMBOL $S_sar8i_refword;
// $S_sar8_next_word = @DEFINE-SYMBOL {
// @LINE {(-11,6.6) (11,6.6) (11,-6.6) (-11,-6.6) (-11,6.6)};
// (-13,1.65) @PIN(terminal=9,direction="left");
// @LINE {(-13,1.65) (-11,1.65)};
// (-10.5,1.65) @TEXT("DATA",size=1.2,halign="start",valign="middle");
// (-13,-1.65) @PIN(terminal=[1, 2, 3, 4, 5, 6, 7, 8],direction="left");
// @LINE {(-13,-1.65) (-11,-1.65)};
// (-10.5,-1.65) @TEXT("CODE[7:0]",size=1.2,halign="start",valign="middle");
// (13,3.3) @PIN(terminal=[11, 12, 13, 14, 15, 16, 17, 18],direction="right");
// @LINE {(13,3.3) (11,3.3)};
// (10.5,3.3) @TEXT("D[7:0]",size=1.2,halign="end",valign="middle");
// (13,0) @PIN(terminal=10,direction="right");
// @LINE {(13,0) (11,0)};
// (10.5,0) @TEXT("DONE",size=1.2,halign="end",valign="middle");
// (13,-3.3) @PIN(terminal=[19, 20, 21, 22, 23, 24, 25, 26],direction="right");
// @LINE {(13,-3.3) (11,-3.3)};
// (10.5,-3.3) @TEXT("NEXT[7:0]",size=1.2,halign="end",valign="middle");
// (0,8.6) @PIN(terminal=32,direction="up");
// @LINE {(0,8.6) (0,6.6)};
// (0,5.8) @TEXT("VDD",size=1.2,halign="middle",valign="middle");
// (-4,-8.6) @PIN(terminal=[27, 28, 29, 30, 31],direction="down");
// @LINE {(-4,-8.6) (-4,-6.6)};
// (-4,-5.8) @TEXT("TRIAL[6:2]",size=1.2,halign="middle",valign="middle");
// (4,-8.6) @PIN(terminal=33,direction="down");
// @LINE {(4,-8.6) (4,-6.6)};
// (4,-5.8) @TEXT("VSS",size=1.2,halign="middle",valign="middle");
// ? @TEXT("${name}",key="name",size=1.6,halign="middle") => @PLACE(0,10.1);
// ? @TEXT("${model}",key="model",size=0.85,halign="middle") => @PLACE(0,-10.6);
// };
// # @SELECT-INSTANCE(model="sar8_next_word") => @SET-SYMBOL $S_sar8_next_word;
// $S_sar8_se_window = @DEFINE-SYMBOL {
// @LINE {(-11,11.55) (11,11.55) (11,-11.55) (-11,-11.55) (-11,11.55)};
// (-13,8.25) @PIN(terminal=1,direction="left");
// @LINE {(-13,8.25) (-11,8.25)};
// (-10.5,8.25) @TEXT("PHASE_REQUEST",size=1.1,halign="start",valign="middle");
// (-13,4.95) @PIN(terminal=2,direction="left");
// @LINE {(-13,4.95) (-11,4.95)};
// (-10.5,4.95) @TEXT("SEL9",size=1.1,halign="start",valign="middle");
// (-13,1.65) @PIN(terminal=3,direction="left");
// @LINE {(-13,1.65) (-11,1.65)};
// (-10.5,1.65) @TEXT("SEL7",size=1.1,halign="start",valign="middle");
// (-13,-1.65) @PIN(terminal=4,direction="left");
// @LINE {(-13,-1.65) (-11,-1.65)};
// (-10.5,-1.65) @TEXT("SEL6",size=1.1,halign="start",valign="middle");
// (-13,-4.95) @PIN(terminal=5,direction="left");
// @LINE {(-13,-4.95) (-11,-4.95)};
// (-10.5,-4.95) @TEXT("SEL5",size=1.1,halign="start",valign="middle");
// (-13,-8.25) @PIN(terminal=6,direction="left");
// @LINE {(-13,-8.25) (-11,-8.25)};
// (-10.5,-8.25) @TEXT("SEL4",size=1.1,halign="start",valign="middle");
// (13,0) @PIN(terminal=9,direction="right");
// @LINE {(13,0) (11,0)};
// (10.5,0) @TEXT("DELIVERED",size=1.1,halign="end",valign="middle");
// (0,13.55) @PIN(terminal=7,direction="up");
// @LINE {(0,13.55) (0,11.55)};
// (0,10.75) @TEXT("VDD",size=1.1,halign="middle",valign="middle");
// (0,-13.55) @PIN(terminal=8,direction="down");
// @LINE {(0,-13.55) (0,-11.55)};
// (0,-10.75) @TEXT("VSS",size=1.1,halign="middle",valign="middle");
// ? @TEXT("${name}",key="name",size=1.6,halign="middle") => @PLACE(0,15.05);
// ? @TEXT("${model}",key="model",size=0.85,halign="middle") => @PLACE(0,-15.55);
// };
// # @SELECT-INSTANCE(model="sar8_se_window") => @SET-SYMBOL $S_sar8_se_window;
// $S_sar8_se_timing = @DEFINE-SYMBOL {
// @LINE {(-17,8.25) (17,8.25) (17,-8.25) (-17,-8.25) (-17,8.25)};
// (-19,4.95) @PIN(terminal=8,direction="left");
// @LINE {(-19,4.95) (-17,4.95)};
// (-16.5,4.95) @TEXT("COMP_P",size=1.2,halign="start",valign="middle");
// (-19,1.65) @PIN(terminal=9,direction="left");
// @LINE {(-19,1.65) (-17,1.65)};
// (-16.5,1.65) @TEXT("COMP_N",size=1.2,halign="start",valign="middle");
// (-19,-1.65) @PIN(terminal=2,direction="left");
// @LINE {(-19,-1.65) (-17,-1.65)};
// (-16.5,-1.65) @TEXT("SAMPLE",size=1.2,halign="start",valign="middle");
// (-19,-4.95) @PIN(terminal=1,direction="left");
// @LINE {(-19,-4.95) (-17,-4.95)};
// (-16.5,-4.95) @TEXT("ACTIVE",size=1.2,halign="start",valign="middle");
// (19,3.3) @PIN(terminal=12,direction="right");
// @LINE {(19,3.3) (17,3.3)};
// (16.5,3.3) @TEXT("DATA",size=1.2,halign="end",valign="middle");
// (19,0) @PIN(terminal=11,direction="right");
// @LINE {(19,0) (17,0)};
// (16.5,0) @TEXT("COMMIT",size=1.2,halign="end",valign="middle");
// (19,-3.3) @PIN(terminal=10,direction="right");
// @LINE {(19,-3.3) (17,-3.3)};
// (16.5,-3.3) @TEXT("CMP_CLK",size=1.2,halign="end",valign="middle");
// (0,10.25) @PIN(terminal=13,direction="up");
// @LINE {(0,10.25) (0,8.25)};
// (0,7.45) @TEXT("VDD",size=1.2,halign="middle",valign="middle");
// (-15,-10.25) @PIN(terminal=3,direction="down");
// @LINE {(-15,-10.25) (-15,-8.25)};
// (-15,-7.45) @TEXT("SEL9",size=1.2,halign="middle",valign="middle");
// (-9,-10.25) @PIN(terminal=4,direction="down");
// @LINE {(-9,-10.25) (-9,-8.25)};
// (-9,-7.45) @TEXT("SEL7",size=1.2,halign="middle",valign="middle");
// (-3,-10.25) @PIN(terminal=5,direction="down");
// @LINE {(-3,-10.25) (-3,-8.25)};
// (-3,-7.45) @TEXT("SEL6",size=1.2,halign="middle",valign="middle");
// (3,-10.25) @PIN(terminal=6,direction="down");
// @LINE {(3,-10.25) (3,-8.25)};
// (3,-7.45) @TEXT("SEL5",size=1.2,halign="middle",valign="middle");
// (9,-10.25) @PIN(terminal=7,direction="down");
// @LINE {(9,-10.25) (9,-8.25)};
// (9,-7.45) @TEXT("SEL4",size=1.2,halign="middle",valign="middle");
// (15,-10.25) @PIN(terminal=14,direction="down");
// @LINE {(15,-10.25) (15,-8.25)};
// (15,-7.45) @TEXT("VSS",size=1.2,halign="middle",valign="middle");
// ? @TEXT("${name}",key="name",size=1.6,halign="middle") => @PLACE(0,11.75);
// ? @TEXT("${model}",key="model",size=0.85,halign="middle") => @PLACE(0,-12.25);
// };
// # @SELECT-INSTANCE(model="sar8_se_timing") => @SET-SYMBOL $S_sar8_se_timing;
// $S_sar8_se_store = @DEFINE-SYMBOL {
// @LINE {(-8.5,6) (8.5,6) (8.5,-6) (-8.5,-6) (-8.5,6)};
// (-10.5,1.65) @PIN(terminal=1,direction="left");
// @LINE {(-10.5,1.65) (-8.5,1.65)};
// (-8,1.65) @TEXT("CK",size=1.2,halign="start",valign="middle");
// (-10.5,-1.65) @PIN(terminal=3,direction="left");
// @LINE {(-10.5,-1.65) (-8.5,-1.65)};
// (-8,-1.65) @TEXT("RESET",size=1.2,halign="start",valign="middle");
// (-4,8) @PIN(terminal=2,direction="up");
// @LINE {(-4,8) (-4,6)};
// (-4,5.2) @TEXT("DATA",size=1.2,halign="middle",valign="middle");
// (4,8) @PIN(terminal=4,direction="up");
// @LINE {(4,8) (4,6)};
// (4,5.2) @TEXT("VDD",size=1.2,halign="middle",valign="middle");
// (-4,-8) @PIN(terminal=5,direction="down");
// @LINE {(-4,-8) (-4,-6)};
// (-4,-5.2) @TEXT("VSS",size=1.2,halign="middle",valign="middle");
// (4,-8) @PIN(terminal=6,direction="down");
// @LINE {(4,-8) (4,-6)};
// (4,-5.2) @TEXT("Q",size=1.2,halign="middle",valign="middle");
// ? @TEXT("${name}",key="name",size=1.6,halign="middle") => @PLACE(0,9.5);
// ? @TEXT("${model}",key="model",size=0.85,halign="middle") => @PLACE(0,-10);
// };
// # @SELECT-INSTANCE(model="sar8_se_store") => @SET-SYMBOL $S_sar8_se_store;
// $S_sar8_se_ctrl = @DEFINE-SYMBOL {
// @LINE(fill="fillcolor",fillcolor="#f1eef8") {(-13,6.6) (13,6.6) (13,-6.6) (-13,-6.6) (-13,6.6)};
// (-15,3.3) @PIN(terminal=11,direction="left");
// @LINE {(-15,3.3) (-13,3.3)};
// (-12.5,3.3) @TEXT("COMP_P",size=1.2,halign="start",valign="middle");
// (-15,0) @PIN(terminal=10,direction="left");
// @LINE {(-15,0) (-13,0)};
// (-12.5,0) @TEXT("COMP_N",size=1.2,halign="start",valign="middle");
// (-15,-3.3) @PIN(terminal=21,direction="left");
// @LINE {(-15,-3.3) (-13,-3.3)};
// (-12.5,-3.3) @TEXT("SAMPLE",size=1.2,halign="start",valign="middle");
// (15,3.3) @PIN(terminal=[12, 13, 14, 15, 16, 17, 18, 19],direction="right");
// @LINE {(15,3.3) (13,3.3)};
// (12.5,3.3) @TEXT("D[7:0]",size=1.2,halign="end",valign="middle");
// (15,0) @PIN(terminal=24,direction="right");
// @LINE {(15,0) (13,0)};
// (12.5,0) @TEXT("ACTIVE",size=1.2,halign="end",valign="middle");
// (15,-3.3) @PIN(terminal=20,direction="right");
// @LINE {(15,-3.3) (13,-3.3)};
// (12.5,-3.3) @TEXT("COMMIT",size=1.2,halign="end",valign="middle");
// (-4,8.6) @PIN(terminal=1,direction="up");
// @LINE {(-4,8.6) (-4,6.6)};
// (-4,5.8) @TEXT("CMP_CLK",size=1.2,halign="middle",valign="middle");
// (4,8.6) @PIN(terminal=22,direction="up");
// @LINE {(4,8.6) (4,6.6)};
// (4,5.8) @TEXT("VDD",size=1.2,halign="middle",valign="middle");
// (-4,-8.6) @PIN(terminal=[2, 3, 4, 5, 6, 7, 8, 9],direction="down");
// @LINE {(-4,-8.6) (-4,-6.6)};
// (-4,-5.8) @TEXT("CODE[7:0]",size=1.2,halign="middle",valign="middle");
// (4,-8.6) @PIN(terminal=23,direction="down");
// @LINE {(4,-8.6) (4,-6.6)};
// (4,-5.8) @TEXT("VSS",size=1.2,halign="middle",valign="middle");
// ? @TEXT("${name}",key="name",size=1.6,halign="middle") => @PLACE(0,10.1);
// ? @TEXT("${model}",key="model",size=0.85,halign="middle") => @PLACE(0,-10.6);
// };
// # @SELECT-INSTANCE(model="sar8_se_ctrl") => @SET-SYMBOL $S_sar8_se_ctrl;
// $S_sar8_se_acquire = @DEFINE-SYMBOL {
// @LINE {(-11,6) (11,6) (11,-6) (-11,-6) (-11,6)};
// (-13,0) @PIN(terminal=1,direction="left");
// @LINE {(-13,0) (-11,0)};
// (-10.5,0) @TEXT("REQUEST",size=1.1,halign="start",valign="middle");
// (13,0) @PIN(terminal=4,direction="right");
// @LINE {(13,0) (11,0)};
// (10.5,0) @TEXT("TRACK",size=1.1,halign="end",valign="middle");
// (0,8) @PIN(terminal=2,direction="up");
// @LINE {(0,8) (0,6)};
// (0,5.2) @TEXT("VDD",size=1.1,halign="middle",valign="middle");
// (0,-8) @PIN(terminal=3,direction="down");
// @LINE {(0,-8) (0,-6)};
// (0,-5.2) @TEXT("VSS",size=1.1,halign="middle",valign="middle");
// ? @TEXT("${name}",key="name",size=1.6,halign="middle") => @PLACE(0,9.5);
// ? @TEXT("${model}",key="model",size=0.85,halign="middle") => @PLACE(0,-10);
// };
// # @SELECT-INSTANCE(model="sar8_se_acquire") => @SET-SYMBOL $S_sar8_se_acquire;
// $S_tb_cdac = @DEFINE-SYMBOL {
// @LINE {(-11,6) (11,6) (11,-6) (-11,-6) (-11,6)};
// ? @TEXT("${name}",key="name",size=1.6,halign="middle") => @PLACE(0,9.5);
// ? @TEXT("${model}",key="model",size=0.85,halign="middle") => @PLACE(0,-10);
// };
// # @SELECT-INSTANCE(model="tb_cdac") => @SET-SYMBOL $S_tb_cdac;
// $S_tb_comparator = @DEFINE-SYMBOL {
// @LINE {(-11,6) (11,6) (11,-6) (-11,-6) (-11,6)};
// ? @TEXT("${name}",key="name",size=1.6,halign="middle") => @PLACE(0,9.5);
// ? @TEXT("${model}",key="model",size=0.85,halign="middle") => @PLACE(0,-10);
// };
// # @SELECT-INSTANCE(model="tb_comparator") => @SET-SYMBOL $S_tb_comparator;
// $S_tb_reference = @DEFINE-SYMBOL {
// @LINE {(-11,6) (11,6) (11,-6) (-11,-6) (-11,6)};
// ? @TEXT("${name}",key="name",size=1.6,halign="middle") => @PLACE(0,9.5);
// ? @TEXT("${model}",key="model",size=0.85,halign="middle") => @PLACE(0,-10);
// };
// # @SELECT-INSTANCE(model="tb_reference") => @SET-SYMBOL $S_tb_reference;
// $S_tb_sampler = @DEFINE-SYMBOL {
// @LINE {(-11,6) (11,6) (11,-6) (-11,-6) (-11,6)};
// ? @TEXT("${name}",key="name",size=1.6,halign="middle") => @PLACE(0,9.5);
// ? @TEXT("${model}",key="model",size=0.85,halign="middle") => @PLACE(0,-10);
// };
// # @SELECT-INSTANCE(model="tb_sampler") => @SET-SYMBOL $S_tb_sampler;
// $S_tb_sar = @DEFINE-SYMBOL {
// @LINE {(-11,6) (11,6) (11,-6) (-11,-6) (-11,6)};
// ? @TEXT("${name}",key="name",size=1.6,halign="middle") => @PLACE(0,9.5);
// ? @TEXT("${model}",key="model",size=0.85,halign="middle") => @PLACE(0,-10);
// };
// # @SELECT-INSTANCE(model="tb_sar") => @SET-SYMBOL $S_tb_sar;
// $S_tb_sar_top = @DEFINE-SYMBOL {
// @LINE {(-11,9.9) (11,9.9) (11,-9.9) (-11,-9.9) (-11,9.9)};
// (-13,6.6) @PIN(terminal=9,direction="left");
// @LINE {(-13,6.6) (-11,6.6)};
// (-10.5,6.6) @TEXT("SAMPLE",size=1.1,halign="start",valign="middle");
// (-13,3.3) @PIN(terminal=11,direction="left");
// @LINE {(-13,3.3) (-11,3.3)};
// (-10.5,3.3) @TEXT("VINN",size=1.1,halign="start",valign="middle");
// (-13,0) @PIN(terminal=12,direction="left");
// @LINE {(-13,0) (-11,0)};
// (-10.5,0) @TEXT("VINP",size=1.1,halign="start",valign="middle");
// (-13,-3.3) @PIN(terminal=13,direction="left");
// @LINE {(-13,-3.3) (-11,-3.3)};
// (-10.5,-3.3) @TEXT("VREFN",size=1.1,halign="start",valign="middle");
// (-13,-6.6) @PIN(terminal=14,direction="left");
// @LINE {(-13,-6.6) (-11,-6.6)};
// (-10.5,-6.6) @TEXT("VREFP",size=1.1,halign="start",valign="middle");
// (13,0) @PIN(terminal=[1, 2, 3, 4, 5, 6, 7, 8],direction="right");
// @LINE {(13,0) (11,0)};
// (10.5,0) @TEXT("D[7:0]",size=1.1,halign="end",valign="middle");
// (0,11.9) @PIN(terminal=10,direction="up");
// @LINE {(0,11.9) (0,9.9)};
// (0,9.1) @TEXT("VDD!",size=1.1,halign="middle",valign="middle");
// (0,-11.9) @PIN(terminal=15,direction="down");
// @LINE {(0,-11.9) (0,-9.9)};
// (0,-9.1) @TEXT("0",size=1.1,halign="middle",valign="middle");
// ? @TEXT("${name}",key="name",size=1.6,halign="middle") => @PLACE(0,13.4);
// ? @TEXT("${model}",key="model",size=0.85,halign="middle") => @PLACE(0,-13.9);
// };
// # @SELECT-INSTANCE(model="tb_sar_top") => @SET-SYMBOL $S_tb_sar_top;
// $S_tb_sar_stalled_top = @DEFINE-SYMBOL {
// @LINE {(-11,9.9) (11,9.9) (11,-9.9) (-11,-9.9) (-11,9.9)};
// (-13,6.6) @PIN(terminal=9,direction="left");
// @LINE {(-13,6.6) (-11,6.6)};
// (-10.5,6.6) @TEXT("SAMPLE",size=1.1,halign="start",valign="middle");
// (-13,3.3) @PIN(terminal=11,direction="left");
// @LINE {(-13,3.3) (-11,3.3)};
// (-10.5,3.3) @TEXT("VINN",size=1.1,halign="start",valign="middle");
// (-13,0) @PIN(terminal=12,direction="left");
// @LINE {(-13,0) (-11,0)};
// (-10.5,0) @TEXT("VINP",size=1.1,halign="start",valign="middle");
// (-13,-3.3) @PIN(terminal=13,direction="left");
// @LINE {(-13,-3.3) (-11,-3.3)};
// (-10.5,-3.3) @TEXT("VREFN",size=1.1,halign="start",valign="middle");
// (-13,-6.6) @PIN(terminal=14,direction="left");
// @LINE {(-13,-6.6) (-11,-6.6)};
// (-10.5,-6.6) @TEXT("VREFP",size=1.1,halign="start",valign="middle");
// (13,0) @PIN(terminal=[1, 2, 3, 4, 5, 6, 7, 8],direction="right");
// @LINE {(13,0) (11,0)};
// (10.5,0) @TEXT("D[7:0]",size=1.1,halign="end",valign="middle");
// (0,11.9) @PIN(terminal=10,direction="up");
// @LINE {(0,11.9) (0,9.9)};
// (0,9.1) @TEXT("VDD!",size=1.1,halign="middle",valign="middle");
// (0,-11.9) @PIN(terminal=15,direction="down");
// @LINE {(0,-11.9) (0,-9.9)};
// (0,-9.1) @TEXT("0",size=1.1,halign="middle",valign="middle");
// ? @TEXT("${name}",key="name",size=1.6,halign="middle") => @PLACE(0,13.4);
// ? @TEXT("${model}",key="model",size=0.85,halign="middle") => @PLACE(0,-13.9);
// };
// # @SELECT-INSTANCE(model="tb_sar_stalled_top") => @SET-SYMBOL $S_tb_sar_stalled_top;
// $S_INVD1BWP12T30P140 = @DEFINE-SYMBOL {
// (-7,0) @PIN(terminal=1,direction="left");
// @LINE {(-7,0) (-5,0)};
// (7,0) @PIN(terminal=2,direction="right");
// @LINE {(5,0) (7,0)};
// (0,7) @PIN(terminal=3,direction="up");
// @LINE {(0,7) (0,5)};
// (0,-7) @PIN(terminal=4,direction="down");
// @LINE {(0,-7) (0,-5)};
// @LINE {(-5,5) (-5,-5) (4,0) (-5,5)};
// (4.5,0) @CIRCLE(radius=0.5);
// ? @TEXT("${name}",key="name",size=1.6,halign="middle") => @PLACE(0,8.5);
// ? @TEXT("",key="model",size=0.85,halign="middle") => @PLACE(0,-9);
// };
// # @SELECT-INSTANCE(model="INVD1BWP12T30P140") => @SET-SYMBOL $S_INVD1BWP12T30P140;
// $S_INVD2BWP12T30P140 = @DEFINE-SYMBOL {
// (-7,0) @PIN(terminal=1,direction="left");
// @LINE {(-7,0) (-5,0)};
// (7,0) @PIN(terminal=2,direction="right");
// @LINE {(5,0) (7,0)};
// (0,7) @PIN(terminal=3,direction="up");
// @LINE {(0,7) (0,5)};
// (0,-7) @PIN(terminal=4,direction="down");
// @LINE {(0,-7) (0,-5)};
// @LINE {(-5,5) (-5,-5) (4,0) (-5,5)};
// (4.5,0) @CIRCLE(radius=0.5);
// ? @TEXT("${name}",key="name",size=1.6,halign="middle") => @PLACE(0,8.5);
// ? @TEXT("",key="model",size=0.85,halign="middle") => @PLACE(0,-9);
// };
// # @SELECT-INSTANCE(model="INVD2BWP12T30P140") => @SET-SYMBOL $S_INVD2BWP12T30P140;
// $S_OR2D1BWP12T30P140 = @DEFINE-SYMBOL {
// (-7,1.7) @PIN(terminal=1,direction="left");
// @LINE {(-7,1.7) (-5,1.7)};
// (-7,-1.7) @PIN(terminal=2,direction="left");
// @LINE {(-7,-1.7) (-5,-1.7)};
// (7,0) @PIN(terminal=3,direction="right");
// @LINE {(5,0) (7,0)};
// (0,7) @PIN(terminal=4,direction="up");
// @LINE {(0,7) (0,5)};
// (0,-7) @PIN(terminal=5,direction="down");
// @LINE {(0,-7) (0,-5)};
// @LINE {(-5,5) (-1,4.6) (2,3) (5,0) (2,-3) (-1,-4.6) (-5,-5) (-3.8,-2) (-3.5,0) (-3.8,2) (-5,5)};
// ? @TEXT("${name}",key="name",size=1.6,halign="middle") => @PLACE(0,8.5);
// ? @TEXT("",key="model",size=0.85,halign="middle") => @PLACE(0,-9);
// };
// # @SELECT-INSTANCE(model="OR2D1BWP12T30P140") => @SET-SYMBOL $S_OR2D1BWP12T30P140;
// $S_ND2D1BWP12T30P140 = @DEFINE-SYMBOL {
// (-7,1.7) @PIN(terminal=1,direction="left");
// @LINE {(-7,1.7) (-5,1.7)};
// (-7,-1.7) @PIN(terminal=2,direction="left");
// @LINE {(-7,-1.7) (-5,-1.7)};
// (7,0) @PIN(terminal=3,direction="right");
// @LINE {(5,0) (7,0)};
// (0,7) @PIN(terminal=4,direction="up");
// @LINE {(0,7) (0,5)};
// (0,-7) @PIN(terminal=5,direction="down");
// @LINE {(0,-7) (0,-5)};
// @LINE {(-5,5) (0,5) (3,4) (4.4,2) (5,0) (4.4,-2) (3,-4) (0,-5) (-5,-5) (-5,5)};
// (5.5,0) @CIRCLE(radius=0.5);
// ? @TEXT("${name}",key="name",size=1.6,halign="middle") => @PLACE(0,8.5);
// ? @TEXT("",key="model",size=0.85,halign="middle") => @PLACE(0,-9);
// };
// # @SELECT-INSTANCE(model="ND2D1BWP12T30P140") => @SET-SYMBOL $S_ND2D1BWP12T30P140;
// $S_DFCNQD1BWP12T30P140 = @DEFINE-SYMBOL {
// (-7,3.4) @PIN(terminal=1,direction="left");
// @LINE {(-7,3.4) (-5,3.4)};
// (-4.5,3.4) @TEXT("D",size=0.7,halign="start",valign="middle");
// (-7,0) @PIN(terminal=2,direction="left");
// @LINE {(-7,0) (-5,0)};
// (-4.5,0) @TEXT("CK",size=0.7,halign="start",valign="middle");
// @LINE {(-5,0.7) (-3.8,0) (-5,-0.7)};
// (-7,-3.4) @PIN(terminal=3,direction="left");
// @LINE {(-7,-3.4) (-5,-3.4)};
// (-4.5,-3.4) @TEXT("RN",size=0.7,halign="start",valign="middle");
// (-5.4,-3.4) @CIRCLE(radius=0.4);
// (7,0) @PIN(terminal=4,direction="right");
// @LINE {(5,0) (7,0)};
// (0,7) @PIN(terminal=5,direction="up");
// @LINE {(0,7) (0,5)};
// (0,-7) @PIN(terminal=6,direction="down");
// @LINE {(0,-7) (0,-5)};
// @LINE {(-5,5) (5,5) (5,-5) (-5,-5) (-5,5)};
// (1,0) @TEXT("DFF",size=0.85,halign="middle",valign="middle");
// ? @TEXT("${name}",key="name",size=1.6,halign="middle") => @PLACE(0,8.5);
// ? @TEXT("",key="model",size=0.85,halign="middle") => @PLACE(0,-9);
// };
// # @SELECT-INSTANCE(model="DFCNQD1BWP12T30P140") => @SET-SYMBOL $S_DFCNQD1BWP12T30P140;
// $S_AN2D1BWP12T30P140 = @DEFINE-SYMBOL {
// @LINE {(-11,6) (11,6) (11,-6) (-11,-6) (-11,6)};
// (-13,1.65) @PIN(terminal=1,direction="left");
// @LINE {(-13,1.65) (-11,1.65)};
// (-10.5,1.65) @TEXT("A1",size=1.1,halign="start",valign="middle");
// (-13,-1.65) @PIN(terminal=2,direction="left");
// @LINE {(-13,-1.65) (-11,-1.65)};
// (-10.5,-1.65) @TEXT("A2",size=1.1,halign="start",valign="middle");
// (13,0) @PIN(terminal=3,direction="right");
// @LINE {(13,0) (11,0)};
// (10.5,0) @TEXT("Z",size=1.1,halign="end",valign="middle");
// (0,8) @PIN(terminal=4,direction="up");
// @LINE {(0,8) (0,6)};
// (0,5.2) @TEXT("VDD",size=1.1,halign="middle",valign="middle");
// (0,-8) @PIN(terminal=5,direction="down");
// @LINE {(0,-8) (0,-6)};
// (0,-5.2) @TEXT("VSS",size=1.1,halign="middle",valign="middle");
// ? @TEXT("${name}",key="name",size=1.6,halign="middle") => @PLACE(0,9.5);
// ? @TEXT("${model}",key="model",size=0.85,halign="middle") => @PLACE(0,-10);
// };
// # @SELECT-INSTANCE(model="AN2D1BWP12T30P140") => @SET-SYMBOL $S_AN2D1BWP12T30P140;
// $S_XOR2D1BWP12T30P140 = @DEFINE-SYMBOL {
// @LINE {(-11,6) (11,6) (11,-6) (-11,-6) (-11,6)};
// (-13,1.65) @PIN(terminal=1,direction="left");
// @LINE {(-13,1.65) (-11,1.65)};
// (-10.5,1.65) @TEXT("A1",size=1.1,halign="start",valign="middle");
// (-13,-1.65) @PIN(terminal=2,direction="left");
// @LINE {(-13,-1.65) (-11,-1.65)};
// (-10.5,-1.65) @TEXT("A2",size=1.1,halign="start",valign="middle");
// (13,0) @PIN(terminal=3,direction="right");
// @LINE {(13,0) (11,0)};
// (10.5,0) @TEXT("Z",size=1.1,halign="end",valign="middle");
// (0,8) @PIN(terminal=4,direction="up");
// @LINE {(0,8) (0,6)};
// (0,5.2) @TEXT("VDD",size=1.1,halign="middle",valign="middle");
// (0,-8) @PIN(terminal=5,direction="down");
// @LINE {(0,-8) (0,-6)};
// (0,-5.2) @TEXT("VSS",size=1.1,halign="middle",valign="middle");
// ? @TEXT("${name}",key="name",size=1.6,halign="middle") => @PLACE(0,9.5);
// ? @TEXT("${model}",key="model",size=0.85,halign="middle") => @PLACE(0,-10);
// };
// # @SELECT-INSTANCE(model="XOR2D1BWP12T30P140") => @SET-SYMBOL $S_XOR2D1BWP12T30P140;
// $S_MUX2D1BWP12T30P140 = @DEFINE-SYMBOL {
// @LINE {(-11,6.6) (11,6.6) (11,-6.6) (-11,-6.6) (-11,6.6)};
// (-13,3.3) @PIN(terminal=1,direction="left");
// @LINE {(-13,3.3) (-11,3.3)};
// (-10.5,3.3) @TEXT("I0",size=1.1,halign="start",valign="middle");
// (-13,0) @PIN(terminal=2,direction="left");
// @LINE {(-13,0) (-11,0)};
// (-10.5,0) @TEXT("I1",size=1.1,halign="start",valign="middle");
// (-13,-3.3) @PIN(terminal=3,direction="left");
// @LINE {(-13,-3.3) (-11,-3.3)};
// (-10.5,-3.3) @TEXT("S",size=1.1,halign="start",valign="middle");
// (13,0) @PIN(terminal=4,direction="right");
// @LINE {(13,0) (11,0)};
// (10.5,0) @TEXT("Z",size=1.1,halign="end",valign="middle");
// (0,8.6) @PIN(terminal=5,direction="up");
// @LINE {(0,8.6) (0,6.6)};
// (0,5.8) @TEXT("VDD",size=1.1,halign="middle",valign="middle");
// (0,-8.6) @PIN(terminal=6,direction="down");
// @LINE {(0,-8.6) (0,-6.6)};
// (0,-5.8) @TEXT("VSS",size=1.1,halign="middle",valign="middle");
// ? @TEXT("${name}",key="name",size=1.6,halign="middle") => @PLACE(0,10.1);
// ? @TEXT("${model}",key="model",size=0.85,halign="middle") => @PLACE(0,-10.6);
// };
// # @SELECT-INSTANCE(model="MUX2D1BWP12T30P140") => @SET-SYMBOL $S_MUX2D1BWP12T30P140;
// $S_BUFFD1BWP12T30P140 = @DEFINE-SYMBOL {
// (-7,0) @PIN(terminal=1,direction="left");
// @LINE {(-7,0) (-5,0)};
// (7,0) @PIN(terminal=2,direction="right");
// @LINE {(5,0) (7,0)};
// (0,7) @PIN(terminal=3,direction="up");
// @LINE {(0,7) (0,5)};
// (0,-7) @PIN(terminal=4,direction="down");
// @LINE {(0,-7) (0,-5)};
// @LINE {(-5,5) (-5,-5) (4,0) (-5,5)};
// ? @TEXT("${name}",key="name",size=1.6,halign="middle") => @PLACE(0,8.5);
// ? @TEXT("",key="model",size=0.85,halign="middle") => @PLACE(0,-9);
// };
// # @SELECT-INSTANCE(model="BUFFD1BWP12T30P140") => @SET-SYMBOL $S_BUFFD1BWP12T30P140;
// $S_BUFFD2BWP12T30P140 = @DEFINE-SYMBOL {
// (-7,0) @PIN(terminal=1,direction="left");
// @LINE {(-7,0) (-5,0)};
// (7,0) @PIN(terminal=2,direction="right");
// @LINE {(5,0) (7,0)};
// (0,7) @PIN(terminal=3,direction="up");
// @LINE {(0,7) (0,5)};
// (0,-7) @PIN(terminal=4,direction="down");
// @LINE {(0,-7) (0,-5)};
// @LINE {(-5,5) (-5,-5) (4,0) (-5,5)};
// ? @TEXT("${name}",key="name",size=1.6,halign="middle") => @PLACE(0,8.5);
// ? @TEXT("",key="model",size=0.85,halign="middle") => @PLACE(0,-9);
// };
// # @SELECT-INSTANCE(model="BUFFD2BWP12T30P140") => @SET-SYMBOL $S_BUFFD2BWP12T30P140;
// $S_CKBD1BWP12T30P140 = @DEFINE-SYMBOL {
// @LINE {(-11,6) (11,6) (11,-6) (-11,-6) (-11,6)};
// (-13,0) @PIN(terminal=1,direction="left");
// @LINE {(-13,0) (-11,0)};
// (-10.5,0) @TEXT("I",size=1.1,halign="start",valign="middle");
// (13,0) @PIN(terminal=2,direction="right");
// @LINE {(13,0) (11,0)};
// (10.5,0) @TEXT("Z",size=1.1,halign="end",valign="middle");
// (0,8) @PIN(terminal=3,direction="up");
// @LINE {(0,8) (0,6)};
// (0,5.2) @TEXT("VDD",size=1.1,halign="middle",valign="middle");
// (0,-8) @PIN(terminal=4,direction="down");
// @LINE {(0,-8) (0,-6)};
// (0,-5.2) @TEXT("VSS",size=1.1,halign="middle",valign="middle");
// ? @TEXT("${name}",key="name",size=1.6,halign="middle") => @PLACE(0,9.5);
// ? @TEXT("${model}",key="model",size=0.85,halign="middle") => @PLACE(0,-10);
// };
// # @SELECT-INSTANCE(model="CKBD1BWP12T30P140") => @SET-SYMBOL $S_CKBD1BWP12T30P140;
// $S_LHCNDQD1BWP12T30P140 = @DEFINE-SYMBOL {
// @LINE {(-11,6.6) (11,6.6) (11,-6.6) (-11,-6.6) (-11,6.6)};
// (-13,3.3) @PIN(terminal=1,direction="left");
// @LINE {(-13,3.3) (-11,3.3)};
// (-10.5,3.3) @TEXT("D",size=1.1,halign="start",valign="middle");
// (-13,0) @PIN(terminal=2,direction="left");
// @LINE {(-13,0) (-11,0)};
// (-10.5,0) @TEXT("E",size=1.1,halign="start",valign="middle");
// (-13,-3.3) @PIN(terminal=3,direction="left");
// @LINE {(-13,-3.3) (-11,-3.3)};
// (-10.5,-3.3) @TEXT("CDN",size=1.1,halign="start",valign="middle");
// (13,0) @PIN(terminal=4,direction="right");
// @LINE {(13,0) (11,0)};
// (10.5,0) @TEXT("Q",size=1.1,halign="end",valign="middle");
// (0,8.6) @PIN(terminal=5,direction="up");
// @LINE {(0,8.6) (0,6.6)};
// (0,5.8) @TEXT("VDD",size=1.1,halign="middle",valign="middle");
// (0,-8.6) @PIN(terminal=6,direction="down");
// @LINE {(0,-8.6) (0,-6.6)};
// (0,-5.8) @TEXT("VSS",size=1.1,halign="middle",valign="middle");
// ? @TEXT("${name}",key="name",size=1.6,halign="middle") => @PLACE(0,10.1);
// ? @TEXT("${model}",key="model",size=0.85,halign="middle") => @PLACE(0,-10.6);
// };
// # @SELECT-INSTANCE(model="LHCNDQD1BWP12T30P140") => @SET-SYMBOL $S_LHCNDQD1BWP12T30P140;
// $S_TIEHBWP12T30P140 = @DEFINE-SYMBOL {
// @LINE {(-11,6) (11,6) (11,-6) (-11,-6) (-11,6)};
// (13,0) @PIN(terminal=1,direction="right");
// @LINE {(13,0) (11,0)};
// (10.5,0) @TEXT("Z",size=1.1,halign="end",valign="middle");
// (0,8) @PIN(terminal=2,direction="up");
// @LINE {(0,8) (0,6)};
// (0,5.2) @TEXT("VDD",size=1.1,halign="middle",valign="middle");
// (0,-8) @PIN(terminal=3,direction="down");
// @LINE {(0,-8) (0,-6)};
// (0,-5.2) @TEXT("VSS",size=1.1,halign="middle",valign="middle");
// ? @TEXT("${name}",key="name",size=1.6,halign="middle") => @PLACE(0,9.5);
// ? @TEXT("${model}",key="model",size=0.85,halign="middle") => @PLACE(0,-10);
// };
// # @SELECT-INSTANCE(model="TIEHBWP12T30P140") => @SET-SYMBOL $S_TIEHBWP12T30P140;
// $S_iprobe = @DEFINE-SYMBOL {
// @LINE {(-11,6) (11,6) (11,-6) (-11,-6) (-11,6)};
// (-13,1.65) @PIN(terminal=1,direction="left");
// @LINE {(-13,1.65) (-11,1.65)};
// (-10.5,1.65) @TEXT("p",size=1.1,halign="start",valign="middle");
// (-13,-1.65) @PIN(terminal=2,direction="left");
// @LINE {(-13,-1.65) (-11,-1.65)};
// (-10.5,-1.65) @TEXT("n",size=1.1,halign="start",valign="middle");
// ? @TEXT("${name}",key="name",size=1.6,halign="middle") => @PLACE(0,9.5);
// ? @TEXT("${model}",key="model",size=0.85,halign="middle") => @PLACE(0,-10);
// };
// # @SELECT-INSTANCE(model="iprobe") => @SET-SYMBOL $S_iprobe;
// $S_DEL025D1BWP12T30P140 = @DEFINE-SYMBOL {
// @LINE {(-11,6) (11,6) (11,-6) (-11,-6) (-11,6)};
// (-13,0) @PIN(terminal=1,direction="left");
// @LINE {(-13,0) (-11,0)};
// (-10.5,0) @TEXT("I",size=1.1,halign="start",valign="middle");
// (13,0) @PIN(terminal=2,direction="right");
// @LINE {(13,0) (11,0)};
// (10.5,0) @TEXT("Z",size=1.1,halign="end",valign="middle");
// (0,8) @PIN(terminal=3,direction="up");
// @LINE {(0,8) (0,6)};
// (0,5.2) @TEXT("VDD",size=1.1,halign="middle",valign="middle");
// (0,-8) @PIN(terminal=4,direction="down");
// @LINE {(0,-8) (0,-6)};
// (0,-5.2) @TEXT("VSS",size=1.1,halign="middle",valign="middle");
// ? @TEXT("${name}",key="name",size=1.6,halign="middle") => @PLACE(0,9.5);
// ? @TEXT("${model}",key="model",size=0.85,halign="middle") => @PLACE(0,-10);
// };
// # @SELECT-INSTANCE(model="DEL025D1BWP12T30P140") => @SET-SYMBOL $S_DEL025D1BWP12T30P140;
// $S_DEL050D1BWP12T30P140 = @DEFINE-SYMBOL {
// @LINE {(-11,6) (11,6) (11,-6) (-11,-6) (-11,6)};
// (-13,0) @PIN(terminal=1,direction="left");
// @LINE {(-13,0) (-11,0)};
// (-10.5,0) @TEXT("I",size=1.1,halign="start",valign="middle");
// (13,0) @PIN(terminal=2,direction="right");
// @LINE {(13,0) (11,0)};
// (10.5,0) @TEXT("Z",size=1.1,halign="end",valign="middle");
// (0,8) @PIN(terminal=3,direction="up");
// @LINE {(0,8) (0,6)};
// (0,5.2) @TEXT("VDD",size=1.1,halign="middle",valign="middle");
// (0,-8) @PIN(terminal=4,direction="down");
// @LINE {(0,-8) (0,-6)};
// (0,-5.2) @TEXT("VSS",size=1.1,halign="middle",valign="middle");
// ? @TEXT("${name}",key="name",size=1.6,halign="middle") => @PLACE(0,9.5);
// ? @TEXT("${model}",key="model",size=0.85,halign="middle") => @PLACE(0,-10);
// };
// # @SELECT-INSTANCE(model="DEL050D1BWP12T30P140") => @SET-SYMBOL $S_DEL050D1BWP12T30P140;
// $S_DEL075D1BWP12T30P140 = @DEFINE-SYMBOL {
// @LINE {(-11,6) (11,6) (11,-6) (-11,-6) (-11,6)};
// (-13,0) @PIN(terminal=1,direction="left");
// @LINE {(-13,0) (-11,0)};
// (-10.5,0) @TEXT("I",size=1.1,halign="start",valign="middle");
// (13,0) @PIN(terminal=2,direction="right");
// @LINE {(13,0) (11,0)};
// (10.5,0) @TEXT("Z",size=1.1,halign="end",valign="middle");
// (0,8) @PIN(terminal=3,direction="up");
// @LINE {(0,8) (0,6)};
// (0,5.2) @TEXT("VDD",size=1.1,halign="middle",valign="middle");
// (0,-8) @PIN(terminal=4,direction="down");
// @LINE {(0,-8) (0,-6)};
// (0,-5.2) @TEXT("VSS",size=1.1,halign="middle",valign="middle");
// ? @TEXT("${name}",key="name",size=1.6,halign="middle") => @PLACE(0,9.5);
// ? @TEXT("${model}",key="model",size=0.85,halign="middle") => @PLACE(0,-10);
// };
// # @SELECT-INSTANCE(model="DEL075D1BWP12T30P140") => @SET-SYMBOL $S_DEL075D1BWP12T30P140;
// $S_DEL100D1BWP12T30P140 = @DEFINE-SYMBOL {
// @LINE {(-11,6) (11,6) (11,-6) (-11,-6) (-11,6)};
// (-13,0) @PIN(terminal=1,direction="left");
// @LINE {(-13,0) (-11,0)};
// (-10.5,0) @TEXT("I",size=1.1,halign="start",valign="middle");
// (13,0) @PIN(terminal=2,direction="right");
// @LINE {(13,0) (11,0)};
// (10.5,0) @TEXT("Z",size=1.1,halign="end",valign="middle");
// (0,8) @PIN(terminal=3,direction="up");
// @LINE {(0,8) (0,6)};
// (0,5.2) @TEXT("VDD",size=1.1,halign="middle",valign="middle");
// (0,-8) @PIN(terminal=4,direction="down");
// @LINE {(0,-8) (0,-6)};
// (0,-5.2) @TEXT("VSS",size=1.1,halign="middle",valign="middle");
// ? @TEXT("${name}",key="name",size=1.6,halign="middle") => @PLACE(0,9.5);
// ? @TEXT("${model}",key="model",size=0.85,halign="middle") => @PLACE(0,-10);
// };
// # @SELECT-INSTANCE(model="DEL100D1BWP12T30P140") => @SET-SYMBOL $S_DEL100D1BWP12T30P140;
// $S_DEL150D1BWP12T30P140 = @DEFINE-SYMBOL {
// @LINE {(-11,6) (11,6) (11,-6) (-11,-6) (-11,6)};
// (-13,0) @PIN(terminal=1,direction="left");
// @LINE {(-13,0) (-11,0)};
// (-10.5,0) @TEXT("I",size=1.1,halign="start",valign="middle");
// (13,0) @PIN(terminal=2,direction="right");
// @LINE {(13,0) (11,0)};
// (10.5,0) @TEXT("Z",size=1.1,halign="end",valign="middle");
// (0,8) @PIN(terminal=3,direction="up");
// @LINE {(0,8) (0,6)};
// (0,5.2) @TEXT("VDD",size=1.1,halign="middle",valign="middle");
// (0,-8) @PIN(terminal=4,direction="down");
// @LINE {(0,-8) (0,-6)};
// (0,-5.2) @TEXT("VSS",size=1.1,halign="middle",valign="middle");
// ? @TEXT("${name}",key="name",size=1.6,halign="middle") => @PLACE(0,9.5);
// ? @TEXT("${model}",key="model",size=0.85,halign="middle") => @PLACE(0,-10);
// };
// # @SELECT-INSTANCE(model="DEL150D1BWP12T30P140") => @SET-SYMBOL $S_DEL150D1BWP12T30P140;
// $S_DEL200D1BWP12T30P140 = @DEFINE-SYMBOL {
// @LINE {(-11,6) (11,6) (11,-6) (-11,-6) (-11,6)};
// (-13,0) @PIN(terminal=1,direction="left");
// @LINE {(-13,0) (-11,0)};
// (-10.5,0) @TEXT("I",size=1.1,halign="start",valign="middle");
// (13,0) @PIN(terminal=2,direction="right");
// @LINE {(13,0) (11,0)};
// (10.5,0) @TEXT("Z",size=1.1,halign="end",valign="middle");
// (0,8) @PIN(terminal=3,direction="up");
// @LINE {(0,8) (0,6)};
// (0,5.2) @TEXT("VDD",size=1.1,halign="middle",valign="middle");
// (0,-8) @PIN(terminal=4,direction="down");
// @LINE {(0,-8) (0,-6)};
// (0,-5.2) @TEXT("VSS",size=1.1,halign="middle",valign="middle");
// ? @TEXT("${name}",key="name",size=1.6,halign="middle") => @PLACE(0,9.5);
// ? @TEXT("${model}",key="model",size=0.85,halign="middle") => @PLACE(0,-10);
// };
// # @SELECT-INSTANCE(model="DEL200D1BWP12T30P140") => @SET-SYMBOL $S_DEL200D1BWP12T30P140;
// $S_DEL250D1BWP12T30P140 = @DEFINE-SYMBOL {
// @LINE {(-11,6) (11,6) (11,-6) (-11,-6) (-11,6)};
// (-13,0) @PIN(terminal=1,direction="left");
// @LINE {(-13,0) (-11,0)};
// (-10.5,0) @TEXT("I",size=1.1,halign="start",valign="middle");
// (13,0) @PIN(terminal=2,direction="right");
// @LINE {(13,0) (11,0)};
// (10.5,0) @TEXT("Z",size=1.1,halign="end",valign="middle");
// (0,8) @PIN(terminal=3,direction="up");
// @LINE {(0,8) (0,6)};
// (0,5.2) @TEXT("VDD",size=1.1,halign="middle",valign="middle");
// (0,-8) @PIN(terminal=4,direction="down");
// @LINE {(0,-8) (0,-6)};
// (0,-5.2) @TEXT("VSS",size=1.1,halign="middle",valign="middle");
// ? @TEXT("${name}",key="name",size=1.6,halign="middle") => @PLACE(0,9.5);
// ? @TEXT("${model}",key="model",size=0.85,halign="middle") => @PLACE(0,-10);
// };
// # @SELECT-INSTANCE(model="DEL250D1BWP12T30P140") => @SET-SYMBOL $S_DEL250D1BWP12T30P140;
// $S_b_cdac = @DEFINE-SYMBOL {
// @LINE {(-11,11.55) (11,11.55) (11,-11.55) (-11,-11.55) (-11,11.55)};
// (-13,8.25) @PIN(terminal=[1, 2, 3, 4, 5, 6, 7, 8],direction="left");
// @LINE {(-13,8.25) (-11,8.25)};
// (-10.5,8.25) @TEXT("GNN[7:0]",size=1.1,halign="start",valign="middle");
// (-13,4.95) @PIN(terminal=[9, 10, 11, 12, 13, 14, 15, 16],direction="left");
// @LINE {(-13,4.95) (-11,4.95)};
// (-10.5,4.95) @TEXT("GNP[7:0]",size=1.1,halign="start",valign="middle");
// (-13,1.65) @PIN(terminal=[17, 18, 19, 20, 21, 22, 23, 24],direction="left");
// @LINE {(-13,1.65) (-11,1.65)};
// (-10.5,1.65) @TEXT("GPN[7:0]",size=1.1,halign="start",valign="middle");
// (-13,-1.65) @PIN(terminal=[25, 26, 27, 28, 29, 30, 31, 32],direction="left");
// @LINE {(-13,-1.65) (-11,-1.65)};
// (-10.5,-1.65) @TEXT("GPP[7:0]",size=1.1,halign="start",valign="middle");
// (-13,-4.95) @PIN(terminal=36,direction="left");
// @LINE {(-13,-4.95) (-11,-4.95)};
// (-10.5,-4.95) @TEXT("VREFN",size=1.1,halign="start",valign="middle");
// (-13,-8.25) @PIN(terminal=37,direction="left");
// @LINE {(-13,-8.25) (-11,-8.25)};
// (-10.5,-8.25) @TEXT("VREFP",size=1.1,halign="start",valign="middle");
// (13,1.65) @PIN(terminal=33,direction="right");
// @LINE {(13,1.65) (11,1.65)};
// (10.5,1.65) @TEXT("TOPN",size=1.1,halign="end",valign="middle");
// (13,-1.65) @PIN(terminal=34,direction="right");
// @LINE {(13,-1.65) (11,-1.65)};
// (10.5,-1.65) @TEXT("TOPP",size=1.1,halign="end",valign="middle");
// (0,13.55) @PIN(terminal=35,direction="up");
// @LINE {(0,13.55) (0,11.55)};
// (0,10.75) @TEXT("VDD",size=1.1,halign="middle",valign="middle");
// (0,-13.55) @PIN(terminal=38,direction="down");
// @LINE {(0,-13.55) (0,-11.55)};
// (0,-10.75) @TEXT("VSS",size=1.1,halign="middle",valign="middle");
// ? @TEXT("${name}",key="name",size=1.6,halign="middle") => @PLACE(0,15.05);
// ? @TEXT("${model}",key="model",size=0.85,halign="middle") => @PLACE(0,-15.55);
// };
// # @SELECT-INSTANCE(model="b_cdac") => @SET-SYMBOL $S_b_cdac;
// $S_b_cdac_bit = @DEFINE-SYMBOL {
// @LINE {(-11,11.55) (11,11.55) (11,-11.55) (-11,-11.55) (-11,11.55)};
// (-13,8.25) @PIN(terminal=1,direction="left");
// @LINE {(-13,8.25) (-11,8.25)};
// (-10.5,8.25) @TEXT("GNN",size=1.1,halign="start",valign="middle");
// (-13,4.95) @PIN(terminal=2,direction="left");
// @LINE {(-13,4.95) (-11,4.95)};
// (-10.5,4.95) @TEXT("GNP",size=1.1,halign="start",valign="middle");
// (-13,1.65) @PIN(terminal=3,direction="left");
// @LINE {(-13,1.65) (-11,1.65)};
// (-10.5,1.65) @TEXT("GPN",size=1.1,halign="start",valign="middle");
// (-13,-1.65) @PIN(terminal=4,direction="left");
// @LINE {(-13,-1.65) (-11,-1.65)};
// (-10.5,-1.65) @TEXT("GPP",size=1.1,halign="start",valign="middle");
// (-13,-4.95) @PIN(terminal=7,direction="left");
// @LINE {(-13,-4.95) (-11,-4.95)};
// (-10.5,-4.95) @TEXT("VREFN",size=1.1,halign="start",valign="middle");
// (-13,-8.25) @PIN(terminal=8,direction="left");
// @LINE {(-13,-8.25) (-11,-8.25)};
// (-10.5,-8.25) @TEXT("VREFP",size=1.1,halign="start",valign="middle");
// (13,1.65) @PIN(terminal=5,direction="right");
// @LINE {(13,1.65) (11,1.65)};
// (10.5,1.65) @TEXT("TOPN",size=1.1,halign="end",valign="middle");
// (13,-1.65) @PIN(terminal=6,direction="right");
// @LINE {(13,-1.65) (11,-1.65)};
// (10.5,-1.65) @TEXT("TOPP",size=1.1,halign="end",valign="middle");
// (0,13.55) @PIN(terminal=9,direction="up");
// @LINE {(0,13.55) (0,11.55)};
// (0,10.75) @TEXT("VDD",size=1.1,halign="middle",valign="middle");
// (0,-13.55) @PIN(terminal=10,direction="down");
// @LINE {(0,-13.55) (0,-11.55)};
// (0,-10.75) @TEXT("VSS",size=1.1,halign="middle",valign="middle");
// ? @TEXT("${name}",key="name",size=1.6,halign="middle") => @PLACE(0,15.05);
// ? @TEXT("${model}",key="model",size=0.85,halign="middle") => @PLACE(0,-15.55);
// };
// # @SELECT-INSTANCE(model="b_cdac_bit") => @SET-SYMBOL $S_b_cdac_bit;
// $S_b_comparator = @DEFINE-SYMBOL {
// @LINE {(-11,6.6) (11,6.6) (11,-6.6) (-11,-6.6) (-11,6.6)};
// (-13,3.3) @PIN(terminal=1,direction="left");
// @LINE {(-13,3.3) (-11,3.3)};
// (-10.5,3.3) @TEXT("CLK",size=1.1,halign="start",valign="middle");
// (-13,0) @PIN(terminal=5,direction="left");
// @LINE {(-13,0) (-11,0)};
// (-10.5,0) @TEXT("VINN",size=1.1,halign="start",valign="middle");
// (-13,-3.3) @PIN(terminal=6,direction="left");
// @LINE {(-13,-3.3) (-11,-3.3)};
// (-10.5,-3.3) @TEXT("VINP",size=1.1,halign="start",valign="middle");
// (13,1.65) @PIN(terminal=2,direction="right");
// @LINE {(13,1.65) (11,1.65)};
// (10.5,1.65) @TEXT("OUTN",size=1.1,halign="end",valign="middle");
// (13,-1.65) @PIN(terminal=3,direction="right");
// @LINE {(13,-1.65) (11,-1.65)};
// (10.5,-1.65) @TEXT("OUTP",size=1.1,halign="end",valign="middle");
// (0,8.6) @PIN(terminal=4,direction="up");
// @LINE {(0,8.6) (0,6.6)};
// (0,5.8) @TEXT("VDD",size=1.1,halign="middle",valign="middle");
// (0,-8.6) @PIN(terminal=7,direction="down");
// @LINE {(0,-8.6) (0,-6.6)};
// (0,-5.8) @TEXT("VSS",size=1.1,halign="middle",valign="middle");
// ? @TEXT("${name}",key="name",size=1.6,halign="middle") => @PLACE(0,10.1);
// ? @TEXT("${model}",key="model",size=0.85,halign="middle") => @PLACE(0,-10.6);
// };
// # @SELECT-INSTANCE(model="b_comparator") => @SET-SYMBOL $S_b_comparator;
// $S_b_reference = @DEFINE-SYMBOL {
// @LINE {(-11,11.55) (11,11.55) (11,-11.55) (-11,-11.55) (-11,11.55)};
// (-13,4.95) @PIN(terminal=[1, 2, 3, 4, 5, 6, 7, 8],direction="left");
// @LINE {(-13,4.95) (-11,4.95)};
// (-10.5,4.95) @TEXT("CODE[7:0]",size=1.1,halign="start",valign="middle");
// (-13,1.65) @PIN(terminal=[9, 10, 11, 12, 13, 14, 15, 16],direction="left");
// @LINE {(-13,1.65) (-11,1.65)};
// (-10.5,1.65) @TEXT("D[7:0]",size=1.1,halign="start",valign="middle");
// (-13,-1.65) @PIN(terminal=49,direction="left");
// @LINE {(-13,-1.65) (-11,-1.65)};
// (-10.5,-1.65) @TEXT("PHI_U",size=1.1,halign="start",valign="middle");
// (-13,-4.95) @PIN(terminal=50,direction="left");
// @LINE {(-13,-4.95) (-11,-4.95)};
// (-10.5,-4.95) @TEXT("SAMPLE",size=1.1,halign="start",valign="middle");
// (13,8.25) @PIN(terminal=[17, 18, 19, 20, 21, 22, 23, 24],direction="right");
// @LINE {(13,8.25) (11,8.25)};
// (10.5,8.25) @TEXT("GNN[7:0]",size=1.1,halign="end",valign="middle");
// (13,4.95) @PIN(terminal=[25, 26, 27, 28, 29, 30, 31, 32],direction="right");
// @LINE {(13,4.95) (11,4.95)};
// (10.5,4.95) @TEXT("GNP[7:0]",size=1.1,halign="end",valign="middle");
// (13,1.65) @PIN(terminal=[33, 34, 35, 36, 37, 38, 39, 40],direction="right");
// @LINE {(13,1.65) (11,1.65)};
// (10.5,1.65) @TEXT("GPN[7:0]",size=1.1,halign="end",valign="middle");
// (13,-1.65) @PIN(terminal=[41, 42, 43, 44, 45, 46, 47, 48],direction="right");
// @LINE {(13,-1.65) (11,-1.65)};
// (10.5,-1.65) @TEXT("GPP[7:0]",size=1.1,halign="end",valign="middle");
// (13,-4.95) @PIN(terminal=53,direction="right");
// @LINE {(13,-4.95) (11,-4.95)};
// (10.5,-4.95) @TEXT("RST_DONE",size=1.1,halign="end",valign="middle");
// (13,-8.25) @PIN(terminal=54,direction="right");
// @LINE {(13,-8.25) (11,-8.25)};
// (10.5,-8.25) @TEXT("PRESET",size=1.1,halign="end",valign="middle");
// (0,13.55) @PIN(terminal=51,direction="up");
// @LINE {(0,13.55) (0,11.55)};
// (0,10.75) @TEXT("VDD",size=1.1,halign="middle",valign="middle");
// (0,-13.55) @PIN(terminal=52,direction="down");
// @LINE {(0,-13.55) (0,-11.55)};
// (0,-10.75) @TEXT("VSS",size=1.1,halign="middle",valign="middle");
// ? @TEXT("${name}",key="name",size=1.6,halign="middle") => @PLACE(0,15.05);
// ? @TEXT("${model}",key="model",size=0.85,halign="middle") => @PLACE(0,-15.55);
// };
// # @SELECT-INSTANCE(model="b_reference") => @SET-SYMBOL $S_b_reference;
// $S_b_edge = @DEFINE-SYMBOL {
// @LINE {(-11,6) (11,6) (11,-6) (-11,-6) (-11,6)};
// (-13,0) @PIN(terminal=1,direction="left");
// @LINE {(-13,0) (-11,0)};
// (-10.5,0) @TEXT("A",size=1.1,halign="start",valign="middle");
// (13,0) @PIN(terminal=4,direction="right");
// @LINE {(13,0) (11,0)};
// (10.5,0) @TEXT("Y",size=1.1,halign="end",valign="middle");
// (0,8) @PIN(terminal=2,direction="up");
// @LINE {(0,8) (0,6)};
// (0,5.2) @TEXT("VDD",size=1.1,halign="middle",valign="middle");
// (0,-8) @PIN(terminal=3,direction="down");
// @LINE {(0,-8) (0,-6)};
// (0,-5.2) @TEXT("VSS",size=1.1,halign="middle",valign="middle");
// ? @TEXT("${name}",key="name",size=1.6,halign="middle") => @PLACE(0,9.5);
// ? @TEXT("${model}",key="model",size=0.85,halign="middle") => @PLACE(0,-10);
// };
// # @SELECT-INSTANCE(model="b_edge") => @SET-SYMBOL $S_b_edge;
// $S_b_idle = @DEFINE-SYMBOL {
// @LINE {(-11,6) (11,6) (11,-6) (-11,-6) (-11,6)};
// (-13,1.65) @PIN(terminal=2,direction="left");
// @LINE {(-13,1.65) (-11,1.65)};
// (-10.5,1.65) @TEXT("SAMPLE",size=1.1,halign="start",valign="middle");
// (-13,-1.65) @PIN(terminal=6,direction="left");
// @LINE {(-13,-1.65) (-11,-1.65)};
// (-10.5,-1.65) @TEXT("SAMPLE_MATCH",size=1.1,halign="start",valign="middle");
// (13,1.65) @PIN(terminal=1,direction="right");
// @LINE {(13,1.65) (11,1.65)};
// (10.5,1.65) @TEXT("ACTIVE",size=1.1,halign="end",valign="middle");
// (13,-1.65) @PIN(terminal=5,direction="right");
// @LINE {(13,-1.65) (11,-1.65)};
// (10.5,-1.65) @TEXT("PRESET",size=1.1,halign="end",valign="middle");
// (0,8) @PIN(terminal=3,direction="up");
// @LINE {(0,8) (0,6)};
// (0,5.2) @TEXT("VDD",size=1.1,halign="middle",valign="middle");
// (0,-8) @PIN(terminal=4,direction="down");
// @LINE {(0,-8) (0,-6)};
// (0,-5.2) @TEXT("VSS",size=1.1,halign="middle",valign="middle");
// ? @TEXT("${name}",key="name",size=1.6,halign="middle") => @PLACE(0,9.5);
// ? @TEXT("${model}",key="model",size=0.85,halign="middle") => @PLACE(0,-10);
// };
// # @SELECT-INSTANCE(model="b_idle") => @SET-SYMBOL $S_b_idle;
// $S_b_sampler = @DEFINE-SYMBOL {
// @LINE {(-11,6) (11,6) (11,-6) (-11,-6) (-11,6)};
// (-13,1.65) @PIN(terminal=1,direction="left");
// @LINE {(-13,1.65) (-11,1.65)};
// (-10.5,1.65) @TEXT("CLKS",size=1.1,halign="start",valign="middle");
// (-13,-1.65) @PIN(terminal=3,direction="left");
// @LINE {(-13,-1.65) (-11,-1.65)};
// (-10.5,-1.65) @TEXT("VIN",size=1.1,halign="start",valign="middle");
// (13,0) @PIN(terminal=2,direction="right");
// @LINE {(13,0) (11,0)};
// (10.5,0) @TEXT("VOUT",size=1.1,halign="end",valign="middle");
// (0,8) @PIN(terminal=4,direction="up");
// @LINE {(0,8) (0,6)};
// (0,5.2) @TEXT("VDD",size=1.1,halign="middle",valign="middle");
// (0,-8) @PIN(terminal=5,direction="down");
// @LINE {(0,-8) (0,-6)};
// (0,-5.2) @TEXT("VSS",size=1.1,halign="middle",valign="middle");
// ? @TEXT("${name}",key="name",size=1.6,halign="middle") => @PLACE(0,9.5);
// ? @TEXT("${model}",key="model",size=0.85,halign="middle") => @PLACE(0,-10);
// };
// # @SELECT-INSTANCE(model="b_sampler") => @SET-SYMBOL $S_b_sampler;
// $S_b_sar = @DEFINE-SYMBOL {
// @LINE {(-11,9.9) (11,9.9) (11,-9.9) (-11,-9.9) (-11,9.9)};
// (-13,3.3) @PIN(terminal=10,direction="left");
// @LINE {(-13,3.3) (-11,3.3)};
// (-10.5,3.3) @TEXT("COMP_N",size=1.1,halign="start",valign="middle");
// (-13,0) @PIN(terminal=11,direction="left");
// @LINE {(-13,0) (-11,0)};
// (-10.5,0) @TEXT("COMP_P",size=1.1,halign="start",valign="middle");
// (-13,-3.3) @PIN(terminal=21,direction="left");
// @LINE {(-13,-3.3) (-11,-3.3)};
// (-10.5,-3.3) @TEXT("SAMPLE",size=1.1,halign="start",valign="middle");
// (13,6.6) @PIN(terminal=1,direction="right");
// @LINE {(13,6.6) (11,6.6)};
// (10.5,6.6) @TEXT("CMP_CLK",size=1.1,halign="end",valign="middle");
// (13,3.3) @PIN(terminal=[2, 3, 4, 5, 6, 7, 8, 9],direction="right");
// @LINE {(13,3.3) (11,3.3)};
// (10.5,3.3) @TEXT("CODE[7:0]",size=1.1,halign="end",valign="middle");
// (13,0) @PIN(terminal=[12, 13, 14, 15, 16, 17, 18, 19],direction="right");
// @LINE {(13,0) (11,0)};
// (10.5,0) @TEXT("D[7:0]",size=1.1,halign="end",valign="middle");
// (13,-3.3) @PIN(terminal=20,direction="right");
// @LINE {(13,-3.3) (11,-3.3)};
// (10.5,-3.3) @TEXT("PHI_U",size=1.1,halign="end",valign="middle");
// (13,-6.6) @PIN(terminal=24,direction="right");
// @LINE {(13,-6.6) (11,-6.6)};
// (10.5,-6.6) @TEXT("ACTIVE",size=1.1,halign="end",valign="middle");
// (0,11.9) @PIN(terminal=22,direction="up");
// @LINE {(0,11.9) (0,9.9)};
// (0,9.1) @TEXT("VDD",size=1.1,halign="middle",valign="middle");
// (0,-11.9) @PIN(terminal=23,direction="down");
// @LINE {(0,-11.9) (0,-9.9)};
// (0,-9.1) @TEXT("VSS",size=1.1,halign="middle",valign="middle");
// ? @TEXT("${name}",key="name",size=1.6,halign="middle") => @PLACE(0,13.4);
// ? @TEXT("${model}",key="model",size=0.85,halign="middle") => @PLACE(0,-13.9);
// };
// # @SELECT-INSTANCE(model="b_sar") => @SET-SYMBOL $S_b_sar;
// $S_sar_adc_b = @DEFINE-SYMBOL {
// @LINE {(-11,9.9) (11,9.9) (11,-9.9) (-11,-9.9) (-11,9.9)};
// (-13,6.6) @PIN(terminal=9,direction="left");
// @LINE {(-13,6.6) (-11,6.6)};
// (-10.5,6.6) @TEXT("SAMPLE",size=1.1,halign="start",valign="middle");
// (-13,3.3) @PIN(terminal=11,direction="left");
// @LINE {(-13,3.3) (-11,3.3)};
// (-10.5,3.3) @TEXT("VINN",size=1.1,halign="start",valign="middle");
// (-13,0) @PIN(terminal=12,direction="left");
// @LINE {(-13,0) (-11,0)};
// (-10.5,0) @TEXT("VINP",size=1.1,halign="start",valign="middle");
// (-13,-3.3) @PIN(terminal=13,direction="left");
// @LINE {(-13,-3.3) (-11,-3.3)};
// (-10.5,-3.3) @TEXT("VREFN",size=1.1,halign="start",valign="middle");
// (-13,-6.6) @PIN(terminal=14,direction="left");
// @LINE {(-13,-6.6) (-11,-6.6)};
// (-10.5,-6.6) @TEXT("VREFP",size=1.1,halign="start",valign="middle");
// (13,0) @PIN(terminal=[1, 2, 3, 4, 5, 6, 7, 8],direction="right");
// @LINE {(13,0) (11,0)};
// (10.5,0) @TEXT("D[7:0]",size=1.1,halign="end",valign="middle");
// (0,11.9) @PIN(terminal=10,direction="up");
// @LINE {(0,11.9) (0,9.9)};
// (0,9.1) @TEXT("VDD",size=1.1,halign="middle",valign="middle");
// (0,-11.9) @PIN(terminal=15,direction="down");
// @LINE {(0,-11.9) (0,-9.9)};
// (0,-9.1) @TEXT("VSS",size=1.1,halign="middle",valign="middle");
// ? @TEXT("${name}",key="name",size=1.6,halign="middle") => @PLACE(0,13.4);
// ? @TEXT("${model}",key="model",size=0.85,halign="middle") => @PLACE(0,-13.9);
// };
// # @SELECT-INSTANCE(model="sar_adc_b") => @SET-SYMBOL $S_sar_adc_b;
// $S_b_delay = @DEFINE-SYMBOL {
// @LINE {(-11,6) (11,6) (11,-6) (-11,-6) (-11,6)};
// (-13,0) @PIN(terminal=1,direction="left");
// @LINE {(-13,0) (-11,0)};
// (-10.5,0) @TEXT("A",size=1.1,halign="start",valign="middle");
// (13,0) @PIN(terminal=4,direction="right");
// @LINE {(13,0) (11,0)};
// (10.5,0) @TEXT("Y",size=1.1,halign="end",valign="middle");
// (0,8) @PIN(terminal=2,direction="up");
// @LINE {(0,8) (0,6)};
// (0,5.2) @TEXT("VDD",size=1.1,halign="middle",valign="middle");
// (0,-8) @PIN(terminal=3,direction="down");
// @LINE {(0,-8) (0,-6)};
// (0,-5.2) @TEXT("VSS",size=1.1,halign="middle",valign="middle");
// ? @TEXT("${name}",key="name",size=1.6,halign="middle") => @PLACE(0,9.5);
// ? @TEXT("${model}",key="model",size=0.85,halign="middle") => @PLACE(0,-10);
// };
// # @SELECT-INSTANCE(model="b_delay") => @SET-SYMBOL $S_b_delay;
// $S_b_behavior_observer = @DEFINE-SYMBOL {
// @LINE {(-11,6) (11,6) (11,-6) (-11,-6) (-11,6)};
// (-13,0) @PIN(terminal=9,direction="left");
// @LINE {(-13,0) (-11,0)};
// (-10.5,0) @TEXT("SAMPLE",size=1.1,halign="start",valign="middle");
// (13,0) @PIN(terminal=[1, 2, 3, 4, 5, 6, 7, 8],direction="right");
// @LINE {(13,0) (11,0)};
// (10.5,0) @TEXT("D[7:0]",size=1.1,halign="end",valign="middle");
// (0,8) @PIN(terminal=10,direction="up");
// @LINE {(0,8) (0,6)};
// (0,5.2) @TEXT("VDD",size=1.1,halign="middle",valign="middle");
// (0,-8) @PIN(terminal=11,direction="down");
// @LINE {(0,-8) (0,-6)};
// (0,-5.2) @TEXT("VSS",size=1.1,halign="middle",valign="middle");
// ? @TEXT("${name}",key="name",size=1.6,halign="middle") => @PLACE(0,9.5);
// ? @TEXT("${model}",key="model",size=0.85,halign="middle") => @PLACE(0,-10);
// };
// # @SELECT-INSTANCE(model="b_behavior_observer") => @SET-SYMBOL $S_b_behavior_observer;
// $S_b_tb_switch = @DEFINE-SYMBOL {
// @LINE {(-11,6.6) (11,6.6) (11,-6.6) (-11,-6.6) (-11,6.6)};
// (-13,3.3) @PIN(terminal=1,direction="left");
// @LINE {(-13,3.3) (-11,3.3)};
// (-10.5,3.3) @TEXT("A",size=1.1,halign="start",valign="middle");
// (-13,0) @PIN(terminal=2,direction="left");
// @LINE {(-13,0) (-11,0)};
// (-10.5,0) @TEXT("B",size=1.1,halign="start",valign="middle");
// (-13,-3.3) @PIN(terminal=3,direction="left");
// @LINE {(-13,-3.3) (-11,-3.3)};
// (-10.5,-3.3) @TEXT("EN",size=1.1,halign="start",valign="middle");
// (0,8.6) @PIN(terminal=4,direction="up");
// @LINE {(0,8.6) (0,6.6)};
// (0,5.8) @TEXT("VDD",size=1.1,halign="middle",valign="middle");
// (0,-8.6) @PIN(terminal=5,direction="down");
// @LINE {(0,-8.6) (0,-6.6)};
// (0,-5.8) @TEXT("VSS",size=1.1,halign="middle",valign="middle");
// ? @TEXT("${name}",key="name",size=1.6,halign="middle") => @PLACE(0,10.1);
// ? @TEXT("${model}",key="model",size=0.85,halign="middle") => @PLACE(0,-10.6);
// };
// # @SELECT-INSTANCE(model="b_tb_switch") => @SET-SYMBOL $S_b_tb_switch;
// $S_b_sampler_bridge = @DEFINE-SYMBOL {
// @LINE {(-11,6) (11,6) (11,-6) (-11,-6) (-11,6)};
// (-13,1.65) @PIN(terminal=1,direction="left");
// @LINE {(-13,1.65) (-11,1.65)};
// (-10.5,1.65) @TEXT("CLKS",size=1.1,halign="start",valign="middle");
// (-13,-1.65) @PIN(terminal=3,direction="left");
// @LINE {(-13,-1.65) (-11,-1.65)};
// (-10.5,-1.65) @TEXT("Vin",size=1.1,halign="start",valign="middle");
// (13,0) @PIN(terminal=2,direction="right");
// @LINE {(13,0) (11,0)};
// (10.5,0) @TEXT("VOUT",size=1.1,halign="end",valign="middle");
// ? @TEXT("${name}",key="name",size=1.6,halign="middle") => @PLACE(0,9.5);
// ? @TEXT("${model}",key="model",size=0.85,halign="middle") => @PLACE(0,-10);
// };
// # @SELECT-INSTANCE(model="b_sampler_bridge") => @SET-SYMBOL $S_b_sampler_bridge;
// } }
// END SARADC RNL

simulator lang=spectre

subckt sar_adc8_join_r4 D0 D1 D2 D3 D4 D5 D6 D7 SAMPLE VDD! VINN VINP  VREFN VREFP 0
    XSEQ (SAMPLE_INT VDD! 0 SEQ_SAMPLE) sar8_se_acquire
    XDONE (ACTIVE DONE VDD! 0) INVD1BWP12T30P140
    XPRESET (DONE SEQ_SAMPLE PRESET VDD! 0) OR2D1BWP12T30P140
    XSAMPLE (SAMPLE SAMPLE_INT VDD! 0) CKBD1BWP12T30P140
    XBOOTN (SEQ_SAMPLE TOPN VINN) sar_bootstrap_flat_8b_p
    XBOOTP (SEQ_SAMPLE TOPP VINP) sar_bootstrap_flat_8b_p
    XCDAC (REFSEL_N0 REFSEL_N1 REFSEL_N2 REFSEL_N3 REFSEL_N4 REFSEL_N5 REFSEL_N6 REFSEL_N7 REFSEL_P0 REFSEL_P1 REFSEL_P2 REFSEL_P3 REFSEL_P4 REFSEL_P5 REFSEL_P6 REFSEL_P7 TOPN TOPP VDD! VREFN VREFP 0)  sar8j_r1_cdac
    XCTRL (CMP_CLK CODE0 CODE1 CODE2 CODE3 CODE4 CODE5 CODE6 CODE7 COMP_N  COMP_P D0 D1 D2 D3 D4 D5 D6 D7 PHI_U SEQ_SAMPLE VDD! 0 ACTIVE) sar8_se_ctrl
    XREF (CODE0 CODE1 CODE2 CODE3 CODE4 CODE5 CODE6 CODE7 REFSEL_N0 REFSEL_N1 REFSEL_N2 REFSEL_N3 REFSEL_N4 REFSEL_N5 REFSEL_N6 REFSEL_N7 REFSEL_P0 REFSEL_P1 REFSEL_P2 REFSEL_P3 REFSEL_P4 REFSEL_P5 REFSEL_P6 REFSEL_P7 VDD! 0 PRESET)  sar8i_refword
    XCOMP (CMP_CLK COMP_N COMP_P VDD! TOPN TOPP 0) sar_strongarm_t28
    CL_COMP_N (COMP_N 0) cfmom_2t nr=8 lr=2.5u w=50n s=50n stm=1 spm=3  multi=2 mismatchflag=1
    CL_COMP_P (COMP_P 0) cfmom_2t nr=8 lr=2.5u w=50n s=50n stm=1 spm=3  multi=2 mismatchflag=1
    CL_CMP_CLK (CMP_CLK 0) cfmom_2t nr=8 lr=2.5u w=50n s=50n stm=1 spm=3  multi=2 mismatchflag=1
// BEGIN SARADC RNL
// @RNL(author="saradc topology") {
// (-24,68) @TEXT("SAR8 / Asynchronous differential ADC",size=2.7,halign="start",textcolor="#223d52");
// (-15,60) @TEXT("Acquisition",size=1.4,halign="start",textcolor="#223d52");
// (65,60) @TEXT("Reference preset",size=1.4,halign="start",textcolor="#223d52");
// #XSAMPLE @SET-SYMBOL $S_CKBD1BWP12T30P140;
// #XSAMPLE @PLACE(0,46) => @ORIENT("R0");
// #XSEQ @SET-SYMBOL $S_sar8_se_acquire;
// #XSEQ @PLACE(29,46) => @ORIENT("R0");
// #XDONE @SET-SYMBOL $S_INVD1BWP12T30P140;
// #XDONE @PLACE(77,46) => @ORIENT("R0");
// #XPRESET @SET-SYMBOL $S_OR2D1BWP12T30P140;
// #XPRESET @PLACE(112,46) => @ORIENT("R0");
// #XBOOTP @SET-SYMBOL $S_sar_bootstrap_flat_8b_p;
// #XBOOTP @PLACE(0,24) => @ORIENT("R0");
// #XBOOTN @SET-SYMBOL $S_sar_bootstrap_flat_8b_p;
// #XBOOTN @PLACE(0,3) => @ORIENT("MX");
// #XCOMP @SET-SYMBOL $S_sar_strongarm_t28;
// #XCOMP @PLACE(67,13) => @ORIENT("R0");
// #XCTRL @SET-SYMBOL $S_sar8_se_ctrl;
// #XCTRL @PLACE(111,13) => @ORIENT("R0");
// #XCDAC @SET-SYMBOL $S_sar8j_r1_cdac;
// #XCDAC @PLACE(36,-11) => @ORIENT("R0");
// #XREF @SET-SYMBOL $S_sar8i_refword;
// #XREF @PLACE(36,-38) => @ORIENT("R0");
// #CL_COMP_P @SET-SYMBOL $CAPACITOR;
// #CL_COMP_P @PLACE(88,23) => @ORIENT("MX");
// #CL_COMP_P @TEXT("CL_COMP_P",key="name",size=1.3,halign="start") => @PLACE(91,26);
// #CL_COMP_P @TEXT("nr=8 lr=2.5u w=50n multi=2",key="value",size=0.9,halign="start") => @PLACE(91,19);
// #CL_COMP_P @TEXT("",key="model");
// #CL_COMP_N @SET-SYMBOL $CAPACITOR;
// #CL_COMP_N @PLACE(84,3) => @ORIENT("R0");
// #CL_COMP_N @TEXT("CL_COMP_N",key="name",size=1.3,halign="start") => @PLACE(87,6);
// #CL_COMP_N @TEXT("nr=8 lr=2.5u w=50n multi=2",key="value",size=0.9,halign="start") => @PLACE(87,-1);
// #CL_COMP_N @TEXT("",key="model");
// #CL_CMP_CLK @SET-SYMBOL $CAPACITOR;
// #CL_CMP_CLK @PLACE(92,36) => @ORIENT("MX");
// #CL_CMP_CLK @TEXT("CL_CMP_CLK",key="name",size=1.3,halign="start") => @PLACE(95,39);
// #CL_CMP_CLK @TEXT("nr=8 lr=2.5u w=50n multi=2",key="value",size=0.9,halign="start") => @PLACE(95,32);
// #CL_CMP_CLK @TEXT("",key="model");
// #XSAMPLE @TEXT("Sample buffer",key="name",size=1.65,halign="middle",textcolor="#223d52") => @PLACE(0,46);
// #XSAMPLE @TEXT("",key="model");
// #XSEQ @TEXT("Track control",key="name",size=1.65,halign="middle",textcolor="#223d52") => @PLACE(29,48.7);
// #XSEQ @TEXT("",key="model");
// #XDONE @TEXT("Done",key="name",size=1.65,halign="middle",textcolor="#223d52") => @PLACE(77,54);
// #XDONE @TEXT("",key="model");
// #XPRESET @TEXT("Preset",key="name",size=1.65,halign="middle",textcolor="#223d52") => @PLACE(112,54);
// #XPRESET @TEXT("",key="model");
// #XBOOTP @TEXT("Bootstrap P",key="name",size=1.65,halign="middle",textcolor="#223d52") => @PLACE(0,24);
// #XBOOTP @TEXT("",key="model");
// #XBOOTN @TEXT("Bootstrap N",key="name",size=1.65,halign="middle",textcolor="#223d52") => @PLACE(0,3);
// #XBOOTN @TEXT("",key="model");
// #XCOMP @TEXT("StrongARM",key="name",size=1.65,halign="middle",textcolor="#223d52") => @PLACE(67,13);
// #XCOMP @TEXT("",key="model");
// #XCTRL @TEXT("SAR",key="name",size=1.65,halign="middle",textcolor="#223d52") => @PLACE(111,13);
// #XCTRL @TEXT("",key="model");
// #XCDAC @TEXT("MOM CDAC",key="name",size=1.65,halign="middle",textcolor="#223d52") => @PLACE(36,-11);
// #XCDAC @TEXT("",key="model");
// #XREF @TEXT("Reference driver",key="name",size=1.65,halign="middle",textcolor="#223d52") => @PLACE(36,-35.5);
// #XREF @TEXT("",key="model");
// #CL_COMP_P @TEXT("C_P",key="name",size=1.05,halign="start") => @PLACE(91,26);
// #CL_COMP_P @TEXT("",key="value");
// #CL_COMP_N @TEXT("C_N",key="name",size=1.05,halign="start") => @PLACE(87,6);
// #CL_COMP_N @TEXT("",key="value");
// #CL_CMP_CLK @TEXT("C_CLK",key="name",size=1.05,halign="start") => @PLACE(95,39);
// #CL_CMP_CLK @TEXT("",key="value");
// %sar_port1 = $IO_PORT @ATTACH &"SAMPLE" => @PLACE(-23,46);
// &"SAMPLE" @WIRE(mode="straight",linecolor="#94601a",linewidth=0.16) {%sar_port1:p #XSAMPLE:1};
// &"SAMPLE_INT" @WIRE(mode="straight",linecolor="#30485d",linewidth=0.16) {#XSAMPLE:2 (14.5,46) (14.5,46) #XSEQ:1};
// &"DONE" @WIRE(mode="straight",linecolor="#30485d",linewidth=0.16) {#XDONE:2 (94.5,46) (94.5,47.7) #XPRESET:1};
// %sar_port2 = $IO_PORT @ATTACH &"VINP" => @PLACE(-25,22.35);
// &"VINP" @WIRE(mode="straight",linecolor="#226e85",linewidth=0.16) {%sar_port2:p #XBOOTP:3};
// %sar_port3 = $IO_PORT @ATTACH &"VINN" => @PLACE(-25,4.65);
// &"VINN" @WIRE(mode="straight",linecolor="#226e85",linewidth=0.16) {%sar_port3:p #XBOOTN:3};
// %sar_port4 = $IO_PORT @ATTACH &"VREFP" => @PLACE(11,-9.35);
// &"VREFP" @WIRE(mode="straight",linecolor="#226e85",linewidth=0.16) {%sar_port4:p #XCDAC:21};
// %sar_port5 = $IO_PORT @ATTACH &"VREFN" => @PLACE(11,-12.65);
// &"VREFN" @WIRE(mode="straight",linecolor="#226e85",linewidth=0.16) {%sar_port5:p #XCDAC:20};
// %sar_junction6 = (28,24);
// %sar_junction6 @CIRCLE(radius=0.34,linecolor="#30485d",fill="fillcolor",fillcolor="#30485d") => @LAYER("top");
// &"TOPP" @WIRE(mode="straight",linecolor="#226e85",linewidth=0.16) {#XBOOTP:2 %sar_junction6 (46,24) (46,14.65) #XCOMP:6};
// &"TOPP" @WIRE(mode="straight",linecolor="#226e85",linewidth=0.16) {%sar_junction6 #XCDAC:18};
// (30,25.8) @TEXT("TOPP",size=1.1,halign="start",textcolor="#223d52");
// %sar_junction7 = (44,3);
// %sar_junction7 @CIRCLE(radius=0.34,linecolor="#30485d",fill="fillcolor",fillcolor="#30485d") => @LAYER("top");
// &"TOPN" @WIRE(mode="straight",linecolor="#226e85",linewidth=0.16) {#XBOOTN:2 %sar_junction7 (46,3) (46,11.35) #XCOMP:5};
// &"TOPN" @WIRE(mode="straight",linecolor="#226e85",linewidth=0.16) {%sar_junction7 #XCDAC:17};
// (32,4.8) @TEXT("TOPN",size=1.1,halign="start",textcolor="#223d52");
// %sar_junction8 = (88,14.65);
// %sar_junction8 @CIRCLE(radius=0.34,linecolor="#30485d",fill="fillcolor",fillcolor="#30485d") => @LAYER("top");
// &"COMP_P" @WIRE(mode="straight",linecolor="#226e85",linewidth=0.16) {#XCOMP:3 %sar_junction8 (92,14.65) (92,16.3) #XCTRL:11};
// &"COMP_P" @WIRE(mode="straight",linecolor="#226e85",linewidth=0.16) {%sar_junction8 #CL_COMP_P:1};
// %sar_junction9 = (84,11.35);
// %sar_junction9 @CIRCLE(radius=0.34,linecolor="#30485d",fill="fillcolor",fillcolor="#30485d") => @LAYER("top");
// &"COMP_N" @WIRE(mode="straight",linecolor="#226e85",linewidth=0.16) {#XCOMP:2 %sar_junction9 (92,11.35) (92,13) #XCTRL:10};
// &"COMP_N" @WIRE(mode="straight",linecolor="#226e85",linewidth=0.16) {%sar_junction9 #CL_COMP_N:1};
// %sar_junction10 = (92,31);
// %sar_junction10 @CIRCLE(radius=0.34,linecolor="#30485d",fill="fillcolor",fillcolor="#30485d") => @LAYER("top");
// &"CMP_CLK" @WIRE(mode="straight",linecolor="#94601a",linewidth=0.16) {#XCOMP:1 (63,31) %sar_junction10 (107,31) #XCTRL:1};
// &"CMP_CLK" @WIRE(mode="straight",linecolor="#94601a",linewidth=0.16) {%sar_junction10 #CL_CMP_CLK:1};
// (70,32.8) @TEXT("CMP_CLK",size=1,halign="start",textcolor="#223d52");
// {&"REFSEL_N0" &"REFSEL_N1" &"REFSEL_N2" &"REFSEL_N3" &"REFSEL_N4" &"REFSEL_N5" &"REFSEL_N6" &"REFSEL_N7"} @WIRE(mode="straight",linewidth=0.24,linecolor="#536f4b") {#XREF:9  #XCDAC:1};
// {&"REFSEL_P0" &"REFSEL_P1" &"REFSEL_P2" &"REFSEL_P3" &"REFSEL_P4" &"REFSEL_P5" &"REFSEL_P6" &"REFSEL_P7"} @WIRE(mode="straight",linewidth=0.24,linecolor="#536f4b") {#XREF:17  #XCDAC:9};
// {&"CODE0" &"CODE1" &"CODE2" &"CODE3" &"CODE4" &"CODE5" &"CODE6" &"CODE7"} @WIRE(mode="straight",linewidth=0.24,linecolor="#66538a") {#XCTRL:2 (107,-29) (58,-29) (58,-38) #XREF:1};
// (72,-27.2) @TEXT("CODE[7:0]",size=1.1,halign="start",textcolor="#223d52");
// &"VDD!" @WIRE(mode="straight",linecolor="#30485d",linewidth=0.16) {#XSEQ:2 (29,57)};
// (29,57.4) @TEXT("VDD!",size=1.1,halign="middle",valign="bottom");
// &"0" @WIRE(mode="straight",linecolor="#30485d",linewidth=0.16) {#XSEQ:3 (29,35)};
// (29,34.6) @TEXT("0",size=1.1,halign="middle",valign="top");
// &"SEQ_SAMPLE" @WIRE(mode="straight",linecolor="#30485d",linewidth=0.16) {#XSEQ:4 (45,46)};
// (45.4,46) @TEXT("SEQ_SAMPLE",size=1.1,halign="start",valign="middle");
// &"ACTIVE" @WIRE(mode="straight",linecolor="#30485d",linewidth=0.16) {#XDONE:1 (67,46)};
// (66.6,46) @TEXT("ACTIVE",size=1.1,halign="end",valign="middle");
// &"VDD!" @WIRE(mode="straight",linecolor="#30485d",linewidth=0.16) {#XDONE:3 (77,56)};
// (77,56.4) @TEXT("VDD!",size=1.1,halign="middle",valign="bottom");
// &"0" @WIRE(mode="straight",linecolor="#30485d",linewidth=0.16) {#XDONE:4 (77,36)};
// (77,35.6) @TEXT("0",size=1.1,halign="middle",valign="top");
// &"SEQ_SAMPLE" @WIRE(mode="straight",linecolor="#30485d",linewidth=0.16) {#XPRESET:2 (102,44.3)};
// (101.6,44.3) @TEXT("SEQ_SAMPLE",size=1.1,halign="end",valign="middle");
// &"PRESET" @WIRE(mode="straight",linecolor="#30485d",linewidth=0.16) {#XPRESET:3 (122,46)};
// (122.4,46) @TEXT("PRESET",size=1.1,halign="start",valign="middle");
// &"VDD!" @WIRE(mode="straight",linecolor="#30485d",linewidth=0.16) {#XPRESET:4 (112,56)};
// (112,56.4) @TEXT("VDD!",size=1.1,halign="middle",valign="bottom");
// &"0" @WIRE(mode="straight",linecolor="#30485d",linewidth=0.16) {#XPRESET:5 (112,36)};
// (112,35.6) @TEXT("0",size=1.1,halign="middle",valign="top");
// &"VDD!" @WIRE(mode="straight",linecolor="#30485d",linewidth=0.16) {#XSAMPLE:3 (0,57)};
// (0,57.4) @TEXT("VDD!",size=1.1,halign="middle",valign="bottom");
// &"0" @WIRE(mode="straight",linecolor="#30485d",linewidth=0.16) {#XSAMPLE:4 (0,35)};
// (0,34.6) @TEXT("0",size=1.1,halign="middle",valign="top");
// &"SEQ_SAMPLE" @WIRE(mode="straight",linecolor="#30485d",linewidth=0.16) {#XBOOTN:1 (-18,1.35)};
// (-18.4,1.35) @TEXT("SEQ_SAMPLE",size=1.1,halign="end",valign="middle");
// &"SEQ_SAMPLE" @WIRE(mode="straight",linecolor="#30485d",linewidth=0.16) {#XBOOTP:1 (-18,25.65)};
// (-18.4,25.65) @TEXT("SEQ_SAMPLE",size=1.1,halign="end",valign="middle");
// &"VDD!" @WIRE(mode="straight",linecolor="#30485d",linewidth=0.16) {#XCDAC:19 (36,0)};
// (36,0.4) @TEXT("VDD!",size=1.1,halign="middle",valign="bottom");
// &"0" @WIRE(mode="straight",linecolor="#30485d",linewidth=0.16) {#XCDAC:22 (36,-22)};
// (36,-22.4) @TEXT("0",size=1.1,halign="middle",valign="top");
// {&"D0" &"D1" &"D2" &"D3" &"D4" &"D5" &"D6" &"D7"} @WIRE(mode="straight",linewidth=0.3) {#XCTRL:12 (129,16.3)};
// (129.4,16.3) @TEXT("D[7:0]",size=1.1,halign="start",valign="middle");
// &"PHI_U" @WIRE(mode="straight",linecolor="#30485d",linewidth=0.16) {#XCTRL:20 (129,9.7)};
// (129.4,9.7) @TEXT("PHI_U",size=1.1,halign="start",valign="middle");
// &"SEQ_SAMPLE" @WIRE(mode="straight",linecolor="#30485d",linewidth=0.16) {#XCTRL:21 (93,9.7)};
// (92.6,9.7) @TEXT("SEQ_SAMPLE",size=1.1,halign="end",valign="middle");
// &"VDD!" @WIRE(mode="straight",linecolor="#30485d",linewidth=0.16) {#XCTRL:22 (115,24.6)};
// (115,25) @TEXT("VDD!",size=1.1,halign="middle",valign="bottom");
// &"0" @WIRE(mode="straight",linecolor="#30485d",linewidth=0.16) {#XCTRL:23 (115,1.4)};
// (115,1) @TEXT("0",size=1.1,halign="middle",valign="top");
// &"ACTIVE" @WIRE(mode="straight",linecolor="#30485d",linewidth=0.16) {#XCTRL:24 (129,13)};
// (129.4,13) @TEXT("ACTIVE",size=1.1,halign="start",valign="middle");
// &"VDD!" @WIRE(mode="straight",linecolor="#30485d",linewidth=0.16) {#XREF:25 (36,-27)};
// (36,-26.6) @TEXT("VDD!",size=1.1,halign="middle",valign="bottom");
// &"0" @WIRE(mode="straight",linecolor="#30485d",linewidth=0.16) {#XREF:26 (36,-49)};
// (36,-49.4) @TEXT("0",size=1.1,halign="middle",valign="top");
// &"PRESET" @WIRE(mode="straight",linecolor="#30485d",linewidth=0.16) {#XREF:27 (18,-38)};
// (17.6,-38) @TEXT("PRESET",size=1.1,halign="end",valign="middle");
// &"VDD!" @WIRE(mode="straight",linecolor="#30485d",linewidth=0.16) {#XCOMP:4 (71,24)};
// (71,24.4) @TEXT("VDD!",size=1.1,halign="middle",valign="bottom");
// &"0" @WIRE(mode="straight",linecolor="#30485d",linewidth=0.16) {#XCOMP:7 (67,2)};
// (67,1.6) @TEXT("0",size=1.1,halign="middle",valign="top");
// &"0" @WIRE(mode="straight",linecolor="#30485d",linewidth=0.16) {#CL_COMP_N:2 (84,-2)};
// (84,-2.4) @TEXT("0",size=1.1,halign="middle",valign="top");
// &"0" @WIRE(mode="straight",linecolor="#30485d",linewidth=0.16) {#CL_COMP_P:2 (88,28)};
// (88,28.4) @TEXT("0",size=1.1,halign="middle",valign="bottom");
// &"0" @WIRE(mode="straight",linecolor="#30485d",linewidth=0.16) {#CL_CMP_CLK:2 (92,41)};
// (92,41.4) @TEXT("0",size=1.1,halign="middle",valign="bottom");
// }
// END SARADC RNL
ends sar_adc8_join_r4

subckt sar_bootstrap_flat_8b_p CLKS VOUT Vin
    Mmain (VOUT G Vin 0) nch_18_mac l=150.0n w=1u multi=1 nf=1 sd=180.0n          ad=1.55e-13 as=1.55e-13 pd=2.31u ps=2.31u nrd=0 nrs=0 sa=155.00n          sb=155.00n sa1=155.00n sa2=155.00n sa3=155.00n sa4=155.00n          sb1=155.00n sb2=155.00n sb3=155.00n spa=180.0n spa1=180.0n          spa2=180.0n spa3=180.0n sap=172.362n sapb=242.67n spba=233.666n          spba1=239.844n spmt=1.11111e+15 spomt=0 spomt1=1.11111e+60          spmb=1.11111e+15 spomb=0 spomb1=1.11111e+60
    Mmain_U1 (VOUT G Vin 0) nch_18_mac l=150.0n w=1u multi=1 nf=1 sd=180.0n          ad=1.55e-13 as=1.55e-13 pd=2.31u ps=2.31u nrd=0 nrs=0 sa=155.00n          sb=155.00n sa1=155.00n sa2=155.00n sa3=155.00n sa4=155.00n          sb1=155.00n sb2=155.00n sb3=155.00n spa=180.0n spa1=180.0n          spa2=180.0n spa3=180.0n sap=172.362n sapb=242.67n spba=233.666n          spba1=239.844n spmt=1.11111e+15 spomt=0 spomt1=1.11111e+60          spmb=1.11111e+15 spomb=0 spomb1=1.11111e+60
    Mmain_U2 (VOUT G Vin 0) nch_18_mac l=150.0n w=1u multi=1 nf=1 sd=180.0n          ad=1.55e-13 as=1.55e-13 pd=2.31u ps=2.31u nrd=0 nrs=0 sa=155.00n          sb=155.00n sa1=155.00n sa2=155.00n sa3=155.00n sa4=155.00n          sb1=155.00n sb2=155.00n sb3=155.00n spa=180.0n spa1=180.0n          spa2=180.0n spa3=180.0n sap=172.362n sapb=242.67n spba=233.666n          spba1=239.844n spmt=1.11111e+15 spomt=0 spomt1=1.11111e+60          spmb=1.11111e+15 spomb=0 spomb1=1.11111e+60
    Mmain_U3 (VOUT G Vin 0) nch_18_mac l=150.0n w=1u multi=1 nf=1 sd=180.0n          ad=1.55e-13 as=1.55e-13 pd=2.31u ps=2.31u nrd=0 nrs=0 sa=155.00n          sb=155.00n sa1=155.00n sa2=155.00n sa3=155.00n sa4=155.00n          sb1=155.00n sb2=155.00n sb3=155.00n spa=180.0n spa1=180.0n          spa2=180.0n spa3=180.0n sap=172.362n sapb=242.67n spba=233.666n          spba1=239.844n spmt=1.11111e+15 spomt=0 spomt1=1.11111e+60          spmb=1.11111e+15 spomb=0 spomb1=1.11111e+60
    M4C (CTRL CLKS BBOT 0) nch_18_mac l=150.0n w=1u multi=1 nf=1 sd=180.0n          ad=1.55e-13 as=1.55e-13 pd=2.31u ps=2.31u nrd=0 nrs=0 sa=155.00n          sb=155.00n sa1=155.00n sa2=155.00n sa3=155.00n sa4=155.00n          sb1=155.00n sb2=155.00n sb3=155.00n spa=180.0n spa1=180.0n          spa2=180.0n spa3=180.0n sap=172.362n sapb=242.67n spba=233.666n          spba1=239.844n spmt=1.11111e+15 spomt=0 spomt1=1.11111e+60          spmb=1.11111e+15 spomb=0 spomb1=1.11111e+60
    Msin (BBOT G Vin 0) nch_18_mac l=150.0n w=1u multi=1 nf=1 sd=180.0n          ad=1.55e-13 as=1.55e-13 pd=2.31u ps=2.31u nrd=0 nrs=0 sa=155.00n          sb=155.00n sa1=155.00n sa2=155.00n sa3=155.00n sa4=155.00n          sb1=155.00n sb2=155.00n sb3=155.00n spa=180.0n spa1=180.0n          spa2=180.0n spa3=180.0n sap=172.362n sapb=242.67n spba=233.666n          spba1=239.844n spmt=1.11111e+15 spomt=0 spomt1=1.11111e+60          spmb=1.11111e+15 spomb=0 spomb1=1.11111e+60
    Maux (G VDD! GRESET 0) nch_18_mac l=150.0n w=1u multi=1 nf=1 sd=180.0n          ad=1.55e-13 as=1.55e-13 pd=2.31u ps=2.31u nrd=0 nrs=0 sa=155.00n          sb=155.00n sa1=155.00n sa2=155.00n sa3=155.00n sa4=155.00n          sb1=155.00n sb2=155.00n sb3=155.00n spa=180.0n spa1=180.0n          spa2=180.0n spa3=180.0n sap=172.362n sapb=242.67n spba=233.666n          spba1=239.844n spmt=1.11111e+15 spomt=0 spomt1=1.11111e+60          spmb=1.11111e+15 spomb=0 spomb1=1.11111e+60
    MRSTG (GRESET CLKSB 0 0) nch_18_mac l=150.0n w=1u multi=1 nf=1          sd=180.0n ad=1.55e-13 as=1.55e-13 pd=2.31u ps=2.31u nrd=0 nrs=0          sa=155.00n sb=155.00n sa1=155.00n sa2=155.00n sa3=155.00n          sa4=155.00n sb1=155.00n sb2=155.00n sb3=155.00n spa=180.0n          spa1=180.0n spa2=180.0n spa3=180.0n sap=172.362n sapb=242.67n          spba=233.666n spba1=239.844n spmt=1.11111e+15 spomt=0          spomt1=1.11111e+60 spmb=1.11111e+15 spomb=0 spomb1=1.11111e+60
    M4A (CTRL G BBOT 0) nch_18_mac l=150.0n w=1u multi=1 nf=1 sd=180.0n          ad=1.55e-13 as=1.55e-13 pd=2.31u ps=2.31u nrd=0 nrs=0 sa=155.00n          sb=155.00n sa1=155.00n sa2=155.00n sa3=155.00n sa4=155.00n          sb1=155.00n sb2=155.00n sb3=155.00n spa=180.0n spa1=180.0n          spa2=180.0n spa3=180.0n sap=172.362n sapb=242.67n spba=233.666n          spba1=239.844n spmt=1.11111e+15 spomt=0 spomt1=1.11111e+60          spmb=1.11111e+15 spomb=0 spomb1=1.11111e+60
    M8 (BBOT CLKSB 0 0) nch_18_mac l=150.0n w=1u multi=1 nf=1 sd=180.0n          ad=1.55e-13 as=1.55e-13 pd=2.31u ps=2.31u nrd=0 nrs=0 sa=155.00n          sb=155.00n sa1=155.00n sa2=155.00n sa3=155.00n sa4=155.00n          sb1=155.00n sb2=155.00n sb3=155.00n spa=180.0n spa1=180.0n          spa2=180.0n spa3=180.0n sap=172.362n sapb=242.67n spba=233.666n          spba1=239.844n spmt=1.11111e+15 spomt=0 spomt1=1.11111e+60          spmb=1.11111e+15 spomb=0 spomb1=1.11111e+60
    MNCLK (CLKSB CLKS 0 0) nch_18_mac l=150.0n w=1u multi=1 nf=1 sd=180.0n          ad=1.55e-13 as=1.55e-13 pd=2.31u ps=2.31u nrd=0 nrs=0 sa=155.00n          sb=155.00n sa1=155.00n sa2=155.00n sa3=155.00n sa4=155.00n          sb1=155.00n sb2=155.00n sb3=155.00n spa=180.0n spa1=180.0n          spa2=180.0n spa3=180.0n sap=172.362n sapb=242.67n spba=233.666n          spba1=239.844n spmt=1.11111e+15 spomt=0 spomt1=1.11111e+60          spmb=1.11111e+15 spomb=0 spomb1=1.11111e+60
    M2 (BTOP G VDD! BTOP) pch_18_mac l=150.0n w=1u multi=1 nf=1 sd=180.0n          ad=1.55e-13 as=1.55e-13 pd=2.31u ps=2.31u nrd=0 nrs=0 sa=155.00n          sb=155.00n sa1=155.00n sa2=155.00n sa3=155.00n sa4=155.00n          sb1=155.00n sb2=155.00n sb3=155.00n spa=180.0n spa1=180.0n          spa2=180.0n spa3=180.0n sap=172.362n sapb=242.67n spba=233.666n          spba1=239.844n spmt=1.11111e+15 spomt=0 spomt1=1.11111e+60          spmb=1.11111e+15 spomb=0 spomb1=1.11111e+60
    M4 (G CTRL BTOP BTOP) pch_18_mac l=150.0n w=1u multi=1 nf=1 sd=180.0n          ad=1.55e-13 as=1.55e-13 pd=2.31u ps=2.31u nrd=0 nrs=0 sa=155.00n          sb=155.00n sa1=155.00n sa2=155.00n sa3=155.00n sa4=155.00n          sb1=155.00n sb2=155.00n sb3=155.00n spa=180.0n spa1=180.0n          spa2=180.0n spa3=180.0n sap=172.362n sapb=242.67n spba=233.666n          spba1=239.844n spmt=1.11111e+15 spomt=0 spomt1=1.11111e+60          spmb=1.11111e+15 spomb=0 spomb1=1.11111e+60
    M4B (CTRL CLKS VDD! VDD!) pch_18_mac l=150.0n w=1u multi=1 nf=1          sd=180.0n ad=1.55e-13 as=1.55e-13 pd=2.31u ps=2.31u nrd=0 nrs=0          sa=155.00n sb=155.00n sa1=155.00n sa2=155.00n sa3=155.00n          sa4=155.00n sb1=155.00n sb2=155.00n sb3=155.00n spa=180.0n          spa1=180.0n spa2=180.0n spa3=180.0n sap=172.362n sapb=242.67n          spba=233.666n spba1=239.844n spmt=1.11111e+15 spomt=0          spomt1=1.11111e+60 spmb=1.11111e+15 spomb=0 spomb1=1.11111e+60
    MPCLK (CLKSB CLKS VDD! VDD!) pch_18_mac l=150.0n w=1u multi=1 nf=1          sd=180.0n ad=1.55e-13 as=1.55e-13 pd=2.31u ps=2.31u nrd=0 nrs=0          sa=155.00n sb=155.00n sa1=155.00n sa2=155.00n sa3=155.00n          sa4=155.00n sb1=155.00n sb2=155.00n sb3=155.00n spa=180.0n          spa1=180.0n spa2=180.0n spa3=180.0n sap=172.362n sapb=242.67n          spba=233.666n spba1=239.844n spmt=1.11111e+15 spomt=0          spomt1=1.11111e+60 spmb=1.11111e+15 spomb=0 spomb1=1.11111e+60
    Cboot (BTOP BBOT) cfmom_2t nr=8 lr=2.5u w=50n s=50n stm=1 spm=3          multi=200 mismatchflag=1
// BEGIN SARADC RNL
// @RNL(author="saradc topology") {
// (-13,67) @TEXT("Bootstrap  /  four parallel sampling switches",size=1.65,halign="start",textcolor="#223d52");
// #MPCLK @SET-SYMBOL $PMOS_4TERM;
// #MPCLK @PLACE(0,35) => @ORIENT("R0");
// #MPCLK @TEXT("MPCLK",key="name",size=1.3,halign="start") => @PLACE(3,38);
// #MPCLK @TEXT("l=150.0n w=1u multi=1",key="value",size=0.9,halign="start") => @PLACE(3,31);
// #MPCLK @TEXT("",key="model");
// #MNCLK @SET-SYMBOL $NMOS_4TERM;
// #MNCLK @PLACE(0,5) => @ORIENT("R0");
// #MNCLK @TEXT("MNCLK",key="name",size=1.3,halign="start") => @PLACE(3,8);
// #MNCLK @TEXT("l=150.0n w=1u multi=1",key="value",size=0.9,halign="start") => @PLACE(3,1);
// #MNCLK @TEXT("",key="model");
// #M4B @SET-SYMBOL $PMOS_4TERM;
// #M4B @PLACE(38,35) => @ORIENT("R0");
// #M4B @TEXT("M4B",key="name",size=1.3,halign="start") => @PLACE(41,38);
// #M4B @TEXT("l=150.0n w=1u multi=1",key="value",size=0.9,halign="start") => @PLACE(41,31);
// #M4B @TEXT("",key="model");
// #M4C @SET-SYMBOL $NMOS_4TERM;
// #M4C @PLACE(38,5) => @ORIENT("R0");
// #M4C @TEXT("M4C",key="name",size=1.3,halign="start") => @PLACE(41,8);
// #M4C @TEXT("l=150.0n w=1u multi=1",key="value",size=0.9,halign="start") => @PLACE(41,1);
// #M4C @TEXT("",key="model");
// #M4A @SET-SYMBOL $NMOS_4TERM;
// #M4A @PLACE(56,5) => @ORIENT("R0");
// #M4A @TEXT("M4A",key="name",size=1.3,halign="start") => @PLACE(59,8);
// #M4A @TEXT("l=150.0n w=1u multi=1",key="value",size=0.9,halign="start") => @PLACE(59,1);
// #M4A @TEXT("",key="model");
// #Cboot @SET-SYMBOL $CAPACITOR;
// #Cboot @PLACE(80,21) => @ORIENT("R0");
// #Cboot @TEXT("Cboot",key="name",size=1.3,halign="start") => @PLACE(83,24);
// #Cboot @TEXT("nr=8 lr=2.5u w=50n multi=200",key="value",size=0.9,halign="start") => @PLACE(83,17);
// #Cboot @TEXT("",key="model");
// #M2 @SET-SYMBOL $PMOS_4TERM;
// #M2 @PLACE(80,48) => @ORIENT("R0");
// #M2 @TEXT("M2",key="name",size=1.3,halign="start") => @PLACE(83,51);
// #M2 @TEXT("l=150.0n w=1u multi=1",key="value",size=0.9,halign="start") => @PLACE(83,44);
// #M2 @TEXT("",key="model");
// #M8 @SET-SYMBOL $NMOS_4TERM;
// #M8 @PLACE(80,-9) => @ORIENT("R0");
// #M8 @TEXT("M8",key="name",size=1.3,halign="start") => @PLACE(83,-6);
// #M8 @TEXT("l=150.0n w=1u multi=1",key="value",size=0.9,halign="start") => @PLACE(83,-13);
// #M8 @TEXT("",key="model");
// #Msin @SET-SYMBOL $NMOS_4TERM;
// #Msin @PLACE(101,-9) => @ORIENT("R0");
// #Msin @TEXT("Msin",key="name",size=1.3,halign="start") => @PLACE(104,-6);
// #Msin @TEXT("l=150.0n w=1u multi=1",key="value",size=0.9,halign="start") => @PLACE(104,-13);
// #Msin @TEXT("",key="model");
// #M4 @SET-SYMBOL $PMOS_4TERM;
// #M4 @PLACE(116,43) => @ORIENT("R0");
// #M4 @TEXT("M4",key="name",size=1.3,halign="start") => @PLACE(119,46);
// #M4 @TEXT("l=150.0n w=1u multi=1",key="value",size=0.9,halign="start") => @PLACE(119,39);
// #M4 @TEXT("",key="model");
// #Maux @SET-SYMBOL $NMOS_4TERM;
// #Maux @PLACE(116,4) => @ORIENT("R0");
// #Maux @TEXT("Maux",key="name",size=1.3,halign="start") => @PLACE(119,7);
// #Maux @TEXT("l=150.0n w=1u multi=1",key="value",size=0.9,halign="start") => @PLACE(119,0);
// #Maux @TEXT("",key="model");
// #MRSTG @SET-SYMBOL $NMOS_4TERM;
// #MRSTG @PLACE(116,-22) => @ORIENT("R0");
// #MRSTG @TEXT("MRSTG",key="name",size=1.3,halign="start") => @PLACE(119,-19);
// #MRSTG @TEXT("l=150.0n w=1u multi=1",key="value",size=0.9,halign="start") => @PLACE(119,-26);
// #MRSTG @TEXT("",key="model");
// #Mmain_U3 @SET-SYMBOL $NMOS_4TERM;
// #Mmain_U3 @PLACE(158,38) => @ORIENT("R270");
// #Mmain_U3 @TEXT("Mmain_U3",key="name",size=1.3,halign="start") => @PLACE(161,41);
// #Mmain_U3 @TEXT("l=150.0n w=1u multi=1",key="value",size=0.9,halign="start") => @PLACE(161,34);
// #Mmain_U3 @TEXT("",key="model");
// #Mmain @SET-SYMBOL $NMOS_4TERM;
// #Mmain @PLACE(158,17) => @ORIENT("R270");
// #Mmain @TEXT("Mmain",key="name",size=1.3,halign="start") => @PLACE(161,20);
// #Mmain @TEXT("l=150.0n w=1u multi=1",key="value",size=0.9,halign="start") => @PLACE(161,13);
// #Mmain @TEXT("",key="model");
// #Mmain_U1 @SET-SYMBOL $NMOS_4TERM;
// #Mmain_U1 @PLACE(158,-4) => @ORIENT("R270");
// #Mmain_U1 @TEXT("Mmain_U1",key="name",size=1.3,halign="start") => @PLACE(161,-1);
// #Mmain_U1 @TEXT("l=150.0n w=1u multi=1",key="value",size=0.9,halign="start") => @PLACE(161,-8);
// #Mmain_U1 @TEXT("",key="model");
// #Mmain_U2 @SET-SYMBOL $NMOS_4TERM;
// #Mmain_U2 @PLACE(158,-25) => @ORIENT("R270");
// #Mmain_U2 @TEXT("Mmain_U2",key="name",size=1.3,halign="start") => @PLACE(161,-22);
// #Mmain_U2 @TEXT("l=150.0n w=1u multi=1",key="value",size=0.9,halign="start") => @PLACE(161,-29);
// #Mmain_U2 @TEXT("",key="model");
// &"CLKSB" @WIRE(mode="straight",linecolor="#30485d",linewidth=0.16) {#MPCLK:1 (0,20)};
// $JUNCTION @ATTACH (0,20);
// &"CLKSB" @WIRE(mode="straight",linecolor="#30485d",linewidth=0.16) {#MNCLK:1 (0,20)};
// $JUNCTION @ATTACH (0,20);
// &"CTRL" @WIRE(mode="straight",linecolor="#30485d",linewidth=0.16) {(56,60) (113,60)};
// &"CTRL" @WIRE(mode="straight",linecolor="#30485d",linewidth=0.16) {#M4A:1 (56,60)};
// $JUNCTION @ATTACH (56,60);
// &"CTRL" @WIRE(mode="straight",linecolor="#30485d",linewidth=0.16) {#M4:2 (113,60)};
// $JUNCTION @ATTACH (113,60);
// &"CTRL" @WIRE(mode="straight",linecolor="#30485d",linewidth=0.16) {(28,60) (31,60) (56,60)};
// &"CTRL" @WIRE(mode="straight",linecolor="#30485d",linewidth=0.16) {#M4B:1 (38,29) (31,29) (31,60)};
// $JUNCTION @ATTACH (31,60);
// &"CTRL" @WIRE(mode="straight",linecolor="#30485d",linewidth=0.16) {#M4C:1 (38,12) (28,12) (28,60)};
// $JUNCTION @ATTACH (28,60);
// &"BTOP" @WIRE(mode="straight",linecolor="#226e85",linewidth=0.16) {#Cboot:1 (80,31)};
// $JUNCTION @ATTACH (80,31);
// &"BTOP" @WIRE(mode="straight",linecolor="#226e85",linewidth=0.16) {#M2:1 (80,31)};
// $JUNCTION @ATTACH (80,31);
// &"BTOP" @WIRE(mode="straight",linecolor="#226e85",linewidth=0.16) {#M4:3 (116,48) (124,48) (124,31) (80,31)};
// &"BBOT" @WIRE(mode="straight",linecolor="#226e85",linewidth=0.16) {(38,-2) (56,-2) (80,-2) (101,-2)};
// &"BBOT" @WIRE(mode="straight",linecolor="#226e85",linewidth=0.16) {#Cboot:2 (80,-2)};
// $JUNCTION @ATTACH (80,-2);
// &"BBOT" @WIRE(mode="straight",linecolor="#226e85",linewidth=0.16) {#M4C:3 (38,-2)};
// $JUNCTION @ATTACH (38,-2);
// &"BBOT" @WIRE(mode="straight",linecolor="#226e85",linewidth=0.16) {#M4A:3 (56,-2)};
// $JUNCTION @ATTACH (56,-2);
// &"BBOT" @WIRE(mode="straight",linecolor="#226e85",linewidth=0.16) {#M8:1 (80,-2)};
// $JUNCTION @ATTACH (80,-2);
// &"BBOT" @WIRE(mode="straight",linecolor="#226e85",linewidth=0.16) {#Msin:1 (101,-2)};
// $JUNCTION @ATTACH (101,-2);
// &"G" @WIRE(mode="straight",linecolor="#226e85",linewidth=0.16) {(138,-22) (138,-1) (138,6) (138,20) (138,41)};
// &"G" @WIRE(mode="straight",linecolor="#226e85",linewidth=0.16) {#M4:1 (138,41)};
// $JUNCTION @ATTACH (138,41);
// &"G" @WIRE(mode="straight",linecolor="#226e85",linewidth=0.16) {#Maux:1 (138,6)};
// $JUNCTION @ATTACH (138,6);
// &"G" @WIRE(mode="straight",linecolor="#226e85",linewidth=0.16) {#Mmain:2 (138,20)};
// $JUNCTION @ATTACH (138,20);
// &"G" @WIRE(mode="straight",linecolor="#226e85",linewidth=0.16) {#Mmain_U1:2 (138,-1)};
// $JUNCTION @ATTACH (138,-1);
// &"G" @WIRE(mode="straight",linecolor="#226e85",linewidth=0.16) {#Mmain_U2:2 (138,-22)};
// $JUNCTION @ATTACH (138,-22);
// &"G" @WIRE(mode="straight",linecolor="#226e85",linewidth=0.16) {#Mmain_U3:2 (138,41)};
// $JUNCTION @ATTACH (138,41);
// &"GRESET" @WIRE(mode="straight",linecolor="#30485d",linewidth=0.16) {#Maux:3 (116,2) (116,-20) #MRSTG:1};
// &"Vin" @WIRE(mode="straight",linecolor="#226e85",linewidth=0.16) {(146,-25) (146,-11) (146,-4) (146,17) (146,38)};
// &"Vin" @WIRE(mode="straight",linecolor="#226e85",linewidth=0.16) {#Msin:3 (146,-11)};
// $JUNCTION @ATTACH (146,-11);
// &"Vin" @WIRE(mode="straight",linecolor="#226e85",linewidth=0.16) {#Mmain:3 (146,17)};
// $JUNCTION @ATTACH (146,17);
// &"Vin" @WIRE(mode="straight",linecolor="#226e85",linewidth=0.16) {#Mmain_U1:3 (146,-4)};
// $JUNCTION @ATTACH (146,-4);
// &"Vin" @WIRE(mode="straight",linecolor="#226e85",linewidth=0.16) {#Mmain_U2:3 (146,-25)};
// $JUNCTION @ATTACH (146,-25);
// &"Vin" @WIRE(mode="straight",linecolor="#226e85",linewidth=0.16) {#Mmain_U3:3 (146,38)};
// $JUNCTION @ATTACH (146,38);
// &"VOUT" @WIRE(mode="straight",linecolor="#226e85",linewidth=0.16) {(177,-25) (177,-4) (177,17) (177,38)};
// &"VOUT" @WIRE(mode="straight",linecolor="#226e85",linewidth=0.16) {#Mmain:1 (177,17)};
// $JUNCTION @ATTACH (177,17);
// &"VOUT" @WIRE(mode="straight",linecolor="#226e85",linewidth=0.16) {#Mmain_U1:1 (177,-4)};
// $JUNCTION @ATTACH (177,-4);
// &"VOUT" @WIRE(mode="straight",linecolor="#226e85",linewidth=0.16) {#Mmain_U2:1 (177,-25)};
// $JUNCTION @ATTACH (177,-25);
// &"VOUT" @WIRE(mode="straight",linecolor="#226e85",linewidth=0.16) {#Mmain_U3:1 (177,38)};
// $JUNCTION @ATTACH (177,38);
// (-13,-37) @TEXT("Clock inverter",size=1.15,halign="start",textcolor="#223d52");
// (33,-37) @TEXT("Precharge and boost",size=1.15,halign="start",textcolor="#223d52");
// (144,-37) @TEXT("Vin -> VOUT",size=1.15,halign="start",textcolor="#223d52");
// &"0" @WIRE(mode="straight",linecolor="#30485d",linewidth=0.16) {#Mmain:4 (158,13)};
// (158,12.6) @TEXT("0",size=1.1,halign="middle",valign="top");
// &"0" @WIRE(mode="straight",linecolor="#30485d",linewidth=0.16) {#Mmain_U1:4 (158,-8)};
// (158,-8.4) @TEXT("0",size=1.1,halign="middle",valign="top");
// &"0" @WIRE(mode="straight",linecolor="#30485d",linewidth=0.16) {#Mmain_U2:4 (158,-29)};
// (158,-29.4) @TEXT("0",size=1.1,halign="middle",valign="top");
// &"0" @WIRE(mode="straight",linecolor="#30485d",linewidth=0.16) {#Mmain_U3:4 (158,34)};
// (158,33.6) @TEXT("0",size=1.1,halign="middle",valign="top");
// &"CLKS" @WIRE(mode="straight",linecolor="#30485d",linewidth=0.16) {#M4C:2 (32,5)};
// (31.6,5) @TEXT("CLKS",size=1.1,halign="end",valign="middle");
// &"0" @WIRE(mode="straight",linecolor="#30485d",linewidth=0.16) {#M4C:4 (42,5)};
// (42.4,5) @TEXT("0",size=1.1,halign="start",valign="middle");
// &"G" @WIRE(mode="straight",linecolor="#30485d",linewidth=0.16) {#Msin:2 (95,-9)};
// (94.6,-9) @TEXT("G",size=1.1,halign="end",valign="middle");
// &"0" @WIRE(mode="straight",linecolor="#30485d",linewidth=0.16) {#Msin:4 (105,-9)};
// (105.4,-9) @TEXT("0",size=1.1,halign="start",valign="middle");
// &"VDD!" @WIRE(mode="straight",linecolor="#30485d",linewidth=0.16) {#Maux:2 (110,4)};
// (109.6,4) @TEXT("VDD!",size=1.1,halign="end",valign="middle");
// &"0" @WIRE(mode="straight",linecolor="#30485d",linewidth=0.16) {#Maux:4 (120,4)};
// (120.4,4) @TEXT("0",size=1.1,halign="start",valign="middle");
// &"CLKSB" @WIRE(mode="straight",linecolor="#30485d",linewidth=0.16) {#MRSTG:2 (110,-22)};
// (109.6,-22) @TEXT("CLKSB",size=1.1,halign="end",valign="middle");
// &"0" @WIRE(mode="straight",linecolor="#30485d",linewidth=0.16) {#MRSTG:3 (116,-27)};
// (116,-27.4) @TEXT("0",size=1.1,halign="middle",valign="top");
// &"0" @WIRE(mode="straight",linecolor="#30485d",linewidth=0.16) {#MRSTG:4 (120,-22)};
// (120.4,-22) @TEXT("0",size=1.1,halign="start",valign="middle");
// &"G" @WIRE(mode="straight",linecolor="#30485d",linewidth=0.16) {#M4A:2 (50,5)};
// (49.6,5) @TEXT("G",size=1.1,halign="end",valign="middle");
// &"0" @WIRE(mode="straight",linecolor="#30485d",linewidth=0.16) {#M4A:4 (60,5)};
// (60.4,5) @TEXT("0",size=1.1,halign="start",valign="middle");
// &"CLKSB" @WIRE(mode="straight",linecolor="#30485d",linewidth=0.16) {#M8:2 (74,-9)};
// (73.6,-9) @TEXT("CLKSB",size=1.1,halign="end",valign="middle");
// &"0" @WIRE(mode="straight",linecolor="#30485d",linewidth=0.16) {#M8:3 (80,-14)};
// (80,-14.4) @TEXT("0",size=1.1,halign="middle",valign="top");
// &"0" @WIRE(mode="straight",linecolor="#30485d",linewidth=0.16) {#M8:4 (84,-9)};
// (84.4,-9) @TEXT("0",size=1.1,halign="start",valign="middle");
// &"CLKS" @WIRE(mode="straight",linecolor="#30485d",linewidth=0.16) {#MNCLK:2 (-6,5)};
// (-6.4,5) @TEXT("CLKS",size=1.1,halign="end",valign="middle");
// &"0" @WIRE(mode="straight",linecolor="#30485d",linewidth=0.16) {#MNCLK:3 (0,0)};
// (0,-0.4) @TEXT("0",size=1.1,halign="middle",valign="top");
// &"0" @WIRE(mode="straight",linecolor="#30485d",linewidth=0.16) {#MNCLK:4 (4,5)};
// (4.4,5) @TEXT("0",size=1.1,halign="start",valign="middle");
// &"G" @WIRE(mode="straight",linecolor="#30485d",linewidth=0.16) {#M2:2 (74,48)};
// (73.6,48) @TEXT("G",size=1.1,halign="end",valign="middle");
// &"VDD!" @WIRE(mode="straight",linecolor="#30485d",linewidth=0.16) {#M2:3 (80,53)};
// (80,53.4) @TEXT("VDD!",size=1.1,halign="middle",valign="bottom");
// &"BTOP" @WIRE(mode="straight",linecolor="#30485d",linewidth=0.16) {#M2:4 (84,48)};
// (84.4,48) @TEXT("BTOP",size=1.1,halign="start",valign="middle");
// &"BTOP" @WIRE(mode="straight",linecolor="#30485d",linewidth=0.16) {#M4:4 (120,43)};
// (120.4,43) @TEXT("BTOP",size=1.1,halign="start",valign="middle");
// &"CLKS" @WIRE(mode="straight",linecolor="#30485d",linewidth=0.16) {#M4B:2 (32,35)};
// (31.6,35) @TEXT("CLKS",size=1.1,halign="end",valign="middle");
// &"VDD!" @WIRE(mode="straight",linecolor="#30485d",linewidth=0.16) {#M4B:3 (38,40)};
// (38,40.4) @TEXT("VDD!",size=1.1,halign="middle",valign="bottom");
// &"VDD!" @WIRE(mode="straight",linecolor="#30485d",linewidth=0.16) {#M4B:4 (42,35)};
// (42.4,35) @TEXT("VDD!",size=1.1,halign="start",valign="middle");
// &"CLKS" @WIRE(mode="straight",linecolor="#30485d",linewidth=0.16) {#MPCLK:2 (-6,35)};
// (-6.4,35) @TEXT("CLKS",size=1.1,halign="end",valign="middle");
// &"VDD!" @WIRE(mode="straight",linecolor="#30485d",linewidth=0.16) {#MPCLK:3 (0,40)};
// (0,40.4) @TEXT("VDD!",size=1.1,halign="middle",valign="bottom");
// &"VDD!" @WIRE(mode="straight",linecolor="#30485d",linewidth=0.16) {#MPCLK:4 (4,35)};
// (4.4,35) @TEXT("VDD!",size=1.1,halign="start",valign="middle");
// }
// END SARADC RNL
ends sar_bootstrap_flat_8b_p

subckt sar8j_r1_sw_b0 BOT SEL VDD VREFN VREFP VSS
    MP_HIGH (BOT SEL VREFP VDD) pch_mac l=90n w=175.00n multi=3 nf=1          sd=100n ad=1.3125e-14 as=1.3125e-14 pd=500n ps=500n nrd=1.633331          nrs=1.633331 sa=75.0n sb=75.0n sa1=75.0n sa2=75.0n sa3=75.0n          sa4=75.0n sb1=75.0n sb2=75.0n sb3=75.0n spa=100n spa1=100n          spa2=100n spa3=100n sap=91.9776n sapb=114.444n spba=115.715n          spba1=117.043n dfm_flag=0 spmt=1.11111e+15 spomt=0          spomt1=1.11111e+60 spmb=1.11111e+15 spomb=0 spomb1=1.11111e+60
    MN_LOW (BOT SEL VREFN VSS) nch_mac l=90n w=150.0n multi=3 nf=1 sd=100n          ad=1.125e-14 as=1.125e-14 pd=450.0n ps=450.0n nrd=2.702751          nrs=2.702751 sa=75.0n sb=75.0n sa1=75.0n sa2=75.0n sa3=75.0n          sa4=75.0n sb1=75.0n sb2=75.0n sb3=75.0n spa=100n spa1=100n          spa2=100n spa3=100n sap=91.9776n sapb=114.444n spba=115.715n          spba1=117.043n dfm_flag=0 spmt=1.11111e+15 spomt=0          spomt1=1.11111e+60 spmb=1.11111e+15 spomb=0 spomb1=1.11111e+60
// BEGIN SARADC RNL
// @RNL(author="saradc topology") {
// #MP_HIGH @SET-SYMBOL $PMOS_4TERM;
// #MP_HIGH @PLACE(0,14) => @ORIENT("R0");
// #MP_HIGH @TEXT("MP_HIGH",key="name",size=1.3,halign="start") => @PLACE(3,17);
// #MP_HIGH @TEXT("l=90n w=175.00n multi=3",key="value",size=0.9,halign="start") => @PLACE(3,10);
// #MP_HIGH @TEXT("",key="model");
// #MN_LOW @SET-SYMBOL $NMOS_4TERM;
// #MN_LOW @PLACE(0,-14) => @ORIENT("R0");
// #MN_LOW @TEXT("MN_LOW",key="name",size=1.3,halign="start") => @PLACE(3,-11);
// #MN_LOW @TEXT("l=90n w=150.0n multi=3",key="value",size=0.9,halign="start") => @PLACE(3,-18);
// #MN_LOW @TEXT("",key="model");
// (-27,36) @TEXT("Bit 0 reference switch",size=2,halign="start",textcolor="#223d52");
// (-27,31) @TEXT("SEL low selects VREFP. SEL high selects VREFN.",size=1.12,halign="start",textcolor="#223d52");
// %sar_junction1 = (0,0);
// %sar_junction1 @CIRCLE(radius=0.34,linecolor="#30485d",fill="fillcolor",fillcolor="#30485d") => @LAYER("top");
// &"BOT" @WIRE(mode="straight",linecolor="#226e85",linewidth=0.16) {#MP_HIGH:1 %sar_junction1 #MN_LOW:1};
// %sar_port2 = $IO_PORT @ATTACH &"BOT" => @PLACE(22,0) => @ORIENT("MY");
// &"BOT" @WIRE(mode="straight",linecolor="#226e85",linewidth=0.16) {%sar_junction1 %sar_port2:p};
// %sar_junction3 = (-13,0);
// %sar_junction3 @CIRCLE(radius=0.34,linecolor="#30485d",fill="fillcolor",fillcolor="#30485d") => @LAYER("top");
// %sar_port4 = $IO_PORT @ATTACH &"SEL" => @PLACE(-24,0) => @ORIENT("R0");
// &"SEL" @WIRE(mode="straight",linecolor="#94601a",linewidth=0.16) {%sar_port4:p %sar_junction3};
// &"SEL" @WIRE(mode="straight",linecolor="#94601a",linewidth=0.16) {%sar_junction3 (-13,14) #MP_HIGH:2};
// &"SEL" @WIRE(mode="straight",linecolor="#94601a",linewidth=0.16) {%sar_junction3 (-13,-14) #MN_LOW:2};
// %sar_port5 = $IO_PORT @ATTACH &"VREFP" => @PLACE(0,25) => @ORIENT("R270");
// &"VREFP" @WIRE(mode="straight",linecolor="#226e85",linewidth=0.16) {%sar_port5:p #MP_HIGH:3};
// %sar_port6 = $IO_PORT @ATTACH &"VREFN" => @PLACE(0,-25) => @ORIENT("R90");
// &"VREFN" @WIRE(mode="straight",linecolor="#226e85",linewidth=0.16) {%sar_port6:p #MN_LOW:3};
// &"VDD" @WIRE(mode="straight",linecolor="#30485d",linewidth=0.16) {#MP_HIGH:4 (4,14)};
// (4.4,14) @TEXT("VDD",size=1.1,halign="start",valign="middle");
// &"VSS" @WIRE(mode="straight",linecolor="#30485d",linewidth=0.16) {#MN_LOW:4 (4,-14)};
// (4.4,-14) @TEXT("VSS",size=1.1,halign="start",valign="middle");
// }
// END SARADC RNL
ends sar8j_r1_sw_b0

subckt sar8j_r1_sw_b1 BOT SEL VDD VREFN VREFP VSS
    MP_HIGH (BOT SEL VREFP VDD) pch_mac l=90n w=175.00n multi=6 nf=1          sd=100n ad=1.3125e-14 as=1.3125e-14 pd=500n ps=500n nrd=1.633331          nrs=1.633331 sa=75.0n sb=75.0n sa1=75.0n sa2=75.0n sa3=75.0n          sa4=75.0n sb1=75.0n sb2=75.0n sb3=75.0n spa=100n spa1=100n          spa2=100n spa3=100n sap=91.9776n sapb=114.444n spba=115.715n          spba1=117.043n dfm_flag=0 spmt=1.11111e+15 spomt=0          spomt1=1.11111e+60 spmb=1.11111e+15 spomb=0 spomb1=1.11111e+60
    MN_LOW (BOT SEL VREFN VSS) nch_mac l=90n w=150.0n multi=6 nf=1 sd=100n          ad=1.125e-14 as=1.125e-14 pd=450.0n ps=450.0n nrd=2.702751          nrs=2.702751 sa=75.0n sb=75.0n sa1=75.0n sa2=75.0n sa3=75.0n          sa4=75.0n sb1=75.0n sb2=75.0n sb3=75.0n spa=100n spa1=100n          spa2=100n spa3=100n sap=91.9776n sapb=114.444n spba=115.715n          spba1=117.043n dfm_flag=0 spmt=1.11111e+15 spomt=0          spomt1=1.11111e+60 spmb=1.11111e+15 spomb=0 spomb1=1.11111e+60
// BEGIN SARADC RNL
// @RNL(author="saradc topology") {
// #MP_HIGH @SET-SYMBOL $PMOS_4TERM;
// #MP_HIGH @PLACE(0,14) => @ORIENT("R0");
// #MP_HIGH @TEXT("MP_HIGH",key="name",size=1.3,halign="start") => @PLACE(3,17);
// #MP_HIGH @TEXT("l=90n w=175.00n multi=6",key="value",size=0.9,halign="start") => @PLACE(3,10);
// #MP_HIGH @TEXT("",key="model");
// #MN_LOW @SET-SYMBOL $NMOS_4TERM;
// #MN_LOW @PLACE(0,-14) => @ORIENT("R0");
// #MN_LOW @TEXT("MN_LOW",key="name",size=1.3,halign="start") => @PLACE(3,-11);
// #MN_LOW @TEXT("l=90n w=150.0n multi=6",key="value",size=0.9,halign="start") => @PLACE(3,-18);
// #MN_LOW @TEXT("",key="model");
// (-27,36) @TEXT("Bit 1 reference switch",size=2,halign="start",textcolor="#223d52");
// (-27,31) @TEXT("SEL low selects VREFP. SEL high selects VREFN.",size=1.12,halign="start",textcolor="#223d52");
// %sar_junction1 = (0,0);
// %sar_junction1 @CIRCLE(radius=0.34,linecolor="#30485d",fill="fillcolor",fillcolor="#30485d") => @LAYER("top");
// &"BOT" @WIRE(mode="straight",linecolor="#226e85",linewidth=0.16) {#MP_HIGH:1 %sar_junction1 #MN_LOW:1};
// %sar_port2 = $IO_PORT @ATTACH &"BOT" => @PLACE(22,0) => @ORIENT("MY");
// &"BOT" @WIRE(mode="straight",linecolor="#226e85",linewidth=0.16) {%sar_junction1 %sar_port2:p};
// %sar_junction3 = (-13,0);
// %sar_junction3 @CIRCLE(radius=0.34,linecolor="#30485d",fill="fillcolor",fillcolor="#30485d") => @LAYER("top");
// %sar_port4 = $IO_PORT @ATTACH &"SEL" => @PLACE(-24,0) => @ORIENT("R0");
// &"SEL" @WIRE(mode="straight",linecolor="#94601a",linewidth=0.16) {%sar_port4:p %sar_junction3};
// &"SEL" @WIRE(mode="straight",linecolor="#94601a",linewidth=0.16) {%sar_junction3 (-13,14) #MP_HIGH:2};
// &"SEL" @WIRE(mode="straight",linecolor="#94601a",linewidth=0.16) {%sar_junction3 (-13,-14) #MN_LOW:2};
// %sar_port5 = $IO_PORT @ATTACH &"VREFP" => @PLACE(0,25) => @ORIENT("R270");
// &"VREFP" @WIRE(mode="straight",linecolor="#226e85",linewidth=0.16) {%sar_port5:p #MP_HIGH:3};
// %sar_port6 = $IO_PORT @ATTACH &"VREFN" => @PLACE(0,-25) => @ORIENT("R90");
// &"VREFN" @WIRE(mode="straight",linecolor="#226e85",linewidth=0.16) {%sar_port6:p #MN_LOW:3};
// &"VDD" @WIRE(mode="straight",linecolor="#30485d",linewidth=0.16) {#MP_HIGH:4 (4,14)};
// (4.4,14) @TEXT("VDD",size=1.1,halign="start",valign="middle");
// &"VSS" @WIRE(mode="straight",linecolor="#30485d",linewidth=0.16) {#MN_LOW:4 (4,-14)};
// (4.4,-14) @TEXT("VSS",size=1.1,halign="start",valign="middle");
// }
// END SARADC RNL
ends sar8j_r1_sw_b1

subckt sar8j_r1_sw_b2 BOT SEL VDD VREFN VREFP VSS
    MP_HIGH (BOT SEL VREFP VDD) pch_mac l=90n w=175.00n multi=12 nf=1          sd=100n ad=1.3125e-14 as=1.3125e-14 pd=500n ps=500n nrd=1.633331          nrs=1.633331 sa=75.0n sb=75.0n sa1=75.0n sa2=75.0n sa3=75.0n          sa4=75.0n sb1=75.0n sb2=75.0n sb3=75.0n spa=100n spa1=100n          spa2=100n spa3=100n sap=91.9776n sapb=114.444n spba=115.715n          spba1=117.043n dfm_flag=0 spmt=1.11111e+15 spomt=0          spomt1=1.11111e+60 spmb=1.11111e+15 spomb=0 spomb1=1.11111e+60
    MN_LOW (BOT SEL VREFN VSS) nch_mac l=90n w=150.0n multi=12 nf=1 sd=100n          ad=1.125e-14 as=1.125e-14 pd=450.0n ps=450.0n nrd=2.702751          nrs=2.702751 sa=75.0n sb=75.0n sa1=75.0n sa2=75.0n sa3=75.0n          sa4=75.0n sb1=75.0n sb2=75.0n sb3=75.0n spa=100n spa1=100n          spa2=100n spa3=100n sap=91.9776n sapb=114.444n spba=115.715n          spba1=117.043n dfm_flag=0 spmt=1.11111e+15 spomt=0          spomt1=1.11111e+60 spmb=1.11111e+15 spomb=0 spomb1=1.11111e+60
// BEGIN SARADC RNL
// @RNL(author="saradc topology") {
// #MP_HIGH @SET-SYMBOL $PMOS_4TERM;
// #MP_HIGH @PLACE(0,14) => @ORIENT("R0");
// #MP_HIGH @TEXT("MP_HIGH",key="name",size=1.3,halign="start") => @PLACE(3,17);
// #MP_HIGH @TEXT("l=90n w=175.00n multi=12",key="value",size=0.9,halign="start") => @PLACE(3,10);
// #MP_HIGH @TEXT("",key="model");
// #MN_LOW @SET-SYMBOL $NMOS_4TERM;
// #MN_LOW @PLACE(0,-14) => @ORIENT("R0");
// #MN_LOW @TEXT("MN_LOW",key="name",size=1.3,halign="start") => @PLACE(3,-11);
// #MN_LOW @TEXT("l=90n w=150.0n multi=12",key="value",size=0.9,halign="start") => @PLACE(3,-18);
// #MN_LOW @TEXT("",key="model");
// (-27,36) @TEXT("Bit 2 reference switch",size=2,halign="start",textcolor="#223d52");
// (-27,31) @TEXT("SEL low selects VREFP. SEL high selects VREFN.",size=1.12,halign="start",textcolor="#223d52");
// %sar_junction1 = (0,0);
// %sar_junction1 @CIRCLE(radius=0.34,linecolor="#30485d",fill="fillcolor",fillcolor="#30485d") => @LAYER("top");
// &"BOT" @WIRE(mode="straight",linecolor="#226e85",linewidth=0.16) {#MP_HIGH:1 %sar_junction1 #MN_LOW:1};
// %sar_port2 = $IO_PORT @ATTACH &"BOT" => @PLACE(22,0) => @ORIENT("MY");
// &"BOT" @WIRE(mode="straight",linecolor="#226e85",linewidth=0.16) {%sar_junction1 %sar_port2:p};
// %sar_junction3 = (-13,0);
// %sar_junction3 @CIRCLE(radius=0.34,linecolor="#30485d",fill="fillcolor",fillcolor="#30485d") => @LAYER("top");
// %sar_port4 = $IO_PORT @ATTACH &"SEL" => @PLACE(-24,0) => @ORIENT("R0");
// &"SEL" @WIRE(mode="straight",linecolor="#94601a",linewidth=0.16) {%sar_port4:p %sar_junction3};
// &"SEL" @WIRE(mode="straight",linecolor="#94601a",linewidth=0.16) {%sar_junction3 (-13,14) #MP_HIGH:2};
// &"SEL" @WIRE(mode="straight",linecolor="#94601a",linewidth=0.16) {%sar_junction3 (-13,-14) #MN_LOW:2};
// %sar_port5 = $IO_PORT @ATTACH &"VREFP" => @PLACE(0,25) => @ORIENT("R270");
// &"VREFP" @WIRE(mode="straight",linecolor="#226e85",linewidth=0.16) {%sar_port5:p #MP_HIGH:3};
// %sar_port6 = $IO_PORT @ATTACH &"VREFN" => @PLACE(0,-25) => @ORIENT("R90");
// &"VREFN" @WIRE(mode="straight",linecolor="#226e85",linewidth=0.16) {%sar_port6:p #MN_LOW:3};
// &"VDD" @WIRE(mode="straight",linecolor="#30485d",linewidth=0.16) {#MP_HIGH:4 (4,14)};
// (4.4,14) @TEXT("VDD",size=1.1,halign="start",valign="middle");
// &"VSS" @WIRE(mode="straight",linecolor="#30485d",linewidth=0.16) {#MN_LOW:4 (4,-14)};
// (4.4,-14) @TEXT("VSS",size=1.1,halign="start",valign="middle");
// }
// END SARADC RNL
ends sar8j_r1_sw_b2

subckt sar8j_r1_sw_b3 BOT SEL VDD VREFN VREFP VSS
    MP_HIGH (BOT SEL VREFP VDD) pch_mac l=90n w=175.00n multi=24 nf=1          sd=100n ad=1.3125e-14 as=1.3125e-14 pd=500n ps=500n nrd=1.633331          nrs=1.633331 sa=75.0n sb=75.0n sa1=75.0n sa2=75.0n sa3=75.0n          sa4=75.0n sb1=75.0n sb2=75.0n sb3=75.0n spa=100n spa1=100n          spa2=100n spa3=100n sap=91.9776n sapb=114.444n spba=115.715n          spba1=117.043n dfm_flag=0 spmt=1.11111e+15 spomt=0          spomt1=1.11111e+60 spmb=1.11111e+15 spomb=0 spomb1=1.11111e+60
    MN_LOW (BOT SEL VREFN VSS) nch_mac l=90n w=150.0n multi=24 nf=1 sd=100n          ad=1.125e-14 as=1.125e-14 pd=450.0n ps=450.0n nrd=2.702751          nrs=2.702751 sa=75.0n sb=75.0n sa1=75.0n sa2=75.0n sa3=75.0n          sa4=75.0n sb1=75.0n sb2=75.0n sb3=75.0n spa=100n spa1=100n          spa2=100n spa3=100n sap=91.9776n sapb=114.444n spba=115.715n          spba1=117.043n dfm_flag=0 spmt=1.11111e+15 spomt=0          spomt1=1.11111e+60 spmb=1.11111e+15 spomb=0 spomb1=1.11111e+60
// BEGIN SARADC RNL
// @RNL(author="saradc topology") {
// #MP_HIGH @SET-SYMBOL $PMOS_4TERM;
// #MP_HIGH @PLACE(0,14) => @ORIENT("R0");
// #MP_HIGH @TEXT("MP_HIGH",key="name",size=1.3,halign="start") => @PLACE(3,17);
// #MP_HIGH @TEXT("l=90n w=175.00n multi=24",key="value",size=0.9,halign="start") => @PLACE(3,10);
// #MP_HIGH @TEXT("",key="model");
// #MN_LOW @SET-SYMBOL $NMOS_4TERM;
// #MN_LOW @PLACE(0,-14) => @ORIENT("R0");
// #MN_LOW @TEXT("MN_LOW",key="name",size=1.3,halign="start") => @PLACE(3,-11);
// #MN_LOW @TEXT("l=90n w=150.0n multi=24",key="value",size=0.9,halign="start") => @PLACE(3,-18);
// #MN_LOW @TEXT("",key="model");
// (-27,36) @TEXT("Bit 3 reference switch",size=2,halign="start",textcolor="#223d52");
// (-27,31) @TEXT("SEL low selects VREFP. SEL high selects VREFN.",size=1.12,halign="start",textcolor="#223d52");
// %sar_junction1 = (0,0);
// %sar_junction1 @CIRCLE(radius=0.34,linecolor="#30485d",fill="fillcolor",fillcolor="#30485d") => @LAYER("top");
// &"BOT" @WIRE(mode="straight",linecolor="#226e85",linewidth=0.16) {#MP_HIGH:1 %sar_junction1 #MN_LOW:1};
// %sar_port2 = $IO_PORT @ATTACH &"BOT" => @PLACE(22,0) => @ORIENT("MY");
// &"BOT" @WIRE(mode="straight",linecolor="#226e85",linewidth=0.16) {%sar_junction1 %sar_port2:p};
// %sar_junction3 = (-13,0);
// %sar_junction3 @CIRCLE(radius=0.34,linecolor="#30485d",fill="fillcolor",fillcolor="#30485d") => @LAYER("top");
// %sar_port4 = $IO_PORT @ATTACH &"SEL" => @PLACE(-24,0) => @ORIENT("R0");
// &"SEL" @WIRE(mode="straight",linecolor="#94601a",linewidth=0.16) {%sar_port4:p %sar_junction3};
// &"SEL" @WIRE(mode="straight",linecolor="#94601a",linewidth=0.16) {%sar_junction3 (-13,14) #MP_HIGH:2};
// &"SEL" @WIRE(mode="straight",linecolor="#94601a",linewidth=0.16) {%sar_junction3 (-13,-14) #MN_LOW:2};
// %sar_port5 = $IO_PORT @ATTACH &"VREFP" => @PLACE(0,25) => @ORIENT("R270");
// &"VREFP" @WIRE(mode="straight",linecolor="#226e85",linewidth=0.16) {%sar_port5:p #MP_HIGH:3};
// %sar_port6 = $IO_PORT @ATTACH &"VREFN" => @PLACE(0,-25) => @ORIENT("R90");
// &"VREFN" @WIRE(mode="straight",linecolor="#226e85",linewidth=0.16) {%sar_port6:p #MN_LOW:3};
// &"VDD" @WIRE(mode="straight",linecolor="#30485d",linewidth=0.16) {#MP_HIGH:4 (4,14)};
// (4.4,14) @TEXT("VDD",size=1.1,halign="start",valign="middle");
// &"VSS" @WIRE(mode="straight",linecolor="#30485d",linewidth=0.16) {#MN_LOW:4 (4,-14)};
// (4.4,-14) @TEXT("VSS",size=1.1,halign="start",valign="middle");
// }
// END SARADC RNL
ends sar8j_r1_sw_b3

subckt sar8j_r1_sw_b4 BOT SEL VDD VREFN VREFP VSS
    MP_HIGH (BOT SEL VREFP VDD) pch_mac l=90n w=175.00n multi=48 nf=1          sd=100n ad=1.3125e-14 as=1.3125e-14 pd=500n ps=500n nrd=1.633331          nrs=1.633331 sa=75.0n sb=75.0n sa1=75.0n sa2=75.0n sa3=75.0n          sa4=75.0n sb1=75.0n sb2=75.0n sb3=75.0n spa=100n spa1=100n          spa2=100n spa3=100n sap=91.9776n sapb=114.444n spba=115.715n          spba1=117.043n dfm_flag=0 spmt=1.11111e+15 spomt=0          spomt1=1.11111e+60 spmb=1.11111e+15 spomb=0 spomb1=1.11111e+60
    MN_LOW (BOT SEL VREFN VSS) nch_mac l=90n w=150.0n multi=48 nf=1 sd=100n          ad=1.125e-14 as=1.125e-14 pd=450.0n ps=450.0n nrd=2.702751          nrs=2.702751 sa=75.0n sb=75.0n sa1=75.0n sa2=75.0n sa3=75.0n          sa4=75.0n sb1=75.0n sb2=75.0n sb3=75.0n spa=100n spa1=100n          spa2=100n spa3=100n sap=91.9776n sapb=114.444n spba=115.715n          spba1=117.043n dfm_flag=0 spmt=1.11111e+15 spomt=0          spomt1=1.11111e+60 spmb=1.11111e+15 spomb=0 spomb1=1.11111e+60
// BEGIN SARADC RNL
// @RNL(author="saradc topology") {
// #MP_HIGH @SET-SYMBOL $PMOS_4TERM;
// #MP_HIGH @PLACE(0,14) => @ORIENT("R0");
// #MP_HIGH @TEXT("MP_HIGH",key="name",size=1.3,halign="start") => @PLACE(3,17);
// #MP_HIGH @TEXT("l=90n w=175.00n multi=48",key="value",size=0.9,halign="start") => @PLACE(3,10);
// #MP_HIGH @TEXT("",key="model");
// #MN_LOW @SET-SYMBOL $NMOS_4TERM;
// #MN_LOW @PLACE(0,-14) => @ORIENT("R0");
// #MN_LOW @TEXT("MN_LOW",key="name",size=1.3,halign="start") => @PLACE(3,-11);
// #MN_LOW @TEXT("l=90n w=150.0n multi=48",key="value",size=0.9,halign="start") => @PLACE(3,-18);
// #MN_LOW @TEXT("",key="model");
// (-27,36) @TEXT("Bit 4 reference switch",size=2,halign="start",textcolor="#223d52");
// (-27,31) @TEXT("SEL low selects VREFP. SEL high selects VREFN.",size=1.12,halign="start",textcolor="#223d52");
// %sar_junction1 = (0,0);
// %sar_junction1 @CIRCLE(radius=0.34,linecolor="#30485d",fill="fillcolor",fillcolor="#30485d") => @LAYER("top");
// &"BOT" @WIRE(mode="straight",linecolor="#226e85",linewidth=0.16) {#MP_HIGH:1 %sar_junction1 #MN_LOW:1};
// %sar_port2 = $IO_PORT @ATTACH &"BOT" => @PLACE(22,0) => @ORIENT("MY");
// &"BOT" @WIRE(mode="straight",linecolor="#226e85",linewidth=0.16) {%sar_junction1 %sar_port2:p};
// %sar_junction3 = (-13,0);
// %sar_junction3 @CIRCLE(radius=0.34,linecolor="#30485d",fill="fillcolor",fillcolor="#30485d") => @LAYER("top");
// %sar_port4 = $IO_PORT @ATTACH &"SEL" => @PLACE(-24,0) => @ORIENT("R0");
// &"SEL" @WIRE(mode="straight",linecolor="#94601a",linewidth=0.16) {%sar_port4:p %sar_junction3};
// &"SEL" @WIRE(mode="straight",linecolor="#94601a",linewidth=0.16) {%sar_junction3 (-13,14) #MP_HIGH:2};
// &"SEL" @WIRE(mode="straight",linecolor="#94601a",linewidth=0.16) {%sar_junction3 (-13,-14) #MN_LOW:2};
// %sar_port5 = $IO_PORT @ATTACH &"VREFP" => @PLACE(0,25) => @ORIENT("R270");
// &"VREFP" @WIRE(mode="straight",linecolor="#226e85",linewidth=0.16) {%sar_port5:p #MP_HIGH:3};
// %sar_port6 = $IO_PORT @ATTACH &"VREFN" => @PLACE(0,-25) => @ORIENT("R90");
// &"VREFN" @WIRE(mode="straight",linecolor="#226e85",linewidth=0.16) {%sar_port6:p #MN_LOW:3};
// &"VDD" @WIRE(mode="straight",linecolor="#30485d",linewidth=0.16) {#MP_HIGH:4 (4,14)};
// (4.4,14) @TEXT("VDD",size=1.1,halign="start",valign="middle");
// &"VSS" @WIRE(mode="straight",linecolor="#30485d",linewidth=0.16) {#MN_LOW:4 (4,-14)};
// (4.4,-14) @TEXT("VSS",size=1.1,halign="start",valign="middle");
// }
// END SARADC RNL
ends sar8j_r1_sw_b4

subckt sar8j_r1_sw_b5 BOT SEL VDD VREFN VREFP VSS
    MP_HIGH (BOT SEL VREFP VDD) pch_mac l=90n w=175.00n multi=96 nf=1          sd=100n ad=1.3125e-14 as=1.3125e-14 pd=500n ps=500n nrd=1.633331          nrs=1.633331 sa=75.0n sb=75.0n sa1=75.0n sa2=75.0n sa3=75.0n          sa4=75.0n sb1=75.0n sb2=75.0n sb3=75.0n spa=100n spa1=100n          spa2=100n spa3=100n sap=91.9776n sapb=114.444n spba=115.715n          spba1=117.043n dfm_flag=0 spmt=1.11111e+15 spomt=0          spomt1=1.11111e+60 spmb=1.11111e+15 spomb=0 spomb1=1.11111e+60
    MN_LOW (BOT SEL VREFN VSS) nch_mac l=90n w=150.0n multi=96 nf=1 sd=100n          ad=1.125e-14 as=1.125e-14 pd=450.0n ps=450.0n nrd=2.702751          nrs=2.702751 sa=75.0n sb=75.0n sa1=75.0n sa2=75.0n sa3=75.0n          sa4=75.0n sb1=75.0n sb2=75.0n sb3=75.0n spa=100n spa1=100n          spa2=100n spa3=100n sap=91.9776n sapb=114.444n spba=115.715n          spba1=117.043n dfm_flag=0 spmt=1.11111e+15 spomt=0          spomt1=1.11111e+60 spmb=1.11111e+15 spomb=0 spomb1=1.11111e+60
// BEGIN SARADC RNL
// @RNL(author="saradc topology") {
// #MP_HIGH @SET-SYMBOL $PMOS_4TERM;
// #MP_HIGH @PLACE(0,14) => @ORIENT("R0");
// #MP_HIGH @TEXT("MP_HIGH",key="name",size=1.3,halign="start") => @PLACE(3,17);
// #MP_HIGH @TEXT("l=90n w=175.00n multi=96",key="value",size=0.9,halign="start") => @PLACE(3,10);
// #MP_HIGH @TEXT("",key="model");
// #MN_LOW @SET-SYMBOL $NMOS_4TERM;
// #MN_LOW @PLACE(0,-14) => @ORIENT("R0");
// #MN_LOW @TEXT("MN_LOW",key="name",size=1.3,halign="start") => @PLACE(3,-11);
// #MN_LOW @TEXT("l=90n w=150.0n multi=96",key="value",size=0.9,halign="start") => @PLACE(3,-18);
// #MN_LOW @TEXT("",key="model");
// (-27,36) @TEXT("Bit 5 reference switch",size=2,halign="start",textcolor="#223d52");
// (-27,31) @TEXT("SEL low selects VREFP. SEL high selects VREFN.",size=1.12,halign="start",textcolor="#223d52");
// %sar_junction1 = (0,0);
// %sar_junction1 @CIRCLE(radius=0.34,linecolor="#30485d",fill="fillcolor",fillcolor="#30485d") => @LAYER("top");
// &"BOT" @WIRE(mode="straight",linecolor="#226e85",linewidth=0.16) {#MP_HIGH:1 %sar_junction1 #MN_LOW:1};
// %sar_port2 = $IO_PORT @ATTACH &"BOT" => @PLACE(22,0) => @ORIENT("MY");
// &"BOT" @WIRE(mode="straight",linecolor="#226e85",linewidth=0.16) {%sar_junction1 %sar_port2:p};
// %sar_junction3 = (-13,0);
// %sar_junction3 @CIRCLE(radius=0.34,linecolor="#30485d",fill="fillcolor",fillcolor="#30485d") => @LAYER("top");
// %sar_port4 = $IO_PORT @ATTACH &"SEL" => @PLACE(-24,0) => @ORIENT("R0");
// &"SEL" @WIRE(mode="straight",linecolor="#94601a",linewidth=0.16) {%sar_port4:p %sar_junction3};
// &"SEL" @WIRE(mode="straight",linecolor="#94601a",linewidth=0.16) {%sar_junction3 (-13,14) #MP_HIGH:2};
// &"SEL" @WIRE(mode="straight",linecolor="#94601a",linewidth=0.16) {%sar_junction3 (-13,-14) #MN_LOW:2};
// %sar_port5 = $IO_PORT @ATTACH &"VREFP" => @PLACE(0,25) => @ORIENT("R270");
// &"VREFP" @WIRE(mode="straight",linecolor="#226e85",linewidth=0.16) {%sar_port5:p #MP_HIGH:3};
// %sar_port6 = $IO_PORT @ATTACH &"VREFN" => @PLACE(0,-25) => @ORIENT("R90");
// &"VREFN" @WIRE(mode="straight",linecolor="#226e85",linewidth=0.16) {%sar_port6:p #MN_LOW:3};
// &"VDD" @WIRE(mode="straight",linecolor="#30485d",linewidth=0.16) {#MP_HIGH:4 (4,14)};
// (4.4,14) @TEXT("VDD",size=1.1,halign="start",valign="middle");
// &"VSS" @WIRE(mode="straight",linecolor="#30485d",linewidth=0.16) {#MN_LOW:4 (4,-14)};
// (4.4,-14) @TEXT("VSS",size=1.1,halign="start",valign="middle");
// }
// END SARADC RNL
ends sar8j_r1_sw_b5

subckt sar8j_r1_sw_b6 BOT SEL VDD VREFN VREFP VSS
    MP_HIGH (BOT SEL VREFP VDD) pch_mac l=90n w=175.00n multi=192 nf=1          sd=100n ad=1.3125e-14 as=1.3125e-14 pd=500n ps=500n nrd=1.633331          nrs=1.633331 sa=75.0n sb=75.0n sa1=75.0n sa2=75.0n sa3=75.0n          sa4=75.0n sb1=75.0n sb2=75.0n sb3=75.0n spa=100n spa1=100n          spa2=100n spa3=100n sap=91.9776n sapb=114.444n spba=115.715n          spba1=117.043n dfm_flag=0 spmt=1.11111e+15 spomt=0          spomt1=1.11111e+60 spmb=1.11111e+15 spomb=0 spomb1=1.11111e+60
    MN_LOW (BOT SEL VREFN VSS) nch_mac l=90n w=150.0n multi=192 nf=1          sd=100n ad=1.125e-14 as=1.125e-14 pd=450.0n ps=450.0n nrd=2.702751          nrs=2.702751 sa=75.0n sb=75.0n sa1=75.0n sa2=75.0n sa3=75.0n          sa4=75.0n sb1=75.0n sb2=75.0n sb3=75.0n spa=100n spa1=100n          spa2=100n spa3=100n sap=91.9776n sapb=114.444n spba=115.715n          spba1=117.043n dfm_flag=0 spmt=1.11111e+15 spomt=0          spomt1=1.11111e+60 spmb=1.11111e+15 spomb=0 spomb1=1.11111e+60
// BEGIN SARADC RNL
// @RNL(author="saradc topology") {
// #MP_HIGH @SET-SYMBOL $PMOS_4TERM;
// #MP_HIGH @PLACE(0,14) => @ORIENT("R0");
// #MP_HIGH @TEXT("MP_HIGH",key="name",size=1.3,halign="start") => @PLACE(3,17);
// #MP_HIGH @TEXT("l=90n w=175.00n multi=192",key="value",size=0.9,halign="start") => @PLACE(3,10);
// #MP_HIGH @TEXT("",key="model");
// #MN_LOW @SET-SYMBOL $NMOS_4TERM;
// #MN_LOW @PLACE(0,-14) => @ORIENT("R0");
// #MN_LOW @TEXT("MN_LOW",key="name",size=1.3,halign="start") => @PLACE(3,-11);
// #MN_LOW @TEXT("l=90n w=150.0n multi=192",key="value",size=0.9,halign="start") => @PLACE(3,-18);
// #MN_LOW @TEXT("",key="model");
// (-27,36) @TEXT("Bit 6 reference switch",size=2,halign="start",textcolor="#223d52");
// (-27,31) @TEXT("SEL low selects VREFP. SEL high selects VREFN.",size=1.12,halign="start",textcolor="#223d52");
// %sar_junction1 = (0,0);
// %sar_junction1 @CIRCLE(radius=0.34,linecolor="#30485d",fill="fillcolor",fillcolor="#30485d") => @LAYER("top");
// &"BOT" @WIRE(mode="straight",linecolor="#226e85",linewidth=0.16) {#MP_HIGH:1 %sar_junction1 #MN_LOW:1};
// %sar_port2 = $IO_PORT @ATTACH &"BOT" => @PLACE(22,0) => @ORIENT("MY");
// &"BOT" @WIRE(mode="straight",linecolor="#226e85",linewidth=0.16) {%sar_junction1 %sar_port2:p};
// %sar_junction3 = (-13,0);
// %sar_junction3 @CIRCLE(radius=0.34,linecolor="#30485d",fill="fillcolor",fillcolor="#30485d") => @LAYER("top");
// %sar_port4 = $IO_PORT @ATTACH &"SEL" => @PLACE(-24,0) => @ORIENT("R0");
// &"SEL" @WIRE(mode="straight",linecolor="#94601a",linewidth=0.16) {%sar_port4:p %sar_junction3};
// &"SEL" @WIRE(mode="straight",linecolor="#94601a",linewidth=0.16) {%sar_junction3 (-13,14) #MP_HIGH:2};
// &"SEL" @WIRE(mode="straight",linecolor="#94601a",linewidth=0.16) {%sar_junction3 (-13,-14) #MN_LOW:2};
// %sar_port5 = $IO_PORT @ATTACH &"VREFP" => @PLACE(0,25) => @ORIENT("R270");
// &"VREFP" @WIRE(mode="straight",linecolor="#226e85",linewidth=0.16) {%sar_port5:p #MP_HIGH:3};
// %sar_port6 = $IO_PORT @ATTACH &"VREFN" => @PLACE(0,-25) => @ORIENT("R90");
// &"VREFN" @WIRE(mode="straight",linecolor="#226e85",linewidth=0.16) {%sar_port6:p #MN_LOW:3};
// &"VDD" @WIRE(mode="straight",linecolor="#30485d",linewidth=0.16) {#MP_HIGH:4 (4,14)};
// (4.4,14) @TEXT("VDD",size=1.1,halign="start",valign="middle");
// &"VSS" @WIRE(mode="straight",linecolor="#30485d",linewidth=0.16) {#MN_LOW:4 (4,-14)};
// (4.4,-14) @TEXT("VSS",size=1.1,halign="start",valign="middle");
// }
// END SARADC RNL
ends sar8j_r1_sw_b6

subckt sar8j_r1_sw_b7 BOT SEL VDD VREFN VREFP VSS
    MP_HIGH (BOT SEL VREFP VDD) pch_mac l=90n w=175.00n multi=384 nf=1          sd=100n ad=1.3125e-14 as=1.3125e-14 pd=500n ps=500n nrd=1.633331          nrs=1.633331 sa=75.0n sb=75.0n sa1=75.0n sa2=75.0n sa3=75.0n          sa4=75.0n sb1=75.0n sb2=75.0n sb3=75.0n spa=100n spa1=100n          spa2=100n spa3=100n sap=91.9776n sapb=114.444n spba=115.715n          spba1=117.043n dfm_flag=0 spmt=1.11111e+15 spomt=0          spomt1=1.11111e+60 spmb=1.11111e+15 spomb=0 spomb1=1.11111e+60
    MN_LOW (BOT SEL VREFN VSS) nch_mac l=90n w=150.0n multi=384 nf=1          sd=100n ad=1.125e-14 as=1.125e-14 pd=450.0n ps=450.0n nrd=2.702751          nrs=2.702751 sa=75.0n sb=75.0n sa1=75.0n sa2=75.0n sa3=75.0n          sa4=75.0n sb1=75.0n sb2=75.0n sb3=75.0n spa=100n spa1=100n          spa2=100n spa3=100n sap=91.9776n sapb=114.444n spba=115.715n          spba1=117.043n dfm_flag=0 spmt=1.11111e+15 spomt=0          spomt1=1.11111e+60 spmb=1.11111e+15 spomb=0 spomb1=1.11111e+60
// BEGIN SARADC RNL
// @RNL(author="saradc topology") {
// #MP_HIGH @SET-SYMBOL $PMOS_4TERM;
// #MP_HIGH @PLACE(0,14) => @ORIENT("R0");
// #MP_HIGH @TEXT("MP_HIGH",key="name",size=1.3,halign="start") => @PLACE(3,17);
// #MP_HIGH @TEXT("l=90n w=175.00n multi=384",key="value",size=0.9,halign="start") => @PLACE(3,10);
// #MP_HIGH @TEXT("",key="model");
// #MN_LOW @SET-SYMBOL $NMOS_4TERM;
// #MN_LOW @PLACE(0,-14) => @ORIENT("R0");
// #MN_LOW @TEXT("MN_LOW",key="name",size=1.3,halign="start") => @PLACE(3,-11);
// #MN_LOW @TEXT("l=90n w=150.0n multi=384",key="value",size=0.9,halign="start") => @PLACE(3,-18);
// #MN_LOW @TEXT("",key="model");
// (-27,36) @TEXT("Bit 7 reference switch",size=2,halign="start",textcolor="#223d52");
// (-27,31) @TEXT("SEL low selects VREFP. SEL high selects VREFN.",size=1.12,halign="start",textcolor="#223d52");
// %sar_junction1 = (0,0);
// %sar_junction1 @CIRCLE(radius=0.34,linecolor="#30485d",fill="fillcolor",fillcolor="#30485d") => @LAYER("top");
// &"BOT" @WIRE(mode="straight",linecolor="#226e85",linewidth=0.16) {#MP_HIGH:1 %sar_junction1 #MN_LOW:1};
// %sar_port2 = $IO_PORT @ATTACH &"BOT" => @PLACE(22,0) => @ORIENT("MY");
// &"BOT" @WIRE(mode="straight",linecolor="#226e85",linewidth=0.16) {%sar_junction1 %sar_port2:p};
// %sar_junction3 = (-13,0);
// %sar_junction3 @CIRCLE(radius=0.34,linecolor="#30485d",fill="fillcolor",fillcolor="#30485d") => @LAYER("top");
// %sar_port4 = $IO_PORT @ATTACH &"SEL" => @PLACE(-24,0) => @ORIENT("R0");
// &"SEL" @WIRE(mode="straight",linecolor="#94601a",linewidth=0.16) {%sar_port4:p %sar_junction3};
// &"SEL" @WIRE(mode="straight",linecolor="#94601a",linewidth=0.16) {%sar_junction3 (-13,14) #MP_HIGH:2};
// &"SEL" @WIRE(mode="straight",linecolor="#94601a",linewidth=0.16) {%sar_junction3 (-13,-14) #MN_LOW:2};
// %sar_port5 = $IO_PORT @ATTACH &"VREFP" => @PLACE(0,25) => @ORIENT("R270");
// &"VREFP" @WIRE(mode="straight",linecolor="#226e85",linewidth=0.16) {%sar_port5:p #MP_HIGH:3};
// %sar_port6 = $IO_PORT @ATTACH &"VREFN" => @PLACE(0,-25) => @ORIENT("R90");
// &"VREFN" @WIRE(mode="straight",linecolor="#226e85",linewidth=0.16) {%sar_port6:p #MN_LOW:3};
// &"VDD" @WIRE(mode="straight",linecolor="#30485d",linewidth=0.16) {#MP_HIGH:4 (4,14)};
// (4.4,14) @TEXT("VDD",size=1.1,halign="start",valign="middle");
// &"VSS" @WIRE(mode="straight",linecolor="#30485d",linewidth=0.16) {#MN_LOW:4 (4,-14)};
// (4.4,-14) @TEXT("VSS",size=1.1,halign="start",valign="middle");
// }
// END SARADC RNL
ends sar8j_r1_sw_b7

subckt sar8j_r1_cdac REFSEL_N0 REFSEL_N1 REFSEL_N2 REFSEL_N3 REFSEL_N4 REFSEL_N5 REFSEL_N6 REFSEL_N7      REFSEL_P0 REFSEL_P1 REFSEL_P2 REFSEL_P3 REFSEL_P4 REFSEL_P5 REFSEL_P6 REFSEL_P7      TOPN TOPP VDD VREFN VREFP VSS
    CMOMN8 (TOPN VREFN) cfmom_2t nr=8 lr=2u w=50n s=50n stm=1 spm=3          multi=1 mismatchflag=1
    CMOMN7 (TOPN BN7) cfmom_2t nr=8 lr=2u w=50n s=50n stm=1 spm=3          multi=128 mismatchflag=1
    CMOMN6 (TOPN BN6) cfmom_2t nr=8 lr=2u w=50n s=50n stm=1 spm=3 multi=64          mismatchflag=1
    CMOMN5 (TOPN BN5) cfmom_2t nr=8 lr=2u w=50n s=50n stm=1 spm=3 multi=32          mismatchflag=1
    CMOMN4 (TOPN BN4) cfmom_2t nr=8 lr=2u w=50n s=50n stm=1 spm=3 multi=16          mismatchflag=1
    CMOMN3 (TOPN BN3) cfmom_2t nr=8 lr=2u w=50n s=50n stm=1 spm=3 multi=8          mismatchflag=1
    CMOMN2 (TOPN BN2) cfmom_2t nr=8 lr=2u w=50n s=50n stm=1 spm=3 multi=4          mismatchflag=1
    CMOMN1 (TOPN BN1) cfmom_2t nr=8 lr=2u w=50n s=50n stm=1 spm=3 multi=2          mismatchflag=1
    CMOMN0 (TOPN BN0) cfmom_2t nr=8 lr=2u w=50n s=50n stm=1 spm=3 multi=1          mismatchflag=1
    CMOMP8 (TOPP VREFP) cfmom_2t nr=8 lr=2u w=50n s=50n stm=1 spm=3          multi=1 mismatchflag=1
    CMOMP7 (TOPP BP7) cfmom_2t nr=8 lr=2u w=50n s=50n stm=1 spm=3          multi=128 mismatchflag=1
    CMOMP6 (TOPP BP6) cfmom_2t nr=8 lr=2u w=50n s=50n stm=1 spm=3 multi=64          mismatchflag=1
    CMOMP5 (TOPP BP5) cfmom_2t nr=8 lr=2u w=50n s=50n stm=1 spm=3 multi=32          mismatchflag=1
    CMOMP4 (TOPP BP4) cfmom_2t nr=8 lr=2u w=50n s=50n stm=1 spm=3 multi=16          mismatchflag=1
    CMOMP3 (TOPP BP3) cfmom_2t nr=8 lr=2u w=50n s=50n stm=1 spm=3 multi=8          mismatchflag=1
    CMOMP2 (TOPP BP2) cfmom_2t nr=8 lr=2u w=50n s=50n stm=1 spm=3 multi=4          mismatchflag=1
    CMOMP1 (TOPP BP1) cfmom_2t nr=8 lr=2u w=50n s=50n stm=1 spm=3 multi=2          mismatchflag=1
    CMOMP0 (TOPP BP0) cfmom_2t nr=8 lr=2u w=50n s=50n stm=1 spm=3 multi=1          mismatchflag=1
    XSN0 (BN0 REFSEL_N0 VDD VREFN VREFP VSS) sar8j_r1_sw_b0
    XSP0 (BP0 REFSEL_P0 VDD VREFN VREFP VSS) sar8j_r1_sw_b0
    XSN1 (BN1 REFSEL_N1 VDD VREFN VREFP VSS) sar8j_r1_sw_b1
    XSP1 (BP1 REFSEL_P1 VDD VREFN VREFP VSS) sar8j_r1_sw_b1
    XSN2 (BN2 REFSEL_N2 VDD VREFN VREFP VSS) sar8j_r1_sw_b2
    XSP2 (BP2 REFSEL_P2 VDD VREFN VREFP VSS) sar8j_r1_sw_b2
    XSN3 (BN3 REFSEL_N3 VDD VREFN VREFP VSS) sar8j_r1_sw_b3
    XSP3 (BP3 REFSEL_P3 VDD VREFN VREFP VSS) sar8j_r1_sw_b3
    XSN4 (BN4 REFSEL_N4 VDD VREFN VREFP VSS) sar8j_r1_sw_b4
    XSP4 (BP4 REFSEL_P4 VDD VREFN VREFP VSS) sar8j_r1_sw_b4
    XSN5 (BN5 REFSEL_N5 VDD VREFN VREFP VSS) sar8j_r1_sw_b5
    XSP5 (BP5 REFSEL_P5 VDD VREFN VREFP VSS) sar8j_r1_sw_b5
    XSN6 (BN6 REFSEL_N6 VDD VREFN VREFP VSS) sar8j_r1_sw_b6
    XSP6 (BP6 REFSEL_P6 VDD VREFN VREFP VSS) sar8j_r1_sw_b6
    XSN7 (BN7 REFSEL_N7 VDD VREFN VREFP VSS) sar8j_r1_sw_b7
    XSP7 (BP7 REFSEL_P7 VDD VREFN VREFP VSS) sar8j_r1_sw_b7
// BEGIN SARADC RNL
// @RNL(author="saradc topology") {
// (-16,60) @TEXT("Differential MOM CDAC",size=2,halign="start",textcolor="#223d52");
// #CMOMP0 @SET-SYMBOL $CAPACITOR;
// #CMOMP0 @PLACE(0,29) => @ORIENT("R0");
// #CMOMP0 @TEXT("CMOMP0",key="name",size=1.3,halign="start") => @PLACE(3,32);
// #CMOMP0 @TEXT("nr=8 lr=2u w=50n multi=1",key="value",size=0.9,halign="start") => @PLACE(3,25);
// #CMOMP0 @TEXT("",key="model");
// %sar_junction1 = (0,41);
// %sar_junction1 @CIRCLE(radius=0.34,linecolor="#30485d",fill="fillcolor",fillcolor="#30485d") => @LAYER("top");
// &"TOPP" @WIRE(mode="straight",linecolor="#226e85",linewidth=0.16) {%sar_junction1 #CMOMP0:1};
// #XSP0 @SET-SYMBOL $S_sar8j_r1_sw_b0;
// #XSP0 @PLACE(0,7) => @ORIENT("R0");
// &"BP0" @WIRE(mode="straight",linecolor="#226e85",linewidth=0.16) {#CMOMP0:2 #XSP0:1};
// #CMOMP0 @TEXT("B0",key="name",size=1.48,halign="start");
// #CMOMP0 @TEXT("1 unit",key="value",size=1.16,halign="start");
// #CMOMP1 @SET-SYMBOL $CAPACITOR;
// #CMOMP1 @PLACE(32,29) => @ORIENT("R0");
// #CMOMP1 @TEXT("CMOMP1",key="name",size=1.3,halign="start") => @PLACE(35,32);
// #CMOMP1 @TEXT("nr=8 lr=2u w=50n multi=2",key="value",size=0.9,halign="start") => @PLACE(35,25);
// #CMOMP1 @TEXT("",key="model");
// %sar_junction2 = (32,41);
// %sar_junction2 @CIRCLE(radius=0.34,linecolor="#30485d",fill="fillcolor",fillcolor="#30485d") => @LAYER("top");
// &"TOPP" @WIRE(mode="straight",linecolor="#226e85",linewidth=0.16) {%sar_junction2 #CMOMP1:1};
// #XSP1 @SET-SYMBOL $S_sar8j_r1_sw_b1;
// #XSP1 @PLACE(32,7) => @ORIENT("R0");
// &"BP1" @WIRE(mode="straight",linecolor="#226e85",linewidth=0.16) {#CMOMP1:2 #XSP1:1};
// #CMOMP1 @TEXT("B1",key="name",size=1.48,halign="start");
// #CMOMP1 @TEXT("2 units",key="value",size=1.16,halign="start");
// #CMOMP2 @SET-SYMBOL $CAPACITOR;
// #CMOMP2 @PLACE(64,29) => @ORIENT("R0");
// #CMOMP2 @TEXT("CMOMP2",key="name",size=1.3,halign="start") => @PLACE(67,32);
// #CMOMP2 @TEXT("nr=8 lr=2u w=50n multi=4",key="value",size=0.9,halign="start") => @PLACE(67,25);
// #CMOMP2 @TEXT("",key="model");
// %sar_junction3 = (64,41);
// %sar_junction3 @CIRCLE(radius=0.34,linecolor="#30485d",fill="fillcolor",fillcolor="#30485d") => @LAYER("top");
// &"TOPP" @WIRE(mode="straight",linecolor="#226e85",linewidth=0.16) {%sar_junction3 #CMOMP2:1};
// #XSP2 @SET-SYMBOL $S_sar8j_r1_sw_b2;
// #XSP2 @PLACE(64,7) => @ORIENT("R0");
// &"BP2" @WIRE(mode="straight",linecolor="#226e85",linewidth=0.16) {#CMOMP2:2 #XSP2:1};
// #CMOMP2 @TEXT("B2",key="name",size=1.48,halign="start");
// #CMOMP2 @TEXT("4 units",key="value",size=1.16,halign="start");
// #CMOMP3 @SET-SYMBOL $CAPACITOR;
// #CMOMP3 @PLACE(96,29) => @ORIENT("R0");
// #CMOMP3 @TEXT("CMOMP3",key="name",size=1.3,halign="start") => @PLACE(99,32);
// #CMOMP3 @TEXT("nr=8 lr=2u w=50n multi=8",key="value",size=0.9,halign="start") => @PLACE(99,25);
// #CMOMP3 @TEXT("",key="model");
// %sar_junction4 = (96,41);
// %sar_junction4 @CIRCLE(radius=0.34,linecolor="#30485d",fill="fillcolor",fillcolor="#30485d") => @LAYER("top");
// &"TOPP" @WIRE(mode="straight",linecolor="#226e85",linewidth=0.16) {%sar_junction4 #CMOMP3:1};
// #XSP3 @SET-SYMBOL $S_sar8j_r1_sw_b3;
// #XSP3 @PLACE(96,7) => @ORIENT("R0");
// &"BP3" @WIRE(mode="straight",linecolor="#226e85",linewidth=0.16) {#CMOMP3:2 #XSP3:1};
// #CMOMP3 @TEXT("B3",key="name",size=1.48,halign="start");
// #CMOMP3 @TEXT("8 units",key="value",size=1.16,halign="start");
// #CMOMP4 @SET-SYMBOL $CAPACITOR;
// #CMOMP4 @PLACE(128,29) => @ORIENT("R0");
// #CMOMP4 @TEXT("CMOMP4",key="name",size=1.3,halign="start") => @PLACE(131,32);
// #CMOMP4 @TEXT("nr=8 lr=2u w=50n multi=16",key="value",size=0.9,halign="start") => @PLACE(131,25);
// #CMOMP4 @TEXT("",key="model");
// %sar_junction5 = (128,41);
// %sar_junction5 @CIRCLE(radius=0.34,linecolor="#30485d",fill="fillcolor",fillcolor="#30485d") => @LAYER("top");
// &"TOPP" @WIRE(mode="straight",linecolor="#226e85",linewidth=0.16) {%sar_junction5 #CMOMP4:1};
// #XSP4 @SET-SYMBOL $S_sar8j_r1_sw_b4;
// #XSP4 @PLACE(128,7) => @ORIENT("R0");
// &"BP4" @WIRE(mode="straight",linecolor="#226e85",linewidth=0.16) {#CMOMP4:2 #XSP4:1};
// #CMOMP4 @TEXT("B4",key="name",size=1.48,halign="start");
// #CMOMP4 @TEXT("16 units",key="value",size=1.16,halign="start");
// #CMOMP5 @SET-SYMBOL $CAPACITOR;
// #CMOMP5 @PLACE(160,29) => @ORIENT("R0");
// #CMOMP5 @TEXT("CMOMP5",key="name",size=1.3,halign="start") => @PLACE(163,32);
// #CMOMP5 @TEXT("nr=8 lr=2u w=50n multi=32",key="value",size=0.9,halign="start") => @PLACE(163,25);
// #CMOMP5 @TEXT("",key="model");
// %sar_junction6 = (160,41);
// %sar_junction6 @CIRCLE(radius=0.34,linecolor="#30485d",fill="fillcolor",fillcolor="#30485d") => @LAYER("top");
// &"TOPP" @WIRE(mode="straight",linecolor="#226e85",linewidth=0.16) {%sar_junction6 #CMOMP5:1};
// #XSP5 @SET-SYMBOL $S_sar8j_r1_sw_b5;
// #XSP5 @PLACE(160,7) => @ORIENT("R0");
// &"BP5" @WIRE(mode="straight",linecolor="#226e85",linewidth=0.16) {#CMOMP5:2 #XSP5:1};
// #CMOMP5 @TEXT("B5",key="name",size=1.48,halign="start");
// #CMOMP5 @TEXT("32 units",key="value",size=1.16,halign="start");
// #CMOMP6 @SET-SYMBOL $CAPACITOR;
// #CMOMP6 @PLACE(192,29) => @ORIENT("R0");
// #CMOMP6 @TEXT("CMOMP6",key="name",size=1.3,halign="start") => @PLACE(195,32);
// #CMOMP6 @TEXT("nr=8 lr=2u w=50n multi=64",key="value",size=0.9,halign="start") => @PLACE(195,25);
// #CMOMP6 @TEXT("",key="model");
// %sar_junction7 = (192,41);
// %sar_junction7 @CIRCLE(radius=0.34,linecolor="#30485d",fill="fillcolor",fillcolor="#30485d") => @LAYER("top");
// &"TOPP" @WIRE(mode="straight",linecolor="#226e85",linewidth=0.16) {%sar_junction7 #CMOMP6:1};
// #XSP6 @SET-SYMBOL $S_sar8j_r1_sw_b6;
// #XSP6 @PLACE(192,7) => @ORIENT("R0");
// &"BP6" @WIRE(mode="straight",linecolor="#226e85",linewidth=0.16) {#CMOMP6:2 #XSP6:1};
// #CMOMP6 @TEXT("B6",key="name",size=1.48,halign="start");
// #CMOMP6 @TEXT("64 units",key="value",size=1.16,halign="start");
// #CMOMP7 @SET-SYMBOL $CAPACITOR;
// #CMOMP7 @PLACE(224,29) => @ORIENT("R0");
// #CMOMP7 @TEXT("CMOMP7",key="name",size=1.3,halign="start") => @PLACE(227,32);
// #CMOMP7 @TEXT("nr=8 lr=2u w=50n multi=128",key="value",size=0.9,halign="start") => @PLACE(227,25);
// #CMOMP7 @TEXT("",key="model");
// %sar_junction8 = (224,41);
// %sar_junction8 @CIRCLE(radius=0.34,linecolor="#30485d",fill="fillcolor",fillcolor="#30485d") => @LAYER("top");
// &"TOPP" @WIRE(mode="straight",linecolor="#226e85",linewidth=0.16) {%sar_junction8 #CMOMP7:1};
// #XSP7 @SET-SYMBOL $S_sar8j_r1_sw_b7;
// #XSP7 @PLACE(224,7) => @ORIENT("R0");
// &"BP7" @WIRE(mode="straight",linecolor="#226e85",linewidth=0.16) {#CMOMP7:2 #XSP7:1};
// #CMOMP7 @TEXT("B7",key="name",size=1.48,halign="start");
// #CMOMP7 @TEXT("128 units",key="value",size=1.16,halign="start");
// #CMOMP8 @SET-SYMBOL $CAPACITOR;
// #CMOMP8 @PLACE(256,29) => @ORIENT("R0");
// #CMOMP8 @TEXT("CMOMP8",key="name",size=1.3,halign="start") => @PLACE(259,32);
// #CMOMP8 @TEXT("nr=8 lr=2u w=50n multi=1",key="value",size=0.9,halign="start") => @PLACE(259,25);
// #CMOMP8 @TEXT("",key="model");
// %sar_junction9 = (256,41);
// %sar_junction9 @CIRCLE(radius=0.34,linecolor="#30485d",fill="fillcolor",fillcolor="#30485d") => @LAYER("top");
// &"TOPP" @WIRE(mode="straight",linecolor="#226e85",linewidth=0.16) {%sar_junction9 #CMOMP8:1};
// #CMOMP8 @TEXT("Dummy",key="name",size=1.48,halign="start");
// #CMOMP8 @TEXT("1 unit",key="value",size=1.16,halign="start");
// %sar_port10 = $IO_PORT @ATTACH &"TOPP" => @PLACE(-11,41) => @ORIENT("R0");
// &"TOPP" @WIRE(mode="straight",linecolor="#226e85",linewidth=0.16) {%sar_port10:p %sar_junction1 %sar_junction2 %sar_junction3 %sar_junction4 %sar_junction5 %sar_junction6 %sar_junction7 %sar_junction8 %sar_junction9};
// (-16,48) @TEXT("P bank / TOPP",size=1.35,halign="start",textcolor="#223d52");
// #CMOMN0 @SET-SYMBOL $CAPACITOR;
// #CMOMN0 @PLACE(0,-29) => @ORIENT("R0");
// #CMOMN0 @TEXT("CMOMN0",key="name",size=1.3,halign="start") => @PLACE(3,-26);
// #CMOMN0 @TEXT("nr=8 lr=2u w=50n multi=1",key="value",size=0.9,halign="start") => @PLACE(3,-33);
// #CMOMN0 @TEXT("",key="model");
// %sar_junction11 = (0,-17);
// %sar_junction11 @CIRCLE(radius=0.34,linecolor="#30485d",fill="fillcolor",fillcolor="#30485d") => @LAYER("top");
// &"TOPN" @WIRE(mode="straight",linecolor="#226e85",linewidth=0.16) {%sar_junction11 #CMOMN0:1};
// #XSN0 @SET-SYMBOL $S_sar8j_r1_sw_b0;
// #XSN0 @PLACE(0,-51) => @ORIENT("R0");
// &"BN0" @WIRE(mode="straight",linecolor="#226e85",linewidth=0.16) {#CMOMN0:2 #XSN0:1};
// #CMOMN0 @TEXT("B0",key="name",size=1.48,halign="start");
// #CMOMN0 @TEXT("1 unit",key="value",size=1.16,halign="start");
// #CMOMN1 @SET-SYMBOL $CAPACITOR;
// #CMOMN1 @PLACE(32,-29) => @ORIENT("R0");
// #CMOMN1 @TEXT("CMOMN1",key="name",size=1.3,halign="start") => @PLACE(35,-26);
// #CMOMN1 @TEXT("nr=8 lr=2u w=50n multi=2",key="value",size=0.9,halign="start") => @PLACE(35,-33);
// #CMOMN1 @TEXT("",key="model");
// %sar_junction12 = (32,-17);
// %sar_junction12 @CIRCLE(radius=0.34,linecolor="#30485d",fill="fillcolor",fillcolor="#30485d") => @LAYER("top");
// &"TOPN" @WIRE(mode="straight",linecolor="#226e85",linewidth=0.16) {%sar_junction12 #CMOMN1:1};
// #XSN1 @SET-SYMBOL $S_sar8j_r1_sw_b1;
// #XSN1 @PLACE(32,-51) => @ORIENT("R0");
// &"BN1" @WIRE(mode="straight",linecolor="#226e85",linewidth=0.16) {#CMOMN1:2 #XSN1:1};
// #CMOMN1 @TEXT("B1",key="name",size=1.48,halign="start");
// #CMOMN1 @TEXT("2 units",key="value",size=1.16,halign="start");
// #CMOMN2 @SET-SYMBOL $CAPACITOR;
// #CMOMN2 @PLACE(64,-29) => @ORIENT("R0");
// #CMOMN2 @TEXT("CMOMN2",key="name",size=1.3,halign="start") => @PLACE(67,-26);
// #CMOMN2 @TEXT("nr=8 lr=2u w=50n multi=4",key="value",size=0.9,halign="start") => @PLACE(67,-33);
// #CMOMN2 @TEXT("",key="model");
// %sar_junction13 = (64,-17);
// %sar_junction13 @CIRCLE(radius=0.34,linecolor="#30485d",fill="fillcolor",fillcolor="#30485d") => @LAYER("top");
// &"TOPN" @WIRE(mode="straight",linecolor="#226e85",linewidth=0.16) {%sar_junction13 #CMOMN2:1};
// #XSN2 @SET-SYMBOL $S_sar8j_r1_sw_b2;
// #XSN2 @PLACE(64,-51) => @ORIENT("R0");
// &"BN2" @WIRE(mode="straight",linecolor="#226e85",linewidth=0.16) {#CMOMN2:2 #XSN2:1};
// #CMOMN2 @TEXT("B2",key="name",size=1.48,halign="start");
// #CMOMN2 @TEXT("4 units",key="value",size=1.16,halign="start");
// #CMOMN3 @SET-SYMBOL $CAPACITOR;
// #CMOMN3 @PLACE(96,-29) => @ORIENT("R0");
// #CMOMN3 @TEXT("CMOMN3",key="name",size=1.3,halign="start") => @PLACE(99,-26);
// #CMOMN3 @TEXT("nr=8 lr=2u w=50n multi=8",key="value",size=0.9,halign="start") => @PLACE(99,-33);
// #CMOMN3 @TEXT("",key="model");
// %sar_junction14 = (96,-17);
// %sar_junction14 @CIRCLE(radius=0.34,linecolor="#30485d",fill="fillcolor",fillcolor="#30485d") => @LAYER("top");
// &"TOPN" @WIRE(mode="straight",linecolor="#226e85",linewidth=0.16) {%sar_junction14 #CMOMN3:1};
// #XSN3 @SET-SYMBOL $S_sar8j_r1_sw_b3;
// #XSN3 @PLACE(96,-51) => @ORIENT("R0");
// &"BN3" @WIRE(mode="straight",linecolor="#226e85",linewidth=0.16) {#CMOMN3:2 #XSN3:1};
// #CMOMN3 @TEXT("B3",key="name",size=1.48,halign="start");
// #CMOMN3 @TEXT("8 units",key="value",size=1.16,halign="start");
// #CMOMN4 @SET-SYMBOL $CAPACITOR;
// #CMOMN4 @PLACE(128,-29) => @ORIENT("R0");
// #CMOMN4 @TEXT("CMOMN4",key="name",size=1.3,halign="start") => @PLACE(131,-26);
// #CMOMN4 @TEXT("nr=8 lr=2u w=50n multi=16",key="value",size=0.9,halign="start") => @PLACE(131,-33);
// #CMOMN4 @TEXT("",key="model");
// %sar_junction15 = (128,-17);
// %sar_junction15 @CIRCLE(radius=0.34,linecolor="#30485d",fill="fillcolor",fillcolor="#30485d") => @LAYER("top");
// &"TOPN" @WIRE(mode="straight",linecolor="#226e85",linewidth=0.16) {%sar_junction15 #CMOMN4:1};
// #XSN4 @SET-SYMBOL $S_sar8j_r1_sw_b4;
// #XSN4 @PLACE(128,-51) => @ORIENT("R0");
// &"BN4" @WIRE(mode="straight",linecolor="#226e85",linewidth=0.16) {#CMOMN4:2 #XSN4:1};
// #CMOMN4 @TEXT("B4",key="name",size=1.48,halign="start");
// #CMOMN4 @TEXT("16 units",key="value",size=1.16,halign="start");
// #CMOMN5 @SET-SYMBOL $CAPACITOR;
// #CMOMN5 @PLACE(160,-29) => @ORIENT("R0");
// #CMOMN5 @TEXT("CMOMN5",key="name",size=1.3,halign="start") => @PLACE(163,-26);
// #CMOMN5 @TEXT("nr=8 lr=2u w=50n multi=32",key="value",size=0.9,halign="start") => @PLACE(163,-33);
// #CMOMN5 @TEXT("",key="model");
// %sar_junction16 = (160,-17);
// %sar_junction16 @CIRCLE(radius=0.34,linecolor="#30485d",fill="fillcolor",fillcolor="#30485d") => @LAYER("top");
// &"TOPN" @WIRE(mode="straight",linecolor="#226e85",linewidth=0.16) {%sar_junction16 #CMOMN5:1};
// #XSN5 @SET-SYMBOL $S_sar8j_r1_sw_b5;
// #XSN5 @PLACE(160,-51) => @ORIENT("R0");
// &"BN5" @WIRE(mode="straight",linecolor="#226e85",linewidth=0.16) {#CMOMN5:2 #XSN5:1};
// #CMOMN5 @TEXT("B5",key="name",size=1.48,halign="start");
// #CMOMN5 @TEXT("32 units",key="value",size=1.16,halign="start");
// #CMOMN6 @SET-SYMBOL $CAPACITOR;
// #CMOMN6 @PLACE(192,-29) => @ORIENT("R0");
// #CMOMN6 @TEXT("CMOMN6",key="name",size=1.3,halign="start") => @PLACE(195,-26);
// #CMOMN6 @TEXT("nr=8 lr=2u w=50n multi=64",key="value",size=0.9,halign="start") => @PLACE(195,-33);
// #CMOMN6 @TEXT("",key="model");
// %sar_junction17 = (192,-17);
// %sar_junction17 @CIRCLE(radius=0.34,linecolor="#30485d",fill="fillcolor",fillcolor="#30485d") => @LAYER("top");
// &"TOPN" @WIRE(mode="straight",linecolor="#226e85",linewidth=0.16) {%sar_junction17 #CMOMN6:1};
// #XSN6 @SET-SYMBOL $S_sar8j_r1_sw_b6;
// #XSN6 @PLACE(192,-51) => @ORIENT("R0");
// &"BN6" @WIRE(mode="straight",linecolor="#226e85",linewidth=0.16) {#CMOMN6:2 #XSN6:1};
// #CMOMN6 @TEXT("B6",key="name",size=1.48,halign="start");
// #CMOMN6 @TEXT("64 units",key="value",size=1.16,halign="start");
// #CMOMN7 @SET-SYMBOL $CAPACITOR;
// #CMOMN7 @PLACE(224,-29) => @ORIENT("R0");
// #CMOMN7 @TEXT("CMOMN7",key="name",size=1.3,halign="start") => @PLACE(227,-26);
// #CMOMN7 @TEXT("nr=8 lr=2u w=50n multi=128",key="value",size=0.9,halign="start") => @PLACE(227,-33);
// #CMOMN7 @TEXT("",key="model");
// %sar_junction18 = (224,-17);
// %sar_junction18 @CIRCLE(radius=0.34,linecolor="#30485d",fill="fillcolor",fillcolor="#30485d") => @LAYER("top");
// &"TOPN" @WIRE(mode="straight",linecolor="#226e85",linewidth=0.16) {%sar_junction18 #CMOMN7:1};
// #XSN7 @SET-SYMBOL $S_sar8j_r1_sw_b7;
// #XSN7 @PLACE(224,-51) => @ORIENT("R0");
// &"BN7" @WIRE(mode="straight",linecolor="#226e85",linewidth=0.16) {#CMOMN7:2 #XSN7:1};
// #CMOMN7 @TEXT("B7",key="name",size=1.48,halign="start");
// #CMOMN7 @TEXT("128 units",key="value",size=1.16,halign="start");
// #CMOMN8 @SET-SYMBOL $CAPACITOR;
// #CMOMN8 @PLACE(256,-29) => @ORIENT("R0");
// #CMOMN8 @TEXT("CMOMN8",key="name",size=1.3,halign="start") => @PLACE(259,-26);
// #CMOMN8 @TEXT("nr=8 lr=2u w=50n multi=1",key="value",size=0.9,halign="start") => @PLACE(259,-33);
// #CMOMN8 @TEXT("",key="model");
// %sar_junction19 = (256,-17);
// %sar_junction19 @CIRCLE(radius=0.34,linecolor="#30485d",fill="fillcolor",fillcolor="#30485d") => @LAYER("top");
// &"TOPN" @WIRE(mode="straight",linecolor="#226e85",linewidth=0.16) {%sar_junction19 #CMOMN8:1};
// #CMOMN8 @TEXT("Dummy",key="name",size=1.48,halign="start");
// #CMOMN8 @TEXT("1 unit",key="value",size=1.16,halign="start");
// %sar_port20 = $IO_PORT @ATTACH &"TOPN" => @PLACE(-11,-17) => @ORIENT("R0");
// &"TOPN" @WIRE(mode="straight",linecolor="#226e85",linewidth=0.16) {%sar_port20:p %sar_junction11 %sar_junction12 %sar_junction13 %sar_junction14 %sar_junction15 %sar_junction16 %sar_junction17 %sar_junction18 %sar_junction19};
// (-16,-10) @TEXT("N bank / TOPN",size=1.35,halign="start",textcolor="#223d52");
// &"VREFN" @WIRE(mode="straight",linecolor="#30485d",linewidth=0.16) {#CMOMN8:2 (256,-34)};
// (256,-34.4) @TEXT("VREFN",size=1.1,halign="middle",valign="top");
// &"VREFP" @WIRE(mode="straight",linecolor="#30485d",linewidth=0.16) {#CMOMP8:2 (256,24)};
// (256,23.6) @TEXT("VREFP",size=1.1,halign="middle",valign="top");
// &"REFSEL_N0" @WIRE(mode="straight",linecolor="#30485d",linewidth=0.16) {#XSN0:2 (-3,-66)};
// (-3,-66.4) @TEXT("REFSEL_N0",size=1.1,halign="middle",valign="top");
// &"VDD" @WIRE(mode="straight",linecolor="#30485d",linewidth=0.16) {#XSN0:3 (6,-36)};
// (6,-35.6) @TEXT("VDD",size=1.1,halign="middle",valign="bottom");
// &"VREFN" @WIRE(mode="straight",linecolor="#30485d",linewidth=0.16) {#XSN0:4 (-14,-55)};
// (-14.4,-55) @TEXT("VREFN",size=1.1,halign="end",valign="middle");
// &"VREFP" @WIRE(mode="straight",linecolor="#30485d",linewidth=0.16) {#XSN0:5 (-14,-47)};
// (-14.4,-47) @TEXT("VREFP",size=1.1,halign="end",valign="middle");
// &"VSS" @WIRE(mode="straight",linecolor="#30485d",linewidth=0.16) {#XSN0:6 (6,-66)};
// (6,-66.4) @TEXT("VSS",size=1.1,halign="middle",valign="top");
// &"REFSEL_P0" @WIRE(mode="straight",linecolor="#30485d",linewidth=0.16) {#XSP0:2 (-3,-8)};
// (-3,-8.4) @TEXT("REFSEL_P0",size=1.1,halign="middle",valign="top");
// &"VDD" @WIRE(mode="straight",linecolor="#30485d",linewidth=0.16) {#XSP0:3 (6,22)};
// (6,22.4) @TEXT("VDD",size=1.1,halign="middle",valign="bottom");
// &"VREFN" @WIRE(mode="straight",linecolor="#30485d",linewidth=0.16) {#XSP0:4 (-14,3)};
// (-14.4,3) @TEXT("VREFN",size=1.1,halign="end",valign="middle");
// &"VREFP" @WIRE(mode="straight",linecolor="#30485d",linewidth=0.16) {#XSP0:5 (-14,11)};
// (-14.4,11) @TEXT("VREFP",size=1.1,halign="end",valign="middle");
// &"VSS" @WIRE(mode="straight",linecolor="#30485d",linewidth=0.16) {#XSP0:6 (6,-8)};
// (6,-8.4) @TEXT("VSS",size=1.1,halign="middle",valign="top");
// &"REFSEL_N1" @WIRE(mode="straight",linecolor="#30485d",linewidth=0.16) {#XSN1:2 (29,-66)};
// (29,-66.4) @TEXT("REFSEL_N1",size=1.1,halign="middle",valign="top");
// &"VDD" @WIRE(mode="straight",linecolor="#30485d",linewidth=0.16) {#XSN1:3 (38,-36)};
// (38,-35.6) @TEXT("VDD",size=1.1,halign="middle",valign="bottom");
// &"VREFN" @WIRE(mode="straight",linecolor="#30485d",linewidth=0.16) {#XSN1:4 (18,-55)};
// (17.6,-55) @TEXT("VREFN",size=1.1,halign="end",valign="middle");
// &"VREFP" @WIRE(mode="straight",linecolor="#30485d",linewidth=0.16) {#XSN1:5 (18,-47)};
// (17.6,-47) @TEXT("VREFP",size=1.1,halign="end",valign="middle");
// &"VSS" @WIRE(mode="straight",linecolor="#30485d",linewidth=0.16) {#XSN1:6 (38,-66)};
// (38,-66.4) @TEXT("VSS",size=1.1,halign="middle",valign="top");
// &"REFSEL_P1" @WIRE(mode="straight",linecolor="#30485d",linewidth=0.16) {#XSP1:2 (29,-8)};
// (29,-8.4) @TEXT("REFSEL_P1",size=1.1,halign="middle",valign="top");
// &"VDD" @WIRE(mode="straight",linecolor="#30485d",linewidth=0.16) {#XSP1:3 (38,22)};
// (38,22.4) @TEXT("VDD",size=1.1,halign="middle",valign="bottom");
// &"VREFN" @WIRE(mode="straight",linecolor="#30485d",linewidth=0.16) {#XSP1:4 (18,3)};
// (17.6,3) @TEXT("VREFN",size=1.1,halign="end",valign="middle");
// &"VREFP" @WIRE(mode="straight",linecolor="#30485d",linewidth=0.16) {#XSP1:5 (18,11)};
// (17.6,11) @TEXT("VREFP",size=1.1,halign="end",valign="middle");
// &"VSS" @WIRE(mode="straight",linecolor="#30485d",linewidth=0.16) {#XSP1:6 (38,-8)};
// (38,-8.4) @TEXT("VSS",size=1.1,halign="middle",valign="top");
// &"REFSEL_N2" @WIRE(mode="straight",linecolor="#30485d",linewidth=0.16) {#XSN2:2 (61,-66)};
// (61,-66.4) @TEXT("REFSEL_N2",size=1.1,halign="middle",valign="top");
// &"VDD" @WIRE(mode="straight",linecolor="#30485d",linewidth=0.16) {#XSN2:3 (70,-36)};
// (70,-35.6) @TEXT("VDD",size=1.1,halign="middle",valign="bottom");
// &"VREFN" @WIRE(mode="straight",linecolor="#30485d",linewidth=0.16) {#XSN2:4 (50,-55)};
// (49.6,-55) @TEXT("VREFN",size=1.1,halign="end",valign="middle");
// &"VREFP" @WIRE(mode="straight",linecolor="#30485d",linewidth=0.16) {#XSN2:5 (50,-47)};
// (49.6,-47) @TEXT("VREFP",size=1.1,halign="end",valign="middle");
// &"VSS" @WIRE(mode="straight",linecolor="#30485d",linewidth=0.16) {#XSN2:6 (70,-66)};
// (70,-66.4) @TEXT("VSS",size=1.1,halign="middle",valign="top");
// &"REFSEL_P2" @WIRE(mode="straight",linecolor="#30485d",linewidth=0.16) {#XSP2:2 (61,-8)};
// (61,-8.4) @TEXT("REFSEL_P2",size=1.1,halign="middle",valign="top");
// &"VDD" @WIRE(mode="straight",linecolor="#30485d",linewidth=0.16) {#XSP2:3 (70,22)};
// (70,22.4) @TEXT("VDD",size=1.1,halign="middle",valign="bottom");
// &"VREFN" @WIRE(mode="straight",linecolor="#30485d",linewidth=0.16) {#XSP2:4 (50,3)};
// (49.6,3) @TEXT("VREFN",size=1.1,halign="end",valign="middle");
// &"VREFP" @WIRE(mode="straight",linecolor="#30485d",linewidth=0.16) {#XSP2:5 (50,11)};
// (49.6,11) @TEXT("VREFP",size=1.1,halign="end",valign="middle");
// &"VSS" @WIRE(mode="straight",linecolor="#30485d",linewidth=0.16) {#XSP2:6 (70,-8)};
// (70,-8.4) @TEXT("VSS",size=1.1,halign="middle",valign="top");
// &"REFSEL_N3" @WIRE(mode="straight",linecolor="#30485d",linewidth=0.16) {#XSN3:2 (93,-66)};
// (93,-66.4) @TEXT("REFSEL_N3",size=1.1,halign="middle",valign="top");
// &"VDD" @WIRE(mode="straight",linecolor="#30485d",linewidth=0.16) {#XSN3:3 (102,-36)};
// (102,-35.6) @TEXT("VDD",size=1.1,halign="middle",valign="bottom");
// &"VREFN" @WIRE(mode="straight",linecolor="#30485d",linewidth=0.16) {#XSN3:4 (82,-55)};
// (81.6,-55) @TEXT("VREFN",size=1.1,halign="end",valign="middle");
// &"VREFP" @WIRE(mode="straight",linecolor="#30485d",linewidth=0.16) {#XSN3:5 (82,-47)};
// (81.6,-47) @TEXT("VREFP",size=1.1,halign="end",valign="middle");
// &"VSS" @WIRE(mode="straight",linecolor="#30485d",linewidth=0.16) {#XSN3:6 (102,-66)};
// (102,-66.4) @TEXT("VSS",size=1.1,halign="middle",valign="top");
// &"REFSEL_P3" @WIRE(mode="straight",linecolor="#30485d",linewidth=0.16) {#XSP3:2 (93,-8)};
// (93,-8.4) @TEXT("REFSEL_P3",size=1.1,halign="middle",valign="top");
// &"VDD" @WIRE(mode="straight",linecolor="#30485d",linewidth=0.16) {#XSP3:3 (102,22)};
// (102,22.4) @TEXT("VDD",size=1.1,halign="middle",valign="bottom");
// &"VREFN" @WIRE(mode="straight",linecolor="#30485d",linewidth=0.16) {#XSP3:4 (82,3)};
// (81.6,3) @TEXT("VREFN",size=1.1,halign="end",valign="middle");
// &"VREFP" @WIRE(mode="straight",linecolor="#30485d",linewidth=0.16) {#XSP3:5 (82,11)};
// (81.6,11) @TEXT("VREFP",size=1.1,halign="end",valign="middle");
// &"VSS" @WIRE(mode="straight",linecolor="#30485d",linewidth=0.16) {#XSP3:6 (102,-8)};
// (102,-8.4) @TEXT("VSS",size=1.1,halign="middle",valign="top");
// &"REFSEL_N4" @WIRE(mode="straight",linecolor="#30485d",linewidth=0.16) {#XSN4:2 (125,-66)};
// (125,-66.4) @TEXT("REFSEL_N4",size=1.1,halign="middle",valign="top");
// &"VDD" @WIRE(mode="straight",linecolor="#30485d",linewidth=0.16) {#XSN4:3 (134,-36)};
// (134,-35.6) @TEXT("VDD",size=1.1,halign="middle",valign="bottom");
// &"VREFN" @WIRE(mode="straight",linecolor="#30485d",linewidth=0.16) {#XSN4:4 (114,-55)};
// (113.6,-55) @TEXT("VREFN",size=1.1,halign="end",valign="middle");
// &"VREFP" @WIRE(mode="straight",linecolor="#30485d",linewidth=0.16) {#XSN4:5 (114,-47)};
// (113.6,-47) @TEXT("VREFP",size=1.1,halign="end",valign="middle");
// &"VSS" @WIRE(mode="straight",linecolor="#30485d",linewidth=0.16) {#XSN4:6 (134,-66)};
// (134,-66.4) @TEXT("VSS",size=1.1,halign="middle",valign="top");
// &"REFSEL_P4" @WIRE(mode="straight",linecolor="#30485d",linewidth=0.16) {#XSP4:2 (125,-8)};
// (125,-8.4) @TEXT("REFSEL_P4",size=1.1,halign="middle",valign="top");
// &"VDD" @WIRE(mode="straight",linecolor="#30485d",linewidth=0.16) {#XSP4:3 (134,22)};
// (134,22.4) @TEXT("VDD",size=1.1,halign="middle",valign="bottom");
// &"VREFN" @WIRE(mode="straight",linecolor="#30485d",linewidth=0.16) {#XSP4:4 (114,3)};
// (113.6,3) @TEXT("VREFN",size=1.1,halign="end",valign="middle");
// &"VREFP" @WIRE(mode="straight",linecolor="#30485d",linewidth=0.16) {#XSP4:5 (114,11)};
// (113.6,11) @TEXT("VREFP",size=1.1,halign="end",valign="middle");
// &"VSS" @WIRE(mode="straight",linecolor="#30485d",linewidth=0.16) {#XSP4:6 (134,-8)};
// (134,-8.4) @TEXT("VSS",size=1.1,halign="middle",valign="top");
// &"REFSEL_N5" @WIRE(mode="straight",linecolor="#30485d",linewidth=0.16) {#XSN5:2 (157,-66)};
// (157,-66.4) @TEXT("REFSEL_N5",size=1.1,halign="middle",valign="top");
// &"VDD" @WIRE(mode="straight",linecolor="#30485d",linewidth=0.16) {#XSN5:3 (166,-36)};
// (166,-35.6) @TEXT("VDD",size=1.1,halign="middle",valign="bottom");
// &"VREFN" @WIRE(mode="straight",linecolor="#30485d",linewidth=0.16) {#XSN5:4 (146,-55)};
// (145.6,-55) @TEXT("VREFN",size=1.1,halign="end",valign="middle");
// &"VREFP" @WIRE(mode="straight",linecolor="#30485d",linewidth=0.16) {#XSN5:5 (146,-47)};
// (145.6,-47) @TEXT("VREFP",size=1.1,halign="end",valign="middle");
// &"VSS" @WIRE(mode="straight",linecolor="#30485d",linewidth=0.16) {#XSN5:6 (166,-66)};
// (166,-66.4) @TEXT("VSS",size=1.1,halign="middle",valign="top");
// &"REFSEL_P5" @WIRE(mode="straight",linecolor="#30485d",linewidth=0.16) {#XSP5:2 (157,-8)};
// (157,-8.4) @TEXT("REFSEL_P5",size=1.1,halign="middle",valign="top");
// &"VDD" @WIRE(mode="straight",linecolor="#30485d",linewidth=0.16) {#XSP5:3 (166,22)};
// (166,22.4) @TEXT("VDD",size=1.1,halign="middle",valign="bottom");
// &"VREFN" @WIRE(mode="straight",linecolor="#30485d",linewidth=0.16) {#XSP5:4 (146,3)};
// (145.6,3) @TEXT("VREFN",size=1.1,halign="end",valign="middle");
// &"VREFP" @WIRE(mode="straight",linecolor="#30485d",linewidth=0.16) {#XSP5:5 (146,11)};
// (145.6,11) @TEXT("VREFP",size=1.1,halign="end",valign="middle");
// &"VSS" @WIRE(mode="straight",linecolor="#30485d",linewidth=0.16) {#XSP5:6 (166,-8)};
// (166,-8.4) @TEXT("VSS",size=1.1,halign="middle",valign="top");
// &"REFSEL_N6" @WIRE(mode="straight",linecolor="#30485d",linewidth=0.16) {#XSN6:2 (189,-66)};
// (189,-66.4) @TEXT("REFSEL_N6",size=1.1,halign="middle",valign="top");
// &"VDD" @WIRE(mode="straight",linecolor="#30485d",linewidth=0.16) {#XSN6:3 (198,-36)};
// (198,-35.6) @TEXT("VDD",size=1.1,halign="middle",valign="bottom");
// &"VREFN" @WIRE(mode="straight",linecolor="#30485d",linewidth=0.16) {#XSN6:4 (178,-55)};
// (177.6,-55) @TEXT("VREFN",size=1.1,halign="end",valign="middle");
// &"VREFP" @WIRE(mode="straight",linecolor="#30485d",linewidth=0.16) {#XSN6:5 (178,-47)};
// (177.6,-47) @TEXT("VREFP",size=1.1,halign="end",valign="middle");
// &"VSS" @WIRE(mode="straight",linecolor="#30485d",linewidth=0.16) {#XSN6:6 (198,-66)};
// (198,-66.4) @TEXT("VSS",size=1.1,halign="middle",valign="top");
// &"REFSEL_P6" @WIRE(mode="straight",linecolor="#30485d",linewidth=0.16) {#XSP6:2 (189,-8)};
// (189,-8.4) @TEXT("REFSEL_P6",size=1.1,halign="middle",valign="top");
// &"VDD" @WIRE(mode="straight",linecolor="#30485d",linewidth=0.16) {#XSP6:3 (198,22)};
// (198,22.4) @TEXT("VDD",size=1.1,halign="middle",valign="bottom");
// &"VREFN" @WIRE(mode="straight",linecolor="#30485d",linewidth=0.16) {#XSP6:4 (178,3)};
// (177.6,3) @TEXT("VREFN",size=1.1,halign="end",valign="middle");
// &"VREFP" @WIRE(mode="straight",linecolor="#30485d",linewidth=0.16) {#XSP6:5 (178,11)};
// (177.6,11) @TEXT("VREFP",size=1.1,halign="end",valign="middle");
// &"VSS" @WIRE(mode="straight",linecolor="#30485d",linewidth=0.16) {#XSP6:6 (198,-8)};
// (198,-8.4) @TEXT("VSS",size=1.1,halign="middle",valign="top");
// &"REFSEL_N7" @WIRE(mode="straight",linecolor="#30485d",linewidth=0.16) {#XSN7:2 (221,-66)};
// (221,-66.4) @TEXT("REFSEL_N7",size=1.1,halign="middle",valign="top");
// &"VDD" @WIRE(mode="straight",linecolor="#30485d",linewidth=0.16) {#XSN7:3 (230,-36)};
// (230,-35.6) @TEXT("VDD",size=1.1,halign="middle",valign="bottom");
// &"VREFN" @WIRE(mode="straight",linecolor="#30485d",linewidth=0.16) {#XSN7:4 (210,-55)};
// (209.6,-55) @TEXT("VREFN",size=1.1,halign="end",valign="middle");
// &"VREFP" @WIRE(mode="straight",linecolor="#30485d",linewidth=0.16) {#XSN7:5 (210,-47)};
// (209.6,-47) @TEXT("VREFP",size=1.1,halign="end",valign="middle");
// &"VSS" @WIRE(mode="straight",linecolor="#30485d",linewidth=0.16) {#XSN7:6 (230,-66)};
// (230,-66.4) @TEXT("VSS",size=1.1,halign="middle",valign="top");
// &"REFSEL_P7" @WIRE(mode="straight",linecolor="#30485d",linewidth=0.16) {#XSP7:2 (221,-8)};
// (221,-8.4) @TEXT("REFSEL_P7",size=1.1,halign="middle",valign="top");
// &"VDD" @WIRE(mode="straight",linecolor="#30485d",linewidth=0.16) {#XSP7:3 (230,22)};
// (230,22.4) @TEXT("VDD",size=1.1,halign="middle",valign="bottom");
// &"VREFN" @WIRE(mode="straight",linecolor="#30485d",linewidth=0.16) {#XSP7:4 (210,3)};
// (209.6,3) @TEXT("VREFN",size=1.1,halign="end",valign="middle");
// &"VREFP" @WIRE(mode="straight",linecolor="#30485d",linewidth=0.16) {#XSP7:5 (210,11)};
// (209.6,11) @TEXT("VREFP",size=1.1,halign="end",valign="middle");
// &"VSS" @WIRE(mode="straight",linecolor="#30485d",linewidth=0.16) {#XSP7:6 (230,-8)};
// (230,-8.4) @TEXT("VSS",size=1.1,halign="middle",valign="top");
// }
// END SARADC RNL
ends sar8j_r1_cdac

subckt sar_strongarm_t28 CLK OUTN OUTP VDD VINN VINP VSS
    MNLATN (OUTN OUTP Y VSS) nch_mac l=30n w=500n multi=1 nf=1 sd=100n          ad=3.75e-14 as=3.75e-14 pd=1.15u ps=1.15u nrd=0.662935          nrs=0.662935 sa=75.0n sb=75.0n sa1=75.0n sa2=75.0n sa3=75.0n          sa4=75.0n sb1=75.0n sb2=75.0n sb3=75.0n spa=100n spa1=100n          spa2=100n spa3=100n sap=91.9776n sapb=114.444n spba=115.715n          spba1=117.043n dfm_flag=0 spmt=1.11111e+15 spomt=0          spomt1=1.11111e+60 spmb=1.11111e+15 spomb=0 spomb1=1.11111e+60
    MNLATP (OUTP OUTN X VSS) nch_mac l=30n w=500n multi=1 nf=1 sd=100n          ad=3.75e-14 as=3.75e-14 pd=1.15u ps=1.15u nrd=0.662935          nrs=0.662935 sa=75.0n sb=75.0n sa1=75.0n sa2=75.0n sa3=75.0n          sa4=75.0n sb1=75.0n sb2=75.0n sb3=75.0n spa=100n spa1=100n          spa2=100n spa3=100n sap=91.9776n sapb=114.444n spba=115.715n          spba1=117.043n dfm_flag=0 spmt=1.11111e+15 spomt=0          spomt1=1.11111e+60 spmb=1.11111e+15 spomb=0 spomb1=1.11111e+60
    MNINN (X VINN TAIL VSS) nch_mac l=30n w=1u multi=1 nf=1 sd=100n          ad=7.5e-14 as=7.5e-14 pd=2.15u ps=2.15u nrd=0.289519 nrs=0.289519          sa=75.0n sb=75.0n sa1=75.0n sa2=75.0n sa3=75.0n sa4=75.0n          sb1=75.0n sb2=75.0n sb3=75.0n spa=100n spa1=100n spa2=100n          spa3=100n sap=91.9776n sapb=114.444n spba=115.715n spba1=117.043n          dfm_flag=0 spmt=1.11111e+15 spomt=0 spomt1=1.11111e+60          spmb=1.11111e+15 spomb=0 spomb1=1.11111e+60
    MNINP (Y VINP TAIL VSS) nch_mac l=30n w=1u multi=1 nf=1 sd=100n          ad=7.5e-14 as=7.5e-14 pd=2.15u ps=2.15u nrd=0.289519 nrs=0.289519          sa=75.0n sb=75.0n sa1=75.0n sa2=75.0n sa3=75.0n sa4=75.0n          sb1=75.0n sb2=75.0n sb3=75.0n spa=100n spa1=100n spa2=100n          spa3=100n sap=91.9776n sapb=114.444n spba=115.715n spba1=117.043n          dfm_flag=0 spmt=1.11111e+15 spomt=0 spomt1=1.11111e+60          spmb=1.11111e+15 spomb=0 spomb1=1.11111e+60
    MNTAIL (TAIL CLK VSS VSS) nch_mac l=30n w=1u multi=1 nf=1 sd=100n          ad=7.5e-14 as=7.5e-14 pd=2.15u ps=2.15u nrd=0.289519 nrs=0.289519          sa=75.0n sb=75.0n sa1=75.0n sa2=75.0n sa3=75.0n sa4=75.0n          sb1=75.0n sb2=75.0n sb3=75.0n spa=100n spa1=100n spa2=100n          spa3=100n sap=91.9776n sapb=114.444n spba=115.715n spba1=117.043n          dfm_flag=0 spmt=1.11111e+15 spomt=0 spomt1=1.11111e+60          spmb=1.11111e+15 spomb=0 spomb1=1.11111e+60
    MPRSTN (OUTN CLK VDD VDD) pch_mac l=30n w=500n multi=1 nf=1 sd=100n          ad=3.75e-14 as=3.75e-14 pd=1.15u ps=1.15u nrd=0.383209          nrs=0.383209 sa=75.0n sb=75.0n sa1=75.0n sa2=75.0n sa3=75.0n          sa4=75.0n sb1=75.0n sb2=75.0n sb3=75.0n spa=100n spa1=100n          spa2=100n spa3=100n sap=91.9776n sapb=114.444n spba=115.715n          spba1=117.043n dfm_flag=0 spmt=1.11111e+15 spomt=0          spomt1=1.11111e+60 spmb=1.11111e+15 spomb=0 spomb1=1.11111e+60
    MPRSTP (OUTP CLK VDD VDD) pch_mac l=30n w=500n multi=1 nf=1 sd=100n          ad=3.75e-14 as=3.75e-14 pd=1.15u ps=1.15u nrd=0.383209          nrs=0.383209 sa=75.0n sb=75.0n sa1=75.0n sa2=75.0n sa3=75.0n          sa4=75.0n sb1=75.0n sb2=75.0n sb3=75.0n spa=100n spa1=100n          spa2=100n spa3=100n sap=91.9776n sapb=114.444n spba=115.715n          spba1=117.043n dfm_flag=0 spmt=1.11111e+15 spomt=0          spomt1=1.11111e+60 spmb=1.11111e+15 spomb=0 spomb1=1.11111e+60
    MPRSTY (Y CLK VDD VDD) pch_mac l=30n w=500n multi=1 nf=1 sd=100n          ad=3.75e-14 as=3.75e-14 pd=1.15u ps=1.15u nrd=0.383209          nrs=0.383209 sa=75.0n sb=75.0n sa1=75.0n sa2=75.0n sa3=75.0n          sa4=75.0n sb1=75.0n sb2=75.0n sb3=75.0n spa=100n spa1=100n          spa2=100n spa3=100n sap=91.9776n sapb=114.444n spba=115.715n          spba1=117.043n dfm_flag=0 spmt=1.11111e+15 spomt=0          spomt1=1.11111e+60 spmb=1.11111e+15 spomb=0 spomb1=1.11111e+60
    MPRSTX (X CLK VDD VDD) pch_mac l=30n w=500n multi=1 nf=1 sd=100n          ad=3.75e-14 as=3.75e-14 pd=1.15u ps=1.15u nrd=0.383209          nrs=0.383209 sa=75.0n sb=75.0n sa1=75.0n sa2=75.0n sa3=75.0n          sa4=75.0n sb1=75.0n sb2=75.0n sb3=75.0n spa=100n spa1=100n          spa2=100n spa3=100n sap=91.9776n sapb=114.444n spba=115.715n          spba1=117.043n dfm_flag=0 spmt=1.11111e+15 spomt=0          spomt1=1.11111e+60 spmb=1.11111e+15 spomb=0 spomb1=1.11111e+60
    MPLATN (OUTN OUTP VDD VDD) pch_mac l=30n w=500n multi=1 nf=1 sd=100n          ad=3.75e-14 as=3.75e-14 pd=1.15u ps=1.15u nrd=0.383209          nrs=0.383209 sa=75.0n sb=75.0n sa1=75.0n sa2=75.0n sa3=75.0n          sa4=75.0n sb1=75.0n sb2=75.0n sb3=75.0n spa=100n spa1=100n          spa2=100n spa3=100n sap=91.9776n sapb=114.444n spba=115.715n          spba1=117.043n dfm_flag=0 spmt=1.11111e+15 spomt=0          spomt1=1.11111e+60 spmb=1.11111e+15 spomb=0 spomb1=1.11111e+60
    MPLATP (OUTP OUTN VDD VDD) pch_mac l=30n w=500n multi=1 nf=1 sd=100n          ad=3.75e-14 as=3.75e-14 pd=1.15u ps=1.15u nrd=0.383209          nrs=0.383209 sa=75.0n sb=75.0n sa1=75.0n sa2=75.0n sa3=75.0n          sa4=75.0n sb1=75.0n sb2=75.0n sb3=75.0n spa=100n spa1=100n          spa2=100n spa3=100n sap=91.9776n sapb=114.444n spba=115.715n          spba1=117.043n dfm_flag=0 spmt=1.11111e+15 spomt=0          spomt1=1.11111e+60 spmb=1.11111e+15 spomb=0 spomb1=1.11111e+60
// BEGIN SARADC RNL
// @RNL(author="saradc topology") {
// (-48,68) @TEXT("StrongARM  /  differential latch",size=1.7,halign="start",textcolor="#223d52");
// #MPLATN @SET-SYMBOL $PMOS_4TERM;
// #MPLATN @PLACE(-20,42) => @ORIENT("MY");
// #MPLATN @TEXT("MPLATN",key="name",size=1.3,halign="start") => @PLACE(-17,45);
// #MPLATN @TEXT("l=30n w=500n multi=1",key="value",size=0.9,halign="start") => @PLACE(-17,38);
// #MPLATN @TEXT("",key="model");
// #MPLATP @SET-SYMBOL $PMOS_4TERM;
// #MPLATP @PLACE(20,42) => @ORIENT("R0");
// #MPLATP @TEXT("MPLATP",key="name",size=1.3,halign="start") => @PLACE(23,45);
// #MPLATP @TEXT("l=30n w=500n multi=1",key="value",size=0.9,halign="start") => @PLACE(23,38);
// #MPLATP @TEXT("",key="model");
// #MNLATN @SET-SYMBOL $NMOS_4TERM;
// #MNLATN @PLACE(-20,20) => @ORIENT("MY");
// #MNLATN @TEXT("MNLATN",key="name",size=1.3,halign="start") => @PLACE(-17,23);
// #MNLATN @TEXT("l=30n w=500n multi=1",key="value",size=0.9,halign="start") => @PLACE(-17,16);
// #MNLATN @TEXT("",key="model");
// #MNLATP @SET-SYMBOL $NMOS_4TERM;
// #MNLATP @PLACE(20,20) => @ORIENT("R0");
// #MNLATP @TEXT("MNLATP",key="name",size=1.3,halign="start") => @PLACE(23,23);
// #MNLATP @TEXT("l=30n w=500n multi=1",key="value",size=0.9,halign="start") => @PLACE(23,16);
// #MNLATP @TEXT("",key="model");
// #MNINP @SET-SYMBOL $NMOS_4TERM;
// #MNINP @PLACE(-20,-5) => @ORIENT("R0");
// #MNINP @TEXT("MNINP",key="name",size=1.3,halign="start") => @PLACE(-17,-2);
// #MNINP @TEXT("l=30n w=1u multi=1",key="value",size=0.9,halign="start") => @PLACE(-17,-9);
// #MNINP @TEXT("",key="model");
// #MNINN @SET-SYMBOL $NMOS_4TERM;
// #MNINN @PLACE(20,-5) => @ORIENT("MY");
// #MNINN @TEXT("MNINN",key="name",size=1.3,halign="start") => @PLACE(23,-2);
// #MNINN @TEXT("l=30n w=1u multi=1",key="value",size=0.9,halign="start") => @PLACE(23,-9);
// #MNINN @TEXT("",key="model");
// #MNTAIL @SET-SYMBOL $NMOS_4TERM;
// #MNTAIL @PLACE(0,-30) => @ORIENT("R0");
// #MNTAIL @TEXT("MNTAIL",key="name",size=1.3,halign="start") => @PLACE(3,-27);
// #MNTAIL @TEXT("l=30n w=1u multi=1",key="value",size=0.9,halign="start") => @PLACE(3,-34);
// #MNTAIL @TEXT("",key="model");
// #MPRSTN @SET-SYMBOL $PMOS_4TERM;
// #MPRSTN @PLACE(-42,42) => @ORIENT("R0");
// #MPRSTN @TEXT("MPRSTN",key="name",size=1.3,halign="start") => @PLACE(-39,45);
// #MPRSTN @TEXT("l=30n w=500n multi=1",key="value",size=0.9,halign="start") => @PLACE(-39,38);
// #MPRSTN @TEXT("",key="model");
// #MPRSTP @SET-SYMBOL $PMOS_4TERM;
// #MPRSTP @PLACE(42,42) => @ORIENT("MY");
// #MPRSTP @TEXT("MPRSTP",key="name",size=1.3,halign="start") => @PLACE(45,45);
// #MPRSTP @TEXT("l=30n w=500n multi=1",key="value",size=0.9,halign="start") => @PLACE(45,38);
// #MPRSTP @TEXT("",key="model");
// #MPRSTY @SET-SYMBOL $PMOS_4TERM;
// #MPRSTY @PLACE(-42,10) => @ORIENT("R0");
// #MPRSTY @TEXT("MPRSTY",key="name",size=1.3,halign="start") => @PLACE(-39,13);
// #MPRSTY @TEXT("l=30n w=500n multi=1",key="value",size=0.9,halign="start") => @PLACE(-39,6);
// #MPRSTY @TEXT("",key="model");
// #MPRSTX @SET-SYMBOL $PMOS_4TERM;
// #MPRSTX @PLACE(42,10) => @ORIENT("MY");
// #MPRSTX @TEXT("MPRSTX",key="name",size=1.3,halign="start") => @PLACE(45,13);
// #MPRSTX @TEXT("l=30n w=500n multi=1",key="value",size=0.9,halign="start") => @PLACE(45,6);
// #MPRSTX @TEXT("",key="model");
// &"VDD" @WIRE(mode="straight",linecolor="#647584",linewidth=0.16) {(-42,61) (-20,61) (20,61) (42,61)};
// &"VDD" @WIRE(mode="straight",linecolor="#647584",linewidth=0.16) {#MPLATN:3 (-20,61)};
// $JUNCTION @ATTACH (-20,61);
// &"VDD" @WIRE(mode="straight",linecolor="#647584",linewidth=0.16) {#MPLATP:3 (20,61)};
// $JUNCTION @ATTACH (20,61);
// &"VDD" @WIRE(mode="straight",linecolor="#647584",linewidth=0.16) {#MPRSTN:3 (-42,61)};
// $JUNCTION @ATTACH (-42,61);
// &"VDD" @WIRE(mode="straight",linecolor="#647584",linewidth=0.16) {#MPRSTP:3 (42,61)};
// $JUNCTION @ATTACH (42,61);
// &"VDD" @WIRE(mode="straight",linecolor="#647584",linewidth=0.16) {#MPRSTY:3 (-42,15) (-55,15) (-55,61) (-42,61)};
// &"VDD" @WIRE(mode="straight",linecolor="#647584",linewidth=0.16) {#MPRSTX:3 (42,15) (55,15) (55,61) (42,61)};
// &"OUTN" @WIRE(mode="straight",linecolor="#226e85",linewidth=0.16) {(-42,31) (-20,31)};
// &"OUTN" @WIRE(mode="straight",linecolor="#226e85",linewidth=0.16) {#MPLATN:1 (-20,31)};
// $JUNCTION @ATTACH (-20,31);
// &"OUTN" @WIRE(mode="straight",linecolor="#226e85",linewidth=0.16) {#MNLATN:1 (-20,31)};
// $JUNCTION @ATTACH (-20,31);
// &"OUTN" @WIRE(mode="straight",linecolor="#226e85",linewidth=0.16) {#MPRSTN:1 (-42,31)};
// $JUNCTION @ATTACH (-42,31);
// &"OUTP" @WIRE(mode="straight",linecolor="#226e85",linewidth=0.16) {(20,33) (42,33)};
// &"OUTP" @WIRE(mode="straight",linecolor="#226e85",linewidth=0.16) {#MPLATP:1 (20,33)};
// $JUNCTION @ATTACH (20,33);
// &"OUTP" @WIRE(mode="straight",linecolor="#226e85",linewidth=0.16) {#MNLATP:1 (20,33)};
// $JUNCTION @ATTACH (20,33);
// &"OUTP" @WIRE(mode="straight",linecolor="#226e85",linewidth=0.16) {#MPRSTP:1 (42,33)};
// $JUNCTION @ATTACH (42,33);
// &"OUTN" @WIRE(mode="straight",linecolor="#226e85",linewidth=0.16) {#MPLATN:1 (-20,36) (8,36) (8,42) #MPLATP:2};
// &"OUTN" @WIRE(mode="straight",linecolor="#226e85",linewidth=0.16) {(8,36) (8,20) #MNLATP:2};
// $JUNCTION @ATTACH (8,36);
// &"OUTP" @WIRE(mode="straight",linecolor="#226e85",linewidth=0.16) {#MPLATP:1 (20,28) (-8,28) (-8,42) #MPLATN:2};
// &"OUTP" @WIRE(mode="straight",linecolor="#226e85",linewidth=0.16) {(-8,28) (-8,20) #MNLATN:2};
// $JUNCTION @ATTACH (-8,28);
// &"Y" @WIRE(mode="straight",linecolor="#226e85",linewidth=0.16) {(-42,4) (-20,4)};
// &"Y" @WIRE(mode="straight",linecolor="#226e85",linewidth=0.16) {#MNLATN:3 (-20,4)};
// $JUNCTION @ATTACH (-20,4);
// &"Y" @WIRE(mode="straight",linecolor="#226e85",linewidth=0.16) {#MNINP:1 (-20,4)};
// $JUNCTION @ATTACH (-20,4);
// &"Y" @WIRE(mode="straight",linecolor="#226e85",linewidth=0.16) {#MPRSTY:1 (-42,4)};
// $JUNCTION @ATTACH (-42,4);
// &"X" @WIRE(mode="straight",linecolor="#226e85",linewidth=0.16) {(20,4) (42,4)};
// &"X" @WIRE(mode="straight",linecolor="#226e85",linewidth=0.16) {#MNLATP:3 (20,4)};
// $JUNCTION @ATTACH (20,4);
// &"X" @WIRE(mode="straight",linecolor="#226e85",linewidth=0.16) {#MNINN:1 (20,4)};
// $JUNCTION @ATTACH (20,4);
// &"X" @WIRE(mode="straight",linecolor="#226e85",linewidth=0.16) {#MPRSTX:1 (42,4)};
// $JUNCTION @ATTACH (42,4);
// &"TAIL" @WIRE(mode="straight",linecolor="#226e85",linewidth=0.16) {(-20,-18) (0,-18) (20,-18)};
// &"TAIL" @WIRE(mode="straight",linecolor="#226e85",linewidth=0.16) {#MNINP:3 (-20,-18)};
// $JUNCTION @ATTACH (-20,-18);
// &"TAIL" @WIRE(mode="straight",linecolor="#226e85",linewidth=0.16) {#MNINN:3 (20,-18)};
// $JUNCTION @ATTACH (20,-18);
// &"TAIL" @WIRE(mode="straight",linecolor="#226e85",linewidth=0.16) {#MNTAIL:1 (0,-18)};
// $JUNCTION @ATTACH (0,-18);
// &"VSS" @WIRE(mode="straight",linecolor="#30485d",linewidth=0.16) {#MNLATN:4 (-24,20)};
// (-24.4,20) @TEXT("VSS",size=1.1,halign="end",valign="middle");
// &"VSS" @WIRE(mode="straight",linecolor="#30485d",linewidth=0.16) {#MNLATP:4 (24,20)};
// (24.4,20) @TEXT("VSS",size=1.1,halign="start",valign="middle");
// &"VINN" @WIRE(mode="straight",linecolor="#30485d",linewidth=0.16) {#MNINN:2 (26,-5)};
// (26.4,-5) @TEXT("VINN",size=1.1,halign="start",valign="middle");
// &"VSS" @WIRE(mode="straight",linecolor="#30485d",linewidth=0.16) {#MNINN:4 (16,-5)};
// (15.6,-5) @TEXT("VSS",size=1.1,halign="end",valign="middle");
// &"VINP" @WIRE(mode="straight",linecolor="#30485d",linewidth=0.16) {#MNINP:2 (-26,-5)};
// (-26.4,-5) @TEXT("VINP",size=1.1,halign="end",valign="middle");
// &"VSS" @WIRE(mode="straight",linecolor="#30485d",linewidth=0.16) {#MNINP:4 (-16,-5)};
// (-15.6,-5) @TEXT("VSS",size=1.1,halign="start",valign="middle");
// &"CLK" @WIRE(mode="straight",linecolor="#30485d",linewidth=0.16) {#MNTAIL:2 (-6,-30)};
// (-6.4,-30) @TEXT("CLK",size=1.1,halign="end",valign="middle");
// &"VSS" @WIRE(mode="straight",linecolor="#30485d",linewidth=0.16) {#MNTAIL:3 (0,-35)};
// (0,-35.4) @TEXT("VSS",size=1.1,halign="middle",valign="top");
// &"VSS" @WIRE(mode="straight",linecolor="#30485d",linewidth=0.16) {#MNTAIL:4 (4,-30)};
// (4.4,-30) @TEXT("VSS",size=1.1,halign="start",valign="middle");
// &"CLK" @WIRE(mode="straight",linecolor="#30485d",linewidth=0.16) {#MPRSTN:2 (-48,42)};
// (-48.4,42) @TEXT("CLK",size=1.1,halign="end",valign="middle");
// &"VDD" @WIRE(mode="straight",linecolor="#30485d",linewidth=0.16) {#MPRSTN:4 (-38,42)};
// (-37.6,42) @TEXT("VDD",size=1.1,halign="start",valign="middle");
// &"CLK" @WIRE(mode="straight",linecolor="#30485d",linewidth=0.16) {#MPRSTP:2 (48,42)};
// (48.4,42) @TEXT("CLK",size=1.1,halign="start",valign="middle");
// &"VDD" @WIRE(mode="straight",linecolor="#30485d",linewidth=0.16) {#MPRSTP:4 (38,42)};
// (37.6,42) @TEXT("VDD",size=1.1,halign="end",valign="middle");
// &"CLK" @WIRE(mode="straight",linecolor="#30485d",linewidth=0.16) {#MPRSTY:2 (-48,10)};
// (-48.4,10) @TEXT("CLK",size=1.1,halign="end",valign="middle");
// &"VDD" @WIRE(mode="straight",linecolor="#30485d",linewidth=0.16) {#MPRSTY:4 (-38,10)};
// (-37.6,10) @TEXT("VDD",size=1.1,halign="start",valign="middle");
// &"CLK" @WIRE(mode="straight",linecolor="#30485d",linewidth=0.16) {#MPRSTX:2 (48,10)};
// (48.4,10) @TEXT("CLK",size=1.1,halign="start",valign="middle");
// &"VDD" @WIRE(mode="straight",linecolor="#30485d",linewidth=0.16) {#MPRSTX:4 (38,10)};
// (37.6,10) @TEXT("VDD",size=1.1,halign="end",valign="middle");
// &"VDD" @WIRE(mode="straight",linecolor="#30485d",linewidth=0.16) {#MPLATN:4 (-24,42)};
// (-24.4,42) @TEXT("VDD",size=1.1,halign="end",valign="middle");
// &"VDD" @WIRE(mode="straight",linecolor="#30485d",linewidth=0.16) {#MPLATP:4 (24,42)};
// (24.4,42) @TEXT("VDD",size=1.1,halign="start",valign="middle");
// }
// END SARADC RNL
ends sar_strongarm_t28

subckt sar8i_refword CODE0 CODE1 CODE2 CODE3 CODE4 CODE5 CODE6 CODE7 REFSEL_N0 REFSEL_N1 REFSEL_N2 REFSEL_N3 REFSEL_N4 REFSEL_N5 REFSEL_N6 REFSEL_N7 REFSEL_P0 REFSEL_P1 REFSEL_P2 REFSEL_P3 REFSEL_P4 REFSEL_P5 REFSEL_P6 REFSEL_P7 VDD VSS PRESET
XPRESET_N (PRESET RUN VDD VSS) INVD1BWP12T30P140
XINITIAL0 (CODE0 RUN QN0 VDD VSS) ND2D1BWP12T30P140
XPN0 (QN0 REFSEL_P0 VDD VSS) INVD1BWP12T30P140
XNN0 (QN0 REFSEL_N0 VDD VSS) BUFFD1BWP12T30P140
XINITIAL1 (CODE1 RUN QN1 VDD VSS) ND2D1BWP12T30P140
XPN1 (QN1 REFSEL_P1 VDD VSS) INVD1BWP12T30P140
XNN1 (QN1 REFSEL_N1 VDD VSS) BUFFD1BWP12T30P140
XINITIAL2 (CODE2 RUN QN2 VDD VSS) ND2D1BWP12T30P140
XPN2 (QN2 REFSEL_P2 VDD VSS) INVD1BWP12T30P140
XNN2 (QN2 REFSEL_N2 VDD VSS) BUFFD1BWP12T30P140
XINITIAL3 (CODE3 RUN QN3 VDD VSS) ND2D1BWP12T30P140
XPN3 (QN3 REFSEL_P3 VDD VSS) INVD1BWP12T30P140
XNN3 (QN3 REFSEL_N3 VDD VSS) BUFFD1BWP12T30P140
XINITIAL4 (CODE4 RUN QN4 VDD VSS) ND2D1BWP12T30P140
XPN4 (QN4 REFSEL_P4 VDD VSS) INVD1BWP12T30P140
XNN4 (QN4 REFSEL_N4 VDD VSS) BUFFD1BWP12T30P140
XINITIAL5 (CODE5 RUN QN5 VDD VSS) ND2D1BWP12T30P140
XPN5 (QN5 REFSEL_P5 VDD VSS) INVD1BWP12T30P140
XNN5 (QN5 REFSEL_N5 VDD VSS) BUFFD1BWP12T30P140
XINITIAL6 (CODE6 RUN QN6 VDD VSS) ND2D1BWP12T30P140
XPN6 (QN6 REFSEL_P6 VDD VSS) INVD1BWP12T30P140
XNN6 (QN6 REFSEL_N6 VDD VSS) BUFFD1BWP12T30P140
// PRESET rises with CODE7 high at the end of every MSB-1 conversion. The INV+INV+ND2 form keeps
// the stacked node within the terminal-voltage rule (native OR2D1 reached 1.124 V).
XINITIAL7_A (CODE7 CODE7_B VDD VSS) INVD1BWP12T30P140
XINITIAL7_B (PRESET PRESET_B VDD VSS) INVD1BWP12T30P140
XINITIAL7 (CODE7_B PRESET_B Q7 VDD VSS) ND2D1BWP12T30P140
XINV7 (Q7 QN7 VDD VSS) INVD1BWP12T30P140
XPN7 (QN7 REFSEL_P7 VDD VSS) INVD2BWP12T30P140
XNN7 (QN7 REFSEL_N7 VDD VSS) BUFFD2BWP12T30P140
// BEGIN SARADC RNL
// @RNL(author="saradc topology") {
// (-24,91) @TEXT("Reference drive",size=2.55,halign="start",textcolor="#223d52");
// #XPRESET_N @SET-SYMBOL $S_INVD1BWP12T30P140;
// #XPRESET_N @PLACE(2,71) => @ORIENT("R0");
// #XPRESET_N @TEXT("",key="name",size=1.65,halign="middle",textcolor="#223d52") => @PLACE(2,71);
// #XPRESET_N @TEXT("",key="model");
// %sar_port1 = $IO_PORT @ATTACH &"PRESET" => @PLACE(-15,71);
// &"PRESET" @WIRE(mode="straight",linecolor="#94601a",linewidth=0.16) {%sar_port1:p #XPRESET_N:1};
// #XINITIAL0 @SET-SYMBOL $S_ND2D1BWP12T30P140;
// #XINITIAL0 @PLACE(0,43) => @ORIENT("R0");
// #XINITIAL0 @TEXT("",key="name",size=1.65,halign="middle",textcolor="#223d52") => @PLACE(0,43);
// #XINITIAL0 @TEXT("",key="model");
// #XNN0 @SET-SYMBOL $S_BUFFD1BWP12T30P140;
// #XNN0 @PLACE(30,49) => @ORIENT("R0");
// #XNN0 @TEXT("",key="name",size=1.65,halign="middle",textcolor="#223d52") => @PLACE(30,49);
// #XNN0 @TEXT("",key="model");
// #XPN0 @SET-SYMBOL $S_INVD1BWP12T30P140;
// #XPN0 @PLACE(54,38) => @ORIENT("R0");
// #XPN0 @TEXT("",key="name",size=1.65,halign="middle",textcolor="#223d52") => @PLACE(54,38);
// #XPN0 @TEXT("",key="model");
// (-22,43) @TEXT("B0",size=1.15,halign="start",textcolor="#223d52");
// %sar_junction2 = (14,43);
// %sar_junction2 @CIRCLE(radius=0.34,linecolor="#30485d",fill="fillcolor",fillcolor="#30485d") => @LAYER("top");
// &"QN0" @WIRE(mode="straight",linecolor="#30485d",linewidth=0.16) {#XINITIAL0:3 %sar_junction2};
// &"QN0" @WIRE(mode="straight",linecolor="#30485d",linewidth=0.16) {%sar_junction2 (14,49) #XNN0:1};
// &"QN0" @WIRE(mode="straight",linecolor="#30485d",linewidth=0.16) {%sar_junction2 (14,38) #XPN0:1};
// #XINITIAL1 @SET-SYMBOL $S_ND2D1BWP12T30P140;
// #XINITIAL1 @PLACE(0,19) => @ORIENT("R0");
// #XINITIAL1 @TEXT("",key="name",size=1.65,halign="middle",textcolor="#223d52") => @PLACE(0,19);
// #XINITIAL1 @TEXT("",key="model");
// #XNN1 @SET-SYMBOL $S_BUFFD1BWP12T30P140;
// #XNN1 @PLACE(30,25) => @ORIENT("R0");
// #XNN1 @TEXT("",key="name",size=1.65,halign="middle",textcolor="#223d52") => @PLACE(30,25);
// #XNN1 @TEXT("",key="model");
// #XPN1 @SET-SYMBOL $S_INVD1BWP12T30P140;
// #XPN1 @PLACE(54,14) => @ORIENT("R0");
// #XPN1 @TEXT("",key="name",size=1.65,halign="middle",textcolor="#223d52") => @PLACE(54,14);
// #XPN1 @TEXT("",key="model");
// (-22,19) @TEXT("B1",size=1.15,halign="start",textcolor="#223d52");
// %sar_junction3 = (14,19);
// %sar_junction3 @CIRCLE(radius=0.34,linecolor="#30485d",fill="fillcolor",fillcolor="#30485d") => @LAYER("top");
// &"QN1" @WIRE(mode="straight",linecolor="#30485d",linewidth=0.16) {#XINITIAL1:3 %sar_junction3};
// &"QN1" @WIRE(mode="straight",linecolor="#30485d",linewidth=0.16) {%sar_junction3 (14,25) #XNN1:1};
// &"QN1" @WIRE(mode="straight",linecolor="#30485d",linewidth=0.16) {%sar_junction3 (14,14) #XPN1:1};
// #XINITIAL2 @SET-SYMBOL $S_ND2D1BWP12T30P140;
// #XINITIAL2 @PLACE(0,-5) => @ORIENT("R0");
// #XINITIAL2 @TEXT("",key="name",size=1.65,halign="middle",textcolor="#223d52") => @PLACE(0,-5);
// #XINITIAL2 @TEXT("",key="model");
// #XNN2 @SET-SYMBOL $S_BUFFD1BWP12T30P140;
// #XNN2 @PLACE(30,1) => @ORIENT("R0");
// #XNN2 @TEXT("",key="name",size=1.65,halign="middle",textcolor="#223d52") => @PLACE(30,1);
// #XNN2 @TEXT("",key="model");
// #XPN2 @SET-SYMBOL $S_INVD1BWP12T30P140;
// #XPN2 @PLACE(54,-10) => @ORIENT("R0");
// #XPN2 @TEXT("",key="name",size=1.65,halign="middle",textcolor="#223d52") => @PLACE(54,-10);
// #XPN2 @TEXT("",key="model");
// (-22,-5) @TEXT("B2",size=1.15,halign="start",textcolor="#223d52");
// %sar_junction4 = (14,-5);
// %sar_junction4 @CIRCLE(radius=0.34,linecolor="#30485d",fill="fillcolor",fillcolor="#30485d") => @LAYER("top");
// &"QN2" @WIRE(mode="straight",linecolor="#30485d",linewidth=0.16) {#XINITIAL2:3 %sar_junction4};
// &"QN2" @WIRE(mode="straight",linecolor="#30485d",linewidth=0.16) {%sar_junction4 (14,1) #XNN2:1};
// &"QN2" @WIRE(mode="straight",linecolor="#30485d",linewidth=0.16) {%sar_junction4 (14,-10) #XPN2:1};
// #XINITIAL3 @SET-SYMBOL $S_ND2D1BWP12T30P140;
// #XINITIAL3 @PLACE(0,-29) => @ORIENT("R0");
// #XINITIAL3 @TEXT("",key="name",size=1.65,halign="middle",textcolor="#223d52") => @PLACE(0,-29);
// #XINITIAL3 @TEXT("",key="model");
// #XNN3 @SET-SYMBOL $S_BUFFD1BWP12T30P140;
// #XNN3 @PLACE(30,-23) => @ORIENT("R0");
// #XNN3 @TEXT("",key="name",size=1.65,halign="middle",textcolor="#223d52") => @PLACE(30,-23);
// #XNN3 @TEXT("",key="model");
// #XPN3 @SET-SYMBOL $S_INVD1BWP12T30P140;
// #XPN3 @PLACE(54,-34) => @ORIENT("R0");
// #XPN3 @TEXT("",key="name",size=1.65,halign="middle",textcolor="#223d52") => @PLACE(54,-34);
// #XPN3 @TEXT("",key="model");
// (-22,-29) @TEXT("B3",size=1.15,halign="start",textcolor="#223d52");
// %sar_junction5 = (14,-29);
// %sar_junction5 @CIRCLE(radius=0.34,linecolor="#30485d",fill="fillcolor",fillcolor="#30485d") => @LAYER("top");
// &"QN3" @WIRE(mode="straight",linecolor="#30485d",linewidth=0.16) {#XINITIAL3:3 %sar_junction5};
// &"QN3" @WIRE(mode="straight",linecolor="#30485d",linewidth=0.16) {%sar_junction5 (14,-23) #XNN3:1};
// &"QN3" @WIRE(mode="straight",linecolor="#30485d",linewidth=0.16) {%sar_junction5 (14,-34) #XPN3:1};
// &"VDD" @WIRE(mode="straight",linecolor="#647584",linewidth=0.16) {#XINITIAL0:4 (0,51.45)};
// (0,51.77) @TEXT("VDD",size=0.98,halign="middle",valign="bottom");
// &"VSS" @WIRE(mode="straight",linecolor="#647584",linewidth=0.16) {#XINITIAL0:5 (0,34.55)};
// (0,34.23) @TEXT("VSS",size=0.98,halign="middle",valign="top");
// &"VDD" @WIRE(mode="straight",linecolor="#647584",linewidth=0.16) {#XNN0:3 (30,57.45)};
// (30,57.77) @TEXT("VDD",size=0.98,halign="middle",valign="bottom");
// &"VSS" @WIRE(mode="straight",linecolor="#647584",linewidth=0.16) {#XNN0:4 (30,40.55)};
// (30,40.23) @TEXT("VSS",size=0.98,halign="middle",valign="top");
// &"VDD" @WIRE(mode="straight",linecolor="#647584",linewidth=0.16) {#XPN0:3 (54,46.45)};
// (54,46.77) @TEXT("VDD",size=0.98,halign="middle",valign="bottom");
// &"VSS" @WIRE(mode="straight",linecolor="#647584",linewidth=0.16) {#XPN0:4 (54,29.55)};
// (54,29.23) @TEXT("VSS",size=0.98,halign="middle",valign="top");
// &"VDD" @WIRE(mode="straight",linecolor="#647584",linewidth=0.16) {#XINITIAL1:4 (0,27.45)};
// (0,27.77) @TEXT("VDD",size=0.98,halign="middle",valign="bottom");
// &"VSS" @WIRE(mode="straight",linecolor="#647584",linewidth=0.16) {#XINITIAL1:5 (0,10.55)};
// (0,10.23) @TEXT("VSS",size=0.98,halign="middle",valign="top");
// &"VDD" @WIRE(mode="straight",linecolor="#647584",linewidth=0.16) {#XNN1:3 (30,33.45)};
// (30,33.77) @TEXT("VDD",size=0.98,halign="middle",valign="bottom");
// &"VSS" @WIRE(mode="straight",linecolor="#647584",linewidth=0.16) {#XNN1:4 (30,16.55)};
// (30,16.23) @TEXT("VSS",size=0.98,halign="middle",valign="top");
// &"VDD" @WIRE(mode="straight",linecolor="#647584",linewidth=0.16) {#XPN1:3 (54,22.45)};
// (54,22.77) @TEXT("VDD",size=0.98,halign="middle",valign="bottom");
// &"VSS" @WIRE(mode="straight",linecolor="#647584",linewidth=0.16) {#XPN1:4 (54,5.55)};
// (54,5.23) @TEXT("VSS",size=0.98,halign="middle",valign="top");
// &"VDD" @WIRE(mode="straight",linecolor="#647584",linewidth=0.16) {#XINITIAL2:4 (0,3.45)};
// (0,3.77) @TEXT("VDD",size=0.98,halign="middle",valign="bottom");
// &"VSS" @WIRE(mode="straight",linecolor="#647584",linewidth=0.16) {#XINITIAL2:5 (0,-13.45)};
// (0,-13.77) @TEXT("VSS",size=0.98,halign="middle",valign="top");
// &"VDD" @WIRE(mode="straight",linecolor="#647584",linewidth=0.16) {#XNN2:3 (30,9.45)};
// (30,9.77) @TEXT("VDD",size=0.98,halign="middle",valign="bottom");
// &"VSS" @WIRE(mode="straight",linecolor="#647584",linewidth=0.16) {#XNN2:4 (30,-7.45)};
// (30,-7.77) @TEXT("VSS",size=0.98,halign="middle",valign="top");
// &"VDD" @WIRE(mode="straight",linecolor="#647584",linewidth=0.16) {#XPN2:3 (54,-1.55)};
// (54,-1.23) @TEXT("VDD",size=0.98,halign="middle",valign="bottom");
// &"VSS" @WIRE(mode="straight",linecolor="#647584",linewidth=0.16) {#XPN2:4 (54,-18.45)};
// (54,-18.77) @TEXT("VSS",size=0.98,halign="middle",valign="top");
// &"VDD" @WIRE(mode="straight",linecolor="#647584",linewidth=0.16) {#XINITIAL3:4 (0,-20.55)};
// (0,-20.23) @TEXT("VDD",size=0.98,halign="middle",valign="bottom");
// &"VSS" @WIRE(mode="straight",linecolor="#647584",linewidth=0.16) {#XINITIAL3:5 (0,-37.45)};
// (0,-37.77) @TEXT("VSS",size=0.98,halign="middle",valign="top");
// &"VDD" @WIRE(mode="straight",linecolor="#647584",linewidth=0.16) {#XNN3:3 (30,-14.55)};
// (30,-14.23) @TEXT("VDD",size=0.98,halign="middle",valign="bottom");
// &"VSS" @WIRE(mode="straight",linecolor="#647584",linewidth=0.16) {#XNN3:4 (30,-31.45)};
// (30,-31.77) @TEXT("VSS",size=0.98,halign="middle",valign="top");
// &"VDD" @WIRE(mode="straight",linecolor="#647584",linewidth=0.16) {#XPN3:3 (54,-25.55)};
// (54,-25.23) @TEXT("VDD",size=0.98,halign="middle",valign="bottom");
// &"VSS" @WIRE(mode="straight",linecolor="#647584",linewidth=0.16) {#XPN3:4 (54,-42.45)};
// (54,-42.77) @TEXT("VSS",size=0.98,halign="middle",valign="top");
// {#XINITIAL0 #XNN0 #XPN0 #XINITIAL1 #XNN1 #XPN1 #XINITIAL2 #XNN2 #XPN2 #XINITIAL3 #XNN3 #XPN3} @GROUP;
// @RECTANGLE(linecolor="#a9b8c5",linewidth=0.16,fill="fillcolor",fillcolor="#f7f9fc") {(-24,-46) (83,60)} => @LAYER("bottom");
// (-21,56) @TEXT("Bits 0-3",size=1.95,halign="start",textcolor="#223d52");
// #XINITIAL4 @SET-SYMBOL $S_ND2D1BWP12T30P140;
// #XINITIAL4 @PLACE(110,43) => @ORIENT("R0");
// #XINITIAL4 @TEXT("",key="name",size=1.65,halign="middle",textcolor="#223d52") => @PLACE(110,43);
// #XINITIAL4 @TEXT("",key="model");
// #XNN4 @SET-SYMBOL $S_BUFFD1BWP12T30P140;
// #XNN4 @PLACE(140,49) => @ORIENT("R0");
// #XNN4 @TEXT("",key="name",size=1.65,halign="middle",textcolor="#223d52") => @PLACE(140,49);
// #XNN4 @TEXT("",key="model");
// #XPN4 @SET-SYMBOL $S_INVD1BWP12T30P140;
// #XPN4 @PLACE(164,38) => @ORIENT("R0");
// #XPN4 @TEXT("",key="name",size=1.65,halign="middle",textcolor="#223d52") => @PLACE(164,38);
// #XPN4 @TEXT("",key="model");
// (88,43) @TEXT("B4",size=1.15,halign="start",textcolor="#223d52");
// %sar_junction6 = (124,43);
// %sar_junction6 @CIRCLE(radius=0.34,linecolor="#30485d",fill="fillcolor",fillcolor="#30485d") => @LAYER("top");
// &"QN4" @WIRE(mode="straight",linecolor="#30485d",linewidth=0.16) {#XINITIAL4:3 %sar_junction6};
// &"QN4" @WIRE(mode="straight",linecolor="#30485d",linewidth=0.16) {%sar_junction6 (124,49) #XNN4:1};
// &"QN4" @WIRE(mode="straight",linecolor="#30485d",linewidth=0.16) {%sar_junction6 (124,38) #XPN4:1};
// #XINITIAL5 @SET-SYMBOL $S_ND2D1BWP12T30P140;
// #XINITIAL5 @PLACE(110,19) => @ORIENT("R0");
// #XINITIAL5 @TEXT("",key="name",size=1.65,halign="middle",textcolor="#223d52") => @PLACE(110,19);
// #XINITIAL5 @TEXT("",key="model");
// #XNN5 @SET-SYMBOL $S_BUFFD1BWP12T30P140;
// #XNN5 @PLACE(140,25) => @ORIENT("R0");
// #XNN5 @TEXT("",key="name",size=1.65,halign="middle",textcolor="#223d52") => @PLACE(140,25);
// #XNN5 @TEXT("",key="model");
// #XPN5 @SET-SYMBOL $S_INVD1BWP12T30P140;
// #XPN5 @PLACE(164,14) => @ORIENT("R0");
// #XPN5 @TEXT("",key="name",size=1.65,halign="middle",textcolor="#223d52") => @PLACE(164,14);
// #XPN5 @TEXT("",key="model");
// (88,19) @TEXT("B5",size=1.15,halign="start",textcolor="#223d52");
// %sar_junction7 = (124,19);
// %sar_junction7 @CIRCLE(radius=0.34,linecolor="#30485d",fill="fillcolor",fillcolor="#30485d") => @LAYER("top");
// &"QN5" @WIRE(mode="straight",linecolor="#30485d",linewidth=0.16) {#XINITIAL5:3 %sar_junction7};
// &"QN5" @WIRE(mode="straight",linecolor="#30485d",linewidth=0.16) {%sar_junction7 (124,25) #XNN5:1};
// &"QN5" @WIRE(mode="straight",linecolor="#30485d",linewidth=0.16) {%sar_junction7 (124,14) #XPN5:1};
// #XINITIAL6 @SET-SYMBOL $S_ND2D1BWP12T30P140;
// #XINITIAL6 @PLACE(110,-5) => @ORIENT("R0");
// #XINITIAL6 @TEXT("",key="name",size=1.65,halign="middle",textcolor="#223d52") => @PLACE(110,-5);
// #XINITIAL6 @TEXT("",key="model");
// #XNN6 @SET-SYMBOL $S_BUFFD1BWP12T30P140;
// #XNN6 @PLACE(140,1) => @ORIENT("R0");
// #XNN6 @TEXT("",key="name",size=1.65,halign="middle",textcolor="#223d52") => @PLACE(140,1);
// #XNN6 @TEXT("",key="model");
// #XPN6 @SET-SYMBOL $S_INVD1BWP12T30P140;
// #XPN6 @PLACE(164,-10) => @ORIENT("R0");
// #XPN6 @TEXT("",key="name",size=1.65,halign="middle",textcolor="#223d52") => @PLACE(164,-10);
// #XPN6 @TEXT("",key="model");
// (88,-5) @TEXT("B6",size=1.15,halign="start",textcolor="#223d52");
// %sar_junction8 = (124,-5);
// %sar_junction8 @CIRCLE(radius=0.34,linecolor="#30485d",fill="fillcolor",fillcolor="#30485d") => @LAYER("top");
// &"QN6" @WIRE(mode="straight",linecolor="#30485d",linewidth=0.16) {#XINITIAL6:3 %sar_junction8};
// &"QN6" @WIRE(mode="straight",linecolor="#30485d",linewidth=0.16) {%sar_junction8 (124,1) #XNN6:1};
// &"QN6" @WIRE(mode="straight",linecolor="#30485d",linewidth=0.16) {%sar_junction8 (124,-10) #XPN6:1};
// &"VDD" @WIRE(mode="straight",linecolor="#647584",linewidth=0.16) {#XINITIAL4:4 (110,51.45)};
// (110,51.77) @TEXT("VDD",size=0.98,halign="middle",valign="bottom");
// &"VSS" @WIRE(mode="straight",linecolor="#647584",linewidth=0.16) {#XINITIAL4:5 (110,34.55)};
// (110,34.23) @TEXT("VSS",size=0.98,halign="middle",valign="top");
// &"VDD" @WIRE(mode="straight",linecolor="#647584",linewidth=0.16) {#XNN4:3 (140,57.45)};
// (140,57.77) @TEXT("VDD",size=0.98,halign="middle",valign="bottom");
// &"VSS" @WIRE(mode="straight",linecolor="#647584",linewidth=0.16) {#XNN4:4 (140,40.55)};
// (140,40.23) @TEXT("VSS",size=0.98,halign="middle",valign="top");
// &"VDD" @WIRE(mode="straight",linecolor="#647584",linewidth=0.16) {#XPN4:3 (164,46.45)};
// (164,46.77) @TEXT("VDD",size=0.98,halign="middle",valign="bottom");
// &"VSS" @WIRE(mode="straight",linecolor="#647584",linewidth=0.16) {#XPN4:4 (164,29.55)};
// (164,29.23) @TEXT("VSS",size=0.98,halign="middle",valign="top");
// &"VDD" @WIRE(mode="straight",linecolor="#647584",linewidth=0.16) {#XINITIAL5:4 (110,27.45)};
// (110,27.77) @TEXT("VDD",size=0.98,halign="middle",valign="bottom");
// &"VSS" @WIRE(mode="straight",linecolor="#647584",linewidth=0.16) {#XINITIAL5:5 (110,10.55)};
// (110,10.23) @TEXT("VSS",size=0.98,halign="middle",valign="top");
// &"VDD" @WIRE(mode="straight",linecolor="#647584",linewidth=0.16) {#XNN5:3 (140,33.45)};
// (140,33.77) @TEXT("VDD",size=0.98,halign="middle",valign="bottom");
// &"VSS" @WIRE(mode="straight",linecolor="#647584",linewidth=0.16) {#XNN5:4 (140,16.55)};
// (140,16.23) @TEXT("VSS",size=0.98,halign="middle",valign="top");
// &"VDD" @WIRE(mode="straight",linecolor="#647584",linewidth=0.16) {#XPN5:3 (164,22.45)};
// (164,22.77) @TEXT("VDD",size=0.98,halign="middle",valign="bottom");
// &"VSS" @WIRE(mode="straight",linecolor="#647584",linewidth=0.16) {#XPN5:4 (164,5.55)};
// (164,5.23) @TEXT("VSS",size=0.98,halign="middle",valign="top");
// &"VDD" @WIRE(mode="straight",linecolor="#647584",linewidth=0.16) {#XINITIAL6:4 (110,3.45)};
// (110,3.77) @TEXT("VDD",size=0.98,halign="middle",valign="bottom");
// &"VSS" @WIRE(mode="straight",linecolor="#647584",linewidth=0.16) {#XINITIAL6:5 (110,-13.45)};
// (110,-13.77) @TEXT("VSS",size=0.98,halign="middle",valign="top");
// &"VDD" @WIRE(mode="straight",linecolor="#647584",linewidth=0.16) {#XNN6:3 (140,9.45)};
// (140,9.77) @TEXT("VDD",size=0.98,halign="middle",valign="bottom");
// &"VSS" @WIRE(mode="straight",linecolor="#647584",linewidth=0.16) {#XNN6:4 (140,-7.45)};
// (140,-7.77) @TEXT("VSS",size=0.98,halign="middle",valign="top");
// &"VDD" @WIRE(mode="straight",linecolor="#647584",linewidth=0.16) {#XPN6:3 (164,-1.55)};
// (164,-1.23) @TEXT("VDD",size=0.98,halign="middle",valign="bottom");
// &"VSS" @WIRE(mode="straight",linecolor="#647584",linewidth=0.16) {#XPN6:4 (164,-18.45)};
// (164,-18.77) @TEXT("VSS",size=0.98,halign="middle",valign="top");
// {#XINITIAL4 #XNN4 #XPN4 #XINITIAL5 #XNN5 #XPN5 #XINITIAL6 #XNN6 #XPN6} @GROUP;
// @RECTANGLE(linecolor="#a9b8c5",linewidth=0.16,fill="fillcolor",fillcolor="#f7f9fc") {(86,-22) (193,60)} => @LAYER("bottom");
// (89,56) @TEXT("Bits 4-6",size=1.95,halign="start",textcolor="#223d52");
// #XINITIAL7_A @SET-SYMBOL $S_INVD1BWP12T30P140;
// #XINITIAL7_A @PLACE(-2,-67) => @ORIENT("R0");
// #XINITIAL7_A @TEXT("",key="name",size=1.65,halign="middle",textcolor="#223d52") => @PLACE(-2,-67);
// #XINITIAL7_A @TEXT("",key="model");
// #XINITIAL7_B @SET-SYMBOL $S_INVD1BWP12T30P140;
// #XINITIAL7_B @PLACE(2,-87) => @ORIENT("R0");
// #XINITIAL7_B @TEXT("",key="name",size=1.65,halign="middle",textcolor="#223d52") => @PLACE(2,-87);
// #XINITIAL7_B @TEXT("",key="model");
// #XINITIAL7 @SET-SYMBOL $S_ND2D1BWP12T30P140;
// #XINITIAL7 @PLACE(31,-77) => @ORIENT("R0");
// #XINITIAL7 @TEXT("",key="name",size=1.65,halign="middle",textcolor="#223d52") => @PLACE(31,-77);
// #XINITIAL7 @TEXT("",key="model");
// #XINV7 @SET-SYMBOL $S_INVD1BWP12T30P140;
// #XINV7 @PLACE(57,-77) => @ORIENT("R0");
// #XINV7 @TEXT("",key="name",size=1.65,halign="middle",textcolor="#223d52") => @PLACE(57,-77);
// #XINV7 @TEXT("",key="model");
// #XNN7 @SET-SYMBOL $S_BUFFD2BWP12T30P140;
// #XNN7 @PLACE(90,-71) => @ORIENT("R0");
// #XNN7 @TEXT("",key="name",size=1.65,halign="middle",textcolor="#223d52") => @PLACE(90,-71);
// #XNN7 @TEXT("",key="model");
// #XPN7 @SET-SYMBOL $S_INVD2BWP12T30P140;
// #XPN7 @PLACE(114,-82) => @ORIENT("R0");
// #XPN7 @TEXT("",key="name",size=1.65,halign="middle",textcolor="#223d52") => @PLACE(114,-82);
// #XPN7 @TEXT("",key="model");
// &"VDD" @WIRE(mode="straight",linecolor="#647584",linewidth=0.16) {#XINITIAL7_A:3 (-2,-58.55)};
// (-2,-58.23) @TEXT("VDD",size=0.98,halign="middle",valign="bottom");
// &"VSS" @WIRE(mode="straight",linecolor="#647584",linewidth=0.16) {#XINITIAL7_A:4 (-2,-75.45)};
// (-2,-75.77) @TEXT("VSS",size=0.98,halign="middle",valign="top");
// &"VDD" @WIRE(mode="straight",linecolor="#647584",linewidth=0.16) {#XINITIAL7_B:3 (2,-78.55)};
// (2,-78.23) @TEXT("VDD",size=0.98,halign="middle",valign="bottom");
// &"VSS" @WIRE(mode="straight",linecolor="#647584",linewidth=0.16) {#XINITIAL7_B:4 (2,-95.45)};
// (2,-95.77) @TEXT("VSS",size=0.98,halign="middle",valign="top");
// &"VDD" @WIRE(mode="straight",linecolor="#647584",linewidth=0.16) {#XINITIAL7:4 (31,-68.55)};
// (31,-68.23) @TEXT("VDD",size=0.98,halign="middle",valign="bottom");
// &"VSS" @WIRE(mode="straight",linecolor="#647584",linewidth=0.16) {#XINITIAL7:5 (31,-85.45)};
// (31,-85.77) @TEXT("VSS",size=0.98,halign="middle",valign="top");
// &"VDD" @WIRE(mode="straight",linecolor="#647584",linewidth=0.16) {#XINV7:3 (57,-68.55)};
// (57,-68.23) @TEXT("VDD",size=0.98,halign="middle",valign="bottom");
// &"VSS" @WIRE(mode="straight",linecolor="#647584",linewidth=0.16) {#XINV7:4 (57,-85.45)};
// (57,-85.77) @TEXT("VSS",size=0.98,halign="middle",valign="top");
// &"VDD" @WIRE(mode="straight",linecolor="#647584",linewidth=0.16) {#XNN7:3 (90,-62.55)};
// (90,-62.23) @TEXT("VDD",size=0.98,halign="middle",valign="bottom");
// &"VSS" @WIRE(mode="straight",linecolor="#647584",linewidth=0.16) {#XNN7:4 (90,-79.45)};
// (90,-79.77) @TEXT("VSS",size=0.98,halign="middle",valign="top");
// &"VDD" @WIRE(mode="straight",linecolor="#647584",linewidth=0.16) {#XPN7:3 (114,-73.55)};
// (114,-73.23) @TEXT("VDD",size=0.98,halign="middle",valign="bottom");
// &"VSS" @WIRE(mode="straight",linecolor="#647584",linewidth=0.16) {#XPN7:4 (114,-90.45)};
// (114,-90.77) @TEXT("VSS",size=0.98,halign="middle",valign="top");
// {#XINITIAL7_A #XINITIAL7_B #XINITIAL7 #XINV7 #XNN7 #XPN7} @GROUP;
// @RECTANGLE(linecolor="#a9b8c5",linewidth=0.16,fill="fillcolor",fillcolor="#f7f9fc") {(-24,-99) (151,-51)} => @LAYER("bottom");
// (-21,-55) @TEXT("Bit 7 / MSB",size=1.95,halign="start",textcolor="#223d52");
// (-21,-58.5) @TEXT("PRESET selects the 0x80 startup word.",size=1.26,halign="start",textcolor="#223d52");
// &"CODE7_B" @WIRE(mode="straight",linecolor="#30485d",linewidth=0.16) {#XINITIAL7_A:2 (14.5,-67) (14.5,-75.3) #XINITIAL7:1};
// &"PRESET_B" @WIRE(mode="straight",linecolor="#30485d",linewidth=0.16) {#XINITIAL7_B:2 (16.5,-87) (16.5,-78.7) #XINITIAL7:2};
// &"Q7" @WIRE(mode="straight",linecolor="#30485d",linewidth=0.16) {#XINITIAL7:3 (44,-77) (44,-77) #XINV7:1};
// %sar_junction9 = (72,-77);
// %sar_junction9 @CIRCLE(radius=0.34,linecolor="#30485d",fill="fillcolor",fillcolor="#30485d") => @LAYER("top");
// &"QN7" @WIRE(mode="straight",linecolor="#30485d",linewidth=0.16) {#XINV7:2 %sar_junction9};
// &"QN7" @WIRE(mode="straight",linecolor="#30485d",linewidth=0.16) {%sar_junction9 (72,-71) #XNN7:1};
// &"QN7" @WIRE(mode="straight",linecolor="#30485d",linewidth=0.16) {%sar_junction9 (72,-82) #XPN7:1};
// &"RUN" @WIRE(mode="straight",linecolor="#30485d",linewidth=0.16) {#XPRESET_N:2 (12,71)};
// (12.4,71) @TEXT("RUN",size=1.1,halign="start",valign="middle");
// &"VDD" @WIRE(mode="straight",linecolor="#30485d",linewidth=0.16) {#XPRESET_N:3 (2,81)};
// (2,81.4) @TEXT("VDD",size=1.1,halign="middle",valign="bottom");
// &"VSS" @WIRE(mode="straight",linecolor="#30485d",linewidth=0.16) {#XPRESET_N:4 (2,61)};
// (2,60.6) @TEXT("VSS",size=1.1,halign="middle",valign="top");
// &"CODE0" @WIRE(mode="straight",linecolor="#30485d",linewidth=0.16) {#XINITIAL0:1 (-10,44.7)};
// (-10.4,44.7) @TEXT("CODE0",size=1.1,halign="end",valign="middle");
// &"RUN" @WIRE(mode="straight",linecolor="#30485d",linewidth=0.16) {#XINITIAL0:2 (-10,41.3)};
// (-10.4,41.3) @TEXT("RUN",size=1.1,halign="end",valign="middle");
// &"REFSEL_P0" @WIRE(mode="straight",linecolor="#30485d",linewidth=0.16) {#XPN0:2 (64,38)};
// (64.4,38) @TEXT("REFSEL_P0",size=1.1,halign="start",valign="middle");
// &"REFSEL_N0" @WIRE(mode="straight",linecolor="#30485d",linewidth=0.16) {#XNN0:2 (40,49)};
// (40.4,49) @TEXT("REFSEL_N0",size=1.1,halign="start",valign="middle");
// &"CODE1" @WIRE(mode="straight",linecolor="#30485d",linewidth=0.16) {#XINITIAL1:1 (-10,20.7)};
// (-10.4,20.7) @TEXT("CODE1",size=1.1,halign="end",valign="middle");
// &"RUN" @WIRE(mode="straight",linecolor="#30485d",linewidth=0.16) {#XINITIAL1:2 (-10,17.3)};
// (-10.4,17.3) @TEXT("RUN",size=1.1,halign="end",valign="middle");
// &"REFSEL_P1" @WIRE(mode="straight",linecolor="#30485d",linewidth=0.16) {#XPN1:2 (64,14)};
// (64.4,14) @TEXT("REFSEL_P1",size=1.1,halign="start",valign="middle");
// &"REFSEL_N1" @WIRE(mode="straight",linecolor="#30485d",linewidth=0.16) {#XNN1:2 (40,25)};
// (40.4,25) @TEXT("REFSEL_N1",size=1.1,halign="start",valign="middle");
// &"CODE2" @WIRE(mode="straight",linecolor="#30485d",linewidth=0.16) {#XINITIAL2:1 (-10,-3.3)};
// (-10.4,-3.3) @TEXT("CODE2",size=1.1,halign="end",valign="middle");
// &"RUN" @WIRE(mode="straight",linecolor="#30485d",linewidth=0.16) {#XINITIAL2:2 (-10,-6.7)};
// (-10.4,-6.7) @TEXT("RUN",size=1.1,halign="end",valign="middle");
// &"REFSEL_P2" @WIRE(mode="straight",linecolor="#30485d",linewidth=0.16) {#XPN2:2 (64,-10)};
// (64.4,-10) @TEXT("REFSEL_P2",size=1.1,halign="start",valign="middle");
// &"REFSEL_N2" @WIRE(mode="straight",linecolor="#30485d",linewidth=0.16) {#XNN2:2 (40,1)};
// (40.4,1) @TEXT("REFSEL_N2",size=1.1,halign="start",valign="middle");
// &"CODE3" @WIRE(mode="straight",linecolor="#30485d",linewidth=0.16) {#XINITIAL3:1 (-10,-27.3)};
// (-10.4,-27.3) @TEXT("CODE3",size=1.1,halign="end",valign="middle");
// &"RUN" @WIRE(mode="straight",linecolor="#30485d",linewidth=0.16) {#XINITIAL3:2 (-10,-30.7)};
// (-10.4,-30.7) @TEXT("RUN",size=1.1,halign="end",valign="middle");
// &"REFSEL_P3" @WIRE(mode="straight",linecolor="#30485d",linewidth=0.16) {#XPN3:2 (64,-34)};
// (64.4,-34) @TEXT("REFSEL_P3",size=1.1,halign="start",valign="middle");
// &"REFSEL_N3" @WIRE(mode="straight",linecolor="#30485d",linewidth=0.16) {#XNN3:2 (40,-23)};
// (40.4,-23) @TEXT("REFSEL_N3",size=1.1,halign="start",valign="middle");
// &"CODE4" @WIRE(mode="straight",linecolor="#30485d",linewidth=0.16) {#XINITIAL4:1 (100,44.7)};
// (99.6,44.7) @TEXT("CODE4",size=1.1,halign="end",valign="middle");
// &"RUN" @WIRE(mode="straight",linecolor="#30485d",linewidth=0.16) {#XINITIAL4:2 (100,41.3)};
// (99.6,41.3) @TEXT("RUN",size=1.1,halign="end",valign="middle");
// &"REFSEL_P4" @WIRE(mode="straight",linecolor="#30485d",linewidth=0.16) {#XPN4:2 (174,38)};
// (174.4,38) @TEXT("REFSEL_P4",size=1.1,halign="start",valign="middle");
// &"REFSEL_N4" @WIRE(mode="straight",linecolor="#30485d",linewidth=0.16) {#XNN4:2 (150,49)};
// (150.4,49) @TEXT("REFSEL_N4",size=1.1,halign="start",valign="middle");
// &"CODE5" @WIRE(mode="straight",linecolor="#30485d",linewidth=0.16) {#XINITIAL5:1 (100,20.7)};
// (99.6,20.7) @TEXT("CODE5",size=1.1,halign="end",valign="middle");
// &"RUN" @WIRE(mode="straight",linecolor="#30485d",linewidth=0.16) {#XINITIAL5:2 (100,17.3)};
// (99.6,17.3) @TEXT("RUN",size=1.1,halign="end",valign="middle");
// &"REFSEL_P5" @WIRE(mode="straight",linecolor="#30485d",linewidth=0.16) {#XPN5:2 (174,14)};
// (174.4,14) @TEXT("REFSEL_P5",size=1.1,halign="start",valign="middle");
// &"REFSEL_N5" @WIRE(mode="straight",linecolor="#30485d",linewidth=0.16) {#XNN5:2 (150,25)};
// (150.4,25) @TEXT("REFSEL_N5",size=1.1,halign="start",valign="middle");
// &"CODE6" @WIRE(mode="straight",linecolor="#30485d",linewidth=0.16) {#XINITIAL6:1 (100,-3.3)};
// (99.6,-3.3) @TEXT("CODE6",size=1.1,halign="end",valign="middle");
// &"RUN" @WIRE(mode="straight",linecolor="#30485d",linewidth=0.16) {#XINITIAL6:2 (100,-6.7)};
// (99.6,-6.7) @TEXT("RUN",size=1.1,halign="end",valign="middle");
// &"REFSEL_P6" @WIRE(mode="straight",linecolor="#30485d",linewidth=0.16) {#XPN6:2 (174,-10)};
// (174.4,-10) @TEXT("REFSEL_P6",size=1.1,halign="start",valign="middle");
// &"REFSEL_N6" @WIRE(mode="straight",linecolor="#30485d",linewidth=0.16) {#XNN6:2 (150,1)};
// (150.4,1) @TEXT("REFSEL_N6",size=1.1,halign="start",valign="middle");
// &"CODE7" @WIRE(mode="straight",linecolor="#30485d",linewidth=0.16) {#XINITIAL7_A:1 (-12,-67)};
// (-12.4,-67) @TEXT("CODE7",size=1.1,halign="end",valign="middle");
// &"PRESET" @WIRE(mode="straight",linecolor="#30485d",linewidth=0.16) {#XINITIAL7_B:1 (-8,-87)};
// (-8.4,-87) @TEXT("PRESET",size=1.1,halign="end",valign="middle");
// &"REFSEL_P7" @WIRE(mode="straight",linecolor="#30485d",linewidth=0.16) {#XPN7:2 (124,-82)};
// (124.4,-82) @TEXT("REFSEL_P7",size=1.1,halign="start",valign="middle");
// &"REFSEL_N7" @WIRE(mode="straight",linecolor="#30485d",linewidth=0.16) {#XNN7:2 (100,-71)};
// (100.4,-71) @TEXT("REFSEL_N7",size=1.1,halign="start",valign="middle");
// }
// END SARADC RNL
ends sar8i_refword

subckt sar8_next_word CODE0 CODE1 CODE2 CODE3 CODE4 CODE5 CODE6 CODE7 DATA DONE D0 D1 D2 D3 D4 D5 D6 D7 NEXT0 NEXT1 NEXT2 NEXT3 NEXT4 NEXT5 NEXT6 NEXT7 TRIAL6 TRIAL5 TRIAL4 TRIAL3 TRIAL2 VDD VSS
// Prefix ORs identify the current trial and are evaluated before DATA arrives.
X01 (CODE0 CODE1 ANY01 VDD VSS) OR2D1BWP12T30P140
X23 (CODE2 CODE3 ANY23 VDD VSS) OR2D1BWP12T30P140
X45 (CODE4 CODE5 ANY45 VDD VSS) OR2D1BWP12T30P140
X02 (ANY01 CODE2 ANY02 VDD VSS) OR2D1BWP12T30P140
X03 (ANY01 ANY23 ANY03 VDD VSS) OR2D1BWP12T30P140
X04 (ANY03 CODE4 LOW_BITS VDD VSS) OR2D1BWP12T30P140
X05 (ANY03 ANY45 ANY05 VDD VSS) OR2D1BWP12T30P140
X06 (ANY05 CODE6 ANY06 VDD VSS) OR2D1BWP12T30P140
XREAD0 (CODE0 DONE D0 VDD VSS) AN2D1BWP12T30P140
XEMPTY1 (CODE0 EMPTY1 VDD VSS) INVD1BWP12T30P140
XTRIAL1 (EMPTY1 CODE1 TRIAL1 VDD VSS) AN2D1BWP12T30P140
XVISIBLE1 (CODE0 DONE VISIBLE1 VDD VSS) OR2D1BWP12T30P140
XREAD1 (CODE1 VISIBLE1 D1 VDD VSS) AN2D1BWP12T30P140
XEMPTY2 (ANY01 EMPTY2 VDD VSS) INVD1BWP12T30P140
XTRIAL2 (EMPTY2 CODE2 TRIAL2 VDD VSS) AN2D1BWP12T30P140
XVISIBLE2 (ANY01 DONE VISIBLE2 VDD VSS) OR2D1BWP12T30P140
XREAD2 (CODE2 VISIBLE2 D2 VDD VSS) AN2D1BWP12T30P140
XEMPTY3 (ANY02 EMPTY3 VDD VSS) INVD1BWP12T30P140
XTRIAL3 (EMPTY3 CODE3 TRIAL3 VDD VSS) AN2D1BWP12T30P140
XVISIBLE3 (ANY02 DONE VISIBLE3 VDD VSS) OR2D1BWP12T30P140
XREAD3 (CODE3 VISIBLE3 D3 VDD VSS) AN2D1BWP12T30P140
XEMPTY4 (ANY03 EMPTY4 VDD VSS) INVD1BWP12T30P140
XTRIAL4 (EMPTY4 CODE4 TRIAL4 VDD VSS) AN2D1BWP12T30P140
XVISIBLE4 (ANY03 DONE VISIBLE4 VDD VSS) OR2D1BWP12T30P140
XREAD4 (CODE4 VISIBLE4 D4 VDD VSS) AN2D1BWP12T30P140
XEMPTY5 (LOW_BITS EMPTY5 VDD VSS) INVD1BWP12T30P140
XTRIAL5 (EMPTY5 CODE5 TRIAL5 VDD VSS) AN2D1BWP12T30P140
XVISIBLE5 (LOW_BITS DONE VISIBLE5 VDD VSS) OR2D1BWP12T30P140
XREAD5 (CODE5 VISIBLE5 D5 VDD VSS) AN2D1BWP12T30P140
XEMPTY6 (ANY05 EMPTY6 VDD VSS) INVD1BWP12T30P140
XTRIAL6 (EMPTY6 CODE6 TRIAL6 VDD VSS) AN2D1BWP12T30P140
XVISIBLE6 (ANY05 DONE VISIBLE6 VDD VSS) OR2D1BWP12T30P140
XREAD6 (CODE6 VISIBLE6 D6 VDD VSS) AN2D1BWP12T30P140
XEMPTY7 (ANY06 EMPTY7 VDD VSS) INVD1BWP12T30P140
XTRIAL7 (EMPTY7 CODE7 TRIAL7 VDD VSS) AN2D1BWP12T30P140
XVISIBLE7 (ANY06 DONE VISIBLE7 VDD VSS) OR2D1BWP12T30P140
XREAD7 (CODE7 VISIBLE7 D7 VDD VSS) AN2D1BWP12T30P140
XBASE0 (D0 TRIAL1 BASE0 VDD VSS) OR2D1BWP12T30P140
XKEEP0 (CODE0 DATA KEEP0 VDD VSS) AN2D1BWP12T30P140
XNEXT0 (BASE0 KEEP0 NEXT0 VDD VSS) OR2D1BWP12T30P140
XBASE1 (D1 TRIAL2 BASE1 VDD VSS) OR2D1BWP12T30P140
XKEEP1 (TRIAL1 DATA KEEP1 VDD VSS) AN2D1BWP12T30P140
XNEXT1 (BASE1 KEEP1 NEXT1 VDD VSS) OR2D1BWP12T30P140
XBASE2 (D2 TRIAL3 BASE2 VDD VSS) OR2D1BWP12T30P140
XKEEP2 (TRIAL2 DATA KEEP2 VDD VSS) AN2D1BWP12T30P140
XNEXT2 (BASE2 KEEP2 NEXT2 VDD VSS) OR2D1BWP12T30P140
XBASE3 (D3 TRIAL4 BASE3 VDD VSS) OR2D1BWP12T30P140
XKEEP3 (TRIAL3 DATA KEEP3 VDD VSS) AN2D1BWP12T30P140
XNEXT3 (BASE3 KEEP3 NEXT3 VDD VSS) OR2D1BWP12T30P140
XBASE4 (D4 TRIAL5 BASE4 VDD VSS) OR2D1BWP12T30P140
XKEEP4 (TRIAL4 DATA KEEP4 VDD VSS) AN2D1BWP12T30P140
XNEXT4 (BASE4 KEEP4 NEXT4 VDD VSS) OR2D1BWP12T30P140
XBASE5 (D5 TRIAL6 BASE5 VDD VSS) OR2D1BWP12T30P140
XKEEP5 (TRIAL5 DATA KEEP5 VDD VSS) AN2D1BWP12T30P140
XNEXT5 (BASE5 KEEP5 NEXT5 VDD VSS) OR2D1BWP12T30P140
XBASE6 (D6 TRIAL7 BASE6 VDD VSS) OR2D1BWP12T30P140
XKEEP6 (TRIAL6 DATA KEEP6 VDD VSS) AN2D1BWP12T30P140
XNEXT6 (BASE6 KEEP6 NEXT6 VDD VSS) OR2D1BWP12T30P140
XKEEP7 (TRIAL7 DATA KEEP7 VDD VSS) AN2D1BWP12T30P140
XNEXT7 (D7 KEEP7 NEXT7 VDD VSS) OR2D1BWP12T30P140
// BEGIN SARADC RNL
// @RNL(author="saradc topology") {
// (-18,45) @TEXT("Next trial word",size=2,halign="start",textcolor="#223d52");
// #X01 @SET-SYMBOL $S_OR2D1BWP12T30P140;
// #X01 @PLACE(0,22) => @ORIENT("R0");
// #X23 @SET-SYMBOL $S_OR2D1BWP12T30P140;
// #X23 @PLACE(34,22) => @ORIENT("R0");
// #X45 @SET-SYMBOL $S_OR2D1BWP12T30P140;
// #X45 @PLACE(68,22) => @ORIENT("R0");
// #X02 @SET-SYMBOL $S_OR2D1BWP12T30P140;
// #X02 @PLACE(102,22) => @ORIENT("R0");
// #X03 @SET-SYMBOL $S_OR2D1BWP12T30P140;
// #X03 @PLACE(136,22) => @ORIENT("R0");
// #X04 @SET-SYMBOL $S_OR2D1BWP12T30P140;
// #X04 @PLACE(170,22) => @ORIENT("R0");
// #X05 @SET-SYMBOL $S_OR2D1BWP12T30P140;
// #X05 @PLACE(204,22) => @ORIENT("R0");
// #X06 @SET-SYMBOL $S_OR2D1BWP12T30P140;
// #X06 @PLACE(238,22) => @ORIENT("R0");
// (-24,-5) @TEXT("Bit 0",size=1.2,halign="start",textcolor="#223d52");
// #XREAD0 @SET-SYMBOL $S_AN2D1BWP12T30P140;
// #XREAD0 @PLACE(93,-12) => @ORIENT("R0");
// #XBASE0 @SET-SYMBOL $S_OR2D1BWP12T30P140;
// #XBASE0 @PLACE(124,-12) => @ORIENT("R0");
// #XKEEP0 @SET-SYMBOL $S_AN2D1BWP12T30P140;
// #XKEEP0 @PLACE(155,-12) => @ORIENT("R0");
// #XNEXT0 @SET-SYMBOL $S_OR2D1BWP12T30P140;
// #XNEXT0 @PLACE(186,-12) => @ORIENT("R0");
// (-24,-32) @TEXT("Bit 1",size=1.2,halign="start",textcolor="#223d52");
// #XEMPTY1 @SET-SYMBOL $S_INVD1BWP12T30P140;
// #XEMPTY1 @PLACE(0,-39) => @ORIENT("R0");
// #XTRIAL1 @SET-SYMBOL $S_AN2D1BWP12T30P140;
// #XTRIAL1 @PLACE(31,-39) => @ORIENT("R0");
// #XVISIBLE1 @SET-SYMBOL $S_OR2D1BWP12T30P140;
// #XVISIBLE1 @PLACE(62,-39) => @ORIENT("R0");
// #XREAD1 @SET-SYMBOL $S_AN2D1BWP12T30P140;
// #XREAD1 @PLACE(93,-39) => @ORIENT("R0");
// #XBASE1 @SET-SYMBOL $S_OR2D1BWP12T30P140;
// #XBASE1 @PLACE(124,-39) => @ORIENT("R0");
// #XKEEP1 @SET-SYMBOL $S_AN2D1BWP12T30P140;
// #XKEEP1 @PLACE(155,-39) => @ORIENT("R0");
// #XNEXT1 @SET-SYMBOL $S_OR2D1BWP12T30P140;
// #XNEXT1 @PLACE(186,-39) => @ORIENT("R0");
// (-24,-59) @TEXT("Bit 2",size=1.2,halign="start",textcolor="#223d52");
// #XEMPTY2 @SET-SYMBOL $S_INVD1BWP12T30P140;
// #XEMPTY2 @PLACE(0,-66) => @ORIENT("R0");
// #XTRIAL2 @SET-SYMBOL $S_AN2D1BWP12T30P140;
// #XTRIAL2 @PLACE(31,-66) => @ORIENT("R0");
// #XVISIBLE2 @SET-SYMBOL $S_OR2D1BWP12T30P140;
// #XVISIBLE2 @PLACE(62,-66) => @ORIENT("R0");
// #XREAD2 @SET-SYMBOL $S_AN2D1BWP12T30P140;
// #XREAD2 @PLACE(93,-66) => @ORIENT("R0");
// #XBASE2 @SET-SYMBOL $S_OR2D1BWP12T30P140;
// #XBASE2 @PLACE(124,-66) => @ORIENT("R0");
// #XKEEP2 @SET-SYMBOL $S_AN2D1BWP12T30P140;
// #XKEEP2 @PLACE(155,-66) => @ORIENT("R0");
// #XNEXT2 @SET-SYMBOL $S_OR2D1BWP12T30P140;
// #XNEXT2 @PLACE(186,-66) => @ORIENT("R0");
// (-24,-86) @TEXT("Bit 3",size=1.2,halign="start",textcolor="#223d52");
// #XEMPTY3 @SET-SYMBOL $S_INVD1BWP12T30P140;
// #XEMPTY3 @PLACE(0,-93) => @ORIENT("R0");
// #XTRIAL3 @SET-SYMBOL $S_AN2D1BWP12T30P140;
// #XTRIAL3 @PLACE(31,-93) => @ORIENT("R0");
// #XVISIBLE3 @SET-SYMBOL $S_OR2D1BWP12T30P140;
// #XVISIBLE3 @PLACE(62,-93) => @ORIENT("R0");
// #XREAD3 @SET-SYMBOL $S_AN2D1BWP12T30P140;
// #XREAD3 @PLACE(93,-93) => @ORIENT("R0");
// #XBASE3 @SET-SYMBOL $S_OR2D1BWP12T30P140;
// #XBASE3 @PLACE(124,-93) => @ORIENT("R0");
// #XKEEP3 @SET-SYMBOL $S_AN2D1BWP12T30P140;
// #XKEEP3 @PLACE(155,-93) => @ORIENT("R0");
// #XNEXT3 @SET-SYMBOL $S_OR2D1BWP12T30P140;
// #XNEXT3 @PLACE(186,-93) => @ORIENT("R0");
// (-24,-113) @TEXT("Bit 4",size=1.2,halign="start",textcolor="#223d52");
// #XEMPTY4 @SET-SYMBOL $S_INVD1BWP12T30P140;
// #XEMPTY4 @PLACE(0,-120) => @ORIENT("R0");
// #XTRIAL4 @SET-SYMBOL $S_AN2D1BWP12T30P140;
// #XTRIAL4 @PLACE(31,-120) => @ORIENT("R0");
// #XVISIBLE4 @SET-SYMBOL $S_OR2D1BWP12T30P140;
// #XVISIBLE4 @PLACE(62,-120) => @ORIENT("R0");
// #XREAD4 @SET-SYMBOL $S_AN2D1BWP12T30P140;
// #XREAD4 @PLACE(93,-120) => @ORIENT("R0");
// #XBASE4 @SET-SYMBOL $S_OR2D1BWP12T30P140;
// #XBASE4 @PLACE(124,-120) => @ORIENT("R0");
// #XKEEP4 @SET-SYMBOL $S_AN2D1BWP12T30P140;
// #XKEEP4 @PLACE(155,-120) => @ORIENT("R0");
// #XNEXT4 @SET-SYMBOL $S_OR2D1BWP12T30P140;
// #XNEXT4 @PLACE(186,-120) => @ORIENT("R0");
// (-24,-140) @TEXT("Bit 5",size=1.2,halign="start",textcolor="#223d52");
// #XEMPTY5 @SET-SYMBOL $S_INVD1BWP12T30P140;
// #XEMPTY5 @PLACE(0,-147) => @ORIENT("R0");
// #XTRIAL5 @SET-SYMBOL $S_AN2D1BWP12T30P140;
// #XTRIAL5 @PLACE(31,-147) => @ORIENT("R0");
// #XVISIBLE5 @SET-SYMBOL $S_OR2D1BWP12T30P140;
// #XVISIBLE5 @PLACE(62,-147) => @ORIENT("R0");
// #XREAD5 @SET-SYMBOL $S_AN2D1BWP12T30P140;
// #XREAD5 @PLACE(93,-147) => @ORIENT("R0");
// #XBASE5 @SET-SYMBOL $S_OR2D1BWP12T30P140;
// #XBASE5 @PLACE(124,-147) => @ORIENT("R0");
// #XKEEP5 @SET-SYMBOL $S_AN2D1BWP12T30P140;
// #XKEEP5 @PLACE(155,-147) => @ORIENT("R0");
// #XNEXT5 @SET-SYMBOL $S_OR2D1BWP12T30P140;
// #XNEXT5 @PLACE(186,-147) => @ORIENT("R0");
// (-24,-167) @TEXT("Bit 6",size=1.2,halign="start",textcolor="#223d52");
// #XEMPTY6 @SET-SYMBOL $S_INVD1BWP12T30P140;
// #XEMPTY6 @PLACE(0,-174) => @ORIENT("R0");
// #XTRIAL6 @SET-SYMBOL $S_AN2D1BWP12T30P140;
// #XTRIAL6 @PLACE(31,-174) => @ORIENT("R0");
// #XVISIBLE6 @SET-SYMBOL $S_OR2D1BWP12T30P140;
// #XVISIBLE6 @PLACE(62,-174) => @ORIENT("R0");
// #XREAD6 @SET-SYMBOL $S_AN2D1BWP12T30P140;
// #XREAD6 @PLACE(93,-174) => @ORIENT("R0");
// #XBASE6 @SET-SYMBOL $S_OR2D1BWP12T30P140;
// #XBASE6 @PLACE(124,-174) => @ORIENT("R0");
// #XKEEP6 @SET-SYMBOL $S_AN2D1BWP12T30P140;
// #XKEEP6 @PLACE(155,-174) => @ORIENT("R0");
// #XNEXT6 @SET-SYMBOL $S_OR2D1BWP12T30P140;
// #XNEXT6 @PLACE(186,-174) => @ORIENT("R0");
// (-24,-194) @TEXT("Bit 7",size=1.2,halign="start",textcolor="#223d52");
// #XEMPTY7 @SET-SYMBOL $S_INVD1BWP12T30P140;
// #XEMPTY7 @PLACE(0,-201) => @ORIENT("R0");
// #XTRIAL7 @SET-SYMBOL $S_AN2D1BWP12T30P140;
// #XTRIAL7 @PLACE(31,-201) => @ORIENT("R0");
// #XVISIBLE7 @SET-SYMBOL $S_OR2D1BWP12T30P140;
// #XVISIBLE7 @PLACE(62,-201) => @ORIENT("R0");
// #XREAD7 @SET-SYMBOL $S_AN2D1BWP12T30P140;
// #XREAD7 @PLACE(93,-201) => @ORIENT("R0");
// #XKEEP7 @SET-SYMBOL $S_AN2D1BWP12T30P140;
// #XKEEP7 @PLACE(155,-201) => @ORIENT("R0");
// #XNEXT7 @SET-SYMBOL $S_OR2D1BWP12T30P140;
// #XNEXT7 @PLACE(186,-201) => @ORIENT("R0");
// &"D0" @WIRE(mode="straight",linecolor="#30485d",linewidth=0.16) {#XREAD0:3 (111.5,-12) (111.5,-10.3) #XBASE0:1};
// &"EMPTY1" @WIRE(mode="straight",linecolor="#30485d",linewidth=0.16) {#XEMPTY1:2 (12.5,-39) (12.5,-37.35) #XTRIAL1:1};
// &"VISIBLE1" @WIRE(mode="straight",linecolor="#30485d",linewidth=0.16) {#XVISIBLE1:3 (74.5,-39) (74.5,-40.65) #XREAD1:2};
// &"D1" @WIRE(mode="straight",linecolor="#30485d",linewidth=0.16) {#XREAD1:3 (111.5,-39) (111.5,-37.3) #XBASE1:1};
// &"EMPTY2" @WIRE(mode="straight",linecolor="#30485d",linewidth=0.16) {#XEMPTY2:2 (12.5,-66) (12.5,-64.35) #XTRIAL2:1};
// &"VISIBLE2" @WIRE(mode="straight",linecolor="#30485d",linewidth=0.16) {#XVISIBLE2:3 (74.5,-66) (74.5,-67.65) #XREAD2:2};
// &"D2" @WIRE(mode="straight",linecolor="#30485d",linewidth=0.16) {#XREAD2:3 (111.5,-66) (111.5,-64.3) #XBASE2:1};
// &"EMPTY3" @WIRE(mode="straight",linecolor="#30485d",linewidth=0.16) {#XEMPTY3:2 (12.5,-93) (12.5,-91.35) #XTRIAL3:1};
// &"VISIBLE3" @WIRE(mode="straight",linecolor="#30485d",linewidth=0.16) {#XVISIBLE3:3 (74.5,-93) (74.5,-94.65) #XREAD3:2};
// &"D3" @WIRE(mode="straight",linecolor="#30485d",linewidth=0.16) {#XREAD3:3 (111.5,-93) (111.5,-91.3) #XBASE3:1};
// &"EMPTY4" @WIRE(mode="straight",linecolor="#30485d",linewidth=0.16) {#XEMPTY4:2 (12.5,-120) (12.5,-118.35) #XTRIAL4:1};
// &"VISIBLE4" @WIRE(mode="straight",linecolor="#30485d",linewidth=0.16) {#XVISIBLE4:3 (74.5,-120) (74.5,-121.65) #XREAD4:2};
// &"D4" @WIRE(mode="straight",linecolor="#30485d",linewidth=0.16) {#XREAD4:3 (111.5,-120) (111.5,-118.3) #XBASE4:1};
// &"EMPTY5" @WIRE(mode="straight",linecolor="#30485d",linewidth=0.16) {#XEMPTY5:2 (12.5,-147) (12.5,-145.35) #XTRIAL5:1};
// &"VISIBLE5" @WIRE(mode="straight",linecolor="#30485d",linewidth=0.16) {#XVISIBLE5:3 (74.5,-147) (74.5,-148.65) #XREAD5:2};
// &"D5" @WIRE(mode="straight",linecolor="#30485d",linewidth=0.16) {#XREAD5:3 (111.5,-147) (111.5,-145.3) #XBASE5:1};
// &"EMPTY6" @WIRE(mode="straight",linecolor="#30485d",linewidth=0.16) {#XEMPTY6:2 (12.5,-174) (12.5,-172.35) #XTRIAL6:1};
// &"VISIBLE6" @WIRE(mode="straight",linecolor="#30485d",linewidth=0.16) {#XVISIBLE6:3 (74.5,-174) (74.5,-175.65) #XREAD6:2};
// &"D6" @WIRE(mode="straight",linecolor="#30485d",linewidth=0.16) {#XREAD6:3 (111.5,-174) (111.5,-172.3) #XBASE6:1};
// &"EMPTY7" @WIRE(mode="straight",linecolor="#30485d",linewidth=0.16) {#XEMPTY7:2 (12.5,-201) (12.5,-199.35) #XTRIAL7:1};
// &"VISIBLE7" @WIRE(mode="straight",linecolor="#30485d",linewidth=0.16) {#XVISIBLE7:3 (74.5,-201) (74.5,-202.65) #XREAD7:2};
// &"KEEP0" @WIRE(mode="straight",linecolor="#30485d",linewidth=0.16) {#XKEEP0:3 (173.5,-12) (173.5,-13.7) #XNEXT0:2};
// &"KEEP1" @WIRE(mode="straight",linecolor="#30485d",linewidth=0.16) {#XKEEP1:3 (173.5,-39) (173.5,-40.7) #XNEXT1:2};
// &"KEEP2" @WIRE(mode="straight",linecolor="#30485d",linewidth=0.16) {#XKEEP2:3 (173.5,-66) (173.5,-67.7) #XNEXT2:2};
// &"KEEP3" @WIRE(mode="straight",linecolor="#30485d",linewidth=0.16) {#XKEEP3:3 (173.5,-93) (173.5,-94.7) #XNEXT3:2};
// &"KEEP4" @WIRE(mode="straight",linecolor="#30485d",linewidth=0.16) {#XKEEP4:3 (173.5,-120) (173.5,-121.7) #XNEXT4:2};
// &"KEEP5" @WIRE(mode="straight",linecolor="#30485d",linewidth=0.16) {#XKEEP5:3 (173.5,-147) (173.5,-148.7) #XNEXT5:2};
// &"KEEP6" @WIRE(mode="straight",linecolor="#30485d",linewidth=0.16) {#XKEEP6:3 (173.5,-174) (173.5,-175.7) #XNEXT6:2};
// &"KEEP7" @WIRE(mode="straight",linecolor="#30485d",linewidth=0.16) {#XKEEP7:3 (173.5,-201) (173.5,-202.7) #XNEXT7:2};
// &"CODE0" @WIRE(mode="straight",linecolor="#30485d",linewidth=0.16) {#X01:1 (-10,23.7)};
// (-10.4,23.7) @TEXT("CODE0",size=1.1,halign="end",valign="middle");
// &"CODE1" @WIRE(mode="straight",linecolor="#30485d",linewidth=0.16) {#X01:2 (-10,20.3)};
// (-10.4,20.3) @TEXT("CODE1",size=1.1,halign="end",valign="middle");
// &"ANY01" @WIRE(mode="straight",linecolor="#30485d",linewidth=0.16) {#X01:3 (10,22)};
// (10.4,22) @TEXT("ANY01",size=1.1,halign="start",valign="middle");
// &"VDD" @WIRE(mode="straight",linecolor="#30485d",linewidth=0.16) {#X01:4 (0,32)};
// (0,32.4) @TEXT("VDD",size=1.1,halign="middle",valign="bottom");
// &"VSS" @WIRE(mode="straight",linecolor="#30485d",linewidth=0.16) {#X01:5 (0,12)};
// (0,11.6) @TEXT("VSS",size=1.1,halign="middle",valign="top");
// &"CODE2" @WIRE(mode="straight",linecolor="#30485d",linewidth=0.16) {#X23:1 (24,23.7)};
// (23.6,23.7) @TEXT("CODE2",size=1.1,halign="end",valign="middle");
// &"CODE3" @WIRE(mode="straight",linecolor="#30485d",linewidth=0.16) {#X23:2 (24,20.3)};
// (23.6,20.3) @TEXT("CODE3",size=1.1,halign="end",valign="middle");
// &"ANY23" @WIRE(mode="straight",linecolor="#30485d",linewidth=0.16) {#X23:3 (44,22)};
// (44.4,22) @TEXT("ANY23",size=1.1,halign="start",valign="middle");
// &"VDD" @WIRE(mode="straight",linecolor="#30485d",linewidth=0.16) {#X23:4 (34,32)};
// (34,32.4) @TEXT("VDD",size=1.1,halign="middle",valign="bottom");
// &"VSS" @WIRE(mode="straight",linecolor="#30485d",linewidth=0.16) {#X23:5 (34,12)};
// (34,11.6) @TEXT("VSS",size=1.1,halign="middle",valign="top");
// &"CODE4" @WIRE(mode="straight",linecolor="#30485d",linewidth=0.16) {#X45:1 (58,23.7)};
// (57.6,23.7) @TEXT("CODE4",size=1.1,halign="end",valign="middle");
// &"CODE5" @WIRE(mode="straight",linecolor="#30485d",linewidth=0.16) {#X45:2 (58,20.3)};
// (57.6,20.3) @TEXT("CODE5",size=1.1,halign="end",valign="middle");
// &"ANY45" @WIRE(mode="straight",linecolor="#30485d",linewidth=0.16) {#X45:3 (78,22)};
// (78.4,22) @TEXT("ANY45",size=1.1,halign="start",valign="middle");
// &"VDD" @WIRE(mode="straight",linecolor="#30485d",linewidth=0.16) {#X45:4 (68,32)};
// (68,32.4) @TEXT("VDD",size=1.1,halign="middle",valign="bottom");
// &"VSS" @WIRE(mode="straight",linecolor="#30485d",linewidth=0.16) {#X45:5 (68,12)};
// (68,11.6) @TEXT("VSS",size=1.1,halign="middle",valign="top");
// &"ANY01" @WIRE(mode="straight",linecolor="#30485d",linewidth=0.16) {#X02:1 (92,23.7)};
// (91.6,23.7) @TEXT("ANY01",size=1.1,halign="end",valign="middle");
// &"CODE2" @WIRE(mode="straight",linecolor="#30485d",linewidth=0.16) {#X02:2 (92,20.3)};
// (91.6,20.3) @TEXT("CODE2",size=1.1,halign="end",valign="middle");
// &"ANY02" @WIRE(mode="straight",linecolor="#30485d",linewidth=0.16) {#X02:3 (112,22)};
// (112.4,22) @TEXT("ANY02",size=1.1,halign="start",valign="middle");
// &"VDD" @WIRE(mode="straight",linecolor="#30485d",linewidth=0.16) {#X02:4 (102,32)};
// (102,32.4) @TEXT("VDD",size=1.1,halign="middle",valign="bottom");
// &"VSS" @WIRE(mode="straight",linecolor="#30485d",linewidth=0.16) {#X02:5 (102,12)};
// (102,11.6) @TEXT("VSS",size=1.1,halign="middle",valign="top");
// &"ANY01" @WIRE(mode="straight",linecolor="#30485d",linewidth=0.16) {#X03:1 (126,23.7)};
// (125.6,23.7) @TEXT("ANY01",size=1.1,halign="end",valign="middle");
// &"ANY23" @WIRE(mode="straight",linecolor="#30485d",linewidth=0.16) {#X03:2 (126,20.3)};
// (125.6,20.3) @TEXT("ANY23",size=1.1,halign="end",valign="middle");
// &"ANY03" @WIRE(mode="straight",linecolor="#30485d",linewidth=0.16) {#X03:3 (146,22)};
// (146.4,22) @TEXT("ANY03",size=1.1,halign="start",valign="middle");
// &"VDD" @WIRE(mode="straight",linecolor="#30485d",linewidth=0.16) {#X03:4 (136,32)};
// (136,32.4) @TEXT("VDD",size=1.1,halign="middle",valign="bottom");
// &"VSS" @WIRE(mode="straight",linecolor="#30485d",linewidth=0.16) {#X03:5 (136,12)};
// (136,11.6) @TEXT("VSS",size=1.1,halign="middle",valign="top");
// &"ANY03" @WIRE(mode="straight",linecolor="#30485d",linewidth=0.16) {#X04:1 (160,23.7)};
// (159.6,23.7) @TEXT("ANY03",size=1.1,halign="end",valign="middle");
// &"CODE4" @WIRE(mode="straight",linecolor="#30485d",linewidth=0.16) {#X04:2 (160,20.3)};
// (159.6,20.3) @TEXT("CODE4",size=1.1,halign="end",valign="middle");
// &"LOW_BITS" @WIRE(mode="straight",linecolor="#30485d",linewidth=0.16) {#X04:3 (180,22)};
// (180.4,22) @TEXT("LOW_BITS",size=1.1,halign="start",valign="middle");
// &"VDD" @WIRE(mode="straight",linecolor="#30485d",linewidth=0.16) {#X04:4 (170,32)};
// (170,32.4) @TEXT("VDD",size=1.1,halign="middle",valign="bottom");
// &"VSS" @WIRE(mode="straight",linecolor="#30485d",linewidth=0.16) {#X04:5 (170,12)};
// (170,11.6) @TEXT("VSS",size=1.1,halign="middle",valign="top");
// &"ANY03" @WIRE(mode="straight",linecolor="#30485d",linewidth=0.16) {#X05:1 (194,23.7)};
// (193.6,23.7) @TEXT("ANY03",size=1.1,halign="end",valign="middle");
// &"ANY45" @WIRE(mode="straight",linecolor="#30485d",linewidth=0.16) {#X05:2 (194,20.3)};
// (193.6,20.3) @TEXT("ANY45",size=1.1,halign="end",valign="middle");
// &"ANY05" @WIRE(mode="straight",linecolor="#30485d",linewidth=0.16) {#X05:3 (214,22)};
// (214.4,22) @TEXT("ANY05",size=1.1,halign="start",valign="middle");
// &"VDD" @WIRE(mode="straight",linecolor="#30485d",linewidth=0.16) {#X05:4 (204,32)};
// (204,32.4) @TEXT("VDD",size=1.1,halign="middle",valign="bottom");
// &"VSS" @WIRE(mode="straight",linecolor="#30485d",linewidth=0.16) {#X05:5 (204,12)};
// (204,11.6) @TEXT("VSS",size=1.1,halign="middle",valign="top");
// &"ANY05" @WIRE(mode="straight",linecolor="#30485d",linewidth=0.16) {#X06:1 (228,23.7)};
// (227.6,23.7) @TEXT("ANY05",size=1.1,halign="end",valign="middle");
// &"CODE6" @WIRE(mode="straight",linecolor="#30485d",linewidth=0.16) {#X06:2 (228,20.3)};
// (227.6,20.3) @TEXT("CODE6",size=1.1,halign="end",valign="middle");
// &"ANY06" @WIRE(mode="straight",linecolor="#30485d",linewidth=0.16) {#X06:3 (248,22)};
// (248.4,22) @TEXT("ANY06",size=1.1,halign="start",valign="middle");
// &"VDD" @WIRE(mode="straight",linecolor="#30485d",linewidth=0.16) {#X06:4 (238,32)};
// (238,32.4) @TEXT("VDD",size=1.1,halign="middle",valign="bottom");
// &"VSS" @WIRE(mode="straight",linecolor="#30485d",linewidth=0.16) {#X06:5 (238,12)};
// (238,11.6) @TEXT("VSS",size=1.1,halign="middle",valign="top");
// &"CODE0" @WIRE(mode="straight",linecolor="#30485d",linewidth=0.16) {#XREAD0:1 (77,-10.35)};
// (76.6,-10.35) @TEXT("CODE0",size=1.1,halign="end",valign="middle");
// &"DONE" @WIRE(mode="straight",linecolor="#30485d",linewidth=0.16) {#XREAD0:2 (77,-13.65)};
// (76.6,-13.65) @TEXT("DONE",size=1.1,halign="end",valign="middle");
// &"VDD" @WIRE(mode="straight",linecolor="#30485d",linewidth=0.16) {#XREAD0:4 (93,-1)};
// (93,-0.6) @TEXT("VDD",size=1.1,halign="middle",valign="bottom");
// &"VSS" @WIRE(mode="straight",linecolor="#30485d",linewidth=0.16) {#XREAD0:5 (93,-23)};
// (93,-23.4) @TEXT("VSS",size=1.1,halign="middle",valign="top");
// &"CODE0" @WIRE(mode="straight",linecolor="#30485d",linewidth=0.16) {#XEMPTY1:1 (-10,-39)};
// (-10.4,-39) @TEXT("CODE0",size=1.1,halign="end",valign="middle");
// &"VDD" @WIRE(mode="straight",linecolor="#30485d",linewidth=0.16) {#XEMPTY1:3 (0,-29)};
// (0,-28.6) @TEXT("VDD",size=1.1,halign="middle",valign="bottom");
// &"VSS" @WIRE(mode="straight",linecolor="#30485d",linewidth=0.16) {#XEMPTY1:4 (0,-49)};
// (0,-49.4) @TEXT("VSS",size=1.1,halign="middle",valign="top");
// &"CODE1" @WIRE(mode="straight",linecolor="#30485d",linewidth=0.16) {#XTRIAL1:2 (15,-40.65)};
// (14.6,-40.65) @TEXT("CODE1",size=1.1,halign="end",valign="middle");
// &"TRIAL1" @WIRE(mode="straight",linecolor="#30485d",linewidth=0.16) {#XTRIAL1:3 (47,-39)};
// (47.4,-39) @TEXT("TRIAL1",size=1.1,halign="start",valign="middle");
// &"VDD" @WIRE(mode="straight",linecolor="#30485d",linewidth=0.16) {#XTRIAL1:4 (31,-28)};
// (31,-27.6) @TEXT("VDD",size=1.1,halign="middle",valign="bottom");
// &"VSS" @WIRE(mode="straight",linecolor="#30485d",linewidth=0.16) {#XTRIAL1:5 (31,-50)};
// (31,-50.4) @TEXT("VSS",size=1.1,halign="middle",valign="top");
// &"CODE0" @WIRE(mode="straight",linecolor="#30485d",linewidth=0.16) {#XVISIBLE1:1 (52,-37.3)};
// (51.6,-37.3) @TEXT("CODE0",size=1.1,halign="end",valign="middle");
// &"DONE" @WIRE(mode="straight",linecolor="#30485d",linewidth=0.16) {#XVISIBLE1:2 (52,-40.7)};
// (51.6,-40.7) @TEXT("DONE",size=1.1,halign="end",valign="middle");
// &"VDD" @WIRE(mode="straight",linecolor="#30485d",linewidth=0.16) {#XVISIBLE1:4 (62,-29)};
// (62,-28.6) @TEXT("VDD",size=1.1,halign="middle",valign="bottom");
// &"VSS" @WIRE(mode="straight",linecolor="#30485d",linewidth=0.16) {#XVISIBLE1:5 (62,-49)};
// (62,-49.4) @TEXT("VSS",size=1.1,halign="middle",valign="top");
// &"CODE1" @WIRE(mode="straight",linecolor="#30485d",linewidth=0.16) {#XREAD1:1 (77,-37.35)};
// (76.6,-37.35) @TEXT("CODE1",size=1.1,halign="end",valign="middle");
// &"VDD" @WIRE(mode="straight",linecolor="#30485d",linewidth=0.16) {#XREAD1:4 (93,-28)};
// (93,-27.6) @TEXT("VDD",size=1.1,halign="middle",valign="bottom");
// &"VSS" @WIRE(mode="straight",linecolor="#30485d",linewidth=0.16) {#XREAD1:5 (93,-50)};
// (93,-50.4) @TEXT("VSS",size=1.1,halign="middle",valign="top");
// &"ANY01" @WIRE(mode="straight",linecolor="#30485d",linewidth=0.16) {#XEMPTY2:1 (-10,-66)};
// (-10.4,-66) @TEXT("ANY01",size=1.1,halign="end",valign="middle");
// &"VDD" @WIRE(mode="straight",linecolor="#30485d",linewidth=0.16) {#XEMPTY2:3 (0,-56)};
// (0,-55.6) @TEXT("VDD",size=1.1,halign="middle",valign="bottom");
// &"VSS" @WIRE(mode="straight",linecolor="#30485d",linewidth=0.16) {#XEMPTY2:4 (0,-76)};
// (0,-76.4) @TEXT("VSS",size=1.1,halign="middle",valign="top");
// &"CODE2" @WIRE(mode="straight",linecolor="#30485d",linewidth=0.16) {#XTRIAL2:2 (15,-67.65)};
// (14.6,-67.65) @TEXT("CODE2",size=1.1,halign="end",valign="middle");
// &"TRIAL2" @WIRE(mode="straight",linecolor="#30485d",linewidth=0.16) {#XTRIAL2:3 (47,-66)};
// (47.4,-66) @TEXT("TRIAL2",size=1.1,halign="start",valign="middle");
// &"VDD" @WIRE(mode="straight",linecolor="#30485d",linewidth=0.16) {#XTRIAL2:4 (31,-55)};
// (31,-54.6) @TEXT("VDD",size=1.1,halign="middle",valign="bottom");
// &"VSS" @WIRE(mode="straight",linecolor="#30485d",linewidth=0.16) {#XTRIAL2:5 (31,-77)};
// (31,-77.4) @TEXT("VSS",size=1.1,halign="middle",valign="top");
// &"ANY01" @WIRE(mode="straight",linecolor="#30485d",linewidth=0.16) {#XVISIBLE2:1 (52,-64.3)};
// (51.6,-64.3) @TEXT("ANY01",size=1.1,halign="end",valign="middle");
// &"DONE" @WIRE(mode="straight",linecolor="#30485d",linewidth=0.16) {#XVISIBLE2:2 (52,-67.7)};
// (51.6,-67.7) @TEXT("DONE",size=1.1,halign="end",valign="middle");
// &"VDD" @WIRE(mode="straight",linecolor="#30485d",linewidth=0.16) {#XVISIBLE2:4 (62,-56)};
// (62,-55.6) @TEXT("VDD",size=1.1,halign="middle",valign="bottom");
// &"VSS" @WIRE(mode="straight",linecolor="#30485d",linewidth=0.16) {#XVISIBLE2:5 (62,-76)};
// (62,-76.4) @TEXT("VSS",size=1.1,halign="middle",valign="top");
// &"CODE2" @WIRE(mode="straight",linecolor="#30485d",linewidth=0.16) {#XREAD2:1 (77,-64.35)};
// (76.6,-64.35) @TEXT("CODE2",size=1.1,halign="end",valign="middle");
// &"VDD" @WIRE(mode="straight",linecolor="#30485d",linewidth=0.16) {#XREAD2:4 (93,-55)};
// (93,-54.6) @TEXT("VDD",size=1.1,halign="middle",valign="bottom");
// &"VSS" @WIRE(mode="straight",linecolor="#30485d",linewidth=0.16) {#XREAD2:5 (93,-77)};
// (93,-77.4) @TEXT("VSS",size=1.1,halign="middle",valign="top");
// &"ANY02" @WIRE(mode="straight",linecolor="#30485d",linewidth=0.16) {#XEMPTY3:1 (-10,-93)};
// (-10.4,-93) @TEXT("ANY02",size=1.1,halign="end",valign="middle");
// &"VDD" @WIRE(mode="straight",linecolor="#30485d",linewidth=0.16) {#XEMPTY3:3 (0,-83)};
// (0,-82.6) @TEXT("VDD",size=1.1,halign="middle",valign="bottom");
// &"VSS" @WIRE(mode="straight",linecolor="#30485d",linewidth=0.16) {#XEMPTY3:4 (0,-103)};
// (0,-103.4) @TEXT("VSS",size=1.1,halign="middle",valign="top");
// &"CODE3" @WIRE(mode="straight",linecolor="#30485d",linewidth=0.16) {#XTRIAL3:2 (15,-94.65)};
// (14.6,-94.65) @TEXT("CODE3",size=1.1,halign="end",valign="middle");
// &"TRIAL3" @WIRE(mode="straight",linecolor="#30485d",linewidth=0.16) {#XTRIAL3:3 (47,-93)};
// (47.4,-93) @TEXT("TRIAL3",size=1.1,halign="start",valign="middle");
// &"VDD" @WIRE(mode="straight",linecolor="#30485d",linewidth=0.16) {#XTRIAL3:4 (31,-82)};
// (31,-81.6) @TEXT("VDD",size=1.1,halign="middle",valign="bottom");
// &"VSS" @WIRE(mode="straight",linecolor="#30485d",linewidth=0.16) {#XTRIAL3:5 (31,-104)};
// (31,-104.4) @TEXT("VSS",size=1.1,halign="middle",valign="top");
// &"ANY02" @WIRE(mode="straight",linecolor="#30485d",linewidth=0.16) {#XVISIBLE3:1 (52,-91.3)};
// (51.6,-91.3) @TEXT("ANY02",size=1.1,halign="end",valign="middle");
// &"DONE" @WIRE(mode="straight",linecolor="#30485d",linewidth=0.16) {#XVISIBLE3:2 (52,-94.7)};
// (51.6,-94.7) @TEXT("DONE",size=1.1,halign="end",valign="middle");
// &"VDD" @WIRE(mode="straight",linecolor="#30485d",linewidth=0.16) {#XVISIBLE3:4 (62,-83)};
// (62,-82.6) @TEXT("VDD",size=1.1,halign="middle",valign="bottom");
// &"VSS" @WIRE(mode="straight",linecolor="#30485d",linewidth=0.16) {#XVISIBLE3:5 (62,-103)};
// (62,-103.4) @TEXT("VSS",size=1.1,halign="middle",valign="top");
// &"CODE3" @WIRE(mode="straight",linecolor="#30485d",linewidth=0.16) {#XREAD3:1 (77,-91.35)};
// (76.6,-91.35) @TEXT("CODE3",size=1.1,halign="end",valign="middle");
// &"VDD" @WIRE(mode="straight",linecolor="#30485d",linewidth=0.16) {#XREAD3:4 (93,-82)};
// (93,-81.6) @TEXT("VDD",size=1.1,halign="middle",valign="bottom");
// &"VSS" @WIRE(mode="straight",linecolor="#30485d",linewidth=0.16) {#XREAD3:5 (93,-104)};
// (93,-104.4) @TEXT("VSS",size=1.1,halign="middle",valign="top");
// &"ANY03" @WIRE(mode="straight",linecolor="#30485d",linewidth=0.16) {#XEMPTY4:1 (-10,-120)};
// (-10.4,-120) @TEXT("ANY03",size=1.1,halign="end",valign="middle");
// &"VDD" @WIRE(mode="straight",linecolor="#30485d",linewidth=0.16) {#XEMPTY4:3 (0,-110)};
// (0,-109.6) @TEXT("VDD",size=1.1,halign="middle",valign="bottom");
// &"VSS" @WIRE(mode="straight",linecolor="#30485d",linewidth=0.16) {#XEMPTY4:4 (0,-130)};
// (0,-130.4) @TEXT("VSS",size=1.1,halign="middle",valign="top");
// &"CODE4" @WIRE(mode="straight",linecolor="#30485d",linewidth=0.16) {#XTRIAL4:2 (15,-121.65)};
// (14.6,-121.65) @TEXT("CODE4",size=1.1,halign="end",valign="middle");
// &"TRIAL4" @WIRE(mode="straight",linecolor="#30485d",linewidth=0.16) {#XTRIAL4:3 (47,-120)};
// (47.4,-120) @TEXT("TRIAL4",size=1.1,halign="start",valign="middle");
// &"VDD" @WIRE(mode="straight",linecolor="#30485d",linewidth=0.16) {#XTRIAL4:4 (31,-109)};
// (31,-108.6) @TEXT("VDD",size=1.1,halign="middle",valign="bottom");
// &"VSS" @WIRE(mode="straight",linecolor="#30485d",linewidth=0.16) {#XTRIAL4:5 (31,-131)};
// (31,-131.4) @TEXT("VSS",size=1.1,halign="middle",valign="top");
// &"ANY03" @WIRE(mode="straight",linecolor="#30485d",linewidth=0.16) {#XVISIBLE4:1 (52,-118.3)};
// (51.6,-118.3) @TEXT("ANY03",size=1.1,halign="end",valign="middle");
// &"DONE" @WIRE(mode="straight",linecolor="#30485d",linewidth=0.16) {#XVISIBLE4:2 (52,-121.7)};
// (51.6,-121.7) @TEXT("DONE",size=1.1,halign="end",valign="middle");
// &"VDD" @WIRE(mode="straight",linecolor="#30485d",linewidth=0.16) {#XVISIBLE4:4 (62,-110)};
// (62,-109.6) @TEXT("VDD",size=1.1,halign="middle",valign="bottom");
// &"VSS" @WIRE(mode="straight",linecolor="#30485d",linewidth=0.16) {#XVISIBLE4:5 (62,-130)};
// (62,-130.4) @TEXT("VSS",size=1.1,halign="middle",valign="top");
// &"CODE4" @WIRE(mode="straight",linecolor="#30485d",linewidth=0.16) {#XREAD4:1 (77,-118.35)};
// (76.6,-118.35) @TEXT("CODE4",size=1.1,halign="end",valign="middle");
// &"VDD" @WIRE(mode="straight",linecolor="#30485d",linewidth=0.16) {#XREAD4:4 (93,-109)};
// (93,-108.6) @TEXT("VDD",size=1.1,halign="middle",valign="bottom");
// &"VSS" @WIRE(mode="straight",linecolor="#30485d",linewidth=0.16) {#XREAD4:5 (93,-131)};
// (93,-131.4) @TEXT("VSS",size=1.1,halign="middle",valign="top");
// &"LOW_BITS" @WIRE(mode="straight",linecolor="#30485d",linewidth=0.16) {#XEMPTY5:1 (-10,-147)};
// (-10.4,-147) @TEXT("LOW_BITS",size=1.1,halign="end",valign="middle");
// &"VDD" @WIRE(mode="straight",linecolor="#30485d",linewidth=0.16) {#XEMPTY5:3 (0,-137)};
// (0,-136.6) @TEXT("VDD",size=1.1,halign="middle",valign="bottom");
// &"VSS" @WIRE(mode="straight",linecolor="#30485d",linewidth=0.16) {#XEMPTY5:4 (0,-157)};
// (0,-157.4) @TEXT("VSS",size=1.1,halign="middle",valign="top");
// &"CODE5" @WIRE(mode="straight",linecolor="#30485d",linewidth=0.16) {#XTRIAL5:2 (15,-148.65)};
// (14.6,-148.65) @TEXT("CODE5",size=1.1,halign="end",valign="middle");
// &"TRIAL5" @WIRE(mode="straight",linecolor="#30485d",linewidth=0.16) {#XTRIAL5:3 (47,-147)};
// (47.4,-147) @TEXT("TRIAL5",size=1.1,halign="start",valign="middle");
// &"VDD" @WIRE(mode="straight",linecolor="#30485d",linewidth=0.16) {#XTRIAL5:4 (31,-136)};
// (31,-135.6) @TEXT("VDD",size=1.1,halign="middle",valign="bottom");
// &"VSS" @WIRE(mode="straight",linecolor="#30485d",linewidth=0.16) {#XTRIAL5:5 (31,-158)};
// (31,-158.4) @TEXT("VSS",size=1.1,halign="middle",valign="top");
// &"LOW_BITS" @WIRE(mode="straight",linecolor="#30485d",linewidth=0.16) {#XVISIBLE5:1 (52,-145.3)};
// (51.6,-145.3) @TEXT("LOW_BITS",size=1.1,halign="end",valign="middle");
// &"DONE" @WIRE(mode="straight",linecolor="#30485d",linewidth=0.16) {#XVISIBLE5:2 (52,-148.7)};
// (51.6,-148.7) @TEXT("DONE",size=1.1,halign="end",valign="middle");
// &"VDD" @WIRE(mode="straight",linecolor="#30485d",linewidth=0.16) {#XVISIBLE5:4 (62,-137)};
// (62,-136.6) @TEXT("VDD",size=1.1,halign="middle",valign="bottom");
// &"VSS" @WIRE(mode="straight",linecolor="#30485d",linewidth=0.16) {#XVISIBLE5:5 (62,-157)};
// (62,-157.4) @TEXT("VSS",size=1.1,halign="middle",valign="top");
// &"CODE5" @WIRE(mode="straight",linecolor="#30485d",linewidth=0.16) {#XREAD5:1 (77,-145.35)};
// (76.6,-145.35) @TEXT("CODE5",size=1.1,halign="end",valign="middle");
// &"VDD" @WIRE(mode="straight",linecolor="#30485d",linewidth=0.16) {#XREAD5:4 (93,-136)};
// (93,-135.6) @TEXT("VDD",size=1.1,halign="middle",valign="bottom");
// &"VSS" @WIRE(mode="straight",linecolor="#30485d",linewidth=0.16) {#XREAD5:5 (93,-158)};
// (93,-158.4) @TEXT("VSS",size=1.1,halign="middle",valign="top");
// &"ANY05" @WIRE(mode="straight",linecolor="#30485d",linewidth=0.16) {#XEMPTY6:1 (-10,-174)};
// (-10.4,-174) @TEXT("ANY05",size=1.1,halign="end",valign="middle");
// &"VDD" @WIRE(mode="straight",linecolor="#30485d",linewidth=0.16) {#XEMPTY6:3 (0,-164)};
// (0,-163.6) @TEXT("VDD",size=1.1,halign="middle",valign="bottom");
// &"VSS" @WIRE(mode="straight",linecolor="#30485d",linewidth=0.16) {#XEMPTY6:4 (0,-184)};
// (0,-184.4) @TEXT("VSS",size=1.1,halign="middle",valign="top");
// &"CODE6" @WIRE(mode="straight",linecolor="#30485d",linewidth=0.16) {#XTRIAL6:2 (15,-175.65)};
// (14.6,-175.65) @TEXT("CODE6",size=1.1,halign="end",valign="middle");
// &"TRIAL6" @WIRE(mode="straight",linecolor="#30485d",linewidth=0.16) {#XTRIAL6:3 (47,-174)};
// (47.4,-174) @TEXT("TRIAL6",size=1.1,halign="start",valign="middle");
// &"VDD" @WIRE(mode="straight",linecolor="#30485d",linewidth=0.16) {#XTRIAL6:4 (31,-163)};
// (31,-162.6) @TEXT("VDD",size=1.1,halign="middle",valign="bottom");
// &"VSS" @WIRE(mode="straight",linecolor="#30485d",linewidth=0.16) {#XTRIAL6:5 (31,-185)};
// (31,-185.4) @TEXT("VSS",size=1.1,halign="middle",valign="top");
// &"ANY05" @WIRE(mode="straight",linecolor="#30485d",linewidth=0.16) {#XVISIBLE6:1 (52,-172.3)};
// (51.6,-172.3) @TEXT("ANY05",size=1.1,halign="end",valign="middle");
// &"DONE" @WIRE(mode="straight",linecolor="#30485d",linewidth=0.16) {#XVISIBLE6:2 (52,-175.7)};
// (51.6,-175.7) @TEXT("DONE",size=1.1,halign="end",valign="middle");
// &"VDD" @WIRE(mode="straight",linecolor="#30485d",linewidth=0.16) {#XVISIBLE6:4 (62,-164)};
// (62,-163.6) @TEXT("VDD",size=1.1,halign="middle",valign="bottom");
// &"VSS" @WIRE(mode="straight",linecolor="#30485d",linewidth=0.16) {#XVISIBLE6:5 (62,-184)};
// (62,-184.4) @TEXT("VSS",size=1.1,halign="middle",valign="top");
// &"CODE6" @WIRE(mode="straight",linecolor="#30485d",linewidth=0.16) {#XREAD6:1 (77,-172.35)};
// (76.6,-172.35) @TEXT("CODE6",size=1.1,halign="end",valign="middle");
// &"VDD" @WIRE(mode="straight",linecolor="#30485d",linewidth=0.16) {#XREAD6:4 (93,-163)};
// (93,-162.6) @TEXT("VDD",size=1.1,halign="middle",valign="bottom");
// &"VSS" @WIRE(mode="straight",linecolor="#30485d",linewidth=0.16) {#XREAD6:5 (93,-185)};
// (93,-185.4) @TEXT("VSS",size=1.1,halign="middle",valign="top");
// &"ANY06" @WIRE(mode="straight",linecolor="#30485d",linewidth=0.16) {#XEMPTY7:1 (-10,-201)};
// (-10.4,-201) @TEXT("ANY06",size=1.1,halign="end",valign="middle");
// &"VDD" @WIRE(mode="straight",linecolor="#30485d",linewidth=0.16) {#XEMPTY7:3 (0,-191)};
// (0,-190.6) @TEXT("VDD",size=1.1,halign="middle",valign="bottom");
// &"VSS" @WIRE(mode="straight",linecolor="#30485d",linewidth=0.16) {#XEMPTY7:4 (0,-211)};
// (0,-211.4) @TEXT("VSS",size=1.1,halign="middle",valign="top");
// &"CODE7" @WIRE(mode="straight",linecolor="#30485d",linewidth=0.16) {#XTRIAL7:2 (15,-202.65)};
// (14.6,-202.65) @TEXT("CODE7",size=1.1,halign="end",valign="middle");
// &"TRIAL7" @WIRE(mode="straight",linecolor="#30485d",linewidth=0.16) {#XTRIAL7:3 (47,-201)};
// (47.4,-201) @TEXT("TRIAL7",size=1.1,halign="start",valign="middle");
// &"VDD" @WIRE(mode="straight",linecolor="#30485d",linewidth=0.16) {#XTRIAL7:4 (31,-190)};
// (31,-189.6) @TEXT("VDD",size=1.1,halign="middle",valign="bottom");
// &"VSS" @WIRE(mode="straight",linecolor="#30485d",linewidth=0.16) {#XTRIAL7:5 (31,-212)};
// (31,-212.4) @TEXT("VSS",size=1.1,halign="middle",valign="top");
// &"ANY06" @WIRE(mode="straight",linecolor="#30485d",linewidth=0.16) {#XVISIBLE7:1 (52,-199.3)};
// (51.6,-199.3) @TEXT("ANY06",size=1.1,halign="end",valign="middle");
// &"DONE" @WIRE(mode="straight",linecolor="#30485d",linewidth=0.16) {#XVISIBLE7:2 (52,-202.7)};
// (51.6,-202.7) @TEXT("DONE",size=1.1,halign="end",valign="middle");
// &"VDD" @WIRE(mode="straight",linecolor="#30485d",linewidth=0.16) {#XVISIBLE7:4 (62,-191)};
// (62,-190.6) @TEXT("VDD",size=1.1,halign="middle",valign="bottom");
// &"VSS" @WIRE(mode="straight",linecolor="#30485d",linewidth=0.16) {#XVISIBLE7:5 (62,-211)};
// (62,-211.4) @TEXT("VSS",size=1.1,halign="middle",valign="top");
// &"CODE7" @WIRE(mode="straight",linecolor="#30485d",linewidth=0.16) {#XREAD7:1 (77,-199.35)};
// (76.6,-199.35) @TEXT("CODE7",size=1.1,halign="end",valign="middle");
// &"D7" @WIRE(mode="straight",linecolor="#30485d",linewidth=0.16) {#XREAD7:3 (109,-201)};
// (109.4,-201) @TEXT("D7",size=1.1,halign="start",valign="middle");
// &"VDD" @WIRE(mode="straight",linecolor="#30485d",linewidth=0.16) {#XREAD7:4 (93,-190)};
// (93,-189.6) @TEXT("VDD",size=1.1,halign="middle",valign="bottom");
// &"VSS" @WIRE(mode="straight",linecolor="#30485d",linewidth=0.16) {#XREAD7:5 (93,-212)};
// (93,-212.4) @TEXT("VSS",size=1.1,halign="middle",valign="top");
// &"TRIAL1" @WIRE(mode="straight",linecolor="#30485d",linewidth=0.16) {#XBASE0:2 (114,-13.7)};
// (113.6,-13.7) @TEXT("TRIAL1",size=1.1,halign="end",valign="middle");
// &"BASE0" @WIRE(mode="straight",linecolor="#30485d",linewidth=0.16) {#XBASE0:3 (134,-12)};
// (134.4,-12) @TEXT("BASE0",size=1.1,halign="start",valign="middle");
// &"VDD" @WIRE(mode="straight",linecolor="#30485d",linewidth=0.16) {#XBASE0:4 (124,-2)};
// (124,-1.6) @TEXT("VDD",size=1.1,halign="middle",valign="bottom");
// &"VSS" @WIRE(mode="straight",linecolor="#30485d",linewidth=0.16) {#XBASE0:5 (124,-22)};
// (124,-22.4) @TEXT("VSS",size=1.1,halign="middle",valign="top");
// &"CODE0" @WIRE(mode="straight",linecolor="#30485d",linewidth=0.16) {#XKEEP0:1 (139,-10.35)};
// (138.6,-10.35) @TEXT("CODE0",size=1.1,halign="end",valign="middle");
// &"DATA" @WIRE(mode="straight",linecolor="#30485d",linewidth=0.16) {#XKEEP0:2 (139,-13.65)};
// (138.6,-13.65) @TEXT("DATA",size=1.1,halign="end",valign="middle");
// &"VDD" @WIRE(mode="straight",linecolor="#30485d",linewidth=0.16) {#XKEEP0:4 (155,-1)};
// (155,-0.6) @TEXT("VDD",size=1.1,halign="middle",valign="bottom");
// &"VSS" @WIRE(mode="straight",linecolor="#30485d",linewidth=0.16) {#XKEEP0:5 (155,-23)};
// (155,-23.4) @TEXT("VSS",size=1.1,halign="middle",valign="top");
// &"BASE0" @WIRE(mode="straight",linecolor="#30485d",linewidth=0.16) {#XNEXT0:1 (176,-10.3)};
// (175.6,-10.3) @TEXT("BASE0",size=1.1,halign="end",valign="middle");
// &"NEXT0" @WIRE(mode="straight",linecolor="#30485d",linewidth=0.16) {#XNEXT0:3 (196,-12)};
// (196.4,-12) @TEXT("NEXT0",size=1.1,halign="start",valign="middle");
// &"VDD" @WIRE(mode="straight",linecolor="#30485d",linewidth=0.16) {#XNEXT0:4 (186,-2)};
// (186,-1.6) @TEXT("VDD",size=1.1,halign="middle",valign="bottom");
// &"VSS" @WIRE(mode="straight",linecolor="#30485d",linewidth=0.16) {#XNEXT0:5 (186,-22)};
// (186,-22.4) @TEXT("VSS",size=1.1,halign="middle",valign="top");
// &"TRIAL2" @WIRE(mode="straight",linecolor="#30485d",linewidth=0.16) {#XBASE1:2 (114,-40.7)};
// (113.6,-40.7) @TEXT("TRIAL2",size=1.1,halign="end",valign="middle");
// &"BASE1" @WIRE(mode="straight",linecolor="#30485d",linewidth=0.16) {#XBASE1:3 (134,-39)};
// (134.4,-39) @TEXT("BASE1",size=1.1,halign="start",valign="middle");
// &"VDD" @WIRE(mode="straight",linecolor="#30485d",linewidth=0.16) {#XBASE1:4 (124,-29)};
// (124,-28.6) @TEXT("VDD",size=1.1,halign="middle",valign="bottom");
// &"VSS" @WIRE(mode="straight",linecolor="#30485d",linewidth=0.16) {#XBASE1:5 (124,-49)};
// (124,-49.4) @TEXT("VSS",size=1.1,halign="middle",valign="top");
// &"TRIAL1" @WIRE(mode="straight",linecolor="#30485d",linewidth=0.16) {#XKEEP1:1 (139,-37.35)};
// (138.6,-37.35) @TEXT("TRIAL1",size=1.1,halign="end",valign="middle");
// &"DATA" @WIRE(mode="straight",linecolor="#30485d",linewidth=0.16) {#XKEEP1:2 (139,-40.65)};
// (138.6,-40.65) @TEXT("DATA",size=1.1,halign="end",valign="middle");
// &"VDD" @WIRE(mode="straight",linecolor="#30485d",linewidth=0.16) {#XKEEP1:4 (155,-28)};
// (155,-27.6) @TEXT("VDD",size=1.1,halign="middle",valign="bottom");
// &"VSS" @WIRE(mode="straight",linecolor="#30485d",linewidth=0.16) {#XKEEP1:5 (155,-50)};
// (155,-50.4) @TEXT("VSS",size=1.1,halign="middle",valign="top");
// &"BASE1" @WIRE(mode="straight",linecolor="#30485d",linewidth=0.16) {#XNEXT1:1 (176,-37.3)};
// (175.6,-37.3) @TEXT("BASE1",size=1.1,halign="end",valign="middle");
// &"NEXT1" @WIRE(mode="straight",linecolor="#30485d",linewidth=0.16) {#XNEXT1:3 (196,-39)};
// (196.4,-39) @TEXT("NEXT1",size=1.1,halign="start",valign="middle");
// &"VDD" @WIRE(mode="straight",linecolor="#30485d",linewidth=0.16) {#XNEXT1:4 (186,-29)};
// (186,-28.6) @TEXT("VDD",size=1.1,halign="middle",valign="bottom");
// &"VSS" @WIRE(mode="straight",linecolor="#30485d",linewidth=0.16) {#XNEXT1:5 (186,-49)};
// (186,-49.4) @TEXT("VSS",size=1.1,halign="middle",valign="top");
// &"TRIAL3" @WIRE(mode="straight",linecolor="#30485d",linewidth=0.16) {#XBASE2:2 (114,-67.7)};
// (113.6,-67.7) @TEXT("TRIAL3",size=1.1,halign="end",valign="middle");
// &"BASE2" @WIRE(mode="straight",linecolor="#30485d",linewidth=0.16) {#XBASE2:3 (134,-66)};
// (134.4,-66) @TEXT("BASE2",size=1.1,halign="start",valign="middle");
// &"VDD" @WIRE(mode="straight",linecolor="#30485d",linewidth=0.16) {#XBASE2:4 (124,-56)};
// (124,-55.6) @TEXT("VDD",size=1.1,halign="middle",valign="bottom");
// &"VSS" @WIRE(mode="straight",linecolor="#30485d",linewidth=0.16) {#XBASE2:5 (124,-76)};
// (124,-76.4) @TEXT("VSS",size=1.1,halign="middle",valign="top");
// &"TRIAL2" @WIRE(mode="straight",linecolor="#30485d",linewidth=0.16) {#XKEEP2:1 (139,-64.35)};
// (138.6,-64.35) @TEXT("TRIAL2",size=1.1,halign="end",valign="middle");
// &"DATA" @WIRE(mode="straight",linecolor="#30485d",linewidth=0.16) {#XKEEP2:2 (139,-67.65)};
// (138.6,-67.65) @TEXT("DATA",size=1.1,halign="end",valign="middle");
// &"VDD" @WIRE(mode="straight",linecolor="#30485d",linewidth=0.16) {#XKEEP2:4 (155,-55)};
// (155,-54.6) @TEXT("VDD",size=1.1,halign="middle",valign="bottom");
// &"VSS" @WIRE(mode="straight",linecolor="#30485d",linewidth=0.16) {#XKEEP2:5 (155,-77)};
// (155,-77.4) @TEXT("VSS",size=1.1,halign="middle",valign="top");
// &"BASE2" @WIRE(mode="straight",linecolor="#30485d",linewidth=0.16) {#XNEXT2:1 (176,-64.3)};
// (175.6,-64.3) @TEXT("BASE2",size=1.1,halign="end",valign="middle");
// &"NEXT2" @WIRE(mode="straight",linecolor="#30485d",linewidth=0.16) {#XNEXT2:3 (196,-66)};
// (196.4,-66) @TEXT("NEXT2",size=1.1,halign="start",valign="middle");
// &"VDD" @WIRE(mode="straight",linecolor="#30485d",linewidth=0.16) {#XNEXT2:4 (186,-56)};
// (186,-55.6) @TEXT("VDD",size=1.1,halign="middle",valign="bottom");
// &"VSS" @WIRE(mode="straight",linecolor="#30485d",linewidth=0.16) {#XNEXT2:5 (186,-76)};
// (186,-76.4) @TEXT("VSS",size=1.1,halign="middle",valign="top");
// &"TRIAL4" @WIRE(mode="straight",linecolor="#30485d",linewidth=0.16) {#XBASE3:2 (114,-94.7)};
// (113.6,-94.7) @TEXT("TRIAL4",size=1.1,halign="end",valign="middle");
// &"BASE3" @WIRE(mode="straight",linecolor="#30485d",linewidth=0.16) {#XBASE3:3 (134,-93)};
// (134.4,-93) @TEXT("BASE3",size=1.1,halign="start",valign="middle");
// &"VDD" @WIRE(mode="straight",linecolor="#30485d",linewidth=0.16) {#XBASE3:4 (124,-83)};
// (124,-82.6) @TEXT("VDD",size=1.1,halign="middle",valign="bottom");
// &"VSS" @WIRE(mode="straight",linecolor="#30485d",linewidth=0.16) {#XBASE3:5 (124,-103)};
// (124,-103.4) @TEXT("VSS",size=1.1,halign="middle",valign="top");
// &"TRIAL3" @WIRE(mode="straight",linecolor="#30485d",linewidth=0.16) {#XKEEP3:1 (139,-91.35)};
// (138.6,-91.35) @TEXT("TRIAL3",size=1.1,halign="end",valign="middle");
// &"DATA" @WIRE(mode="straight",linecolor="#30485d",linewidth=0.16) {#XKEEP3:2 (139,-94.65)};
// (138.6,-94.65) @TEXT("DATA",size=1.1,halign="end",valign="middle");
// &"VDD" @WIRE(mode="straight",linecolor="#30485d",linewidth=0.16) {#XKEEP3:4 (155,-82)};
// (155,-81.6) @TEXT("VDD",size=1.1,halign="middle",valign="bottom");
// &"VSS" @WIRE(mode="straight",linecolor="#30485d",linewidth=0.16) {#XKEEP3:5 (155,-104)};
// (155,-104.4) @TEXT("VSS",size=1.1,halign="middle",valign="top");
// &"BASE3" @WIRE(mode="straight",linecolor="#30485d",linewidth=0.16) {#XNEXT3:1 (176,-91.3)};
// (175.6,-91.3) @TEXT("BASE3",size=1.1,halign="end",valign="middle");
// &"NEXT3" @WIRE(mode="straight",linecolor="#30485d",linewidth=0.16) {#XNEXT3:3 (196,-93)};
// (196.4,-93) @TEXT("NEXT3",size=1.1,halign="start",valign="middle");
// &"VDD" @WIRE(mode="straight",linecolor="#30485d",linewidth=0.16) {#XNEXT3:4 (186,-83)};
// (186,-82.6) @TEXT("VDD",size=1.1,halign="middle",valign="bottom");
// &"VSS" @WIRE(mode="straight",linecolor="#30485d",linewidth=0.16) {#XNEXT3:5 (186,-103)};
// (186,-103.4) @TEXT("VSS",size=1.1,halign="middle",valign="top");
// &"TRIAL5" @WIRE(mode="straight",linecolor="#30485d",linewidth=0.16) {#XBASE4:2 (114,-121.7)};
// (113.6,-121.7) @TEXT("TRIAL5",size=1.1,halign="end",valign="middle");
// &"BASE4" @WIRE(mode="straight",linecolor="#30485d",linewidth=0.16) {#XBASE4:3 (134,-120)};
// (134.4,-120) @TEXT("BASE4",size=1.1,halign="start",valign="middle");
// &"VDD" @WIRE(mode="straight",linecolor="#30485d",linewidth=0.16) {#XBASE4:4 (124,-110)};
// (124,-109.6) @TEXT("VDD",size=1.1,halign="middle",valign="bottom");
// &"VSS" @WIRE(mode="straight",linecolor="#30485d",linewidth=0.16) {#XBASE4:5 (124,-130)};
// (124,-130.4) @TEXT("VSS",size=1.1,halign="middle",valign="top");
// &"TRIAL4" @WIRE(mode="straight",linecolor="#30485d",linewidth=0.16) {#XKEEP4:1 (139,-118.35)};
// (138.6,-118.35) @TEXT("TRIAL4",size=1.1,halign="end",valign="middle");
// &"DATA" @WIRE(mode="straight",linecolor="#30485d",linewidth=0.16) {#XKEEP4:2 (139,-121.65)};
// (138.6,-121.65) @TEXT("DATA",size=1.1,halign="end",valign="middle");
// &"VDD" @WIRE(mode="straight",linecolor="#30485d",linewidth=0.16) {#XKEEP4:4 (155,-109)};
// (155,-108.6) @TEXT("VDD",size=1.1,halign="middle",valign="bottom");
// &"VSS" @WIRE(mode="straight",linecolor="#30485d",linewidth=0.16) {#XKEEP4:5 (155,-131)};
// (155,-131.4) @TEXT("VSS",size=1.1,halign="middle",valign="top");
// &"BASE4" @WIRE(mode="straight",linecolor="#30485d",linewidth=0.16) {#XNEXT4:1 (176,-118.3)};
// (175.6,-118.3) @TEXT("BASE4",size=1.1,halign="end",valign="middle");
// &"NEXT4" @WIRE(mode="straight",linecolor="#30485d",linewidth=0.16) {#XNEXT4:3 (196,-120)};
// (196.4,-120) @TEXT("NEXT4",size=1.1,halign="start",valign="middle");
// &"VDD" @WIRE(mode="straight",linecolor="#30485d",linewidth=0.16) {#XNEXT4:4 (186,-110)};
// (186,-109.6) @TEXT("VDD",size=1.1,halign="middle",valign="bottom");
// &"VSS" @WIRE(mode="straight",linecolor="#30485d",linewidth=0.16) {#XNEXT4:5 (186,-130)};
// (186,-130.4) @TEXT("VSS",size=1.1,halign="middle",valign="top");
// &"TRIAL6" @WIRE(mode="straight",linecolor="#30485d",linewidth=0.16) {#XBASE5:2 (114,-148.7)};
// (113.6,-148.7) @TEXT("TRIAL6",size=1.1,halign="end",valign="middle");
// &"BASE5" @WIRE(mode="straight",linecolor="#30485d",linewidth=0.16) {#XBASE5:3 (134,-147)};
// (134.4,-147) @TEXT("BASE5",size=1.1,halign="start",valign="middle");
// &"VDD" @WIRE(mode="straight",linecolor="#30485d",linewidth=0.16) {#XBASE5:4 (124,-137)};
// (124,-136.6) @TEXT("VDD",size=1.1,halign="middle",valign="bottom");
// &"VSS" @WIRE(mode="straight",linecolor="#30485d",linewidth=0.16) {#XBASE5:5 (124,-157)};
// (124,-157.4) @TEXT("VSS",size=1.1,halign="middle",valign="top");
// &"TRIAL5" @WIRE(mode="straight",linecolor="#30485d",linewidth=0.16) {#XKEEP5:1 (139,-145.35)};
// (138.6,-145.35) @TEXT("TRIAL5",size=1.1,halign="end",valign="middle");
// &"DATA" @WIRE(mode="straight",linecolor="#30485d",linewidth=0.16) {#XKEEP5:2 (139,-148.65)};
// (138.6,-148.65) @TEXT("DATA",size=1.1,halign="end",valign="middle");
// &"VDD" @WIRE(mode="straight",linecolor="#30485d",linewidth=0.16) {#XKEEP5:4 (155,-136)};
// (155,-135.6) @TEXT("VDD",size=1.1,halign="middle",valign="bottom");
// &"VSS" @WIRE(mode="straight",linecolor="#30485d",linewidth=0.16) {#XKEEP5:5 (155,-158)};
// (155,-158.4) @TEXT("VSS",size=1.1,halign="middle",valign="top");
// &"BASE5" @WIRE(mode="straight",linecolor="#30485d",linewidth=0.16) {#XNEXT5:1 (176,-145.3)};
// (175.6,-145.3) @TEXT("BASE5",size=1.1,halign="end",valign="middle");
// &"NEXT5" @WIRE(mode="straight",linecolor="#30485d",linewidth=0.16) {#XNEXT5:3 (196,-147)};
// (196.4,-147) @TEXT("NEXT5",size=1.1,halign="start",valign="middle");
// &"VDD" @WIRE(mode="straight",linecolor="#30485d",linewidth=0.16) {#XNEXT5:4 (186,-137)};
// (186,-136.6) @TEXT("VDD",size=1.1,halign="middle",valign="bottom");
// &"VSS" @WIRE(mode="straight",linecolor="#30485d",linewidth=0.16) {#XNEXT5:5 (186,-157)};
// (186,-157.4) @TEXT("VSS",size=1.1,halign="middle",valign="top");
// &"TRIAL7" @WIRE(mode="straight",linecolor="#30485d",linewidth=0.16) {#XBASE6:2 (114,-175.7)};
// (113.6,-175.7) @TEXT("TRIAL7",size=1.1,halign="end",valign="middle");
// &"BASE6" @WIRE(mode="straight",linecolor="#30485d",linewidth=0.16) {#XBASE6:3 (134,-174)};
// (134.4,-174) @TEXT("BASE6",size=1.1,halign="start",valign="middle");
// &"VDD" @WIRE(mode="straight",linecolor="#30485d",linewidth=0.16) {#XBASE6:4 (124,-164)};
// (124,-163.6) @TEXT("VDD",size=1.1,halign="middle",valign="bottom");
// &"VSS" @WIRE(mode="straight",linecolor="#30485d",linewidth=0.16) {#XBASE6:5 (124,-184)};
// (124,-184.4) @TEXT("VSS",size=1.1,halign="middle",valign="top");
// &"TRIAL6" @WIRE(mode="straight",linecolor="#30485d",linewidth=0.16) {#XKEEP6:1 (139,-172.35)};
// (138.6,-172.35) @TEXT("TRIAL6",size=1.1,halign="end",valign="middle");
// &"DATA" @WIRE(mode="straight",linecolor="#30485d",linewidth=0.16) {#XKEEP6:2 (139,-175.65)};
// (138.6,-175.65) @TEXT("DATA",size=1.1,halign="end",valign="middle");
// &"VDD" @WIRE(mode="straight",linecolor="#30485d",linewidth=0.16) {#XKEEP6:4 (155,-163)};
// (155,-162.6) @TEXT("VDD",size=1.1,halign="middle",valign="bottom");
// &"VSS" @WIRE(mode="straight",linecolor="#30485d",linewidth=0.16) {#XKEEP6:5 (155,-185)};
// (155,-185.4) @TEXT("VSS",size=1.1,halign="middle",valign="top");
// &"BASE6" @WIRE(mode="straight",linecolor="#30485d",linewidth=0.16) {#XNEXT6:1 (176,-172.3)};
// (175.6,-172.3) @TEXT("BASE6",size=1.1,halign="end",valign="middle");
// &"NEXT6" @WIRE(mode="straight",linecolor="#30485d",linewidth=0.16) {#XNEXT6:3 (196,-174)};
// (196.4,-174) @TEXT("NEXT6",size=1.1,halign="start",valign="middle");
// &"VDD" @WIRE(mode="straight",linecolor="#30485d",linewidth=0.16) {#XNEXT6:4 (186,-164)};
// (186,-163.6) @TEXT("VDD",size=1.1,halign="middle",valign="bottom");
// &"VSS" @WIRE(mode="straight",linecolor="#30485d",linewidth=0.16) {#XNEXT6:5 (186,-184)};
// (186,-184.4) @TEXT("VSS",size=1.1,halign="middle",valign="top");
// &"TRIAL7" @WIRE(mode="straight",linecolor="#30485d",linewidth=0.16) {#XKEEP7:1 (139,-199.35)};
// (138.6,-199.35) @TEXT("TRIAL7",size=1.1,halign="end",valign="middle");
// &"DATA" @WIRE(mode="straight",linecolor="#30485d",linewidth=0.16) {#XKEEP7:2 (139,-202.65)};
// (138.6,-202.65) @TEXT("DATA",size=1.1,halign="end",valign="middle");
// &"VDD" @WIRE(mode="straight",linecolor="#30485d",linewidth=0.16) {#XKEEP7:4 (155,-190)};
// (155,-189.6) @TEXT("VDD",size=1.1,halign="middle",valign="bottom");
// &"VSS" @WIRE(mode="straight",linecolor="#30485d",linewidth=0.16) {#XKEEP7:5 (155,-212)};
// (155,-212.4) @TEXT("VSS",size=1.1,halign="middle",valign="top");
// &"D7" @WIRE(mode="straight",linecolor="#30485d",linewidth=0.16) {#XNEXT7:1 (176,-199.3)};
// (175.6,-199.3) @TEXT("D7",size=1.1,halign="end",valign="middle");
// &"NEXT7" @WIRE(mode="straight",linecolor="#30485d",linewidth=0.16) {#XNEXT7:3 (196,-201)};
// (196.4,-201) @TEXT("NEXT7",size=1.1,halign="start",valign="middle");
// &"VDD" @WIRE(mode="straight",linecolor="#30485d",linewidth=0.16) {#XNEXT7:4 (186,-191)};
// (186,-190.6) @TEXT("VDD",size=1.1,halign="middle",valign="bottom");
// &"VSS" @WIRE(mode="straight",linecolor="#30485d",linewidth=0.16) {#XNEXT7:5 (186,-211)};
// (186,-211.4) @TEXT("VSS",size=1.1,halign="middle",valign="top");
// }
// END SARADC RNL
ends sar8_next_word

subckt sar8_se_window PHASE_REQUEST SEL9 SEL7 SEL6 SEL5 SEL4 VDD VSS DELIVERED
// A transition propagates once per decision. Both polarities traverse real DEL cells.
// Taps by compared bit: 6:T11 5:T9 4:T7 3:T6 2:T5 1,0:T4. Each SELn rises once per
// conversion, on the commit before its first use, and only shortens the window.
XDEL1 (PHASE_REQUEST T1 VDD VSS) DEL250D1BWP12T30P140
XDEL2 (T1 T2 VDD VSS) DEL250D1BWP12T30P140
XDEL3 (T2 T3 VDD VSS) DEL250D1BWP12T30P140
XDEL4 (T3 T4 VDD VSS) DEL250D1BWP12T30P140
XDEL5 (T4 T5 VDD VSS) DEL250D1BWP12T30P140
XDEL6 (T5 T6 VDD VSS) DEL250D1BWP12T30P140
XDEL7 (T6 T7 VDD VSS) DEL250D1BWP12T30P140
XDEL8 (T7 T8 VDD VSS) DEL250D1BWP12T30P140
XDEL9 (T8 T9 VDD VSS) DEL250D1BWP12T30P140
XDEL10 (T9 T10 VDD VSS) DEL250D1BWP12T30P140
XDEL11 (T10 T11 VDD VSS) DEL250D1BWP12T30P140
XTAP9 (T11 T9 SEL9 W9 VDD VSS) MUX2D1BWP12T30P140
XTAP7 (W9 T7 SEL7 W7 VDD VSS) MUX2D1BWP12T30P140
XTAP6 (W7 T6 SEL6 W6 VDD VSS) MUX2D1BWP12T30P140
XTAP5 (W6 T5 SEL5 W5 VDD VSS) MUX2D1BWP12T30P140
XTAP4 (W5 T4 SEL4 DELIVERED VDD VSS) MUX2D1BWP12T30P140
// BEGIN SARADC RNL
// @RNL(author="saradc topology") {
// (-14,59) @TEXT("Settling window / delay chain and selected taps",size=1.9,halign="start",textcolor="#223d52");
// #XDEL1 @SET-SYMBOL $S_DEL250D1BWP12T30P140;
// #XDEL1 @PLACE(0,25) => @ORIENT("R0");
// #XDEL2 @SET-SYMBOL $S_DEL250D1BWP12T30P140;
// #XDEL2 @PLACE(27,25) => @ORIENT("R0");
// #XDEL3 @SET-SYMBOL $S_DEL250D1BWP12T30P140;
// #XDEL3 @PLACE(54,25) => @ORIENT("R0");
// #XDEL4 @SET-SYMBOL $S_DEL250D1BWP12T30P140;
// #XDEL4 @PLACE(81,25) => @ORIENT("R0");
// #XDEL5 @SET-SYMBOL $S_DEL250D1BWP12T30P140;
// #XDEL5 @PLACE(108,25) => @ORIENT("R0");
// #XDEL6 @SET-SYMBOL $S_DEL250D1BWP12T30P140;
// #XDEL6 @PLACE(135,25) => @ORIENT("R0");
// #XDEL7 @SET-SYMBOL $S_DEL250D1BWP12T30P140;
// #XDEL7 @PLACE(162,25) => @ORIENT("R0");
// #XDEL8 @SET-SYMBOL $S_DEL250D1BWP12T30P140;
// #XDEL8 @PLACE(189,25) => @ORIENT("R0");
// #XDEL9 @SET-SYMBOL $S_DEL250D1BWP12T30P140;
// #XDEL9 @PLACE(216,25) => @ORIENT("R0");
// #XDEL10 @SET-SYMBOL $S_DEL250D1BWP12T30P140;
// #XDEL10 @PLACE(243,25) => @ORIENT("R0");
// #XDEL11 @SET-SYMBOL $S_DEL250D1BWP12T30P140;
// #XDEL11 @PLACE(270,25) => @ORIENT("R0");
// #XTAP4 @SET-SYMBOL $S_MUX2D1BWP12T30P140;
// #XTAP4 @PLACE(0,-24) => @ORIENT("R0");
// #XTAP5 @SET-SYMBOL $S_MUX2D1BWP12T30P140;
// #XTAP5 @PLACE(54,-24) => @ORIENT("R0");
// #XTAP6 @SET-SYMBOL $S_MUX2D1BWP12T30P140;
// #XTAP6 @PLACE(108,-24) => @ORIENT("R0");
// #XTAP7 @SET-SYMBOL $S_MUX2D1BWP12T30P140;
// #XTAP7 @PLACE(162,-24) => @ORIENT("R0");
// #XTAP9 @SET-SYMBOL $S_MUX2D1BWP12T30P140;
// #XTAP9 @PLACE(216,-24) => @ORIENT("R0");
// &"T1" @WIRE(mode="straight",linecolor="#30485d",linewidth=0.16) {#XDEL1:2 (13.5,25) (13.5,25) #XDEL2:1};
// &"T2" @WIRE(mode="straight",linecolor="#30485d",linewidth=0.16) {#XDEL2:2 (40.5,25) (40.5,25) #XDEL3:1};
// &"T3" @WIRE(mode="straight",linecolor="#30485d",linewidth=0.16) {#XDEL3:2 (67.5,25) (67.5,25) #XDEL4:1};
// &"T4" @WIRE(mode="straight",linecolor="#30485d",linewidth=0.16) {#XDEL4:2 (94.5,25) (94.5,25) #XDEL5:1};
// &"T5" @WIRE(mode="straight",linecolor="#30485d",linewidth=0.16) {#XDEL5:2 (121.5,25) (121.5,25) #XDEL6:1};
// &"T6" @WIRE(mode="straight",linecolor="#30485d",linewidth=0.16) {#XDEL6:2 (148.5,25) (148.5,25) #XDEL7:1};
// &"T7" @WIRE(mode="straight",linecolor="#30485d",linewidth=0.16) {#XDEL7:2 (175.5,25) (175.5,25) #XDEL8:1};
// &"T8" @WIRE(mode="straight",linecolor="#30485d",linewidth=0.16) {#XDEL8:2 (202.5,25) (202.5,25) #XDEL9:1};
// &"T9" @WIRE(mode="straight",linecolor="#30485d",linewidth=0.16) {#XDEL9:2 (229.5,25) (229.5,25) #XDEL10:1};
// &"T10" @WIRE(mode="straight",linecolor="#30485d",linewidth=0.16) {#XDEL10:2 (256.5,25) (256.5,25) #XDEL11:1};
// &"PHASE_REQUEST" @WIRE(mode="straight",linecolor="#30485d",linewidth=0.16) {#XDEL1:1 (-16,25)};
// (-16.4,25) @TEXT("PHASE_REQUEST",size=1.1,halign="end",valign="middle");
// &"VDD" @WIRE(mode="straight",linecolor="#30485d",linewidth=0.16) {#XDEL1:3 (0,36)};
// (0,36.4) @TEXT("VDD",size=1.1,halign="middle",valign="bottom");
// &"VSS" @WIRE(mode="straight",linecolor="#30485d",linewidth=0.16) {#XDEL1:4 (0,14)};
// (0,13.6) @TEXT("VSS",size=1.1,halign="middle",valign="top");
// &"VDD" @WIRE(mode="straight",linecolor="#30485d",linewidth=0.16) {#XDEL2:3 (27,36)};
// (27,36.4) @TEXT("VDD",size=1.1,halign="middle",valign="bottom");
// &"VSS" @WIRE(mode="straight",linecolor="#30485d",linewidth=0.16) {#XDEL2:4 (27,14)};
// (27,13.6) @TEXT("VSS",size=1.1,halign="middle",valign="top");
// &"VDD" @WIRE(mode="straight",linecolor="#30485d",linewidth=0.16) {#XDEL3:3 (54,36)};
// (54,36.4) @TEXT("VDD",size=1.1,halign="middle",valign="bottom");
// &"VSS" @WIRE(mode="straight",linecolor="#30485d",linewidth=0.16) {#XDEL3:4 (54,14)};
// (54,13.6) @TEXT("VSS",size=1.1,halign="middle",valign="top");
// &"VDD" @WIRE(mode="straight",linecolor="#30485d",linewidth=0.16) {#XDEL4:3 (81,36)};
// (81,36.4) @TEXT("VDD",size=1.1,halign="middle",valign="bottom");
// &"VSS" @WIRE(mode="straight",linecolor="#30485d",linewidth=0.16) {#XDEL4:4 (81,14)};
// (81,13.6) @TEXT("VSS",size=1.1,halign="middle",valign="top");
// &"VDD" @WIRE(mode="straight",linecolor="#30485d",linewidth=0.16) {#XDEL5:3 (108,36)};
// (108,36.4) @TEXT("VDD",size=1.1,halign="middle",valign="bottom");
// &"VSS" @WIRE(mode="straight",linecolor="#30485d",linewidth=0.16) {#XDEL5:4 (108,14)};
// (108,13.6) @TEXT("VSS",size=1.1,halign="middle",valign="top");
// &"VDD" @WIRE(mode="straight",linecolor="#30485d",linewidth=0.16) {#XDEL6:3 (135,36)};
// (135,36.4) @TEXT("VDD",size=1.1,halign="middle",valign="bottom");
// &"VSS" @WIRE(mode="straight",linecolor="#30485d",linewidth=0.16) {#XDEL6:4 (135,14)};
// (135,13.6) @TEXT("VSS",size=1.1,halign="middle",valign="top");
// &"VDD" @WIRE(mode="straight",linecolor="#30485d",linewidth=0.16) {#XDEL7:3 (162,36)};
// (162,36.4) @TEXT("VDD",size=1.1,halign="middle",valign="bottom");
// &"VSS" @WIRE(mode="straight",linecolor="#30485d",linewidth=0.16) {#XDEL7:4 (162,14)};
// (162,13.6) @TEXT("VSS",size=1.1,halign="middle",valign="top");
// &"VDD" @WIRE(mode="straight",linecolor="#30485d",linewidth=0.16) {#XDEL8:3 (189,36)};
// (189,36.4) @TEXT("VDD",size=1.1,halign="middle",valign="bottom");
// &"VSS" @WIRE(mode="straight",linecolor="#30485d",linewidth=0.16) {#XDEL8:4 (189,14)};
// (189,13.6) @TEXT("VSS",size=1.1,halign="middle",valign="top");
// &"VDD" @WIRE(mode="straight",linecolor="#30485d",linewidth=0.16) {#XDEL9:3 (216,36)};
// (216,36.4) @TEXT("VDD",size=1.1,halign="middle",valign="bottom");
// &"VSS" @WIRE(mode="straight",linecolor="#30485d",linewidth=0.16) {#XDEL9:4 (216,14)};
// (216,13.6) @TEXT("VSS",size=1.1,halign="middle",valign="top");
// &"VDD" @WIRE(mode="straight",linecolor="#30485d",linewidth=0.16) {#XDEL10:3 (243,36)};
// (243,36.4) @TEXT("VDD",size=1.1,halign="middle",valign="bottom");
// &"VSS" @WIRE(mode="straight",linecolor="#30485d",linewidth=0.16) {#XDEL10:4 (243,14)};
// (243,13.6) @TEXT("VSS",size=1.1,halign="middle",valign="top");
// &"T11" @WIRE(mode="straight",linecolor="#30485d",linewidth=0.16) {#XDEL11:2 (286,25)};
// (286.4,25) @TEXT("T11",size=1.1,halign="start",valign="middle");
// &"VDD" @WIRE(mode="straight",linecolor="#30485d",linewidth=0.16) {#XDEL11:3 (270,36)};
// (270,36.4) @TEXT("VDD",size=1.1,halign="middle",valign="bottom");
// &"VSS" @WIRE(mode="straight",linecolor="#30485d",linewidth=0.16) {#XDEL11:4 (270,14)};
// (270,13.6) @TEXT("VSS",size=1.1,halign="middle",valign="top");
// &"T11" @WIRE(mode="straight",linecolor="#30485d",linewidth=0.16) {#XTAP9:1 (200,-20.7)};
// (199.6,-20.7) @TEXT("T11",size=1.1,halign="end",valign="middle");
// &"T9" @WIRE(mode="straight",linecolor="#30485d",linewidth=0.16) {#XTAP9:2 (200,-24)};
// (199.6,-24) @TEXT("T9",size=1.1,halign="end",valign="middle");
// &"SEL9" @WIRE(mode="straight",linecolor="#30485d",linewidth=0.16) {#XTAP9:3 (200,-27.3)};
// (199.6,-27.3) @TEXT("SEL9",size=1.1,halign="end",valign="middle");
// &"W9" @WIRE(mode="straight",linecolor="#30485d",linewidth=0.16) {#XTAP9:4 (232,-24)};
// (232.4,-24) @TEXT("W9",size=1.1,halign="start",valign="middle");
// &"VDD" @WIRE(mode="straight",linecolor="#30485d",linewidth=0.16) {#XTAP9:5 (216,-12.4)};
// (216,-12) @TEXT("VDD",size=1.1,halign="middle",valign="bottom");
// &"VSS" @WIRE(mode="straight",linecolor="#30485d",linewidth=0.16) {#XTAP9:6 (216,-35.6)};
// (216,-36) @TEXT("VSS",size=1.1,halign="middle",valign="top");
// &"W9" @WIRE(mode="straight",linecolor="#30485d",linewidth=0.16) {#XTAP7:1 (146,-20.7)};
// (145.6,-20.7) @TEXT("W9",size=1.1,halign="end",valign="middle");
// &"T7" @WIRE(mode="straight",linecolor="#30485d",linewidth=0.16) {#XTAP7:2 (146,-24)};
// (145.6,-24) @TEXT("T7",size=1.1,halign="end",valign="middle");
// &"SEL7" @WIRE(mode="straight",linecolor="#30485d",linewidth=0.16) {#XTAP7:3 (146,-27.3)};
// (145.6,-27.3) @TEXT("SEL7",size=1.1,halign="end",valign="middle");
// &"W7" @WIRE(mode="straight",linecolor="#30485d",linewidth=0.16) {#XTAP7:4 (178,-24)};
// (178.4,-24) @TEXT("W7",size=1.1,halign="start",valign="middle");
// &"VDD" @WIRE(mode="straight",linecolor="#30485d",linewidth=0.16) {#XTAP7:5 (162,-12.4)};
// (162,-12) @TEXT("VDD",size=1.1,halign="middle",valign="bottom");
// &"VSS" @WIRE(mode="straight",linecolor="#30485d",linewidth=0.16) {#XTAP7:6 (162,-35.6)};
// (162,-36) @TEXT("VSS",size=1.1,halign="middle",valign="top");
// &"W7" @WIRE(mode="straight",linecolor="#30485d",linewidth=0.16) {#XTAP6:1 (92,-20.7)};
// (91.6,-20.7) @TEXT("W7",size=1.1,halign="end",valign="middle");
// &"T6" @WIRE(mode="straight",linecolor="#30485d",linewidth=0.16) {#XTAP6:2 (92,-24)};
// (91.6,-24) @TEXT("T6",size=1.1,halign="end",valign="middle");
// &"SEL6" @WIRE(mode="straight",linecolor="#30485d",linewidth=0.16) {#XTAP6:3 (92,-27.3)};
// (91.6,-27.3) @TEXT("SEL6",size=1.1,halign="end",valign="middle");
// &"W6" @WIRE(mode="straight",linecolor="#30485d",linewidth=0.16) {#XTAP6:4 (124,-24)};
// (124.4,-24) @TEXT("W6",size=1.1,halign="start",valign="middle");
// &"VDD" @WIRE(mode="straight",linecolor="#30485d",linewidth=0.16) {#XTAP6:5 (108,-12.4)};
// (108,-12) @TEXT("VDD",size=1.1,halign="middle",valign="bottom");
// &"VSS" @WIRE(mode="straight",linecolor="#30485d",linewidth=0.16) {#XTAP6:6 (108,-35.6)};
// (108,-36) @TEXT("VSS",size=1.1,halign="middle",valign="top");
// &"W6" @WIRE(mode="straight",linecolor="#30485d",linewidth=0.16) {#XTAP5:1 (38,-20.7)};
// (37.6,-20.7) @TEXT("W6",size=1.1,halign="end",valign="middle");
// &"T5" @WIRE(mode="straight",linecolor="#30485d",linewidth=0.16) {#XTAP5:2 (38,-24)};
// (37.6,-24) @TEXT("T5",size=1.1,halign="end",valign="middle");
// &"SEL5" @WIRE(mode="straight",linecolor="#30485d",linewidth=0.16) {#XTAP5:3 (38,-27.3)};
// (37.6,-27.3) @TEXT("SEL5",size=1.1,halign="end",valign="middle");
// &"W5" @WIRE(mode="straight",linecolor="#30485d",linewidth=0.16) {#XTAP5:4 (70,-24)};
// (70.4,-24) @TEXT("W5",size=1.1,halign="start",valign="middle");
// &"VDD" @WIRE(mode="straight",linecolor="#30485d",linewidth=0.16) {#XTAP5:5 (54,-12.4)};
// (54,-12) @TEXT("VDD",size=1.1,halign="middle",valign="bottom");
// &"VSS" @WIRE(mode="straight",linecolor="#30485d",linewidth=0.16) {#XTAP5:6 (54,-35.6)};
// (54,-36) @TEXT("VSS",size=1.1,halign="middle",valign="top");
// &"W5" @WIRE(mode="straight",linecolor="#30485d",linewidth=0.16) {#XTAP4:1 (-16,-20.7)};
// (-16.4,-20.7) @TEXT("W5",size=1.1,halign="end",valign="middle");
// &"T4" @WIRE(mode="straight",linecolor="#30485d",linewidth=0.16) {#XTAP4:2 (-16,-24)};
// (-16.4,-24) @TEXT("T4",size=1.1,halign="end",valign="middle");
// &"SEL4" @WIRE(mode="straight",linecolor="#30485d",linewidth=0.16) {#XTAP4:3 (-16,-27.3)};
// (-16.4,-27.3) @TEXT("SEL4",size=1.1,halign="end",valign="middle");
// &"DELIVERED" @WIRE(mode="straight",linecolor="#30485d",linewidth=0.16) {#XTAP4:4 (16,-24)};
// (16.4,-24) @TEXT("DELIVERED",size=1.1,halign="start",valign="middle");
// &"VDD" @WIRE(mode="straight",linecolor="#30485d",linewidth=0.16) {#XTAP4:5 (0,-12.4)};
// (0,-12) @TEXT("VDD",size=1.1,halign="middle",valign="bottom");
// &"VSS" @WIRE(mode="straight",linecolor="#30485d",linewidth=0.16) {#XTAP4:6 (0,-35.6)};
// (0,-36) @TEXT("VSS",size=1.1,halign="middle",valign="top");
// }
// END SARADC RNL
ends sar8_se_window

subckt sar8_se_timing ACTIVE SAMPLE SEL9 SEL7 SEL6 SEL5 SEL4 COMP_P COMP_N CMP_CLK COMMIT DATA VDD VSS
XPR (COMP_P PR VDD VSS) BUFFD1BWP12T30P140
XNR (COMP_N NR VDD VSS) BUFFD1BWP12T30P140
XNRB (NR NRB VDD VSS) INVD1BWP12T30P140
XDATA (PR NRB DATA VDD VSS) AN2D1BWP12T30P140
XRAW (PR NR RAW VDD VSS) XOR2D1BWP12T30P140
XVD (RAW RAW_T VDD VSS) DEL200D1BWP12T30P140
XVALID (RAW RAW_T VALID VDD VSS) AN2D1BWP12T30P140
XSN (SAMPLE SN VDD VSS) INVD1BWP12T30P140
// VALID drives the inner NAND input: CMP_CLK falls first, so the internal node never floats
// when VALID falls (FF-cold terminal-voltage screen).
XW0 (VALID CMP_CLK WD VDD VSS) AN2D1BWP12T30P140
XW1 (WD SN WRITE VDD VSS) AN2D1BWP12T30P140
XCP (WRITE COMMIT VDD VSS) CKBD1BWP12T30P140
// Tracking clears PHASE, so PHASE_REQUEST and every tap settle high and READY is
// already high when sampling closes: the first trial needs no settling window.
// Each real commit toggles PHASE and launches the opposite transition.
// Two-flop Johnson phase: each register toggles on every second commit, and PHASE = PHA XOR PHB
// changes once per commit without hazards.
XPHA (COMMIT PHB_N SAMPLE VDD VSS PHA) sar8_se_store
XPHBN (PHB PHB_N VDD VSS) INVD1BWP12T30P140
XPHB (COMMIT PHA SAMPLE VDD VSS PHB) sar8_se_store
XPHX (PHA PHB PHASE VDD VSS) XOR2D1BWP12T30P140
XPHR (PHASE PHASE_REQUEST VDD VSS) INVD1BWP12T30P140
XWINDOW (PHASE_REQUEST SEL9 SEL7 SEL6 SEL5 SEL4 VDD VSS DELIVERED) sar8_se_window
XREADY (PHASE DELIVERED READY VDD VSS) XOR2D1BWP12T30P140
// Reset on the committed phase change; only the delayed edge can release reset.
XCLR (READY SN CLR_N VDD VSS) AN2D1BWP12T30P140
// The first compare waits two stages after sampling closes for the bootstrap
// gates to turn off. Reopening the sample clears LIVE through the qualifier.
XSND1 (SN SN_T1 VDD VSS) DEL250D1BWP12T30P140
XSND2 (SN_T1 SN_T2 VDD VSS) DEL250D1BWP12T30P140
XSNQ (SN SN_T2 SN_D VDD VSS) AN2D1BWP12T30P140
XLIVE (ACTIVE SN_D LIVE VDD VSS) AN2D1BWP12T30P140
XIDLE (RAW CLEARED VDD VSS) INVD1BWP12T30P140
XSET0 (LIVE CLEARED SET0 VDD VSS) AN2D1BWP12T30P140
XSET (SET0 READY SET VDD VSS) AN2D1BWP12T30P140
XHIGH (HIGH VDD VSS) TIEHBWP12T30P140
XCLOCK (HIGH SET CLR_N Q VDD VSS) LHCNDQD1BWP12T30P140
XCMP (Q CMP_CLK VDD VSS) CKBD1BWP12T30P140
// BEGIN SARADC RNL
// @RNL(author="saradc topology") {
// (-17,54) @TEXT("Asynchronous compare and commit timing",size=2.05,halign="start",textcolor="#223d52");
// (-17,37) @TEXT("Latch decision",size=1.35,halign="start",textcolor="#223d52");
// #XPR @SET-SYMBOL $S_BUFFD1BWP12T30P140;
// #XPR @PLACE(0,22) => @ORIENT("R0");
// #XNR @SET-SYMBOL $S_BUFFD1BWP12T30P140;
// #XNR @PLACE(33,22) => @ORIENT("R0");
// #XNRB @SET-SYMBOL $S_INVD1BWP12T30P140;
// #XNRB @PLACE(66,22) => @ORIENT("R0");
// #XDATA @SET-SYMBOL $S_AN2D1BWP12T30P140;
// #XDATA @PLACE(99,22) => @ORIENT("R0");
// #XRAW @SET-SYMBOL $S_XOR2D1BWP12T30P140;
// #XRAW @PLACE(132,22) => @ORIENT("R0");
// #XVD @SET-SYMBOL $S_DEL200D1BWP12T30P140;
// #XVD @PLACE(165,22) => @ORIENT("R0");
// #XVALID @SET-SYMBOL $S_AN2D1BWP12T30P140;
// #XVALID @PLACE(198,22) => @ORIENT("R0");
// (-17,-6) @TEXT("Commit and phase",size=1.35,halign="start",textcolor="#223d52");
// #XSN @SET-SYMBOL $S_INVD1BWP12T30P140;
// #XSN @PLACE(0,-21) => @ORIENT("R0");
// #XW0 @SET-SYMBOL $S_AN2D1BWP12T30P140;
// #XW0 @PLACE(33,-21) => @ORIENT("R0");
// #XW1 @SET-SYMBOL $S_AN2D1BWP12T30P140;
// #XW1 @PLACE(66,-21) => @ORIENT("R0");
// #XCP @SET-SYMBOL $S_CKBD1BWP12T30P140;
// #XCP @PLACE(99,-21) => @ORIENT("R0");
// #XPHA @SET-SYMBOL $S_sar8_se_store;
// #XPHA @PLACE(132,-21) => @ORIENT("R0");
// #XPHBN @SET-SYMBOL $S_INVD1BWP12T30P140;
// #XPHBN @PLACE(165,-21) => @ORIENT("R0");
// #XPHB @SET-SYMBOL $S_sar8_se_store;
// #XPHB @PLACE(198,-21) => @ORIENT("R0");
// #XPHX @SET-SYMBOL $S_XOR2D1BWP12T30P140;
// #XPHX @PLACE(231,-21) => @ORIENT("R0");
// (-17,-49) @TEXT("Settling window",size=1.35,halign="start",textcolor="#223d52");
// #XPHR @SET-SYMBOL $S_INVD1BWP12T30P140;
// #XPHR @PLACE(0,-64) => @ORIENT("R0");
// #XWINDOW @SET-SYMBOL $S_sar8_se_window;
// #XWINDOW @PLACE(33,-64) => @ORIENT("R0");
// #XREADY @SET-SYMBOL $S_XOR2D1BWP12T30P140;
// #XREADY @PLACE(66,-64) => @ORIENT("R0");
// #XCLR @SET-SYMBOL $S_AN2D1BWP12T30P140;
// #XCLR @PLACE(99,-64) => @ORIENT("R0");
// #XSND1 @SET-SYMBOL $S_DEL250D1BWP12T30P140;
// #XSND1 @PLACE(132,-64) => @ORIENT("R0");
// #XSND2 @SET-SYMBOL $S_DEL250D1BWP12T30P140;
// #XSND2 @PLACE(165,-64) => @ORIENT("R0");
// #XSNQ @SET-SYMBOL $S_AN2D1BWP12T30P140;
// #XSNQ @PLACE(198,-64) => @ORIENT("R0");
// (-17,-92) @TEXT("Comparator clock",size=1.35,halign="start",textcolor="#223d52");
// #XLIVE @SET-SYMBOL $S_AN2D1BWP12T30P140;
// #XLIVE @PLACE(0,-107) => @ORIENT("R0");
// #XIDLE @SET-SYMBOL $S_INVD1BWP12T30P140;
// #XIDLE @PLACE(33,-107) => @ORIENT("R0");
// #XSET0 @SET-SYMBOL $S_AN2D1BWP12T30P140;
// #XSET0 @PLACE(66,-107) => @ORIENT("R0");
// #XSET @SET-SYMBOL $S_AN2D1BWP12T30P140;
// #XSET @PLACE(99,-107) => @ORIENT("R0");
// #XHIGH @SET-SYMBOL $S_TIEHBWP12T30P140;
// #XHIGH @PLACE(132,-107) => @ORIENT("R0");
// #XCLOCK @SET-SYMBOL $S_LHCNDQD1BWP12T30P140;
// #XCLOCK @PLACE(165,-107) => @ORIENT("R0");
// #XCMP @SET-SYMBOL $S_CKBD1BWP12T30P140;
// #XCMP @PLACE(198,-107) => @ORIENT("R0");
// &"NRB" @WIRE(mode="straight",linecolor="#30485d",linewidth=0.16) {#XNRB:2 (79.5,22) (79.5,20.35) #XDATA:2};
// &"RAW_T" @WIRE(mode="straight",linecolor="#30485d",linewidth=0.16) {#XVD:2 (181.5,22) (181.5,20.35) #XVALID:2};
// &"WD" @WIRE(mode="straight",linecolor="#30485d",linewidth=0.16) {#XW0:3 (49.5,-21) (49.5,-19.35) #XW1:1};
// &"WRITE" @WIRE(mode="straight",linecolor="#30485d",linewidth=0.16) {#XW1:3 (82.5,-21) (82.5,-21) #XCP:1};
// &"PHASE_REQUEST" @WIRE(mode="straight",linecolor="#30485d",linewidth=0.16) {#XPHR:2 (13.5,-64) (13.5,-55.75) #XWINDOW:1};
// &"DELIVERED" @WIRE(mode="straight",linecolor="#30485d",linewidth=0.16) {#XWINDOW:9 (49.5,-64) (49.5,-65.65) #XREADY:2};
// &"SN_T1" @WIRE(mode="straight",linecolor="#30485d",linewidth=0.16) {#XSND1:2 (148.5,-64) (148.5,-64) #XSND2:1};
// &"SN_T2" @WIRE(mode="straight",linecolor="#30485d",linewidth=0.16) {#XSND2:2 (181.5,-64) (181.5,-65.65) #XSNQ:2};
// &"CLEARED" @WIRE(mode="straight",linecolor="#30485d",linewidth=0.16) {#XIDLE:2 (46.5,-107) (46.5,-108.65) #XSET0:2};
// &"SET0" @WIRE(mode="straight",linecolor="#30485d",linewidth=0.16) {#XSET0:3 (82.5,-107) (82.5,-105.35) #XSET:1};
// &"HIGH" @WIRE(mode="straight",linecolor="#30485d",linewidth=0.16) {#XHIGH:1 (148.5,-107) (148.5,-103.7) #XCLOCK:1};
// &"Q" @WIRE(mode="straight",linecolor="#30485d",linewidth=0.16) {#XCLOCK:4 (181.5,-107) (181.5,-107) #XCMP:1};
// &"COMP_P" @WIRE(mode="straight",linecolor="#30485d",linewidth=0.16) {#XPR:1 (-10,22)};
// (-10.4,22) @TEXT("COMP_P",size=1.1,halign="end",valign="middle");
// &"PR" @WIRE(mode="straight",linecolor="#30485d",linewidth=0.16) {#XPR:2 (10,22)};
// (10.4,22) @TEXT("PR",size=1.1,halign="start",valign="middle");
// &"VDD" @WIRE(mode="straight",linecolor="#30485d",linewidth=0.16) {#XPR:3 (0,32)};
// (0,32.4) @TEXT("VDD",size=1.1,halign="middle",valign="bottom");
// &"VSS" @WIRE(mode="straight",linecolor="#30485d",linewidth=0.16) {#XPR:4 (0,12)};
// (0,11.6) @TEXT("VSS",size=1.1,halign="middle",valign="top");
// &"COMP_N" @WIRE(mode="straight",linecolor="#30485d",linewidth=0.16) {#XNR:1 (23,22)};
// (22.6,22) @TEXT("COMP_N",size=1.1,halign="end",valign="middle");
// &"NR" @WIRE(mode="straight",linecolor="#30485d",linewidth=0.16) {#XNR:2 (43,22)};
// (43.4,22) @TEXT("NR",size=1.1,halign="start",valign="middle");
// &"VDD" @WIRE(mode="straight",linecolor="#30485d",linewidth=0.16) {#XNR:3 (33,32)};
// (33,32.4) @TEXT("VDD",size=1.1,halign="middle",valign="bottom");
// &"VSS" @WIRE(mode="straight",linecolor="#30485d",linewidth=0.16) {#XNR:4 (33,12)};
// (33,11.6) @TEXT("VSS",size=1.1,halign="middle",valign="top");
// &"NR" @WIRE(mode="straight",linecolor="#30485d",linewidth=0.16) {#XNRB:1 (56,22)};
// (55.6,22) @TEXT("NR",size=1.1,halign="end",valign="middle");
// &"VDD" @WIRE(mode="straight",linecolor="#30485d",linewidth=0.16) {#XNRB:3 (66,32)};
// (66,32.4) @TEXT("VDD",size=1.1,halign="middle",valign="bottom");
// &"VSS" @WIRE(mode="straight",linecolor="#30485d",linewidth=0.16) {#XNRB:4 (66,12)};
// (66,11.6) @TEXT("VSS",size=1.1,halign="middle",valign="top");
// &"PR" @WIRE(mode="straight",linecolor="#30485d",linewidth=0.16) {#XDATA:1 (83,23.65)};
// (82.6,23.65) @TEXT("PR",size=1.1,halign="end",valign="middle");
// &"DATA" @WIRE(mode="straight",linecolor="#30485d",linewidth=0.16) {#XDATA:3 (115,22)};
// (115.4,22) @TEXT("DATA",size=1.1,halign="start",valign="middle");
// &"VDD" @WIRE(mode="straight",linecolor="#30485d",linewidth=0.16) {#XDATA:4 (99,33)};
// (99,33.4) @TEXT("VDD",size=1.1,halign="middle",valign="bottom");
// &"VSS" @WIRE(mode="straight",linecolor="#30485d",linewidth=0.16) {#XDATA:5 (99,11)};
// (99,10.6) @TEXT("VSS",size=1.1,halign="middle",valign="top");
// &"PR" @WIRE(mode="straight",linecolor="#30485d",linewidth=0.16) {#XRAW:1 (116,23.65)};
// (115.6,23.65) @TEXT("PR",size=1.1,halign="end",valign="middle");
// &"NR" @WIRE(mode="straight",linecolor="#30485d",linewidth=0.16) {#XRAW:2 (116,20.35)};
// (115.6,20.35) @TEXT("NR",size=1.1,halign="end",valign="middle");
// &"RAW" @WIRE(mode="straight",linecolor="#30485d",linewidth=0.16) {#XRAW:3 (148,22)};
// (148.4,22) @TEXT("RAW",size=1.1,halign="start",valign="middle");
// &"VDD" @WIRE(mode="straight",linecolor="#30485d",linewidth=0.16) {#XRAW:4 (132,33)};
// (132,33.4) @TEXT("VDD",size=1.1,halign="middle",valign="bottom");
// &"VSS" @WIRE(mode="straight",linecolor="#30485d",linewidth=0.16) {#XRAW:5 (132,11)};
// (132,10.6) @TEXT("VSS",size=1.1,halign="middle",valign="top");
// &"RAW" @WIRE(mode="straight",linecolor="#30485d",linewidth=0.16) {#XVD:1 (149,22)};
// (148.6,22) @TEXT("RAW",size=1.1,halign="end",valign="middle");
// &"VDD" @WIRE(mode="straight",linecolor="#30485d",linewidth=0.16) {#XVD:3 (165,33)};
// (165,33.4) @TEXT("VDD",size=1.1,halign="middle",valign="bottom");
// &"VSS" @WIRE(mode="straight",linecolor="#30485d",linewidth=0.16) {#XVD:4 (165,11)};
// (165,10.6) @TEXT("VSS",size=1.1,halign="middle",valign="top");
// &"RAW" @WIRE(mode="straight",linecolor="#30485d",linewidth=0.16) {#XVALID:1 (182,23.65)};
// (181.6,23.65) @TEXT("RAW",size=1.1,halign="end",valign="middle");
// &"VALID" @WIRE(mode="straight",linecolor="#30485d",linewidth=0.16) {#XVALID:3 (214,22)};
// (214.4,22) @TEXT("VALID",size=1.1,halign="start",valign="middle");
// &"VDD" @WIRE(mode="straight",linecolor="#30485d",linewidth=0.16) {#XVALID:4 (198,33)};
// (198,33.4) @TEXT("VDD",size=1.1,halign="middle",valign="bottom");
// &"VSS" @WIRE(mode="straight",linecolor="#30485d",linewidth=0.16) {#XVALID:5 (198,11)};
// (198,10.6) @TEXT("VSS",size=1.1,halign="middle",valign="top");
// &"SAMPLE" @WIRE(mode="straight",linecolor="#30485d",linewidth=0.16) {#XSN:1 (-10,-21)};
// (-10.4,-21) @TEXT("SAMPLE",size=1.1,halign="end",valign="middle");
// &"SN" @WIRE(mode="straight",linecolor="#30485d",linewidth=0.16) {#XSN:2 (10,-21)};
// (10.4,-21) @TEXT("SN",size=1.1,halign="start",valign="middle");
// &"VDD" @WIRE(mode="straight",linecolor="#30485d",linewidth=0.16) {#XSN:3 (0,-11)};
// (0,-10.6) @TEXT("VDD",size=1.1,halign="middle",valign="bottom");
// &"VSS" @WIRE(mode="straight",linecolor="#30485d",linewidth=0.16) {#XSN:4 (0,-31)};
// (0,-31.4) @TEXT("VSS",size=1.1,halign="middle",valign="top");
// &"VALID" @WIRE(mode="straight",linecolor="#30485d",linewidth=0.16) {#XW0:1 (17,-19.35)};
// (16.6,-19.35) @TEXT("VALID",size=1.1,halign="end",valign="middle");
// &"CMP_CLK" @WIRE(mode="straight",linecolor="#30485d",linewidth=0.16) {#XW0:2 (17,-22.65)};
// (16.6,-22.65) @TEXT("CMP_CLK",size=1.1,halign="end",valign="middle");
// &"VDD" @WIRE(mode="straight",linecolor="#30485d",linewidth=0.16) {#XW0:4 (33,-10)};
// (33,-9.6) @TEXT("VDD",size=1.1,halign="middle",valign="bottom");
// &"VSS" @WIRE(mode="straight",linecolor="#30485d",linewidth=0.16) {#XW0:5 (33,-32)};
// (33,-32.4) @TEXT("VSS",size=1.1,halign="middle",valign="top");
// &"SN" @WIRE(mode="straight",linecolor="#30485d",linewidth=0.16) {#XW1:2 (50,-22.65)};
// (49.6,-22.65) @TEXT("SN",size=1.1,halign="end",valign="middle");
// &"VDD" @WIRE(mode="straight",linecolor="#30485d",linewidth=0.16) {#XW1:4 (66,-10)};
// (66,-9.6) @TEXT("VDD",size=1.1,halign="middle",valign="bottom");
// &"VSS" @WIRE(mode="straight",linecolor="#30485d",linewidth=0.16) {#XW1:5 (66,-32)};
// (66,-32.4) @TEXT("VSS",size=1.1,halign="middle",valign="top");
// &"COMMIT" @WIRE(mode="straight",linecolor="#30485d",linewidth=0.16) {#XCP:2 (115,-21)};
// (115.4,-21) @TEXT("COMMIT",size=1.1,halign="start",valign="middle");
// &"VDD" @WIRE(mode="straight",linecolor="#30485d",linewidth=0.16) {#XCP:3 (99,-10)};
// (99,-9.6) @TEXT("VDD",size=1.1,halign="middle",valign="bottom");
// &"VSS" @WIRE(mode="straight",linecolor="#30485d",linewidth=0.16) {#XCP:4 (99,-32)};
// (99,-32.4) @TEXT("VSS",size=1.1,halign="middle",valign="top");
// &"COMMIT" @WIRE(mode="straight",linecolor="#30485d",linewidth=0.16) {#XPHA:1 (118.5,-19.35)};
// (118.1,-19.35) @TEXT("COMMIT",size=1.1,halign="end",valign="middle");
// &"PHB_N" @WIRE(mode="straight",linecolor="#30485d",linewidth=0.16) {#XPHA:2 (128,-10)};
// (128,-9.6) @TEXT("PHB_N",size=1.1,halign="middle",valign="bottom");
// &"SAMPLE" @WIRE(mode="straight",linecolor="#30485d",linewidth=0.16) {#XPHA:3 (118.5,-22.65)};
// (118.1,-22.65) @TEXT("SAMPLE",size=1.1,halign="end",valign="middle");
// &"VDD" @WIRE(mode="straight",linecolor="#30485d",linewidth=0.16) {#XPHA:4 (136,-10)};
// (136,-9.6) @TEXT("VDD",size=1.1,halign="middle",valign="bottom");
// &"VSS" @WIRE(mode="straight",linecolor="#30485d",linewidth=0.16) {#XPHA:5 (128,-32)};
// (128,-32.4) @TEXT("VSS",size=1.1,halign="middle",valign="top");
// &"PHA" @WIRE(mode="straight",linecolor="#30485d",linewidth=0.16) {#XPHA:6 (136,-32)};
// (136,-32.4) @TEXT("PHA",size=1.1,halign="middle",valign="top");
// &"PHB" @WIRE(mode="straight",linecolor="#30485d",linewidth=0.16) {#XPHBN:1 (155,-21)};
// (154.6,-21) @TEXT("PHB",size=1.1,halign="end",valign="middle");
// &"PHB_N" @WIRE(mode="straight",linecolor="#30485d",linewidth=0.16) {#XPHBN:2 (175,-21)};
// (175.4,-21) @TEXT("PHB_N",size=1.1,halign="start",valign="middle");
// &"VDD" @WIRE(mode="straight",linecolor="#30485d",linewidth=0.16) {#XPHBN:3 (165,-11)};
// (165,-10.6) @TEXT("VDD",size=1.1,halign="middle",valign="bottom");
// &"VSS" @WIRE(mode="straight",linecolor="#30485d",linewidth=0.16) {#XPHBN:4 (165,-31)};
// (165,-31.4) @TEXT("VSS",size=1.1,halign="middle",valign="top");
// &"COMMIT" @WIRE(mode="straight",linecolor="#30485d",linewidth=0.16) {#XPHB:1 (184.5,-19.35)};
// (184.1,-19.35) @TEXT("COMMIT",size=1.1,halign="end",valign="middle");
// &"PHA" @WIRE(mode="straight",linecolor="#30485d",linewidth=0.16) {#XPHB:2 (194,-10)};
// (194,-9.6) @TEXT("PHA",size=1.1,halign="middle",valign="bottom");
// &"SAMPLE" @WIRE(mode="straight",linecolor="#30485d",linewidth=0.16) {#XPHB:3 (184.5,-22.65)};
// (184.1,-22.65) @TEXT("SAMPLE",size=1.1,halign="end",valign="middle");
// &"VDD" @WIRE(mode="straight",linecolor="#30485d",linewidth=0.16) {#XPHB:4 (202,-10)};
// (202,-9.6) @TEXT("VDD",size=1.1,halign="middle",valign="bottom");
// &"VSS" @WIRE(mode="straight",linecolor="#30485d",linewidth=0.16) {#XPHB:5 (194,-32)};
// (194,-32.4) @TEXT("VSS",size=1.1,halign="middle",valign="top");
// &"PHB" @WIRE(mode="straight",linecolor="#30485d",linewidth=0.16) {#XPHB:6 (202,-32)};
// (202,-32.4) @TEXT("PHB",size=1.1,halign="middle",valign="top");
// &"PHA" @WIRE(mode="straight",linecolor="#30485d",linewidth=0.16) {#XPHX:1 (215,-19.35)};
// (214.6,-19.35) @TEXT("PHA",size=1.1,halign="end",valign="middle");
// &"PHB" @WIRE(mode="straight",linecolor="#30485d",linewidth=0.16) {#XPHX:2 (215,-22.65)};
// (214.6,-22.65) @TEXT("PHB",size=1.1,halign="end",valign="middle");
// &"PHASE" @WIRE(mode="straight",linecolor="#30485d",linewidth=0.16) {#XPHX:3 (247,-21)};
// (247.4,-21) @TEXT("PHASE",size=1.1,halign="start",valign="middle");
// &"VDD" @WIRE(mode="straight",linecolor="#30485d",linewidth=0.16) {#XPHX:4 (231,-10)};
// (231,-9.6) @TEXT("VDD",size=1.1,halign="middle",valign="bottom");
// &"VSS" @WIRE(mode="straight",linecolor="#30485d",linewidth=0.16) {#XPHX:5 (231,-32)};
// (231,-32.4) @TEXT("VSS",size=1.1,halign="middle",valign="top");
// &"PHASE" @WIRE(mode="straight",linecolor="#30485d",linewidth=0.16) {#XPHR:1 (-10,-64)};
// (-10.4,-64) @TEXT("PHASE",size=1.1,halign="end",valign="middle");
// &"VDD" @WIRE(mode="straight",linecolor="#30485d",linewidth=0.16) {#XPHR:3 (0,-54)};
// (0,-53.6) @TEXT("VDD",size=1.1,halign="middle",valign="bottom");
// &"VSS" @WIRE(mode="straight",linecolor="#30485d",linewidth=0.16) {#XPHR:4 (0,-74)};
// (0,-74.4) @TEXT("VSS",size=1.1,halign="middle",valign="top");
// &"SEL9" @WIRE(mode="straight",linecolor="#30485d",linewidth=0.16) {#XWINDOW:2 (17,-59.05)};
// (16.6,-59.05) @TEXT("SEL9",size=1.1,halign="end",valign="middle");
// &"SEL7" @WIRE(mode="straight",linecolor="#30485d",linewidth=0.16) {#XWINDOW:3 (17,-62.35)};
// (16.6,-62.35) @TEXT("SEL7",size=1.1,halign="end",valign="middle");
// &"SEL6" @WIRE(mode="straight",linecolor="#30485d",linewidth=0.16) {#XWINDOW:4 (17,-65.65)};
// (16.6,-65.65) @TEXT("SEL6",size=1.1,halign="end",valign="middle");
// &"SEL5" @WIRE(mode="straight",linecolor="#30485d",linewidth=0.16) {#XWINDOW:5 (17,-68.95)};
// (16.6,-68.95) @TEXT("SEL5",size=1.1,halign="end",valign="middle");
// &"SEL4" @WIRE(mode="straight",linecolor="#30485d",linewidth=0.16) {#XWINDOW:6 (17,-72.25)};
// (16.6,-72.25) @TEXT("SEL4",size=1.1,halign="end",valign="middle");
// &"VDD" @WIRE(mode="straight",linecolor="#30485d",linewidth=0.16) {#XWINDOW:7 (33,-47.45)};
// (33,-47.05) @TEXT("VDD",size=1.1,halign="middle",valign="bottom");
// &"VSS" @WIRE(mode="straight",linecolor="#30485d",linewidth=0.16) {#XWINDOW:8 (33,-80.55)};
// (33,-80.95) @TEXT("VSS",size=1.1,halign="middle",valign="top");
// &"PHASE" @WIRE(mode="straight",linecolor="#30485d",linewidth=0.16) {#XREADY:1 (50,-62.35)};
// (49.6,-62.35) @TEXT("PHASE",size=1.1,halign="end",valign="middle");
// &"READY" @WIRE(mode="straight",linecolor="#30485d",linewidth=0.16) {#XREADY:3 (82,-64)};
// (82.4,-64) @TEXT("READY",size=1.1,halign="start",valign="middle");
// &"VDD" @WIRE(mode="straight",linecolor="#30485d",linewidth=0.16) {#XREADY:4 (66,-53)};
// (66,-52.6) @TEXT("VDD",size=1.1,halign="middle",valign="bottom");
// &"VSS" @WIRE(mode="straight",linecolor="#30485d",linewidth=0.16) {#XREADY:5 (66,-75)};
// (66,-75.4) @TEXT("VSS",size=1.1,halign="middle",valign="top");
// &"READY" @WIRE(mode="straight",linecolor="#30485d",linewidth=0.16) {#XCLR:1 (83,-62.35)};
// (82.6,-62.35) @TEXT("READY",size=1.1,halign="end",valign="middle");
// &"SN" @WIRE(mode="straight",linecolor="#30485d",linewidth=0.16) {#XCLR:2 (83,-65.65)};
// (82.6,-65.65) @TEXT("SN",size=1.1,halign="end",valign="middle");
// &"CLR_N" @WIRE(mode="straight",linecolor="#30485d",linewidth=0.16) {#XCLR:3 (115,-64)};
// (115.4,-64) @TEXT("CLR_N",size=1.1,halign="start",valign="middle");
// &"VDD" @WIRE(mode="straight",linecolor="#30485d",linewidth=0.16) {#XCLR:4 (99,-53)};
// (99,-52.6) @TEXT("VDD",size=1.1,halign="middle",valign="bottom");
// &"VSS" @WIRE(mode="straight",linecolor="#30485d",linewidth=0.16) {#XCLR:5 (99,-75)};
// (99,-75.4) @TEXT("VSS",size=1.1,halign="middle",valign="top");
// &"SN" @WIRE(mode="straight",linecolor="#30485d",linewidth=0.16) {#XSND1:1 (116,-64)};
// (115.6,-64) @TEXT("SN",size=1.1,halign="end",valign="middle");
// &"VDD" @WIRE(mode="straight",linecolor="#30485d",linewidth=0.16) {#XSND1:3 (132,-53)};
// (132,-52.6) @TEXT("VDD",size=1.1,halign="middle",valign="bottom");
// &"VSS" @WIRE(mode="straight",linecolor="#30485d",linewidth=0.16) {#XSND1:4 (132,-75)};
// (132,-75.4) @TEXT("VSS",size=1.1,halign="middle",valign="top");
// &"VDD" @WIRE(mode="straight",linecolor="#30485d",linewidth=0.16) {#XSND2:3 (165,-53)};
// (165,-52.6) @TEXT("VDD",size=1.1,halign="middle",valign="bottom");
// &"VSS" @WIRE(mode="straight",linecolor="#30485d",linewidth=0.16) {#XSND2:4 (165,-75)};
// (165,-75.4) @TEXT("VSS",size=1.1,halign="middle",valign="top");
// &"SN" @WIRE(mode="straight",linecolor="#30485d",linewidth=0.16) {#XSNQ:1 (182,-62.35)};
// (181.6,-62.35) @TEXT("SN",size=1.1,halign="end",valign="middle");
// &"SN_D" @WIRE(mode="straight",linecolor="#30485d",linewidth=0.16) {#XSNQ:3 (214,-64)};
// (214.4,-64) @TEXT("SN_D",size=1.1,halign="start",valign="middle");
// &"VDD" @WIRE(mode="straight",linecolor="#30485d",linewidth=0.16) {#XSNQ:4 (198,-53)};
// (198,-52.6) @TEXT("VDD",size=1.1,halign="middle",valign="bottom");
// &"VSS" @WIRE(mode="straight",linecolor="#30485d",linewidth=0.16) {#XSNQ:5 (198,-75)};
// (198,-75.4) @TEXT("VSS",size=1.1,halign="middle",valign="top");
// &"ACTIVE" @WIRE(mode="straight",linecolor="#30485d",linewidth=0.16) {#XLIVE:1 (-16,-105.35)};
// (-16.4,-105.35) @TEXT("ACTIVE",size=1.1,halign="end",valign="middle");
// &"SN_D" @WIRE(mode="straight",linecolor="#30485d",linewidth=0.16) {#XLIVE:2 (-16,-108.65)};
// (-16.4,-108.65) @TEXT("SN_D",size=1.1,halign="end",valign="middle");
// &"LIVE" @WIRE(mode="straight",linecolor="#30485d",linewidth=0.16) {#XLIVE:3 (16,-107)};
// (16.4,-107) @TEXT("LIVE",size=1.1,halign="start",valign="middle");
// &"VDD" @WIRE(mode="straight",linecolor="#30485d",linewidth=0.16) {#XLIVE:4 (0,-96)};
// (0,-95.6) @TEXT("VDD",size=1.1,halign="middle",valign="bottom");
// &"VSS" @WIRE(mode="straight",linecolor="#30485d",linewidth=0.16) {#XLIVE:5 (0,-118)};
// (0,-118.4) @TEXT("VSS",size=1.1,halign="middle",valign="top");
// &"RAW" @WIRE(mode="straight",linecolor="#30485d",linewidth=0.16) {#XIDLE:1 (23,-107)};
// (22.6,-107) @TEXT("RAW",size=1.1,halign="end",valign="middle");
// &"VDD" @WIRE(mode="straight",linecolor="#30485d",linewidth=0.16) {#XIDLE:3 (33,-97)};
// (33,-96.6) @TEXT("VDD",size=1.1,halign="middle",valign="bottom");
// &"VSS" @WIRE(mode="straight",linecolor="#30485d",linewidth=0.16) {#XIDLE:4 (33,-117)};
// (33,-117.4) @TEXT("VSS",size=1.1,halign="middle",valign="top");
// &"LIVE" @WIRE(mode="straight",linecolor="#30485d",linewidth=0.16) {#XSET0:1 (50,-105.35)};
// (49.6,-105.35) @TEXT("LIVE",size=1.1,halign="end",valign="middle");
// &"VDD" @WIRE(mode="straight",linecolor="#30485d",linewidth=0.16) {#XSET0:4 (66,-96)};
// (66,-95.6) @TEXT("VDD",size=1.1,halign="middle",valign="bottom");
// &"VSS" @WIRE(mode="straight",linecolor="#30485d",linewidth=0.16) {#XSET0:5 (66,-118)};
// (66,-118.4) @TEXT("VSS",size=1.1,halign="middle",valign="top");
// &"READY" @WIRE(mode="straight",linecolor="#30485d",linewidth=0.16) {#XSET:2 (83,-108.65)};
// (82.6,-108.65) @TEXT("READY",size=1.1,halign="end",valign="middle");
// &"SET" @WIRE(mode="straight",linecolor="#30485d",linewidth=0.16) {#XSET:3 (115,-107)};
// (115.4,-107) @TEXT("SET",size=1.1,halign="start",valign="middle");
// &"VDD" @WIRE(mode="straight",linecolor="#30485d",linewidth=0.16) {#XSET:4 (99,-96)};
// (99,-95.6) @TEXT("VDD",size=1.1,halign="middle",valign="bottom");
// &"VSS" @WIRE(mode="straight",linecolor="#30485d",linewidth=0.16) {#XSET:5 (99,-118)};
// (99,-118.4) @TEXT("VSS",size=1.1,halign="middle",valign="top");
// &"VDD" @WIRE(mode="straight",linecolor="#30485d",linewidth=0.16) {#XHIGH:2 (132,-96)};
// (132,-95.6) @TEXT("VDD",size=1.1,halign="middle",valign="bottom");
// &"VSS" @WIRE(mode="straight",linecolor="#30485d",linewidth=0.16) {#XHIGH:3 (132,-118)};
// (132,-118.4) @TEXT("VSS",size=1.1,halign="middle",valign="top");
// &"SET" @WIRE(mode="straight",linecolor="#30485d",linewidth=0.16) {#XCLOCK:2 (149,-107)};
// (148.6,-107) @TEXT("SET",size=1.1,halign="end",valign="middle");
// &"CLR_N" @WIRE(mode="straight",linecolor="#30485d",linewidth=0.16) {#XCLOCK:3 (149,-110.3)};
// (148.6,-110.3) @TEXT("CLR_N",size=1.1,halign="end",valign="middle");
// &"VDD" @WIRE(mode="straight",linecolor="#30485d",linewidth=0.16) {#XCLOCK:5 (165,-95.4)};
// (165,-95) @TEXT("VDD",size=1.1,halign="middle",valign="bottom");
// &"VSS" @WIRE(mode="straight",linecolor="#30485d",linewidth=0.16) {#XCLOCK:6 (165,-118.6)};
// (165,-119) @TEXT("VSS",size=1.1,halign="middle",valign="top");
// &"CMP_CLK" @WIRE(mode="straight",linecolor="#30485d",linewidth=0.16) {#XCMP:2 (214,-107)};
// (214.4,-107) @TEXT("CMP_CLK",size=1.1,halign="start",valign="middle");
// &"VDD" @WIRE(mode="straight",linecolor="#30485d",linewidth=0.16) {#XCMP:3 (198,-96)};
// (198,-95.6) @TEXT("VDD",size=1.1,halign="middle",valign="bottom");
// &"VSS" @WIRE(mode="straight",linecolor="#30485d",linewidth=0.16) {#XCMP:4 (198,-118)};
// (198,-118.4) @TEXT("VSS",size=1.1,halign="middle",valign="top");
// }
// END SARADC RNL
ends sar8_se_timing

subckt sar8_se_store CK DATA RESET VDD VSS Q
XDR (DATA RESET DIN VDD VSS) OR2D1BWP12T30P140
XCLR (RESET RST_N VDD VSS) INVD1BWP12T30P140
XREG (DIN CK RST_N Q VDD VSS) DFCNQD1BWP12T30P140
// BEGIN SARADC RNL
// @RNL(author="saradc topology") {
// #XDR @SET-SYMBOL $S_OR2D1BWP12T30P140;
// #XDR @PLACE(0,10) => @ORIENT("R0");
// #XDR @TEXT("",key="name",size=1.65,halign="middle",textcolor="#223d52") => @PLACE(0,10);
// #XDR @TEXT("",key="model");
// #XCLR @SET-SYMBOL $S_INVD1BWP12T30P140;
// #XCLR @PLACE(0,-10) => @ORIENT("R0");
// #XCLR @TEXT("",key="name",size=1.65,halign="middle",textcolor="#223d52") => @PLACE(0,-10);
// #XCLR @TEXT("",key="model");
// #XREG @SET-SYMBOL $S_DFCNQD1BWP12T30P140;
// #XREG @PLACE(35,0) => @ORIENT("R0");
// #XREG @TEXT("",key="name",size=1.65,halign="middle",textcolor="#223d52") => @PLACE(35,0);
// #XREG @TEXT("",key="model");
// (-22,26) @TEXT("Commit register",size=2,halign="start",textcolor="#223d52");
// %sar_port1 = $IO_PORT @ATTACH &"DATA" => @PLACE(-17,11.7);
// &"DATA" @WIRE(mode="straight",linecolor="#30485d",linewidth=0.16) {%sar_port1:p #XDR:1};
// %sar_junction2 = (-17,0);
// %sar_junction2 @CIRCLE(radius=0.34,linecolor="#30485d",fill="fillcolor",fillcolor="#30485d") => @LAYER("top");
// %sar_port3 = $IO_PORT @ATTACH &"RESET" => @PLACE(-25,0) => @ORIENT("R0");
// &"RESET" @WIRE(mode="straight",linecolor="#94601a",linewidth=0.16) {%sar_port3:p %sar_junction2};
// &"RESET" @WIRE(mode="straight",linecolor="#94601a",linewidth=0.16) {%sar_junction2 (-17,8.3) #XDR:2};
// &"RESET" @WIRE(mode="straight",linecolor="#94601a",linewidth=0.16) {%sar_junction2 (-17,-10) #XCLR:1};
// &"DIN" @WIRE(mode="straight",linecolor="#30485d",linewidth=0.16) {#XDR:3 (17.5,10) (17.5,3.4) #XREG:1};
// &"RST_N" @WIRE(mode="straight",linecolor="#30485d",linewidth=0.16) {#XCLR:2 (17.5,-10) (17.5,-3.4) #XREG:3};
// %sar_port4 = $IO_PORT @ATTACH &"CK" => @PLACE(20,0);
// &"CK" @WIRE(mode="straight",linecolor="#94601a",linewidth=0.16) {%sar_port4:p #XREG:2};
// %sar_port5 = $IO_PORT @ATTACH &"Q" => @PLACE(51,0) => @ORIENT("MY");
// &"Q" @WIRE(mode="straight",linecolor="#30485d",linewidth=0.16) {#XREG:4 %sar_port5:p};
// &"VDD" @WIRE(mode="straight",linecolor="#647584",linewidth=0.16) {#XDR:4 (0,18.45)};
// (0,18.77) @TEXT("VDD",size=0.98,halign="middle",valign="bottom");
// &"VSS" @WIRE(mode="straight",linecolor="#647584",linewidth=0.16) {#XDR:5 (0,1.55)};
// (0,1.23) @TEXT("VSS",size=0.98,halign="middle",valign="top");
// &"VDD" @WIRE(mode="straight",linecolor="#647584",linewidth=0.16) {#XCLR:3 (0,-1.55)};
// (0,-1.23) @TEXT("VDD",size=0.98,halign="middle",valign="bottom");
// &"VSS" @WIRE(mode="straight",linecolor="#647584",linewidth=0.16) {#XCLR:4 (0,-18.45)};
// (0,-18.77) @TEXT("VSS",size=0.98,halign="middle",valign="top");
// &"VDD" @WIRE(mode="straight",linecolor="#647584",linewidth=0.16) {#XREG:5 (35,8.45)};
// (35,8.77) @TEXT("VDD",size=0.98,halign="middle",valign="bottom");
// &"VSS" @WIRE(mode="straight",linecolor="#647584",linewidth=0.16) {#XREG:6 (35,-8.45)};
// (35,-8.77) @TEXT("VSS",size=0.98,halign="middle",valign="top");
// }
// END SARADC RNL
ends sar8_se_store

subckt sar8_se_ctrl CMP_CLK CODE0 CODE1 CODE2 CODE3 CODE4 CODE5 CODE6 CODE7 COMP_N COMP_P D0 D1 D2 D3 D4 D5 D6 D7 COMMIT SAMPLE VDD VSS ACTIVE
XTIM (ACTIVE SAMPLE SEL9 SEL7 SEL6 SEL5 SEL4 COMP_P COMP_N CMP_CLK COMMIT DATA VDD VSS) sar8_se_timing
XWORD (CODE0 CODE1 CODE2 CODE3 CODE4 CODE5 CODE6 CODE7 DATA DONE D0 D1 D2 D3 D4 D5 D6 D7 NEXT0 NEXT1 NEXT2 NEXT3 NEXT4 NEXT5 NEXT6 NEXT7 TRIAL6 TRIAL5 TRIAL4 TRIAL3 TRIAL2 VDD VSS) sar8_next_word
// Sticky tap selects: the commit of bit k sets the select for bit k-1 until the
// next accepted sample. Each feeds only the window multiplexers.
// The OR is INV+INV+ND2: a trial glitch while the select is already set must not lift a
// floating PMOS stack node above the rail (FF-cold terminal-voltage screen).
XSEL9_QB (SEL9 SEL9_QB VDD VSS) INVD1BWP12T30P140
XSEL9_TB (TRIAL6 SEL9_TB VDD VSS) INVD1BWP12T30P140
XSEL9_D (SEL9_QB SEL9_TB SEL9_D VDD VSS) ND2D1BWP12T30P140
XSEL9 (COMMIT SEL9_D SAMPLE VDD VSS SEL9) sar8_se_store
XSEL7_QB (SEL7 SEL7_QB VDD VSS) INVD1BWP12T30P140
XSEL7_TB (TRIAL5 SEL7_TB VDD VSS) INVD1BWP12T30P140
XSEL7_D (SEL7_QB SEL7_TB SEL7_D VDD VSS) ND2D1BWP12T30P140
XSEL7 (COMMIT SEL7_D SAMPLE VDD VSS SEL7) sar8_se_store
XSEL6_QB (SEL6 SEL6_QB VDD VSS) INVD1BWP12T30P140
XSEL6_TB (TRIAL4 SEL6_TB VDD VSS) INVD1BWP12T30P140
XSEL6_D (SEL6_QB SEL6_TB SEL6_D VDD VSS) ND2D1BWP12T30P140
XSEL6 (COMMIT SEL6_D SAMPLE VDD VSS SEL6) sar8_se_store
XSEL5_QB (SEL5 SEL5_QB VDD VSS) INVD1BWP12T30P140
XSEL5_TB (TRIAL3 SEL5_TB VDD VSS) INVD1BWP12T30P140
XSEL5_D (SEL5_QB SEL5_TB SEL5_D VDD VSS) ND2D1BWP12T30P140
XSEL5 (COMMIT SEL5_D SAMPLE VDD VSS SEL5) sar8_se_store
XSEL4_QB (SEL4 SEL4_QB VDD VSS) INVD1BWP12T30P140
XSEL4_TB (TRIAL2 SEL4_TB VDD VSS) INVD1BWP12T30P140
XSEL4_D (SEL4_QB SEL4_TB SEL4_D VDD VSS) ND2D1BWP12T30P140
XSEL4 (COMMIT SEL4_D SAMPLE VDD VSS SEL4) sar8_se_store
XDONE (COMMIT CODE0 SAMPLE VDD VSS DONE) sar8_se_store
XACTIVE (DONE ACTIVE VDD VSS) INVD1BWP12T30P140
XBIT0 (COMMIT NEXT0 SAMPLE VDD VSS CODE0) sar8_se_store
XBIT1 (COMMIT NEXT1 SAMPLE VDD VSS CODE1) sar8_se_store
XBIT2 (COMMIT NEXT2 SAMPLE VDD VSS CODE2) sar8_se_store
XBIT3 (COMMIT NEXT3 SAMPLE VDD VSS CODE3) sar8_se_store
XBIT4 (COMMIT NEXT4 SAMPLE VDD VSS CODE4) sar8_se_store
XBIT5 (COMMIT NEXT5 SAMPLE VDD VSS CODE5) sar8_se_store
XBIT6 (COMMIT NEXT6 SAMPLE VDD VSS CODE6) sar8_se_store
XMSBD (NEXT7 MSBD VDD VSS) INVD1BWP12T30P140
XBIT7 (COMMIT MSBD SAMPLE VDD VSS MSBQ) sar8_se_store
XMSBQ (MSBQ CODE7 VDD VSS) INVD1BWP12T30P140
// BEGIN SARADC RNL
// @RNL(author="saradc topology") {
// (-25,92) @TEXT("SAR / Single-edge controller",size=2.55,halign="start",textcolor="#223d52");
// #XTIM @SET-SYMBOL $S_sar8_se_timing;
// #XTIM @PLACE(-2,55) => @ORIENT("R0");
// #XWORD @SET-SYMBOL $S_sar8_next_word;
// #XWORD @PLACE(64,55) => @ORIENT("R0");
// #XDONE @SET-SYMBOL $S_sar8_se_store;
// #XDONE @PLACE(136,55) => @ORIENT("R0");
// #XACTIVE @SET-SYMBOL $S_INVD1BWP12T30P140;
// #XACTIVE @PLACE(165,55) => @ORIENT("R0");
// #XTIM @TEXT("Timing",key="name",size=1.65,halign="middle",textcolor="#223d52") => @PLACE(-2,55);
// #XTIM @TEXT("",key="model");
// #XWORD @TEXT("Trial word",key="name",size=1.65,halign="middle",textcolor="#223d52") => @PLACE(64,55);
// #XWORD @TEXT("",key="model");
// #XDONE @TEXT("Last bit",key="name",size=1.65,halign="middle",textcolor="#223d52") => @PLACE(136,55);
// #XDONE @TEXT("",key="model");
// #XACTIVE @TEXT("Active",key="name",size=1.65,halign="middle",textcolor="#223d52") => @PLACE(165,64);
// #XACTIVE @TEXT("",key="model");
// {#XTIM} @GROUP;
// @RECTANGLE(linecolor="#a9b8c5",linewidth=0.16,fill="fillcolor",fillcolor="#f7f9fc") {(-25,36) (25,79)} => @LAYER("bottom");
// (-22,75) @TEXT("Compare and commit",size=1.95,halign="start",textcolor="#223d52");
// (-22,71.5) @TEXT("Latch the comparator result.",size=1.26,halign="start",textcolor="#223d52");
// {#XWORD} @GROUP;
// @RECTANGLE(linecolor="#a9b8c5",linewidth=0.16,fill="fillcolor",fillcolor="#f7f9fc") {(42,36) (90,79)} => @LAYER("bottom");
// (45,75) @TEXT("Next trial word",size=1.95,halign="start",textcolor="#223d52");
// (45,71.5) @TEXT("Build the next word and expose D.",size=1.26,halign="start",textcolor="#223d52");
// {#XDONE #XACTIVE} @GROUP;
// @RECTANGLE(linecolor="#a9b8c5",linewidth=0.16,fill="fillcolor",fillcolor="#f7f9fc") {(116,36) (190,79)} => @LAYER("bottom");
// (119,75) @TEXT("Conversion complete",size=1.95,halign="start",textcolor="#223d52");
// (119,71.5) @TEXT("Release ACTIVE after the last commit.",size=1.26,halign="start",textcolor="#223d52");
// &"DATA" @WIRE(mode="straight",linecolor="#30485d",linewidth=0.16) {#XTIM:12 (34,58.3) (34,56.65) #XWORD:9};
// &"COMMIT" @WIRE(mode="straight",linecolor="#94601a",linewidth=0.16) {#XTIM:11 (32,55) (32,83) (110,83) (110,56.65) #XDONE:1};
// (78,85) @TEXT("COMMIT",size=1.1,halign="start",textcolor="#223d52");
// %sar_junction1 = (149,47);
// %sar_junction1 @CIRCLE(radius=0.34,linecolor="#30485d",fill="fillcolor",fillcolor="#30485d") => @LAYER("top");
// &"DONE" @WIRE(mode="straight",linecolor="#30485d",linewidth=0.16) {#XDONE:6 %sar_junction1 (150,47) (150,55) #XACTIVE:1};
// &"DONE" @WIRE(mode="straight",linecolor="#30485d",linewidth=0.16) {%sar_junction1 (149,38) (94,38) (94,55) #XWORD:10};
// #XBIT7 @SET-SYMBOL $S_sar8_se_store;
// #XBIT7 @PLACE(0,-4) => @ORIENT("R0");
// #XBIT7 @TEXT("B7",key="name",size=1.65,halign="middle",textcolor="#223d52") => @PLACE(0,-4);
// #XBIT7 @TEXT("",key="model");
// #XBIT6 @SET-SYMBOL $S_sar8_se_store;
// #XBIT6 @PLACE(26,-4) => @ORIENT("R0");
// #XBIT6 @TEXT("B6",key="name",size=1.65,halign="middle",textcolor="#223d52") => @PLACE(26,-4);
// #XBIT6 @TEXT("",key="model");
// #XBIT5 @SET-SYMBOL $S_sar8_se_store;
// #XBIT5 @PLACE(52,-4) => @ORIENT("R0");
// #XBIT5 @TEXT("B5",key="name",size=1.65,halign="middle",textcolor="#223d52") => @PLACE(52,-4);
// #XBIT5 @TEXT("",key="model");
// #XBIT4 @SET-SYMBOL $S_sar8_se_store;
// #XBIT4 @PLACE(78,-4) => @ORIENT("R0");
// #XBIT4 @TEXT("B4",key="name",size=1.65,halign="middle",textcolor="#223d52") => @PLACE(78,-4);
// #XBIT4 @TEXT("",key="model");
// #XBIT3 @SET-SYMBOL $S_sar8_se_store;
// #XBIT3 @PLACE(104,-4) => @ORIENT("R0");
// #XBIT3 @TEXT("B3",key="name",size=1.65,halign="middle",textcolor="#223d52") => @PLACE(104,-4);
// #XBIT3 @TEXT("",key="model");
// #XBIT2 @SET-SYMBOL $S_sar8_se_store;
// #XBIT2 @PLACE(130,-4) => @ORIENT("R0");
// #XBIT2 @TEXT("B2",key="name",size=1.65,halign="middle",textcolor="#223d52") => @PLACE(130,-4);
// #XBIT2 @TEXT("",key="model");
// #XBIT1 @SET-SYMBOL $S_sar8_se_store;
// #XBIT1 @PLACE(156,-4) => @ORIENT("R0");
// #XBIT1 @TEXT("B1",key="name",size=1.65,halign="middle",textcolor="#223d52") => @PLACE(156,-4);
// #XBIT1 @TEXT("",key="model");
// #XBIT0 @SET-SYMBOL $S_sar8_se_store;
// #XBIT0 @PLACE(182,-4) => @ORIENT("R0");
// #XBIT0 @TEXT("B0",key="name",size=1.65,halign="middle",textcolor="#223d52") => @PLACE(182,-4);
// #XBIT0 @TEXT("",key="model");
// #XMSBD @SET-SYMBOL $S_INVD1BWP12T30P140;
// #XMSBD @PLACE(-13,5) => @ORIENT("R0");
// #XMSBQ @SET-SYMBOL $S_INVD1BWP12T30P140;
// #XMSBQ @PLACE(-10,-22) => @ORIENT("R0");
// #XMSBD @TEXT("MSB in",key="name",size=1.65,halign="middle",textcolor="#223d52") => @PLACE(-13,13);
// #XMSBD @TEXT("",key="model");
// #XMSBQ @TEXT("MSB out",key="name",size=1.65,halign="middle",textcolor="#223d52") => @PLACE(-10,-14);
// #XMSBQ @TEXT("",key="model");
// {#XBIT7 #XBIT6 #XBIT5 #XBIT4 #XBIT3 #XBIT2 #XBIT1 #XBIT0 #XMSBD #XMSBQ} @GROUP;
// @RECTANGLE(linecolor="#a9b8c5",linewidth=0.16,fill="fillcolor",fillcolor="#f7f9fc") {(-24,-35) (204,30)} => @LAYER("bottom");
// (-21,26) @TEXT("Bit registers",size=1.95,halign="start",textcolor="#223d52");
// (-21,22.5) @TEXT("COMMIT stores NEXT as CODE for the next comparison.",size=1.26,halign="start",textcolor="#223d52");
// %sar_junction2 = (101,18);
// %sar_junction2 @CIRCLE(radius=0.34,linecolor="#30485d",fill="fillcolor",fillcolor="#30485d") => @LAYER("top");
// {&"NEXT0" &"NEXT1" &"NEXT2" &"NEXT3" &"NEXT4" &"NEXT5" &"NEXT6" &"NEXT7"} @WIRE(mode="straight",linewidth=0.27,linecolor="#66538a") {#XWORD:19 (101,51.7) %sar_junction2};
// %sar_junction3 = (178,18);
// %sar_junction3 @CIRCLE(radius=0.34,linecolor="#30485d",fill="fillcolor",fillcolor="#30485d") => @LAYER("top");
// %sar_junction4 = (186,-31);
// %sar_junction4 @CIRCLE(radius=0.34,linecolor="#30485d",fill="fillcolor",fillcolor="#30485d") => @LAYER("top");
// &"NEXT0" @WIRE(mode="straight",linecolor="#30485d",linewidth=0.16) {%sar_junction3 #XBIT0:2};
// &"CODE0" @WIRE(mode="straight",linecolor="#30485d",linewidth=0.16) {#XBIT0:6 %sar_junction4};
// %sar_junction5 = (152,18);
// %sar_junction5 @CIRCLE(radius=0.34,linecolor="#30485d",fill="fillcolor",fillcolor="#30485d") => @LAYER("top");
// %sar_junction6 = (160,-31);
// %sar_junction6 @CIRCLE(radius=0.34,linecolor="#30485d",fill="fillcolor",fillcolor="#30485d") => @LAYER("top");
// &"NEXT1" @WIRE(mode="straight",linecolor="#30485d",linewidth=0.16) {%sar_junction5 #XBIT1:2};
// &"CODE1" @WIRE(mode="straight",linecolor="#30485d",linewidth=0.16) {#XBIT1:6 %sar_junction6};
// %sar_junction7 = (126,18);
// %sar_junction7 @CIRCLE(radius=0.34,linecolor="#30485d",fill="fillcolor",fillcolor="#30485d") => @LAYER("top");
// %sar_junction8 = (134,-31);
// %sar_junction8 @CIRCLE(radius=0.34,linecolor="#30485d",fill="fillcolor",fillcolor="#30485d") => @LAYER("top");
// &"NEXT2" @WIRE(mode="straight",linecolor="#30485d",linewidth=0.16) {%sar_junction7 #XBIT2:2};
// &"CODE2" @WIRE(mode="straight",linecolor="#30485d",linewidth=0.16) {#XBIT2:6 %sar_junction8};
// %sar_junction9 = (100,18);
// %sar_junction9 @CIRCLE(radius=0.34,linecolor="#30485d",fill="fillcolor",fillcolor="#30485d") => @LAYER("top");
// %sar_junction10 = (108,-31);
// %sar_junction10 @CIRCLE(radius=0.34,linecolor="#30485d",fill="fillcolor",fillcolor="#30485d") => @LAYER("top");
// &"NEXT3" @WIRE(mode="straight",linecolor="#30485d",linewidth=0.16) {%sar_junction9 #XBIT3:2};
// &"CODE3" @WIRE(mode="straight",linecolor="#30485d",linewidth=0.16) {#XBIT3:6 %sar_junction10};
// %sar_junction11 = (74,18);
// %sar_junction11 @CIRCLE(radius=0.34,linecolor="#30485d",fill="fillcolor",fillcolor="#30485d") => @LAYER("top");
// %sar_junction12 = (82,-31);
// %sar_junction12 @CIRCLE(radius=0.34,linecolor="#30485d",fill="fillcolor",fillcolor="#30485d") => @LAYER("top");
// &"NEXT4" @WIRE(mode="straight",linecolor="#30485d",linewidth=0.16) {%sar_junction11 #XBIT4:2};
// &"CODE4" @WIRE(mode="straight",linecolor="#30485d",linewidth=0.16) {#XBIT4:6 %sar_junction12};
// %sar_junction13 = (48,18);
// %sar_junction13 @CIRCLE(radius=0.34,linecolor="#30485d",fill="fillcolor",fillcolor="#30485d") => @LAYER("top");
// %sar_junction14 = (56,-31);
// %sar_junction14 @CIRCLE(radius=0.34,linecolor="#30485d",fill="fillcolor",fillcolor="#30485d") => @LAYER("top");
// &"NEXT5" @WIRE(mode="straight",linecolor="#30485d",linewidth=0.16) {%sar_junction13 #XBIT5:2};
// &"CODE5" @WIRE(mode="straight",linecolor="#30485d",linewidth=0.16) {#XBIT5:6 %sar_junction14};
// %sar_junction15 = (22,18);
// %sar_junction15 @CIRCLE(radius=0.34,linecolor="#30485d",fill="fillcolor",fillcolor="#30485d") => @LAYER("top");
// %sar_junction16 = (30,-31);
// %sar_junction16 @CIRCLE(radius=0.34,linecolor="#30485d",fill="fillcolor",fillcolor="#30485d") => @LAYER("top");
// &"NEXT6" @WIRE(mode="straight",linecolor="#30485d",linewidth=0.16) {%sar_junction15 #XBIT6:2};
// &"CODE6" @WIRE(mode="straight",linecolor="#30485d",linewidth=0.16) {#XBIT6:6 %sar_junction16};
// &"MSBD" @WIRE(mode="straight",linecolor="#30485d",linewidth=0.16) {#XMSBD:2 (-4,5) #XBIT7:2};
// &"MSBQ" @WIRE(mode="straight",linecolor="#30485d",linewidth=0.16) {#XBIT7:6 (4,-18) (-19,-18) (-19,-22) #XMSBQ:1};
// %sar_junction17 = (-21,18);
// %sar_junction17 @CIRCLE(radius=0.34,linecolor="#30485d",fill="fillcolor",fillcolor="#30485d") => @LAYER("top");
// %sar_junction18 = (-3,-31);
// %sar_junction18 @CIRCLE(radius=0.34,linecolor="#30485d",fill="fillcolor",fillcolor="#30485d") => @LAYER("top");
// &"NEXT7" @WIRE(mode="straight",linecolor="#30485d",linewidth=0.16) {%sar_junction17 (-21,5) #XMSBD:1};
// &"CODE7" @WIRE(mode="straight",linecolor="#30485d",linewidth=0.16) {#XMSBQ:2 %sar_junction18};
// {&"NEXT0" &"NEXT1" &"NEXT2" &"NEXT3" &"NEXT4" &"NEXT5" &"NEXT6" &"NEXT7"} @WIRE(mode="straight",linewidth=0.27,linecolor="#66538a") {%sar_junction17 %sar_junction15 %sar_junction13 %sar_junction11 %sar_junction9 %sar_junction2 %sar_junction7 %sar_junction5 %sar_junction3};
// {&"CODE0" &"CODE1" &"CODE2" &"CODE3" &"CODE4" &"CODE5" &"CODE6" &"CODE7"} @WIRE(mode="straight",linewidth=0.27,linecolor="#66538a") {#XWORD:1 (35,53.35) (35,32) (-28,32) (-28,-31) %sar_junction18 %sar_junction16 %sar_junction14 %sar_junction12 %sar_junction10 %sar_junction8 %sar_junction6 %sar_junction4};
// (152,20.2) @TEXT("NEXT[7:0]",size=1.15,halign="start",textcolor="#223d52");
// (152,-28.8) @TEXT("CODE[7:0]",size=1.15,halign="start",textcolor="#223d52");
// #XSEL9_QB @SET-SYMBOL $S_INVD1BWP12T30P140;
// #XSEL9_QB @PLACE(0,-60) => @ORIENT("R0");
// #XSEL9_QB @TEXT("",key="name",size=1.65,halign="middle",textcolor="#223d52") => @PLACE(0,-60);
// #XSEL9_QB @TEXT("",key="model");
// #XSEL9_TB @SET-SYMBOL $S_INVD1BWP12T30P140;
// #XSEL9_TB @PLACE(2,-76) => @ORIENT("R0");
// #XSEL9_TB @TEXT("",key="name",size=1.65,halign="middle",textcolor="#223d52") => @PLACE(2,-76);
// #XSEL9_TB @TEXT("",key="model");
// #XSEL9_D @SET-SYMBOL $S_ND2D1BWP12T30P140;
// #XSEL9_D @PLACE(16,-67) => @ORIENT("R0");
// #XSEL9_D @TEXT("",key="name",size=1.65,halign="middle",textcolor="#223d52") => @PLACE(16,-67);
// #XSEL9_D @TEXT("",key="model");
// #XSEL9 @SET-SYMBOL $S_sar8_se_store;
// #XSEL9 @PLACE(22,-88) => @ORIENT("R0");
// #XSEL9 @TEXT("Tap 9",key="name",size=1.65,halign="middle",textcolor="#223d52") => @PLACE(22,-88);
// #XSEL9 @TEXT("",key="model");
// &"SEL9_QB" @WIRE(mode="straight",linecolor="#30485d",linewidth=0.16) {#XSEL9_QB:2 (8,-60) (8,-65.3) #XSEL9_D:1};
// &"SEL9_TB" @WIRE(mode="straight",linecolor="#30485d",linewidth=0.16) {#XSEL9_TB:2 (9,-76) (9,-68.7) #XSEL9_D:2};
// &"SEL9_D" @WIRE(mode="straight",linecolor="#30485d",linewidth=0.16) {#XSEL9_D:3 (27,-67) (27,-77) (18,-77) #XSEL9:2};
// #XSEL7_QB @SET-SYMBOL $S_INVD1BWP12T30P140;
// #XSEL7_QB @PLACE(41,-60) => @ORIENT("R0");
// #XSEL7_QB @TEXT("",key="name",size=1.65,halign="middle",textcolor="#223d52") => @PLACE(41,-60);
// #XSEL7_QB @TEXT("",key="model");
// #XSEL7_TB @SET-SYMBOL $S_INVD1BWP12T30P140;
// #XSEL7_TB @PLACE(43,-76) => @ORIENT("R0");
// #XSEL7_TB @TEXT("",key="name",size=1.65,halign="middle",textcolor="#223d52") => @PLACE(43,-76);
// #XSEL7_TB @TEXT("",key="model");
// #XSEL7_D @SET-SYMBOL $S_ND2D1BWP12T30P140;
// #XSEL7_D @PLACE(57,-67) => @ORIENT("R0");
// #XSEL7_D @TEXT("",key="name",size=1.65,halign="middle",textcolor="#223d52") => @PLACE(57,-67);
// #XSEL7_D @TEXT("",key="model");
// #XSEL7 @SET-SYMBOL $S_sar8_se_store;
// #XSEL7 @PLACE(63,-88) => @ORIENT("R0");
// #XSEL7 @TEXT("Tap 7",key="name",size=1.65,halign="middle",textcolor="#223d52") => @PLACE(63,-88);
// #XSEL7 @TEXT("",key="model");
// &"SEL7_QB" @WIRE(mode="straight",linecolor="#30485d",linewidth=0.16) {#XSEL7_QB:2 (49,-60) (49,-65.3) #XSEL7_D:1};
// &"SEL7_TB" @WIRE(mode="straight",linecolor="#30485d",linewidth=0.16) {#XSEL7_TB:2 (50,-76) (50,-68.7) #XSEL7_D:2};
// &"SEL7_D" @WIRE(mode="straight",linecolor="#30485d",linewidth=0.16) {#XSEL7_D:3 (68,-67) (68,-77) (59,-77) #XSEL7:2};
// #XSEL6_QB @SET-SYMBOL $S_INVD1BWP12T30P140;
// #XSEL6_QB @PLACE(82,-60) => @ORIENT("R0");
// #XSEL6_QB @TEXT("",key="name",size=1.65,halign="middle",textcolor="#223d52") => @PLACE(82,-60);
// #XSEL6_QB @TEXT("",key="model");
// #XSEL6_TB @SET-SYMBOL $S_INVD1BWP12T30P140;
// #XSEL6_TB @PLACE(84,-76) => @ORIENT("R0");
// #XSEL6_TB @TEXT("",key="name",size=1.65,halign="middle",textcolor="#223d52") => @PLACE(84,-76);
// #XSEL6_TB @TEXT("",key="model");
// #XSEL6_D @SET-SYMBOL $S_ND2D1BWP12T30P140;
// #XSEL6_D @PLACE(98,-67) => @ORIENT("R0");
// #XSEL6_D @TEXT("",key="name",size=1.65,halign="middle",textcolor="#223d52") => @PLACE(98,-67);
// #XSEL6_D @TEXT("",key="model");
// #XSEL6 @SET-SYMBOL $S_sar8_se_store;
// #XSEL6 @PLACE(104,-88) => @ORIENT("R0");
// #XSEL6 @TEXT("Tap 6",key="name",size=1.65,halign="middle",textcolor="#223d52") => @PLACE(104,-88);
// #XSEL6 @TEXT("",key="model");
// &"SEL6_QB" @WIRE(mode="straight",linecolor="#30485d",linewidth=0.16) {#XSEL6_QB:2 (90,-60) (90,-65.3) #XSEL6_D:1};
// &"SEL6_TB" @WIRE(mode="straight",linecolor="#30485d",linewidth=0.16) {#XSEL6_TB:2 (91,-76) (91,-68.7) #XSEL6_D:2};
// &"SEL6_D" @WIRE(mode="straight",linecolor="#30485d",linewidth=0.16) {#XSEL6_D:3 (109,-67) (109,-77) (100,-77) #XSEL6:2};
// #XSEL5_QB @SET-SYMBOL $S_INVD1BWP12T30P140;
// #XSEL5_QB @PLACE(123,-60) => @ORIENT("R0");
// #XSEL5_QB @TEXT("",key="name",size=1.65,halign="middle",textcolor="#223d52") => @PLACE(123,-60);
// #XSEL5_QB @TEXT("",key="model");
// #XSEL5_TB @SET-SYMBOL $S_INVD1BWP12T30P140;
// #XSEL5_TB @PLACE(125,-76) => @ORIENT("R0");
// #XSEL5_TB @TEXT("",key="name",size=1.65,halign="middle",textcolor="#223d52") => @PLACE(125,-76);
// #XSEL5_TB @TEXT("",key="model");
// #XSEL5_D @SET-SYMBOL $S_ND2D1BWP12T30P140;
// #XSEL5_D @PLACE(139,-67) => @ORIENT("R0");
// #XSEL5_D @TEXT("",key="name",size=1.65,halign="middle",textcolor="#223d52") => @PLACE(139,-67);
// #XSEL5_D @TEXT("",key="model");
// #XSEL5 @SET-SYMBOL $S_sar8_se_store;
// #XSEL5 @PLACE(145,-88) => @ORIENT("R0");
// #XSEL5 @TEXT("Tap 5",key="name",size=1.65,halign="middle",textcolor="#223d52") => @PLACE(145,-88);
// #XSEL5 @TEXT("",key="model");
// &"SEL5_QB" @WIRE(mode="straight",linecolor="#30485d",linewidth=0.16) {#XSEL5_QB:2 (131,-60) (131,-65.3) #XSEL5_D:1};
// &"SEL5_TB" @WIRE(mode="straight",linecolor="#30485d",linewidth=0.16) {#XSEL5_TB:2 (132,-76) (132,-68.7) #XSEL5_D:2};
// &"SEL5_D" @WIRE(mode="straight",linecolor="#30485d",linewidth=0.16) {#XSEL5_D:3 (150,-67) (150,-77) (141,-77) #XSEL5:2};
// #XSEL4_QB @SET-SYMBOL $S_INVD1BWP12T30P140;
// #XSEL4_QB @PLACE(164,-60) => @ORIENT("R0");
// #XSEL4_QB @TEXT("",key="name",size=1.65,halign="middle",textcolor="#223d52") => @PLACE(164,-60);
// #XSEL4_QB @TEXT("",key="model");
// #XSEL4_TB @SET-SYMBOL $S_INVD1BWP12T30P140;
// #XSEL4_TB @PLACE(166,-76) => @ORIENT("R0");
// #XSEL4_TB @TEXT("",key="name",size=1.65,halign="middle",textcolor="#223d52") => @PLACE(166,-76);
// #XSEL4_TB @TEXT("",key="model");
// #XSEL4_D @SET-SYMBOL $S_ND2D1BWP12T30P140;
// #XSEL4_D @PLACE(180,-67) => @ORIENT("R0");
// #XSEL4_D @TEXT("",key="name",size=1.65,halign="middle",textcolor="#223d52") => @PLACE(180,-67);
// #XSEL4_D @TEXT("",key="model");
// #XSEL4 @SET-SYMBOL $S_sar8_se_store;
// #XSEL4 @PLACE(186,-88) => @ORIENT("R0");
// #XSEL4 @TEXT("Tap 4",key="name",size=1.65,halign="middle",textcolor="#223d52") => @PLACE(186,-88);
// #XSEL4 @TEXT("",key="model");
// &"SEL4_QB" @WIRE(mode="straight",linecolor="#30485d",linewidth=0.16) {#XSEL4_QB:2 (172,-60) (172,-65.3) #XSEL4_D:1};
// &"SEL4_TB" @WIRE(mode="straight",linecolor="#30485d",linewidth=0.16) {#XSEL4_TB:2 (173,-76) (173,-68.7) #XSEL4_D:2};
// &"SEL4_D" @WIRE(mode="straight",linecolor="#30485d",linewidth=0.16) {#XSEL4_D:3 (191,-67) (191,-77) (182,-77) #XSEL4:2};
// &"VDD" @WIRE(mode="straight",linecolor="#647584",linewidth=0.16) {#XSEL9_QB:3 (0,-51.55)};
// (0,-51.23) @TEXT("VDD",size=0.98,halign="middle",valign="bottom");
// &"VSS" @WIRE(mode="straight",linecolor="#647584",linewidth=0.16) {#XSEL9_QB:4 (0,-68.45)};
// (0,-68.77) @TEXT("VSS",size=0.98,halign="middle",valign="top");
// &"VDD" @WIRE(mode="straight",linecolor="#647584",linewidth=0.16) {#XSEL9_TB:3 (2,-67.55)};
// (2,-67.23) @TEXT("VDD",size=0.98,halign="middle",valign="bottom");
// &"VSS" @WIRE(mode="straight",linecolor="#647584",linewidth=0.16) {#XSEL9_TB:4 (2,-84.45)};
// (2,-84.77) @TEXT("VSS",size=0.98,halign="middle",valign="top");
// &"VDD" @WIRE(mode="straight",linecolor="#647584",linewidth=0.16) {#XSEL9_D:4 (16,-58.55)};
// (16,-58.23) @TEXT("VDD",size=0.98,halign="middle",valign="bottom");
// &"VSS" @WIRE(mode="straight",linecolor="#647584",linewidth=0.16) {#XSEL9_D:5 (16,-75.45)};
// (16,-75.77) @TEXT("VSS",size=0.98,halign="middle",valign="top");
// &"VDD" @WIRE(mode="straight",linecolor="#647584",linewidth=0.16) {#XSEL9:4 (26,-78.55)};
// (26,-78.23) @TEXT("VDD",size=0.98,halign="middle",valign="bottom");
// &"VSS" @WIRE(mode="straight",linecolor="#647584",linewidth=0.16) {#XSEL9:5 (18,-97.45)};
// (18,-97.77) @TEXT("VSS",size=0.98,halign="middle",valign="top");
// &"VDD" @WIRE(mode="straight",linecolor="#647584",linewidth=0.16) {#XSEL7_QB:3 (41,-51.55)};
// (41,-51.23) @TEXT("VDD",size=0.98,halign="middle",valign="bottom");
// &"VSS" @WIRE(mode="straight",linecolor="#647584",linewidth=0.16) {#XSEL7_QB:4 (41,-68.45)};
// (41,-68.77) @TEXT("VSS",size=0.98,halign="middle",valign="top");
// &"VDD" @WIRE(mode="straight",linecolor="#647584",linewidth=0.16) {#XSEL7_TB:3 (43,-67.55)};
// (43,-67.23) @TEXT("VDD",size=0.98,halign="middle",valign="bottom");
// &"VSS" @WIRE(mode="straight",linecolor="#647584",linewidth=0.16) {#XSEL7_TB:4 (43,-84.45)};
// (43,-84.77) @TEXT("VSS",size=0.98,halign="middle",valign="top");
// &"VDD" @WIRE(mode="straight",linecolor="#647584",linewidth=0.16) {#XSEL7_D:4 (57,-58.55)};
// (57,-58.23) @TEXT("VDD",size=0.98,halign="middle",valign="bottom");
// &"VSS" @WIRE(mode="straight",linecolor="#647584",linewidth=0.16) {#XSEL7_D:5 (57,-75.45)};
// (57,-75.77) @TEXT("VSS",size=0.98,halign="middle",valign="top");
// &"VDD" @WIRE(mode="straight",linecolor="#647584",linewidth=0.16) {#XSEL7:4 (67,-78.55)};
// (67,-78.23) @TEXT("VDD",size=0.98,halign="middle",valign="bottom");
// &"VSS" @WIRE(mode="straight",linecolor="#647584",linewidth=0.16) {#XSEL7:5 (59,-97.45)};
// (59,-97.77) @TEXT("VSS",size=0.98,halign="middle",valign="top");
// &"VDD" @WIRE(mode="straight",linecolor="#647584",linewidth=0.16) {#XSEL6_QB:3 (82,-51.55)};
// (82,-51.23) @TEXT("VDD",size=0.98,halign="middle",valign="bottom");
// &"VSS" @WIRE(mode="straight",linecolor="#647584",linewidth=0.16) {#XSEL6_QB:4 (82,-68.45)};
// (82,-68.77) @TEXT("VSS",size=0.98,halign="middle",valign="top");
// &"VDD" @WIRE(mode="straight",linecolor="#647584",linewidth=0.16) {#XSEL6_TB:3 (84,-67.55)};
// (84,-67.23) @TEXT("VDD",size=0.98,halign="middle",valign="bottom");
// &"VSS" @WIRE(mode="straight",linecolor="#647584",linewidth=0.16) {#XSEL6_TB:4 (84,-84.45)};
// (84,-84.77) @TEXT("VSS",size=0.98,halign="middle",valign="top");
// &"VDD" @WIRE(mode="straight",linecolor="#647584",linewidth=0.16) {#XSEL6_D:4 (98,-58.55)};
// (98,-58.23) @TEXT("VDD",size=0.98,halign="middle",valign="bottom");
// &"VSS" @WIRE(mode="straight",linecolor="#647584",linewidth=0.16) {#XSEL6_D:5 (98,-75.45)};
// (98,-75.77) @TEXT("VSS",size=0.98,halign="middle",valign="top");
// &"VDD" @WIRE(mode="straight",linecolor="#647584",linewidth=0.16) {#XSEL6:4 (108,-78.55)};
// (108,-78.23) @TEXT("VDD",size=0.98,halign="middle",valign="bottom");
// &"VSS" @WIRE(mode="straight",linecolor="#647584",linewidth=0.16) {#XSEL6:5 (100,-97.45)};
// (100,-97.77) @TEXT("VSS",size=0.98,halign="middle",valign="top");
// &"VDD" @WIRE(mode="straight",linecolor="#647584",linewidth=0.16) {#XSEL5_QB:3 (123,-51.55)};
// (123,-51.23) @TEXT("VDD",size=0.98,halign="middle",valign="bottom");
// &"VSS" @WIRE(mode="straight",linecolor="#647584",linewidth=0.16) {#XSEL5_QB:4 (123,-68.45)};
// (123,-68.77) @TEXT("VSS",size=0.98,halign="middle",valign="top");
// &"VDD" @WIRE(mode="straight",linecolor="#647584",linewidth=0.16) {#XSEL5_TB:3 (125,-67.55)};
// (125,-67.23) @TEXT("VDD",size=0.98,halign="middle",valign="bottom");
// &"VSS" @WIRE(mode="straight",linecolor="#647584",linewidth=0.16) {#XSEL5_TB:4 (125,-84.45)};
// (125,-84.77) @TEXT("VSS",size=0.98,halign="middle",valign="top");
// &"VDD" @WIRE(mode="straight",linecolor="#647584",linewidth=0.16) {#XSEL5_D:4 (139,-58.55)};
// (139,-58.23) @TEXT("VDD",size=0.98,halign="middle",valign="bottom");
// &"VSS" @WIRE(mode="straight",linecolor="#647584",linewidth=0.16) {#XSEL5_D:5 (139,-75.45)};
// (139,-75.77) @TEXT("VSS",size=0.98,halign="middle",valign="top");
// &"VDD" @WIRE(mode="straight",linecolor="#647584",linewidth=0.16) {#XSEL5:4 (149,-78.55)};
// (149,-78.23) @TEXT("VDD",size=0.98,halign="middle",valign="bottom");
// &"VSS" @WIRE(mode="straight",linecolor="#647584",linewidth=0.16) {#XSEL5:5 (141,-97.45)};
// (141,-97.77) @TEXT("VSS",size=0.98,halign="middle",valign="top");
// &"VDD" @WIRE(mode="straight",linecolor="#647584",linewidth=0.16) {#XSEL4_QB:3 (164,-51.55)};
// (164,-51.23) @TEXT("VDD",size=0.98,halign="middle",valign="bottom");
// &"VSS" @WIRE(mode="straight",linecolor="#647584",linewidth=0.16) {#XSEL4_QB:4 (164,-68.45)};
// (164,-68.77) @TEXT("VSS",size=0.98,halign="middle",valign="top");
// &"VDD" @WIRE(mode="straight",linecolor="#647584",linewidth=0.16) {#XSEL4_TB:3 (166,-67.55)};
// (166,-67.23) @TEXT("VDD",size=0.98,halign="middle",valign="bottom");
// &"VSS" @WIRE(mode="straight",linecolor="#647584",linewidth=0.16) {#XSEL4_TB:4 (166,-84.45)};
// (166,-84.77) @TEXT("VSS",size=0.98,halign="middle",valign="top");
// &"VDD" @WIRE(mode="straight",linecolor="#647584",linewidth=0.16) {#XSEL4_D:4 (180,-58.55)};
// (180,-58.23) @TEXT("VDD",size=0.98,halign="middle",valign="bottom");
// &"VSS" @WIRE(mode="straight",linecolor="#647584",linewidth=0.16) {#XSEL4_D:5 (180,-75.45)};
// (180,-75.77) @TEXT("VSS",size=0.98,halign="middle",valign="top");
// &"VDD" @WIRE(mode="straight",linecolor="#647584",linewidth=0.16) {#XSEL4:4 (190,-78.55)};
// (190,-78.23) @TEXT("VDD",size=0.98,halign="middle",valign="bottom");
// &"VSS" @WIRE(mode="straight",linecolor="#647584",linewidth=0.16) {#XSEL4:5 (182,-97.45)};
// (182,-97.77) @TEXT("VSS",size=0.98,halign="middle",valign="top");
// {#XSEL9_QB #XSEL9_TB #XSEL9_D #XSEL9 #XSEL7_QB #XSEL7_TB #XSEL7_D #XSEL7 #XSEL6_QB #XSEL6_TB #XSEL6_D #XSEL6 #XSEL5_QB #XSEL5_TB #XSEL5_D #XSEL5 #XSEL4_QB #XSEL4_TB #XSEL4_D #XSEL4} @GROUP;
// @RECTANGLE(linecolor="#a9b8c5",linewidth=0.16,fill="fillcolor",fillcolor="#f7f9fc") {(-24,-104) (204,-38)} => @LAYER("bottom");
// (-21,-42) @TEXT("Settling window selection",size=1.95,halign="start",textcolor="#223d52");
// (-21,-45.5) @TEXT("The trial bit sets a tap until the next sample.",size=1.26,halign="start",textcolor="#223d52");
// &"ACTIVE" @WIRE(mode="straight",linecolor="#30485d",linewidth=0.16) {#XTIM:1 (-24,50.05)};
// (-24.4,50.05) @TEXT("ACTIVE",size=1.1,halign="end",valign="middle");
// &"SAMPLE" @WIRE(mode="straight",linecolor="#30485d",linewidth=0.16) {#XTIM:2 (-24,53.35)};
// (-24.4,53.35) @TEXT("SAMPLE",size=1.1,halign="end",valign="middle");
// &"SEL9" @WIRE(mode="straight",linecolor="#30485d",linewidth=0.16) {#XTIM:3 (-17,41.75)};
// (-17,41.35) @TEXT("SEL9",size=1.1,halign="middle",valign="top");
// &"SEL7" @WIRE(mode="straight",linecolor="#30485d",linewidth=0.16) {#XTIM:4 (-11,41.75)};
// (-11,41.35) @TEXT("SEL7",size=1.1,halign="middle",valign="top");
// &"SEL6" @WIRE(mode="straight",linecolor="#30485d",linewidth=0.16) {#XTIM:5 (-5,41.75)};
// (-5,41.35) @TEXT("SEL6",size=1.1,halign="middle",valign="top");
// &"SEL5" @WIRE(mode="straight",linecolor="#30485d",linewidth=0.16) {#XTIM:6 (1,41.75)};
// (1,41.35) @TEXT("SEL5",size=1.1,halign="middle",valign="top");
// &"SEL4" @WIRE(mode="straight",linecolor="#30485d",linewidth=0.16) {#XTIM:7 (7,41.75)};
// (7,41.35) @TEXT("SEL4",size=1.1,halign="middle",valign="top");
// &"COMP_P" @WIRE(mode="straight",linecolor="#30485d",linewidth=0.16) {#XTIM:8 (-24,59.95)};
// (-24.4,59.95) @TEXT("COMP_P",size=1.1,halign="end",valign="middle");
// &"COMP_N" @WIRE(mode="straight",linecolor="#30485d",linewidth=0.16) {#XTIM:9 (-24,56.65)};
// (-24.4,56.65) @TEXT("COMP_N",size=1.1,halign="end",valign="middle");
// &"CMP_CLK" @WIRE(mode="straight",linecolor="#30485d",linewidth=0.16) {#XTIM:10 (20,51.7)};
// (20.4,51.7) @TEXT("CMP_CLK",size=1.1,halign="start",valign="middle");
// &"VDD" @WIRE(mode="straight",linecolor="#30485d",linewidth=0.16) {#XTIM:13 (-2,68.25)};
// (-2,68.65) @TEXT("VDD",size=1.1,halign="middle",valign="bottom");
// &"VSS" @WIRE(mode="straight",linecolor="#30485d",linewidth=0.16) {#XTIM:14 (13,41.75)};
// (13,41.35) @TEXT("VSS",size=1.1,halign="middle",valign="top");
// {&"D0" &"D1" &"D2" &"D3" &"D4" &"D5" &"D6" &"D7"} @WIRE(mode="straight",linewidth=0.3) {#XWORD:11 (80,58.3)};
// (80.4,58.3) @TEXT("D[7:0]",size=1.1,halign="start",valign="middle");
// {&"TRIAL6" &"TRIAL5" &"TRIAL4" &"TRIAL3" &"TRIAL2"} @WIRE(mode="straight",linewidth=0.3) {#XWORD:27 (60,43.4)};
// (60,43) @TEXT("TRIAL[2:6]",size=1.1,halign="middle",valign="top");
// &"VDD" @WIRE(mode="straight",linecolor="#30485d",linewidth=0.16) {#XWORD:32 (64,66.6)};
// (64,67) @TEXT("VDD",size=1.1,halign="middle",valign="bottom");
// &"VSS" @WIRE(mode="straight",linecolor="#30485d",linewidth=0.16) {#XWORD:33 (68,43.4)};
// (68,43) @TEXT("VSS",size=1.1,halign="middle",valign="top");
// &"SEL9" @WIRE(mode="straight",linecolor="#30485d",linewidth=0.16) {#XSEL9_QB:1 (-10,-60)};
// (-10.4,-60) @TEXT("SEL9",size=1.1,halign="end",valign="middle");
// &"TRIAL6" @WIRE(mode="straight",linecolor="#30485d",linewidth=0.16) {#XSEL9_TB:1 (-8,-76)};
// (-8.4,-76) @TEXT("TRIAL6",size=1.1,halign="end",valign="middle");
// &"COMMIT" @WIRE(mode="straight",linecolor="#30485d",linewidth=0.16) {#XSEL9:1 (8.5,-86.35)};
// (8.1,-86.35) @TEXT("COMMIT",size=1.1,halign="end",valign="middle");
// &"SAMPLE" @WIRE(mode="straight",linecolor="#30485d",linewidth=0.16) {#XSEL9:3 (8.5,-89.65)};
// (8.1,-89.65) @TEXT("SAMPLE",size=1.1,halign="end",valign="middle");
// &"SEL9" @WIRE(mode="straight",linecolor="#30485d",linewidth=0.16) {#XSEL9:6 (26,-99)};
// (26,-99.4) @TEXT("SEL9",size=1.1,halign="middle",valign="top");
// &"SEL7" @WIRE(mode="straight",linecolor="#30485d",linewidth=0.16) {#XSEL7_QB:1 (31,-60)};
// (30.6,-60) @TEXT("SEL7",size=1.1,halign="end",valign="middle");
// &"TRIAL5" @WIRE(mode="straight",linecolor="#30485d",linewidth=0.16) {#XSEL7_TB:1 (33,-76)};
// (32.6,-76) @TEXT("TRIAL5",size=1.1,halign="end",valign="middle");
// &"COMMIT" @WIRE(mode="straight",linecolor="#30485d",linewidth=0.16) {#XSEL7:1 (49.5,-86.35)};
// (49.1,-86.35) @TEXT("COMMIT",size=1.1,halign="end",valign="middle");
// &"SAMPLE" @WIRE(mode="straight",linecolor="#30485d",linewidth=0.16) {#XSEL7:3 (49.5,-89.65)};
// (49.1,-89.65) @TEXT("SAMPLE",size=1.1,halign="end",valign="middle");
// &"SEL7" @WIRE(mode="straight",linecolor="#30485d",linewidth=0.16) {#XSEL7:6 (67,-99)};
// (67,-99.4) @TEXT("SEL7",size=1.1,halign="middle",valign="top");
// &"SEL6" @WIRE(mode="straight",linecolor="#30485d",linewidth=0.16) {#XSEL6_QB:1 (72,-60)};
// (71.6,-60) @TEXT("SEL6",size=1.1,halign="end",valign="middle");
// &"TRIAL4" @WIRE(mode="straight",linecolor="#30485d",linewidth=0.16) {#XSEL6_TB:1 (74,-76)};
// (73.6,-76) @TEXT("TRIAL4",size=1.1,halign="end",valign="middle");
// &"COMMIT" @WIRE(mode="straight",linecolor="#30485d",linewidth=0.16) {#XSEL6:1 (90.5,-86.35)};
// (90.1,-86.35) @TEXT("COMMIT",size=1.1,halign="end",valign="middle");
// &"SAMPLE" @WIRE(mode="straight",linecolor="#30485d",linewidth=0.16) {#XSEL6:3 (90.5,-89.65)};
// (90.1,-89.65) @TEXT("SAMPLE",size=1.1,halign="end",valign="middle");
// &"SEL6" @WIRE(mode="straight",linecolor="#30485d",linewidth=0.16) {#XSEL6:6 (108,-99)};
// (108,-99.4) @TEXT("SEL6",size=1.1,halign="middle",valign="top");
// &"SEL5" @WIRE(mode="straight",linecolor="#30485d",linewidth=0.16) {#XSEL5_QB:1 (113,-60)};
// (112.6,-60) @TEXT("SEL5",size=1.1,halign="end",valign="middle");
// &"TRIAL3" @WIRE(mode="straight",linecolor="#30485d",linewidth=0.16) {#XSEL5_TB:1 (115,-76)};
// (114.6,-76) @TEXT("TRIAL3",size=1.1,halign="end",valign="middle");
// &"COMMIT" @WIRE(mode="straight",linecolor="#30485d",linewidth=0.16) {#XSEL5:1 (131.5,-86.35)};
// (131.1,-86.35) @TEXT("COMMIT",size=1.1,halign="end",valign="middle");
// &"SAMPLE" @WIRE(mode="straight",linecolor="#30485d",linewidth=0.16) {#XSEL5:3 (131.5,-89.65)};
// (131.1,-89.65) @TEXT("SAMPLE",size=1.1,halign="end",valign="middle");
// &"SEL5" @WIRE(mode="straight",linecolor="#30485d",linewidth=0.16) {#XSEL5:6 (149,-99)};
// (149,-99.4) @TEXT("SEL5",size=1.1,halign="middle",valign="top");
// &"SEL4" @WIRE(mode="straight",linecolor="#30485d",linewidth=0.16) {#XSEL4_QB:1 (154,-60)};
// (153.6,-60) @TEXT("SEL4",size=1.1,halign="end",valign="middle");
// &"TRIAL2" @WIRE(mode="straight",linecolor="#30485d",linewidth=0.16) {#XSEL4_TB:1 (156,-76)};
// (155.6,-76) @TEXT("TRIAL2",size=1.1,halign="end",valign="middle");
// &"COMMIT" @WIRE(mode="straight",linecolor="#30485d",linewidth=0.16) {#XSEL4:1 (172.5,-86.35)};
// (172.1,-86.35) @TEXT("COMMIT",size=1.1,halign="end",valign="middle");
// &"SAMPLE" @WIRE(mode="straight",linecolor="#30485d",linewidth=0.16) {#XSEL4:3 (172.5,-89.65)};
// (172.1,-89.65) @TEXT("SAMPLE",size=1.1,halign="end",valign="middle");
// &"SEL4" @WIRE(mode="straight",linecolor="#30485d",linewidth=0.16) {#XSEL4:6 (190,-99)};
// (190,-99.4) @TEXT("SEL4",size=1.1,halign="middle",valign="top");
// &"CODE0" @WIRE(mode="straight",linecolor="#30485d",linewidth=0.16) {#XDONE:2 (132,66)};
// (132,66.4) @TEXT("CODE0",size=1.1,halign="middle",valign="bottom");
// &"SAMPLE" @WIRE(mode="straight",linecolor="#30485d",linewidth=0.16) {#XDONE:3 (122.5,53.35)};
// (122.1,53.35) @TEXT("SAMPLE",size=1.1,halign="end",valign="middle");
// &"VDD" @WIRE(mode="straight",linecolor="#30485d",linewidth=0.16) {#XDONE:4 (140,66)};
// (140,66.4) @TEXT("VDD",size=1.1,halign="middle",valign="bottom");
// &"VSS" @WIRE(mode="straight",linecolor="#30485d",linewidth=0.16) {#XDONE:5 (132,44)};
// (132,43.6) @TEXT("VSS",size=1.1,halign="middle",valign="top");
// &"ACTIVE" @WIRE(mode="straight",linecolor="#30485d",linewidth=0.16) {#XACTIVE:2 (175,55)};
// (175.4,55) @TEXT("ACTIVE",size=1.1,halign="start",valign="middle");
// &"VDD" @WIRE(mode="straight",linecolor="#30485d",linewidth=0.16) {#XACTIVE:3 (165,65)};
// (165,65.4) @TEXT("VDD",size=1.1,halign="middle",valign="bottom");
// &"VSS" @WIRE(mode="straight",linecolor="#30485d",linewidth=0.16) {#XACTIVE:4 (165,45)};
// (165,44.6) @TEXT("VSS",size=1.1,halign="middle",valign="top");
// &"COMMIT" @WIRE(mode="straight",linecolor="#30485d",linewidth=0.16) {#XBIT0:1 (168.5,-2.35)};
// (168.1,-2.35) @TEXT("COMMIT",size=1.1,halign="end",valign="middle");
// &"SAMPLE" @WIRE(mode="straight",linecolor="#30485d",linewidth=0.16) {#XBIT0:3 (168.5,-5.65)};
// (168.1,-5.65) @TEXT("SAMPLE",size=1.1,halign="end",valign="middle");
// &"VDD" @WIRE(mode="straight",linecolor="#30485d",linewidth=0.16) {#XBIT0:4 (186,7)};
// (186,7.4) @TEXT("VDD",size=1.1,halign="middle",valign="bottom");
// &"VSS" @WIRE(mode="straight",linecolor="#30485d",linewidth=0.16) {#XBIT0:5 (178,-15)};
// (178,-15.4) @TEXT("VSS",size=1.1,halign="middle",valign="top");
// &"COMMIT" @WIRE(mode="straight",linecolor="#30485d",linewidth=0.16) {#XBIT1:1 (142.5,-2.35)};
// (142.1,-2.35) @TEXT("COMMIT",size=1.1,halign="end",valign="middle");
// &"SAMPLE" @WIRE(mode="straight",linecolor="#30485d",linewidth=0.16) {#XBIT1:3 (142.5,-5.65)};
// (142.1,-5.65) @TEXT("SAMPLE",size=1.1,halign="end",valign="middle");
// &"VDD" @WIRE(mode="straight",linecolor="#30485d",linewidth=0.16) {#XBIT1:4 (160,7)};
// (160,7.4) @TEXT("VDD",size=1.1,halign="middle",valign="bottom");
// &"VSS" @WIRE(mode="straight",linecolor="#30485d",linewidth=0.16) {#XBIT1:5 (152,-15)};
// (152,-15.4) @TEXT("VSS",size=1.1,halign="middle",valign="top");
// &"COMMIT" @WIRE(mode="straight",linecolor="#30485d",linewidth=0.16) {#XBIT2:1 (116.5,-2.35)};
// (116.1,-2.35) @TEXT("COMMIT",size=1.1,halign="end",valign="middle");
// &"SAMPLE" @WIRE(mode="straight",linecolor="#30485d",linewidth=0.16) {#XBIT2:3 (116.5,-5.65)};
// (116.1,-5.65) @TEXT("SAMPLE",size=1.1,halign="end",valign="middle");
// &"VDD" @WIRE(mode="straight",linecolor="#30485d",linewidth=0.16) {#XBIT2:4 (134,7)};
// (134,7.4) @TEXT("VDD",size=1.1,halign="middle",valign="bottom");
// &"VSS" @WIRE(mode="straight",linecolor="#30485d",linewidth=0.16) {#XBIT2:5 (126,-15)};
// (126,-15.4) @TEXT("VSS",size=1.1,halign="middle",valign="top");
// &"COMMIT" @WIRE(mode="straight",linecolor="#30485d",linewidth=0.16) {#XBIT3:1 (90.5,-2.35)};
// (90.1,-2.35) @TEXT("COMMIT",size=1.1,halign="end",valign="middle");
// &"SAMPLE" @WIRE(mode="straight",linecolor="#30485d",linewidth=0.16) {#XBIT3:3 (90.5,-5.65)};
// (90.1,-5.65) @TEXT("SAMPLE",size=1.1,halign="end",valign="middle");
// &"VDD" @WIRE(mode="straight",linecolor="#30485d",linewidth=0.16) {#XBIT3:4 (108,7)};
// (108,7.4) @TEXT("VDD",size=1.1,halign="middle",valign="bottom");
// &"VSS" @WIRE(mode="straight",linecolor="#30485d",linewidth=0.16) {#XBIT3:5 (100,-15)};
// (100,-15.4) @TEXT("VSS",size=1.1,halign="middle",valign="top");
// &"COMMIT" @WIRE(mode="straight",linecolor="#30485d",linewidth=0.16) {#XBIT4:1 (64.5,-2.35)};
// (64.1,-2.35) @TEXT("COMMIT",size=1.1,halign="end",valign="middle");
// &"SAMPLE" @WIRE(mode="straight",linecolor="#30485d",linewidth=0.16) {#XBIT4:3 (64.5,-5.65)};
// (64.1,-5.65) @TEXT("SAMPLE",size=1.1,halign="end",valign="middle");
// &"VDD" @WIRE(mode="straight",linecolor="#30485d",linewidth=0.16) {#XBIT4:4 (82,7)};
// (82,7.4) @TEXT("VDD",size=1.1,halign="middle",valign="bottom");
// &"VSS" @WIRE(mode="straight",linecolor="#30485d",linewidth=0.16) {#XBIT4:5 (74,-15)};
// (74,-15.4) @TEXT("VSS",size=1.1,halign="middle",valign="top");
// &"COMMIT" @WIRE(mode="straight",linecolor="#30485d",linewidth=0.16) {#XBIT5:1 (38.5,-2.35)};
// (38.1,-2.35) @TEXT("COMMIT",size=1.1,halign="end",valign="middle");
// &"SAMPLE" @WIRE(mode="straight",linecolor="#30485d",linewidth=0.16) {#XBIT5:3 (38.5,-5.65)};
// (38.1,-5.65) @TEXT("SAMPLE",size=1.1,halign="end",valign="middle");
// &"VDD" @WIRE(mode="straight",linecolor="#30485d",linewidth=0.16) {#XBIT5:4 (56,7)};
// (56,7.4) @TEXT("VDD",size=1.1,halign="middle",valign="bottom");
// &"VSS" @WIRE(mode="straight",linecolor="#30485d",linewidth=0.16) {#XBIT5:5 (48,-15)};
// (48,-15.4) @TEXT("VSS",size=1.1,halign="middle",valign="top");
// &"COMMIT" @WIRE(mode="straight",linecolor="#30485d",linewidth=0.16) {#XBIT6:1 (12.5,-2.35)};
// (12.1,-2.35) @TEXT("COMMIT",size=1.1,halign="end",valign="middle");
// &"SAMPLE" @WIRE(mode="straight",linecolor="#30485d",linewidth=0.16) {#XBIT6:3 (12.5,-5.65)};
// (12.1,-5.65) @TEXT("SAMPLE",size=1.1,halign="end",valign="middle");
// &"VDD" @WIRE(mode="straight",linecolor="#30485d",linewidth=0.16) {#XBIT6:4 (30,7)};
// (30,7.4) @TEXT("VDD",size=1.1,halign="middle",valign="bottom");
// &"VSS" @WIRE(mode="straight",linecolor="#30485d",linewidth=0.16) {#XBIT6:5 (22,-15)};
// (22,-15.4) @TEXT("VSS",size=1.1,halign="middle",valign="top");
// &"VDD" @WIRE(mode="straight",linecolor="#30485d",linewidth=0.16) {#XMSBD:3 (-13,15)};
// (-13,15.4) @TEXT("VDD",size=1.1,halign="middle",valign="bottom");
// &"VSS" @WIRE(mode="straight",linecolor="#30485d",linewidth=0.16) {#XMSBD:4 (-13,-5)};
// (-13,-5.4) @TEXT("VSS",size=1.1,halign="middle",valign="top");
// &"COMMIT" @WIRE(mode="straight",linecolor="#30485d",linewidth=0.16) {#XBIT7:1 (-13.5,-2.35)};
// (-13.9,-2.35) @TEXT("COMMIT",size=1.1,halign="end",valign="middle");
// &"SAMPLE" @WIRE(mode="straight",linecolor="#30485d",linewidth=0.16) {#XBIT7:3 (-13.5,-5.65)};
// (-13.9,-5.65) @TEXT("SAMPLE",size=1.1,halign="end",valign="middle");
// &"VDD" @WIRE(mode="straight",linecolor="#30485d",linewidth=0.16) {#XBIT7:4 (4,7)};
// (4,7.4) @TEXT("VDD",size=1.1,halign="middle",valign="bottom");
// &"VSS" @WIRE(mode="straight",linecolor="#30485d",linewidth=0.16) {#XBIT7:5 (-4,-15)};
// (-4,-15.4) @TEXT("VSS",size=1.1,halign="middle",valign="top");
// &"VDD" @WIRE(mode="straight",linecolor="#30485d",linewidth=0.16) {#XMSBQ:3 (-10,-12)};
// (-10,-11.6) @TEXT("VDD",size=1.1,halign="middle",valign="bottom");
// &"VSS" @WIRE(mode="straight",linecolor="#30485d",linewidth=0.16) {#XMSBQ:4 (-10,-32)};
// (-10,-32.4) @TEXT("VSS",size=1.1,halign="middle",valign="top");
// }
// END SARADC RNL
ends sar8_se_ctrl

subckt sar8_se_acquire REQUEST VDD VSS TRACK
XDEL (REQUEST TAP VDD VSS) DEL200D1BWP12T30P140
XQUAL (REQUEST TAP ACCEPTED VDD VSS) AN2D1BWP12T30P140
XOUT (ACCEPTED TRACK VDD VSS) CKBD1BWP12T30P140
// BEGIN SARADC RNL
// @RNL(author="saradc topology") {
// #XDEL @SET-SYMBOL $S_DEL200D1BWP12T30P140;
// #XDEL @PLACE(0,0) => @ORIENT("R0");
// #XQUAL @SET-SYMBOL $S_AN2D1BWP12T30P140;
// #XQUAL @PLACE(0,-33) => @ORIENT("R0");
// #XOUT @SET-SYMBOL $S_CKBD1BWP12T30P140;
// #XOUT @PLACE(0,-66) => @ORIENT("R0");
// &"REQUEST" @WIRE(mode="straight",linecolor="#30485d",linewidth=0.16) {#XDEL:1 (-13,0) (-13,-31.35) #XQUAL:1};
// &"TAP" @WIRE(mode="straight",linecolor="#30485d",linewidth=0.16) {#XDEL:2 (0,0) (0,-34.65) #XQUAL:2};
// &"ACCEPTED" @WIRE(mode="straight",linecolor="#30485d",linewidth=0.16) {#XQUAL:3 (0,-33) (0,-66) #XOUT:1};
// (-89,30) @TEXT("sar8_se_acquire / source-derived connections",size=1.4,halign="start",textcolor="#223d52");
// &"VDD" @WIRE(mode="straight",linecolor="#30485d",linewidth=0.16) {#XDEL:3 (0,11)};
// (0,11.4) @TEXT("VDD",size=1.1,halign="middle",valign="bottom");
// &"VSS" @WIRE(mode="straight",linecolor="#30485d",linewidth=0.16) {#XDEL:4 (0,-11)};
// (0,-11.4) @TEXT("VSS",size=1.1,halign="middle",valign="top");
// &"VDD" @WIRE(mode="straight",linecolor="#30485d",linewidth=0.16) {#XQUAL:4 (0,-22)};
// (0,-21.6) @TEXT("VDD",size=1.1,halign="middle",valign="bottom");
// &"VSS" @WIRE(mode="straight",linecolor="#30485d",linewidth=0.16) {#XQUAL:5 (0,-44)};
// (0,-44.4) @TEXT("VSS",size=1.1,halign="middle",valign="top");
// &"TRACK" @WIRE(mode="straight",linecolor="#30485d",linewidth=0.16) {#XOUT:2 (16,-66)};
// (16.4,-66) @TEXT("TRACK",size=1.1,halign="start",valign="middle");
// &"VDD" @WIRE(mode="straight",linecolor="#30485d",linewidth=0.16) {#XOUT:3 (0,-55)};
// (0,-54.6) @TEXT("VDD",size=1.1,halign="middle",valign="bottom");
// &"VSS" @WIRE(mode="straight",linecolor="#30485d",linewidth=0.16) {#XOUT:4 (0,-77)};
// (0,-77.4) @TEXT("VSS",size=1.1,halign="middle",valign="top");
// }
// END SARADC RNL
ends sar8_se_acquire

subckt tb_cdac
// Isolated CDAC: precharge top plates, release, then single-bit steps and full-scale reversal.
VDPRE (d_pre 0) vsource type=pwl wave=[0 0.9 40n 0.9 40.1n 0]
VDCM (d_cm 0) vsource dc=0.45
XDPN (d_n d_cm d_pre VDD! 0) b_tb_switch
XDPP (d_p d_cm d_pre VDD! 0) b_tb_switch
VDgnn0 (d_gnn0 0) vsource type=pwl wave=[0 0.90000000000000002 5.9900000000000014e-08 0.90000000000000002 6.0000000000000008e-08 0 7.9900000000000007e-08 0 8.0000000000000002e-08 0.90000000000000002 9.9900000000000014e-08 0.90000000000000002 1.0000000000000001e-07 0.90000000000000002 1.1990000000000001e-07 0.90000000000000002 1.2000000000000002e-07 0.90000000000000002 1.399e-07 0.90000000000000002 1.4000000000000001e-07 0.90000000000000002 1.599e-07 0.90000000000000002 1.6e-07 0.90000000000000002 1.7990000000000002e-07 0.90000000000000002 1.8000000000000002e-07 0.90000000000000002 1.9990000000000001e-07 0.90000000000000002 2.0000000000000002e-07 0.90000000000000002 2.199e-07 0.90000000000000002 2.2000000000000001e-07 0 2.3990000000000002e-07 0 2.4000000000000003e-07 0.90000000000000002]
VDgnn1 (d_gnn1 0) vsource type=pwl wave=[0 0.90000000000000002 5.9900000000000014e-08 0.90000000000000002 6.0000000000000008e-08 0.90000000000000002 7.9900000000000007e-08 0.90000000000000002 8.0000000000000002e-08 0 9.9900000000000014e-08 0 1.0000000000000001e-07 0.90000000000000002 1.1990000000000001e-07 0.90000000000000002 1.2000000000000002e-07 0.90000000000000002 1.399e-07 0.90000000000000002 1.4000000000000001e-07 0.90000000000000002 1.599e-07 0.90000000000000002 1.6e-07 0.90000000000000002 1.7990000000000002e-07 0.90000000000000002 1.8000000000000002e-07 0.90000000000000002 1.9990000000000001e-07 0.90000000000000002 2.0000000000000002e-07 0.90000000000000002 2.199e-07 0.90000000000000002 2.2000000000000001e-07 0 2.3990000000000002e-07 0 2.4000000000000003e-07 0.90000000000000002]
VDgnn2 (d_gnn2 0) vsource type=pwl wave=[0 0.90000000000000002 5.9900000000000014e-08 0.90000000000000002 6.0000000000000008e-08 0.90000000000000002 7.9900000000000007e-08 0.90000000000000002 8.0000000000000002e-08 0.90000000000000002 9.9900000000000014e-08 0.90000000000000002 1.0000000000000001e-07 0 1.1990000000000001e-07 0 1.2000000000000002e-07 0.90000000000000002 1.399e-07 0.90000000000000002 1.4000000000000001e-07 0.90000000000000002 1.599e-07 0.90000000000000002 1.6e-07 0.90000000000000002 1.7990000000000002e-07 0.90000000000000002 1.8000000000000002e-07 0.90000000000000002 1.9990000000000001e-07 0.90000000000000002 2.0000000000000002e-07 0.90000000000000002 2.199e-07 0.90000000000000002 2.2000000000000001e-07 0 2.3990000000000002e-07 0 2.4000000000000003e-07 0.90000000000000002]
VDgnn3 (d_gnn3 0) vsource type=pwl wave=[0 0.90000000000000002 5.9900000000000014e-08 0.90000000000000002 6.0000000000000008e-08 0.90000000000000002 7.9900000000000007e-08 0.90000000000000002 8.0000000000000002e-08 0.90000000000000002 9.9900000000000014e-08 0.90000000000000002 1.0000000000000001e-07 0.90000000000000002 1.1990000000000001e-07 0.90000000000000002 1.2000000000000002e-07 0 1.399e-07 0 1.4000000000000001e-07 0.90000000000000002 1.599e-07 0.90000000000000002 1.6e-07 0.90000000000000002 1.7990000000000002e-07 0.90000000000000002 1.8000000000000002e-07 0.90000000000000002 1.9990000000000001e-07 0.90000000000000002 2.0000000000000002e-07 0.90000000000000002 2.199e-07 0.90000000000000002 2.2000000000000001e-07 0 2.3990000000000002e-07 0 2.4000000000000003e-07 0.90000000000000002]
VDgnn4 (d_gnn4 0) vsource type=pwl wave=[0 0.90000000000000002 5.9900000000000014e-08 0.90000000000000002 6.0000000000000008e-08 0.90000000000000002 7.9900000000000007e-08 0.90000000000000002 8.0000000000000002e-08 0.90000000000000002 9.9900000000000014e-08 0.90000000000000002 1.0000000000000001e-07 0.90000000000000002 1.1990000000000001e-07 0.90000000000000002 1.2000000000000002e-07 0.90000000000000002 1.399e-07 0.90000000000000002 1.4000000000000001e-07 0 1.599e-07 0 1.6e-07 0.90000000000000002 1.7990000000000002e-07 0.90000000000000002 1.8000000000000002e-07 0.90000000000000002 1.9990000000000001e-07 0.90000000000000002 2.0000000000000002e-07 0.90000000000000002 2.199e-07 0.90000000000000002 2.2000000000000001e-07 0 2.3990000000000002e-07 0 2.4000000000000003e-07 0.90000000000000002]
VDgnn5 (d_gnn5 0) vsource type=pwl wave=[0 0.90000000000000002 5.9900000000000014e-08 0.90000000000000002 6.0000000000000008e-08 0.90000000000000002 7.9900000000000007e-08 0.90000000000000002 8.0000000000000002e-08 0.90000000000000002 9.9900000000000014e-08 0.90000000000000002 1.0000000000000001e-07 0.90000000000000002 1.1990000000000001e-07 0.90000000000000002 1.2000000000000002e-07 0.90000000000000002 1.399e-07 0.90000000000000002 1.4000000000000001e-07 0.90000000000000002 1.599e-07 0.90000000000000002 1.6e-07 0 1.7990000000000002e-07 0 1.8000000000000002e-07 0.90000000000000002 1.9990000000000001e-07 0.90000000000000002 2.0000000000000002e-07 0.90000000000000002 2.199e-07 0.90000000000000002 2.2000000000000001e-07 0 2.3990000000000002e-07 0 2.4000000000000003e-07 0.90000000000000002]
VDgnn6 (d_gnn6 0) vsource type=pwl wave=[0 0.90000000000000002 5.9900000000000014e-08 0.90000000000000002 6.0000000000000008e-08 0.90000000000000002 7.9900000000000007e-08 0.90000000000000002 8.0000000000000002e-08 0.90000000000000002 9.9900000000000014e-08 0.90000000000000002 1.0000000000000001e-07 0.90000000000000002 1.1990000000000001e-07 0.90000000000000002 1.2000000000000002e-07 0.90000000000000002 1.399e-07 0.90000000000000002 1.4000000000000001e-07 0.90000000000000002 1.599e-07 0.90000000000000002 1.6e-07 0.90000000000000002 1.7990000000000002e-07 0.90000000000000002 1.8000000000000002e-07 0 1.9990000000000001e-07 0 2.0000000000000002e-07 0.90000000000000002 2.199e-07 0.90000000000000002 2.2000000000000001e-07 0 2.3990000000000002e-07 0 2.4000000000000003e-07 0.90000000000000002]
VDgnn7 (d_gnn7 0) vsource type=pwl wave=[0 0.90000000000000002 5.9900000000000014e-08 0.90000000000000002 6.0000000000000008e-08 0.90000000000000002 7.9900000000000007e-08 0.90000000000000002 8.0000000000000002e-08 0.90000000000000002 9.9900000000000014e-08 0.90000000000000002 1.0000000000000001e-07 0.90000000000000002 1.1990000000000001e-07 0.90000000000000002 1.2000000000000002e-07 0.90000000000000002 1.399e-07 0.90000000000000002 1.4000000000000001e-07 0.90000000000000002 1.599e-07 0.90000000000000002 1.6e-07 0.90000000000000002 1.7990000000000002e-07 0.90000000000000002 1.8000000000000002e-07 0.90000000000000002 1.9990000000000001e-07 0.90000000000000002 2.0000000000000002e-07 0 2.199e-07 0 2.2000000000000001e-07 0 2.3990000000000002e-07 0 2.4000000000000003e-07 0.90000000000000002]
VDgpn0 (d_gpn0 0) vsource type=pwl wave=[0 0 5.9900000000000014e-08 0 6.0000000000000008e-08 0.90000000000000002 7.9900000000000007e-08 0.90000000000000002 8.0000000000000002e-08 0 9.9900000000000014e-08 0 1.0000000000000001e-07 0 1.1990000000000001e-07 0 1.2000000000000002e-07 0 1.399e-07 0 1.4000000000000001e-07 0 1.599e-07 0 1.6e-07 0 1.7990000000000002e-07 0 1.8000000000000002e-07 0 1.9990000000000001e-07 0 2.0000000000000002e-07 0 2.199e-07 0 2.2000000000000001e-07 0.90000000000000002 2.3990000000000002e-07 0.90000000000000002 2.4000000000000003e-07 0]
VDgpn1 (d_gpn1 0) vsource type=pwl wave=[0 0 5.9900000000000014e-08 0 6.0000000000000008e-08 0 7.9900000000000007e-08 0 8.0000000000000002e-08 0.90000000000000002 9.9900000000000014e-08 0.90000000000000002 1.0000000000000001e-07 0 1.1990000000000001e-07 0 1.2000000000000002e-07 0 1.399e-07 0 1.4000000000000001e-07 0 1.599e-07 0 1.6e-07 0 1.7990000000000002e-07 0 1.8000000000000002e-07 0 1.9990000000000001e-07 0 2.0000000000000002e-07 0 2.199e-07 0 2.2000000000000001e-07 0.90000000000000002 2.3990000000000002e-07 0.90000000000000002 2.4000000000000003e-07 0]
VDgpn2 (d_gpn2 0) vsource type=pwl wave=[0 0 5.9900000000000014e-08 0 6.0000000000000008e-08 0 7.9900000000000007e-08 0 8.0000000000000002e-08 0 9.9900000000000014e-08 0 1.0000000000000001e-07 0.90000000000000002 1.1990000000000001e-07 0.90000000000000002 1.2000000000000002e-07 0 1.399e-07 0 1.4000000000000001e-07 0 1.599e-07 0 1.6e-07 0 1.7990000000000002e-07 0 1.8000000000000002e-07 0 1.9990000000000001e-07 0 2.0000000000000002e-07 0 2.199e-07 0 2.2000000000000001e-07 0.90000000000000002 2.3990000000000002e-07 0.90000000000000002 2.4000000000000003e-07 0]
VDgpn3 (d_gpn3 0) vsource type=pwl wave=[0 0 5.9900000000000014e-08 0 6.0000000000000008e-08 0 7.9900000000000007e-08 0 8.0000000000000002e-08 0 9.9900000000000014e-08 0 1.0000000000000001e-07 0 1.1990000000000001e-07 0 1.2000000000000002e-07 0.90000000000000002 1.399e-07 0.90000000000000002 1.4000000000000001e-07 0 1.599e-07 0 1.6e-07 0 1.7990000000000002e-07 0 1.8000000000000002e-07 0 1.9990000000000001e-07 0 2.0000000000000002e-07 0 2.199e-07 0 2.2000000000000001e-07 0.90000000000000002 2.3990000000000002e-07 0.90000000000000002 2.4000000000000003e-07 0]
VDgpn4 (d_gpn4 0) vsource type=pwl wave=[0 0 5.9900000000000014e-08 0 6.0000000000000008e-08 0 7.9900000000000007e-08 0 8.0000000000000002e-08 0 9.9900000000000014e-08 0 1.0000000000000001e-07 0 1.1990000000000001e-07 0 1.2000000000000002e-07 0 1.399e-07 0 1.4000000000000001e-07 0.90000000000000002 1.599e-07 0.90000000000000002 1.6e-07 0 1.7990000000000002e-07 0 1.8000000000000002e-07 0 1.9990000000000001e-07 0 2.0000000000000002e-07 0 2.199e-07 0 2.2000000000000001e-07 0.90000000000000002 2.3990000000000002e-07 0.90000000000000002 2.4000000000000003e-07 0]
VDgpn5 (d_gpn5 0) vsource type=pwl wave=[0 0 5.9900000000000014e-08 0 6.0000000000000008e-08 0 7.9900000000000007e-08 0 8.0000000000000002e-08 0 9.9900000000000014e-08 0 1.0000000000000001e-07 0 1.1990000000000001e-07 0 1.2000000000000002e-07 0 1.399e-07 0 1.4000000000000001e-07 0 1.599e-07 0 1.6e-07 0.90000000000000002 1.7990000000000002e-07 0.90000000000000002 1.8000000000000002e-07 0 1.9990000000000001e-07 0 2.0000000000000002e-07 0 2.199e-07 0 2.2000000000000001e-07 0.90000000000000002 2.3990000000000002e-07 0.90000000000000002 2.4000000000000003e-07 0]
VDgpn6 (d_gpn6 0) vsource type=pwl wave=[0 0 5.9900000000000014e-08 0 6.0000000000000008e-08 0 7.9900000000000007e-08 0 8.0000000000000002e-08 0 9.9900000000000014e-08 0 1.0000000000000001e-07 0 1.1990000000000001e-07 0 1.2000000000000002e-07 0 1.399e-07 0 1.4000000000000001e-07 0 1.599e-07 0 1.6e-07 0 1.7990000000000002e-07 0 1.8000000000000002e-07 0.90000000000000002 1.9990000000000001e-07 0.90000000000000002 2.0000000000000002e-07 0 2.199e-07 0 2.2000000000000001e-07 0.90000000000000002 2.3990000000000002e-07 0.90000000000000002 2.4000000000000003e-07 0]
VDgpn7 (d_gpn7 0) vsource type=pwl wave=[0 0 5.9900000000000014e-08 0 6.0000000000000008e-08 0 7.9900000000000007e-08 0 8.0000000000000002e-08 0 9.9900000000000014e-08 0 1.0000000000000001e-07 0 1.1990000000000001e-07 0 1.2000000000000002e-07 0 1.399e-07 0 1.4000000000000001e-07 0 1.599e-07 0 1.6e-07 0 1.7990000000000002e-07 0 1.8000000000000002e-07 0 1.9990000000000001e-07 0 2.0000000000000002e-07 0.90000000000000002 2.199e-07 0.90000000000000002 2.2000000000000001e-07 0.90000000000000002 2.3990000000000002e-07 0.90000000000000002 2.4000000000000003e-07 0]
XDAC (d_gnn0 d_gnn1 d_gnn2 d_gnn3 d_gnn4 d_gnn5 d_gnn6 d_gnn7 d_gpn0 d_gpn1 d_gpn2 d_gpn3 d_gpn4 d_gpn5 d_gpn6 d_gpn7 d_n d_p VDD! d_rn d_rp 0) sar8j_r1_cdac
VDRN (d_rns 0) vsource dc=0
VDRP (d_rps 0) vsource dc=0.9
RDRN (d_rns d_rn) resistor r=50
RDRP (d_rps d_rp) resistor r=50
CDRN (d_rn 0) capacitor c=4p
CDRP (d_rp 0) capacitor c=4p

// BEGIN SARADC RNL
// @RNL(author="saradc topology") {
// #VDPRE @SET-SYMBOL $VOLTAGE_SOURCE;
// #VDPRE @PLACE(-70,0) => @ORIENT("R0");
// #VDPRE @TEXT("VDPRE",key="name",size=1.3,halign="start") => @PLACE(-67,3);
// #VDPRE @TEXT("",key="value",size=0.9,halign="start") => @PLACE(-67,-4);
// #VDPRE @TEXT("",key="model");
// #VDCM @SET-SYMBOL $VOLTAGE_SOURCE;
// #VDCM @PLACE(-70,-33) => @ORIENT("R0");
// #VDCM @TEXT("VDCM",key="name",size=1.3,halign="start") => @PLACE(-67,-30);
// #VDCM @TEXT("",key="value",size=0.9,halign="start") => @PLACE(-67,-37);
// #VDCM @TEXT("",key="model");
// #VDgnn0 @SET-SYMBOL $VOLTAGE_SOURCE;
// #VDgnn0 @PLACE(-70,-66) => @ORIENT("R0");
// #VDgnn0 @TEXT("VDgnn0",key="name",size=1.3,halign="start") => @PLACE(-67,-63);
// #VDgnn0 @TEXT("",key="value",size=0.9,halign="start") => @PLACE(-67,-70);
// #VDgnn0 @TEXT("",key="model");
// #VDgnn1 @SET-SYMBOL $VOLTAGE_SOURCE;
// #VDgnn1 @PLACE(-70,-99) => @ORIENT("R0");
// #VDgnn1 @TEXT("VDgnn1",key="name",size=1.3,halign="start") => @PLACE(-67,-96);
// #VDgnn1 @TEXT("",key="value",size=0.9,halign="start") => @PLACE(-67,-103);
// #VDgnn1 @TEXT("",key="model");
// #VDgnn2 @SET-SYMBOL $VOLTAGE_SOURCE;
// #VDgnn2 @PLACE(-70,-132) => @ORIENT("R0");
// #VDgnn2 @TEXT("VDgnn2",key="name",size=1.3,halign="start") => @PLACE(-67,-129);
// #VDgnn2 @TEXT("",key="value",size=0.9,halign="start") => @PLACE(-67,-136);
// #VDgnn2 @TEXT("",key="model");
// #VDgnn3 @SET-SYMBOL $VOLTAGE_SOURCE;
// #VDgnn3 @PLACE(-70,-165) => @ORIENT("R0");
// #VDgnn3 @TEXT("VDgnn3",key="name",size=1.3,halign="start") => @PLACE(-67,-162);
// #VDgnn3 @TEXT("",key="value",size=0.9,halign="start") => @PLACE(-67,-169);
// #VDgnn3 @TEXT("",key="model");
// #VDgnn4 @SET-SYMBOL $VOLTAGE_SOURCE;
// #VDgnn4 @PLACE(-70,-198) => @ORIENT("R0");
// #VDgnn4 @TEXT("VDgnn4",key="name",size=1.3,halign="start") => @PLACE(-67,-195);
// #VDgnn4 @TEXT("",key="value",size=0.9,halign="start") => @PLACE(-67,-202);
// #VDgnn4 @TEXT("",key="model");
// #VDgnn5 @SET-SYMBOL $VOLTAGE_SOURCE;
// #VDgnn5 @PLACE(-70,-231) => @ORIENT("R0");
// #VDgnn5 @TEXT("VDgnn5",key="name",size=1.3,halign="start") => @PLACE(-67,-228);
// #VDgnn5 @TEXT("",key="value",size=0.9,halign="start") => @PLACE(-67,-235);
// #VDgnn5 @TEXT("",key="model");
// #VDgnn6 @SET-SYMBOL $VOLTAGE_SOURCE;
// #VDgnn6 @PLACE(-70,-264) => @ORIENT("R0");
// #VDgnn6 @TEXT("VDgnn6",key="name",size=1.3,halign="start") => @PLACE(-67,-261);
// #VDgnn6 @TEXT("",key="value",size=0.9,halign="start") => @PLACE(-67,-268);
// #VDgnn6 @TEXT("",key="model");
// #VDgnn7 @SET-SYMBOL $VOLTAGE_SOURCE;
// #VDgnn7 @PLACE(-70,-297) => @ORIENT("R0");
// #VDgnn7 @TEXT("VDgnn7",key="name",size=1.3,halign="start") => @PLACE(-67,-294);
// #VDgnn7 @TEXT("",key="value",size=0.9,halign="start") => @PLACE(-67,-301);
// #VDgnn7 @TEXT("",key="model");
// #VDgpn0 @SET-SYMBOL $VOLTAGE_SOURCE;
// #VDgpn0 @PLACE(-70,-330) => @ORIENT("R0");
// #VDgpn0 @TEXT("VDgpn0",key="name",size=1.3,halign="start") => @PLACE(-67,-327);
// #VDgpn0 @TEXT("",key="value",size=0.9,halign="start") => @PLACE(-67,-334);
// #VDgpn0 @TEXT("",key="model");
// #VDgpn1 @SET-SYMBOL $VOLTAGE_SOURCE;
// #VDgpn1 @PLACE(-70,-363) => @ORIENT("R0");
// #VDgpn1 @TEXT("VDgpn1",key="name",size=1.3,halign="start") => @PLACE(-67,-360);
// #VDgpn1 @TEXT("",key="value",size=0.9,halign="start") => @PLACE(-67,-367);
// #VDgpn1 @TEXT("",key="model");
// #VDgpn2 @SET-SYMBOL $VOLTAGE_SOURCE;
// #VDgpn2 @PLACE(-15,0) => @ORIENT("R0");
// #VDgpn2 @TEXT("VDgpn2",key="name",size=1.3,halign="start") => @PLACE(-12,3);
// #VDgpn2 @TEXT("",key="value",size=0.9,halign="start") => @PLACE(-12,-4);
// #VDgpn2 @TEXT("",key="model");
// #VDgpn3 @SET-SYMBOL $VOLTAGE_SOURCE;
// #VDgpn3 @PLACE(-15,-33) => @ORIENT("R0");
// #VDgpn3 @TEXT("VDgpn3",key="name",size=1.3,halign="start") => @PLACE(-12,-30);
// #VDgpn3 @TEXT("",key="value",size=0.9,halign="start") => @PLACE(-12,-37);
// #VDgpn3 @TEXT("",key="model");
// #VDgpn4 @SET-SYMBOL $VOLTAGE_SOURCE;
// #VDgpn4 @PLACE(-15,-66) => @ORIENT("R0");
// #VDgpn4 @TEXT("VDgpn4",key="name",size=1.3,halign="start") => @PLACE(-12,-63);
// #VDgpn4 @TEXT("",key="value",size=0.9,halign="start") => @PLACE(-12,-70);
// #VDgpn4 @TEXT("",key="model");
// #VDgpn5 @SET-SYMBOL $VOLTAGE_SOURCE;
// #VDgpn5 @PLACE(-15,-99) => @ORIENT("R0");
// #VDgpn5 @TEXT("VDgpn5",key="name",size=1.3,halign="start") => @PLACE(-12,-96);
// #VDgpn5 @TEXT("",key="value",size=0.9,halign="start") => @PLACE(-12,-103);
// #VDgpn5 @TEXT("",key="model");
// #VDgpn6 @SET-SYMBOL $VOLTAGE_SOURCE;
// #VDgpn6 @PLACE(-15,-132) => @ORIENT("R0");
// #VDgpn6 @TEXT("VDgpn6",key="name",size=1.3,halign="start") => @PLACE(-12,-129);
// #VDgpn6 @TEXT("",key="value",size=0.9,halign="start") => @PLACE(-12,-136);
// #VDgpn6 @TEXT("",key="model");
// #VDgpn7 @SET-SYMBOL $VOLTAGE_SOURCE;
// #VDgpn7 @PLACE(-15,-165) => @ORIENT("R0");
// #VDgpn7 @TEXT("VDgpn7",key="name",size=1.3,halign="start") => @PLACE(-12,-162);
// #VDgpn7 @TEXT("",key="value",size=0.9,halign="start") => @PLACE(-12,-169);
// #VDgpn7 @TEXT("",key="model");
// #VDRN @SET-SYMBOL $VOLTAGE_SOURCE;
// #VDRN @PLACE(-15,-198) => @ORIENT("R0");
// #VDRN @TEXT("VDRN",key="name",size=1.3,halign="start") => @PLACE(-12,-195);
// #VDRN @TEXT("",key="value",size=0.9,halign="start") => @PLACE(-12,-202);
// #VDRN @TEXT("",key="model");
// #VDRP @SET-SYMBOL $VOLTAGE_SOURCE;
// #VDRP @PLACE(-15,-231) => @ORIENT("R0");
// #VDRP @TEXT("VDRP",key="name",size=1.3,halign="start") => @PLACE(-12,-228);
// #VDRP @TEXT("",key="value",size=0.9,halign="start") => @PLACE(-12,-235);
// #VDRP @TEXT("",key="model");
// #XDPN @SET-SYMBOL $S_b_tb_switch;
// #XDPN @PLACE(0,0) => @ORIENT("R0");
// #XDPP @SET-SYMBOL $S_b_tb_switch;
// #XDPP @PLACE(0,-33) => @ORIENT("R0");
// #XDAC @SET-SYMBOL $S_sar8j_r1_cdac;
// #XDAC @PLACE(0,-66) => @ORIENT("R0");
// #RDRN @SET-SYMBOL $RESISTOR;
// #RDRN @PLACE(90,0) => @ORIENT("R0");
// #RDRN @TEXT("RDRN",key="name",size=1.3,halign="start") => @PLACE(93,3);
// #RDRN @TEXT("r=50",key="value",size=0.9,halign="start") => @PLACE(93,-4);
// #RDRN @TEXT("",key="model");
// #RDRP @SET-SYMBOL $RESISTOR;
// #RDRP @PLACE(90,-33) => @ORIENT("R0");
// #RDRP @TEXT("RDRP",key="name",size=1.3,halign="start") => @PLACE(93,-30);
// #RDRP @TEXT("r=50",key="value",size=0.9,halign="start") => @PLACE(93,-37);
// #RDRP @TEXT("",key="model");
// #CDRN @SET-SYMBOL $CAPACITOR;
// #CDRN @PLACE(90,-66) => @ORIENT("R0");
// #CDRN @TEXT("CDRN",key="name",size=1.3,halign="start") => @PLACE(93,-63);
// #CDRN @TEXT("c=4p",key="value",size=0.9,halign="start") => @PLACE(93,-70);
// #CDRN @TEXT("",key="model");
// #CDRP @SET-SYMBOL $CAPACITOR;
// #CDRP @PLACE(90,-99) => @ORIENT("R0");
// #CDRP @TEXT("CDRP",key="name",size=1.3,halign="start") => @PLACE(93,-96);
// #CDRP @TEXT("c=4p",key="value",size=0.9,halign="start") => @PLACE(93,-103);
// #CDRP @TEXT("",key="model");
// (-89,30) @TEXT("tb_cdac / source-derived connections",size=1.4,halign="start",textcolor="#223d52");
// &"d_pre" @WIRE(mode="straight",linecolor="#30485d",linewidth=0.16) {#VDPRE:1 (-70,5)};
// (-70,5.4) @TEXT("d_pre",size=1.1,halign="middle",valign="bottom");
// &"0" @WIRE(mode="straight",linecolor="#30485d",linewidth=0.16) {#VDPRE:2 (-70,-5)};
// (-70,-5.4) @TEXT("0",size=1.1,halign="middle",valign="top");
// &"d_cm" @WIRE(mode="straight",linecolor="#30485d",linewidth=0.16) {#VDCM:1 (-70,-28)};
// (-70,-27.6) @TEXT("d_cm",size=1.1,halign="middle",valign="bottom");
// &"0" @WIRE(mode="straight",linecolor="#30485d",linewidth=0.16) {#VDCM:2 (-70,-38)};
// (-70,-38.4) @TEXT("0",size=1.1,halign="middle",valign="top");
// &"d_n" @WIRE(mode="straight",linecolor="#30485d",linewidth=0.16) {#XDPN:1 (-16,3.3)};
// (-16.4,3.3) @TEXT("d_n",size=1.1,halign="end",valign="middle");
// &"d_cm" @WIRE(mode="straight",linecolor="#30485d",linewidth=0.16) {#XDPN:2 (-16,0)};
// (-16.4,0) @TEXT("d_cm",size=1.1,halign="end",valign="middle");
// &"d_pre" @WIRE(mode="straight",linecolor="#30485d",linewidth=0.16) {#XDPN:3 (-16,-3.3)};
// (-16.4,-3.3) @TEXT("d_pre",size=1.1,halign="end",valign="middle");
// &"VDD!" @WIRE(mode="straight",linecolor="#30485d",linewidth=0.16) {#XDPN:4 (0,11.6)};
// (0,12) @TEXT("VDD!",size=1.1,halign="middle",valign="bottom");
// &"0" @WIRE(mode="straight",linecolor="#30485d",linewidth=0.16) {#XDPN:5 (0,-11.6)};
// (0,-12) @TEXT("0",size=1.1,halign="middle",valign="top");
// &"d_p" @WIRE(mode="straight",linecolor="#30485d",linewidth=0.16) {#XDPP:1 (-16,-29.7)};
// (-16.4,-29.7) @TEXT("d_p",size=1.1,halign="end",valign="middle");
// &"d_cm" @WIRE(mode="straight",linecolor="#30485d",linewidth=0.16) {#XDPP:2 (-16,-33)};
// (-16.4,-33) @TEXT("d_cm",size=1.1,halign="end",valign="middle");
// &"d_pre" @WIRE(mode="straight",linecolor="#30485d",linewidth=0.16) {#XDPP:3 (-16,-36.3)};
// (-16.4,-36.3) @TEXT("d_pre",size=1.1,halign="end",valign="middle");
// &"VDD!" @WIRE(mode="straight",linecolor="#30485d",linewidth=0.16) {#XDPP:4 (0,-21.4)};
// (0,-21) @TEXT("VDD!",size=1.1,halign="middle",valign="bottom");
// &"0" @WIRE(mode="straight",linecolor="#30485d",linewidth=0.16) {#XDPP:5 (0,-44.6)};
// (0,-45) @TEXT("0",size=1.1,halign="middle",valign="top");
// &"d_gnn0" @WIRE(mode="straight",linecolor="#30485d",linewidth=0.16) {#VDgnn0:1 (-70,-61)};
// (-70,-60.6) @TEXT("d_gnn0",size=1.1,halign="middle",valign="bottom");
// &"0" @WIRE(mode="straight",linecolor="#30485d",linewidth=0.16) {#VDgnn0:2 (-70,-71)};
// (-70,-71.4) @TEXT("0",size=1.1,halign="middle",valign="top");
// &"d_gnn1" @WIRE(mode="straight",linecolor="#30485d",linewidth=0.16) {#VDgnn1:1 (-70,-94)};
// (-70,-93.6) @TEXT("d_gnn1",size=1.1,halign="middle",valign="bottom");
// &"0" @WIRE(mode="straight",linecolor="#30485d",linewidth=0.16) {#VDgnn1:2 (-70,-104)};
// (-70,-104.4) @TEXT("0",size=1.1,halign="middle",valign="top");
// &"d_gnn2" @WIRE(mode="straight",linecolor="#30485d",linewidth=0.16) {#VDgnn2:1 (-70,-127)};
// (-70,-126.6) @TEXT("d_gnn2",size=1.1,halign="middle",valign="bottom");
// &"0" @WIRE(mode="straight",linecolor="#30485d",linewidth=0.16) {#VDgnn2:2 (-70,-137)};
// (-70,-137.4) @TEXT("0",size=1.1,halign="middle",valign="top");
// &"d_gnn3" @WIRE(mode="straight",linecolor="#30485d",linewidth=0.16) {#VDgnn3:1 (-70,-160)};
// (-70,-159.6) @TEXT("d_gnn3",size=1.1,halign="middle",valign="bottom");
// &"0" @WIRE(mode="straight",linecolor="#30485d",linewidth=0.16) {#VDgnn3:2 (-70,-170)};
// (-70,-170.4) @TEXT("0",size=1.1,halign="middle",valign="top");
// &"d_gnn4" @WIRE(mode="straight",linecolor="#30485d",linewidth=0.16) {#VDgnn4:1 (-70,-193)};
// (-70,-192.6) @TEXT("d_gnn4",size=1.1,halign="middle",valign="bottom");
// &"0" @WIRE(mode="straight",linecolor="#30485d",linewidth=0.16) {#VDgnn4:2 (-70,-203)};
// (-70,-203.4) @TEXT("0",size=1.1,halign="middle",valign="top");
// &"d_gnn5" @WIRE(mode="straight",linecolor="#30485d",linewidth=0.16) {#VDgnn5:1 (-70,-226)};
// (-70,-225.6) @TEXT("d_gnn5",size=1.1,halign="middle",valign="bottom");
// &"0" @WIRE(mode="straight",linecolor="#30485d",linewidth=0.16) {#VDgnn5:2 (-70,-236)};
// (-70,-236.4) @TEXT("0",size=1.1,halign="middle",valign="top");
// &"d_gnn6" @WIRE(mode="straight",linecolor="#30485d",linewidth=0.16) {#VDgnn6:1 (-70,-259)};
// (-70,-258.6) @TEXT("d_gnn6",size=1.1,halign="middle",valign="bottom");
// &"0" @WIRE(mode="straight",linecolor="#30485d",linewidth=0.16) {#VDgnn6:2 (-70,-269)};
// (-70,-269.4) @TEXT("0",size=1.1,halign="middle",valign="top");
// &"d_gnn7" @WIRE(mode="straight",linecolor="#30485d",linewidth=0.16) {#VDgnn7:1 (-70,-292)};
// (-70,-291.6) @TEXT("d_gnn7",size=1.1,halign="middle",valign="bottom");
// &"0" @WIRE(mode="straight",linecolor="#30485d",linewidth=0.16) {#VDgnn7:2 (-70,-302)};
// (-70,-302.4) @TEXT("0",size=1.1,halign="middle",valign="top");
// &"d_gpn0" @WIRE(mode="straight",linecolor="#30485d",linewidth=0.16) {#VDgpn0:1 (-70,-325)};
// (-70,-324.6) @TEXT("d_gpn0",size=1.1,halign="middle",valign="bottom");
// &"0" @WIRE(mode="straight",linecolor="#30485d",linewidth=0.16) {#VDgpn0:2 (-70,-335)};
// (-70,-335.4) @TEXT("0",size=1.1,halign="middle",valign="top");
// &"d_gpn1" @WIRE(mode="straight",linecolor="#30485d",linewidth=0.16) {#VDgpn1:1 (-70,-358)};
// (-70,-357.6) @TEXT("d_gpn1",size=1.1,halign="middle",valign="bottom");
// &"0" @WIRE(mode="straight",linecolor="#30485d",linewidth=0.16) {#VDgpn1:2 (-70,-368)};
// (-70,-368.4) @TEXT("0",size=1.1,halign="middle",valign="top");
// &"d_gpn2" @WIRE(mode="straight",linecolor="#30485d",linewidth=0.16) {#VDgpn2:1 (-15,5)};
// (-15,5.4) @TEXT("d_gpn2",size=1.1,halign="middle",valign="bottom");
// &"0" @WIRE(mode="straight",linecolor="#30485d",linewidth=0.16) {#VDgpn2:2 (-15,-5)};
// (-15,-5.4) @TEXT("0",size=1.1,halign="middle",valign="top");
// &"d_gpn3" @WIRE(mode="straight",linecolor="#30485d",linewidth=0.16) {#VDgpn3:1 (-15,-28)};
// (-15,-27.6) @TEXT("d_gpn3",size=1.1,halign="middle",valign="bottom");
// &"0" @WIRE(mode="straight",linecolor="#30485d",linewidth=0.16) {#VDgpn3:2 (-15,-38)};
// (-15,-38.4) @TEXT("0",size=1.1,halign="middle",valign="top");
// &"d_gpn4" @WIRE(mode="straight",linecolor="#30485d",linewidth=0.16) {#VDgpn4:1 (-15,-61)};
// (-15,-60.6) @TEXT("d_gpn4",size=1.1,halign="middle",valign="bottom");
// &"0" @WIRE(mode="straight",linecolor="#30485d",linewidth=0.16) {#VDgpn4:2 (-15,-71)};
// (-15,-71.4) @TEXT("0",size=1.1,halign="middle",valign="top");
// &"d_gpn5" @WIRE(mode="straight",linecolor="#30485d",linewidth=0.16) {#VDgpn5:1 (-15,-94)};
// (-15,-93.6) @TEXT("d_gpn5",size=1.1,halign="middle",valign="bottom");
// &"0" @WIRE(mode="straight",linecolor="#30485d",linewidth=0.16) {#VDgpn5:2 (-15,-104)};
// (-15,-104.4) @TEXT("0",size=1.1,halign="middle",valign="top");
// &"d_gpn6" @WIRE(mode="straight",linecolor="#30485d",linewidth=0.16) {#VDgpn6:1 (-15,-127)};
// (-15,-126.6) @TEXT("d_gpn6",size=1.1,halign="middle",valign="bottom");
// &"0" @WIRE(mode="straight",linecolor="#30485d",linewidth=0.16) {#VDgpn6:2 (-15,-137)};
// (-15,-137.4) @TEXT("0",size=1.1,halign="middle",valign="top");
// &"d_gpn7" @WIRE(mode="straight",linecolor="#30485d",linewidth=0.16) {#VDgpn7:1 (-15,-160)};
// (-15,-159.6) @TEXT("d_gpn7",size=1.1,halign="middle",valign="bottom");
// &"0" @WIRE(mode="straight",linecolor="#30485d",linewidth=0.16) {#VDgpn7:2 (-15,-170)};
// (-15,-170.4) @TEXT("0",size=1.1,halign="middle",valign="top");
// {&"d_gnn0" &"d_gnn1" &"d_gnn2" &"d_gnn3" &"d_gnn4" &"d_gnn5" &"d_gnn6" &"d_gnn7"} @WIRE(mode="straight",linewidth=0.3) {#XDAC:1 (-8,-77)};
// (-8,-77.4) @TEXT("d_gnn[7:0]",size=1.1,halign="middle",valign="top");
// {&"d_gpn0" &"d_gpn1" &"d_gpn2" &"d_gpn3" &"d_gpn4" &"d_gpn5" &"d_gpn6" &"d_gpn7"} @WIRE(mode="straight",linewidth=0.3) {#XDAC:9 (8,-77)};
// (8,-77.4) @TEXT("d_gpn[7:0]",size=1.1,halign="middle",valign="top");
// &"d_n" @WIRE(mode="straight",linecolor="#30485d",linewidth=0.16) {#XDAC:17 (8,-55)};
// (8,-54.6) @TEXT("d_n",size=1.1,halign="middle",valign="bottom");
// &"d_p" @WIRE(mode="straight",linecolor="#30485d",linewidth=0.16) {#XDAC:18 (-8,-55)};
// (-8,-54.6) @TEXT("d_p",size=1.1,halign="middle",valign="bottom");
// &"VDD!" @WIRE(mode="straight",linecolor="#30485d",linewidth=0.16) {#XDAC:19 (0,-55)};
// (0,-54.6) @TEXT("VDD!",size=1.1,halign="middle",valign="bottom");
// &"d_rn" @WIRE(mode="straight",linecolor="#30485d",linewidth=0.16) {#XDAC:20 (-18,-67.65)};
// (-18.4,-67.65) @TEXT("d_rn",size=1.1,halign="end",valign="middle");
// &"d_rp" @WIRE(mode="straight",linecolor="#30485d",linewidth=0.16) {#XDAC:21 (-18,-64.35)};
// (-18.4,-64.35) @TEXT("d_rp",size=1.1,halign="end",valign="middle");
// &"0" @WIRE(mode="straight",linecolor="#30485d",linewidth=0.16) {#XDAC:22 (0,-77)};
// (0,-77.4) @TEXT("0",size=1.1,halign="middle",valign="top");
// &"d_rns" @WIRE(mode="straight",linecolor="#30485d",linewidth=0.16) {#VDRN:1 (-15,-193)};
// (-15,-192.6) @TEXT("d_rns",size=1.1,halign="middle",valign="bottom");
// &"0" @WIRE(mode="straight",linecolor="#30485d",linewidth=0.16) {#VDRN:2 (-15,-203)};
// (-15,-203.4) @TEXT("0",size=1.1,halign="middle",valign="top");
// &"d_rps" @WIRE(mode="straight",linecolor="#30485d",linewidth=0.16) {#VDRP:1 (-15,-226)};
// (-15,-225.6) @TEXT("d_rps",size=1.1,halign="middle",valign="bottom");
// &"0" @WIRE(mode="straight",linecolor="#30485d",linewidth=0.16) {#VDRP:2 (-15,-236)};
// (-15,-236.4) @TEXT("0",size=1.1,halign="middle",valign="top");
// &"d_rns" @WIRE(mode="straight",linecolor="#30485d",linewidth=0.16) {#RDRN:1 (90,5)};
// (90,5.4) @TEXT("d_rns",size=1.1,halign="middle",valign="bottom");
// &"d_rn" @WIRE(mode="straight",linecolor="#30485d",linewidth=0.16) {#RDRN:2 (90,-5)};
// (90,-5.4) @TEXT("d_rn",size=1.1,halign="middle",valign="top");
// &"d_rps" @WIRE(mode="straight",linecolor="#30485d",linewidth=0.16) {#RDRP:1 (90,-28)};
// (90,-27.6) @TEXT("d_rps",size=1.1,halign="middle",valign="bottom");
// &"d_rp" @WIRE(mode="straight",linecolor="#30485d",linewidth=0.16) {#RDRP:2 (90,-38)};
// (90,-38.4) @TEXT("d_rp",size=1.1,halign="middle",valign="top");
// &"d_rn" @WIRE(mode="straight",linecolor="#30485d",linewidth=0.16) {#CDRN:1 (90,-61)};
// (90,-60.6) @TEXT("d_rn",size=1.1,halign="middle",valign="bottom");
// &"0" @WIRE(mode="straight",linecolor="#30485d",linewidth=0.16) {#CDRN:2 (90,-71)};
// (90,-71.4) @TEXT("0",size=1.1,halign="middle",valign="top");
// &"d_rp" @WIRE(mode="straight",linecolor="#30485d",linewidth=0.16) {#CDRP:1 (90,-94)};
// (90,-93.6) @TEXT("d_rp",size=1.1,halign="middle",valign="bottom");
// &"0" @WIRE(mode="straight",linecolor="#30485d",linewidth=0.16) {#CDRP:2 (90,-104)};
// (90,-104.4) @TEXT("0",size=1.1,halign="middle",valign="top");
// }
// END SARADC RNL
ends tb_cdac

subckt tb_comparator
// Comparator delay/reset at stated differential inputs; native MOM plus receiver gate loads.
VCCLOCK (c_clock 0) vsource type=pulse val0=0 val1=0.9 delay=5n rise=100p fall=100p width=4.9n period=10n
VCN (c_n 0) vsource dc=0.45
VCP (c_p 0) vsource type=pwl wave=[0 0.55000000000000004 9.900000000000001e-09 0.55000000000000004 1e-08 0.34999999999999998 1.99e-08 0.34999999999999998 2e-08 0.47999999999999998 2.9900000000000003e-08 0.47999999999999998 3.0000000000000004e-08 0.42000000000000004 3.99e-08 0.42000000000000004 4.0000000000000001e-08 0.45351562500000003 4.9899999999999997e-08 0.45351562500000003 4.9999999999999998e-08 0.44648437499999999 5.9900000000000014e-08 0.44648437499999999 6.0000000000000008e-08 0.45100000000000001 6.990000000000001e-08 0.45100000000000001 7.0000000000000005e-08 0.44900000000000001 7.9900000000000007e-08 0.44900000000000001 8.0000000000000002e-08 0.4501 8.9900000000000004e-08 0.4501 8.9999999999999999e-08 0.44990000000000002]
XCOMP (c_clock c_outn c_outp VDD! c_n c_p 0) sar_strongarm_t28
CCN (c_outn 0) cfmom_2t nr=8 lr=2.5u w=50n s=50n stm=1 spm=3 multi=2 mismatchflag=1
CCP (c_outp 0) cfmom_2t nr=8 lr=2.5u w=50n s=50n stm=1 spm=3 multi=2 mismatchflag=1
XCRN (c_outn c_unusedn VDD! 0) INVD1BWP12T30P140
XCRP (c_outp c_unusedp VDD! 0) INVD1BWP12T30P140
// Independent floating-input kickback fixture, same nominal CDAC-side MOM geometry.
VKINIT (k_init 0) vsource type=pwl wave=[0 0.9 10n 0.9 10.1n 0]
VKP (k_sp 0) vsource dc=0.4505
VKN (k_sn 0) vsource dc=0.4495
XKP (k_p k_sp k_init VDD! 0) b_tb_switch
XKN (k_n k_sn k_init VDD! 0) b_tb_switch
CKP (k_p 0) cfmom_2t nr=8 lr=2u w=50n s=50n stm=1 spm=3 multi=256 mismatchflag=1
CKN (k_n 0) cfmom_2t nr=8 lr=2u w=50n s=50n stm=1 spm=3 multi=256 mismatchflag=1
VKC (k_clock 0) vsource type=pulse val0=0 val1=0.9 delay=15n rise=100p fall=100p width=4.9n period=1000n
XKCOMP (k_clock k_outn k_outp VDD! k_n k_p 0) sar_strongarm_t28
CKON (k_outn 0) capacitor c=10f
CKOP (k_outp 0) capacitor c=10f

// BEGIN SARADC RNL
// @RNL(author="saradc topology") {
// #VCCLOCK @SET-SYMBOL $VOLTAGE_SOURCE;
// #VCCLOCK @PLACE(-70,0) => @ORIENT("R0");
// #VCCLOCK @TEXT("VCCLOCK",key="name",size=1.3,halign="start") => @PLACE(-67,3);
// #VCCLOCK @TEXT("",key="value",size=0.9,halign="start") => @PLACE(-67,-4);
// #VCCLOCK @TEXT("",key="model");
// #VCN @SET-SYMBOL $VOLTAGE_SOURCE;
// #VCN @PLACE(-70,-33) => @ORIENT("R0");
// #VCN @TEXT("VCN",key="name",size=1.3,halign="start") => @PLACE(-67,-30);
// #VCN @TEXT("",key="value",size=0.9,halign="start") => @PLACE(-67,-37);
// #VCN @TEXT("",key="model");
// #VCP @SET-SYMBOL $VOLTAGE_SOURCE;
// #VCP @PLACE(-70,-66) => @ORIENT("R0");
// #VCP @TEXT("VCP",key="name",size=1.3,halign="start") => @PLACE(-67,-63);
// #VCP @TEXT("",key="value",size=0.9,halign="start") => @PLACE(-67,-70);
// #VCP @TEXT("",key="model");
// #VKINIT @SET-SYMBOL $VOLTAGE_SOURCE;
// #VKINIT @PLACE(-70,-99) => @ORIENT("R0");
// #VKINIT @TEXT("VKINIT",key="name",size=1.3,halign="start") => @PLACE(-67,-96);
// #VKINIT @TEXT("",key="value",size=0.9,halign="start") => @PLACE(-67,-103);
// #VKINIT @TEXT("",key="model");
// #VKP @SET-SYMBOL $VOLTAGE_SOURCE;
// #VKP @PLACE(-70,-132) => @ORIENT("R0");
// #VKP @TEXT("VKP",key="name",size=1.3,halign="start") => @PLACE(-67,-129);
// #VKP @TEXT("",key="value",size=0.9,halign="start") => @PLACE(-67,-136);
// #VKP @TEXT("",key="model");
// #VKN @SET-SYMBOL $VOLTAGE_SOURCE;
// #VKN @PLACE(-70,-165) => @ORIENT("R0");
// #VKN @TEXT("VKN",key="name",size=1.3,halign="start") => @PLACE(-67,-162);
// #VKN @TEXT("",key="value",size=0.9,halign="start") => @PLACE(-67,-169);
// #VKN @TEXT("",key="model");
// #VKC @SET-SYMBOL $VOLTAGE_SOURCE;
// #VKC @PLACE(-70,-198) => @ORIENT("R0");
// #VKC @TEXT("VKC",key="name",size=1.3,halign="start") => @PLACE(-67,-195);
// #VKC @TEXT("",key="value",size=0.9,halign="start") => @PLACE(-67,-202);
// #VKC @TEXT("",key="model");
// #XCOMP @SET-SYMBOL $S_sar_strongarm_t28;
// #XCOMP @PLACE(0,0) => @ORIENT("R0");
// #XCRN @SET-SYMBOL $S_INVD1BWP12T30P140;
// #XCRN @PLACE(0,-33) => @ORIENT("R0");
// #XCRP @SET-SYMBOL $S_INVD1BWP12T30P140;
// #XCRP @PLACE(0,-66) => @ORIENT("R0");
// #XKP @SET-SYMBOL $S_b_tb_switch;
// #XKP @PLACE(0,-99) => @ORIENT("R0");
// #XKN @SET-SYMBOL $S_b_tb_switch;
// #XKN @PLACE(0,-132) => @ORIENT("R0");
// #XKCOMP @SET-SYMBOL $S_sar_strongarm_t28;
// #XKCOMP @PLACE(0,-165) => @ORIENT("R0");
// #CCN @SET-SYMBOL $CAPACITOR;
// #CCN @PLACE(90,0) => @ORIENT("R0");
// #CCN @TEXT("CCN",key="name",size=1.3,halign="start") => @PLACE(93,3);
// #CCN @TEXT("nr=8 lr=2.5u w=50n multi=2",key="value",size=0.9,halign="start") => @PLACE(93,-4);
// #CCN @TEXT("",key="model");
// #CCP @SET-SYMBOL $CAPACITOR;
// #CCP @PLACE(90,-33) => @ORIENT("R0");
// #CCP @TEXT("CCP",key="name",size=1.3,halign="start") => @PLACE(93,-30);
// #CCP @TEXT("nr=8 lr=2.5u w=50n multi=2",key="value",size=0.9,halign="start") => @PLACE(93,-37);
// #CCP @TEXT("",key="model");
// #CKP @SET-SYMBOL $CAPACITOR;
// #CKP @PLACE(90,-66) => @ORIENT("R0");
// #CKP @TEXT("CKP",key="name",size=1.3,halign="start") => @PLACE(93,-63);
// #CKP @TEXT("nr=8 lr=2u w=50n multi=256",key="value",size=0.9,halign="start") => @PLACE(93,-70);
// #CKP @TEXT("",key="model");
// #CKN @SET-SYMBOL $CAPACITOR;
// #CKN @PLACE(90,-99) => @ORIENT("R0");
// #CKN @TEXT("CKN",key="name",size=1.3,halign="start") => @PLACE(93,-96);
// #CKN @TEXT("nr=8 lr=2u w=50n multi=256",key="value",size=0.9,halign="start") => @PLACE(93,-103);
// #CKN @TEXT("",key="model");
// #CKON @SET-SYMBOL $CAPACITOR;
// #CKON @PLACE(90,-132) => @ORIENT("R0");
// #CKON @TEXT("CKON",key="name",size=1.3,halign="start") => @PLACE(93,-129);
// #CKON @TEXT("c=10f",key="value",size=0.9,halign="start") => @PLACE(93,-136);
// #CKON @TEXT("",key="model");
// #CKOP @SET-SYMBOL $CAPACITOR;
// #CKOP @PLACE(90,-165) => @ORIENT("R0");
// #CKOP @TEXT("CKOP",key="name",size=1.3,halign="start") => @PLACE(93,-162);
// #CKOP @TEXT("c=10f",key="value",size=0.9,halign="start") => @PLACE(93,-169);
// #CKOP @TEXT("",key="model");
// &"c_clock" @WIRE(mode="straight",linecolor="#30485d",linewidth=0.16) {#VCCLOCK:1 (-37,2) (-37,8) #XCOMP:1};
// &"c_n" @WIRE(mode="straight",linecolor="#30485d",linewidth=0.16) {#VCN:1 (-42.5,-31) (-42.5,-1.65) #XCOMP:5};
// &"c_p" @WIRE(mode="straight",linecolor="#30485d",linewidth=0.16) {#VCP:1 (-42.5,-64) (-42.5,1.65) #XCOMP:6};
// &"k_sp" @WIRE(mode="straight",linecolor="#30485d",linewidth=0.16) {#VKP:1 (-41.5,-130) (-41.5,-99) #XKP:2};
// &"k_sn" @WIRE(mode="straight",linecolor="#30485d",linewidth=0.16) {#VKN:1 (-41.5,-163) (-41.5,-132) #XKN:2};
// &"k_clock" @WIRE(mode="straight",linecolor="#30485d",linewidth=0.16) {#VKC:1 (-37,-196) (-37,-157) #XKCOMP:1};
// &"k_outn" @WIRE(mode="straight",linecolor="#30485d",linewidth=0.16) {#XKCOMP:2 (52.5,-166.65) (52.5,-130) #CKON:1};
// &"k_outp" @WIRE(mode="straight",linecolor="#30485d",linewidth=0.16) {#XKCOMP:3 (52.5,-163.35) (52.5,-163) #CKOP:1};
// (-89,30) @TEXT("tb_comparator / source-derived connections",size=1.4,halign="start",textcolor="#223d52");
// &"0" @WIRE(mode="straight",linecolor="#30485d",linewidth=0.16) {#VCCLOCK:2 (-70,-5)};
// (-70,-5.4) @TEXT("0",size=1.1,halign="middle",valign="top");
// &"0" @WIRE(mode="straight",linecolor="#30485d",linewidth=0.16) {#VCN:2 (-70,-38)};
// (-70,-38.4) @TEXT("0",size=1.1,halign="middle",valign="top");
// &"0" @WIRE(mode="straight",linecolor="#30485d",linewidth=0.16) {#VCP:2 (-70,-71)};
// (-70,-71.4) @TEXT("0",size=1.1,halign="middle",valign="top");
// &"c_outn" @WIRE(mode="straight",linecolor="#30485d",linewidth=0.16) {#XCOMP:2 (18,-1.65)};
// (18.4,-1.65) @TEXT("c_outn",size=1.1,halign="start",valign="middle");
// &"c_outp" @WIRE(mode="straight",linecolor="#30485d",linewidth=0.16) {#XCOMP:3 (18,1.65)};
// (18.4,1.65) @TEXT("c_outp",size=1.1,halign="start",valign="middle");
// &"VDD!" @WIRE(mode="straight",linecolor="#30485d",linewidth=0.16) {#XCOMP:4 (4,11)};
// (4,11.4) @TEXT("VDD!",size=1.1,halign="middle",valign="bottom");
// &"0" @WIRE(mode="straight",linecolor="#30485d",linewidth=0.16) {#XCOMP:7 (0,-11)};
// (0,-11.4) @TEXT("0",size=1.1,halign="middle",valign="top");
// &"c_outn" @WIRE(mode="straight",linecolor="#30485d",linewidth=0.16) {#CCN:1 (90,5)};
// (90,5.4) @TEXT("c_outn",size=1.1,halign="middle",valign="bottom");
// &"0" @WIRE(mode="straight",linecolor="#30485d",linewidth=0.16) {#CCN:2 (90,-5)};
// (90,-5.4) @TEXT("0",size=1.1,halign="middle",valign="top");
// &"c_outp" @WIRE(mode="straight",linecolor="#30485d",linewidth=0.16) {#CCP:1 (90,-28)};
// (90,-27.6) @TEXT("c_outp",size=1.1,halign="middle",valign="bottom");
// &"0" @WIRE(mode="straight",linecolor="#30485d",linewidth=0.16) {#CCP:2 (90,-38)};
// (90,-38.4) @TEXT("0",size=1.1,halign="middle",valign="top");
// &"c_outn" @WIRE(mode="straight",linecolor="#30485d",linewidth=0.16) {#XCRN:1 (-10,-33)};
// (-10.4,-33) @TEXT("c_outn",size=1.1,halign="end",valign="middle");
// &"c_unusedn" @WIRE(mode="straight",linecolor="#30485d",linewidth=0.16) {#XCRN:2 (10,-33)};
// (10.4,-33) @TEXT("c_unusedn",size=1.1,halign="start",valign="middle");
// &"VDD!" @WIRE(mode="straight",linecolor="#30485d",linewidth=0.16) {#XCRN:3 (0,-23)};
// (0,-22.6) @TEXT("VDD!",size=1.1,halign="middle",valign="bottom");
// &"0" @WIRE(mode="straight",linecolor="#30485d",linewidth=0.16) {#XCRN:4 (0,-43)};
// (0,-43.4) @TEXT("0",size=1.1,halign="middle",valign="top");
// &"c_outp" @WIRE(mode="straight",linecolor="#30485d",linewidth=0.16) {#XCRP:1 (-10,-66)};
// (-10.4,-66) @TEXT("c_outp",size=1.1,halign="end",valign="middle");
// &"c_unusedp" @WIRE(mode="straight",linecolor="#30485d",linewidth=0.16) {#XCRP:2 (10,-66)};
// (10.4,-66) @TEXT("c_unusedp",size=1.1,halign="start",valign="middle");
// &"VDD!" @WIRE(mode="straight",linecolor="#30485d",linewidth=0.16) {#XCRP:3 (0,-56)};
// (0,-55.6) @TEXT("VDD!",size=1.1,halign="middle",valign="bottom");
// &"0" @WIRE(mode="straight",linecolor="#30485d",linewidth=0.16) {#XCRP:4 (0,-76)};
// (0,-76.4) @TEXT("0",size=1.1,halign="middle",valign="top");
// &"k_init" @WIRE(mode="straight",linecolor="#30485d",linewidth=0.16) {#VKINIT:1 (-70,-94)};
// (-70,-93.6) @TEXT("k_init",size=1.1,halign="middle",valign="bottom");
// &"0" @WIRE(mode="straight",linecolor="#30485d",linewidth=0.16) {#VKINIT:2 (-70,-104)};
// (-70,-104.4) @TEXT("0",size=1.1,halign="middle",valign="top");
// &"0" @WIRE(mode="straight",linecolor="#30485d",linewidth=0.16) {#VKP:2 (-70,-137)};
// (-70,-137.4) @TEXT("0",size=1.1,halign="middle",valign="top");
// &"0" @WIRE(mode="straight",linecolor="#30485d",linewidth=0.16) {#VKN:2 (-70,-170)};
// (-70,-170.4) @TEXT("0",size=1.1,halign="middle",valign="top");
// &"k_p" @WIRE(mode="straight",linecolor="#30485d",linewidth=0.16) {#XKP:1 (-16,-95.7)};
// (-16.4,-95.7) @TEXT("k_p",size=1.1,halign="end",valign="middle");
// &"k_init" @WIRE(mode="straight",linecolor="#30485d",linewidth=0.16) {#XKP:3 (-16,-102.3)};
// (-16.4,-102.3) @TEXT("k_init",size=1.1,halign="end",valign="middle");
// &"VDD!" @WIRE(mode="straight",linecolor="#30485d",linewidth=0.16) {#XKP:4 (0,-87.4)};
// (0,-87) @TEXT("VDD!",size=1.1,halign="middle",valign="bottom");
// &"0" @WIRE(mode="straight",linecolor="#30485d",linewidth=0.16) {#XKP:5 (0,-110.6)};
// (0,-111) @TEXT("0",size=1.1,halign="middle",valign="top");
// &"k_n" @WIRE(mode="straight",linecolor="#30485d",linewidth=0.16) {#XKN:1 (-16,-128.7)};
// (-16.4,-128.7) @TEXT("k_n",size=1.1,halign="end",valign="middle");
// &"k_init" @WIRE(mode="straight",linecolor="#30485d",linewidth=0.16) {#XKN:3 (-16,-135.3)};
// (-16.4,-135.3) @TEXT("k_init",size=1.1,halign="end",valign="middle");
// &"VDD!" @WIRE(mode="straight",linecolor="#30485d",linewidth=0.16) {#XKN:4 (0,-120.4)};
// (0,-120) @TEXT("VDD!",size=1.1,halign="middle",valign="bottom");
// &"0" @WIRE(mode="straight",linecolor="#30485d",linewidth=0.16) {#XKN:5 (0,-143.6)};
// (0,-144) @TEXT("0",size=1.1,halign="middle",valign="top");
// &"k_p" @WIRE(mode="straight",linecolor="#30485d",linewidth=0.16) {#CKP:1 (90,-61)};
// (90,-60.6) @TEXT("k_p",size=1.1,halign="middle",valign="bottom");
// &"0" @WIRE(mode="straight",linecolor="#30485d",linewidth=0.16) {#CKP:2 (90,-71)};
// (90,-71.4) @TEXT("0",size=1.1,halign="middle",valign="top");
// &"k_n" @WIRE(mode="straight",linecolor="#30485d",linewidth=0.16) {#CKN:1 (90,-94)};
// (90,-93.6) @TEXT("k_n",size=1.1,halign="middle",valign="bottom");
// &"0" @WIRE(mode="straight",linecolor="#30485d",linewidth=0.16) {#CKN:2 (90,-104)};
// (90,-104.4) @TEXT("0",size=1.1,halign="middle",valign="top");
// &"0" @WIRE(mode="straight",linecolor="#30485d",linewidth=0.16) {#VKC:2 (-70,-203)};
// (-70,-203.4) @TEXT("0",size=1.1,halign="middle",valign="top");
// &"VDD!" @WIRE(mode="straight",linecolor="#30485d",linewidth=0.16) {#XKCOMP:4 (4,-154)};
// (4,-153.6) @TEXT("VDD!",size=1.1,halign="middle",valign="bottom");
// &"k_n" @WIRE(mode="straight",linecolor="#30485d",linewidth=0.16) {#XKCOMP:5 (-18,-166.65)};
// (-18.4,-166.65) @TEXT("k_n",size=1.1,halign="end",valign="middle");
// &"k_p" @WIRE(mode="straight",linecolor="#30485d",linewidth=0.16) {#XKCOMP:6 (-18,-163.35)};
// (-18.4,-163.35) @TEXT("k_p",size=1.1,halign="end",valign="middle");
// &"0" @WIRE(mode="straight",linecolor="#30485d",linewidth=0.16) {#XKCOMP:7 (0,-176)};
// (0,-176.4) @TEXT("0",size=1.1,halign="middle",valign="top");
// &"0" @WIRE(mode="straight",linecolor="#30485d",linewidth=0.16) {#CKON:2 (90,-137)};
// (90,-137.4) @TEXT("0",size=1.1,halign="middle",valign="top");
// &"0" @WIRE(mode="straight",linecolor="#30485d",linewidth=0.16) {#CKOP:2 (90,-170)};
// (90,-170.4) @TEXT("0",size=1.1,halign="middle",valign="top");
// }
// END SARADC RNL
ends tb_comparator

subckt tb_reference
// Reference storage, nonoverlap and gate-drive test with the ACTUAL CDAC as the load.
VRRESET (r_reset 0) vsource type=pwl wave=[0 0.9 20n 0.9 20.1n 0]
VRPHI (r_phi 0) vsource type=pulse val0=0 val1=0.9 delay=50n rise=100p fall=100p width=1.9n period=80n
VRB0 (r_bit0 0) vsource type=pwl wave=[0 0 4.4900000000000005e-08 0 4.5000000000000006e-08 0 1.2490000000000001e-07 0 1.2500000000000002e-07 0 2.0490000000000001e-07 0 2.0500000000000002e-07 0.90000000000000002 2.8490000000000002e-07 0.90000000000000002 2.8500000000000002e-07 0.90000000000000002 3.6489999999999999e-07 0.90000000000000002 3.65e-07 0 4.4490000000000002e-07 0 4.4500000000000003e-07 0]
VRB1 (r_bit1 0) vsource type=pwl wave=[0 0 4.4900000000000005e-08 0 4.5000000000000006e-08 0 1.2490000000000001e-07 0 1.2500000000000002e-07 0 2.0490000000000001e-07 0 2.0500000000000002e-07 0.90000000000000002 2.8490000000000002e-07 0.90000000000000002 2.8500000000000002e-07 0 3.6489999999999999e-07 0 3.65e-07 0.90000000000000002 4.4490000000000002e-07 0.90000000000000002 4.4500000000000003e-07 0]
VRB2 (r_bit2 0) vsource type=pwl wave=[0 0 4.4900000000000005e-08 0 4.5000000000000006e-08 0 1.2490000000000001e-07 0 1.2500000000000002e-07 0 2.0490000000000001e-07 0 2.0500000000000002e-07 0.90000000000000002 2.8490000000000002e-07 0.90000000000000002 2.8500000000000002e-07 0.90000000000000002 3.6489999999999999e-07 0.90000000000000002 3.65e-07 0 4.4490000000000002e-07 0 4.4500000000000003e-07 0]
VRB3 (r_bit3 0) vsource type=pwl wave=[0 0 4.4900000000000005e-08 0 4.5000000000000006e-08 0 1.2490000000000001e-07 0 1.2500000000000002e-07 0 2.0490000000000001e-07 0 2.0500000000000002e-07 0.90000000000000002 2.8490000000000002e-07 0.90000000000000002 2.8500000000000002e-07 0 3.6489999999999999e-07 0 3.65e-07 0.90000000000000002 4.4490000000000002e-07 0.90000000000000002 4.4500000000000003e-07 0]
VRB4 (r_bit4 0) vsource type=pwl wave=[0 0 4.4900000000000005e-08 0 4.5000000000000006e-08 0 1.2490000000000001e-07 0 1.2500000000000002e-07 0 2.0490000000000001e-07 0 2.0500000000000002e-07 0.90000000000000002 2.8490000000000002e-07 0.90000000000000002 2.8500000000000002e-07 0.90000000000000002 3.6489999999999999e-07 0.90000000000000002 3.65e-07 0 4.4490000000000002e-07 0 4.4500000000000003e-07 0]
VRB5 (r_bit5 0) vsource type=pwl wave=[0 0 4.4900000000000005e-08 0 4.5000000000000006e-08 0 1.2490000000000001e-07 0 1.2500000000000002e-07 0 2.0490000000000001e-07 0 2.0500000000000002e-07 0.90000000000000002 2.8490000000000002e-07 0.90000000000000002 2.8500000000000002e-07 0 3.6489999999999999e-07 0 3.65e-07 0.90000000000000002 4.4490000000000002e-07 0.90000000000000002 4.4500000000000003e-07 0]
VRB6 (r_bit6 0) vsource type=pwl wave=[0 0 4.4900000000000005e-08 0 4.5000000000000006e-08 0 1.2490000000000001e-07 0 1.2500000000000002e-07 0 2.0490000000000001e-07 0 2.0500000000000002e-07 0.90000000000000002 2.8490000000000002e-07 0.90000000000000002 2.8500000000000002e-07 0.90000000000000002 3.6489999999999999e-07 0.90000000000000002 3.65e-07 0 4.4490000000000002e-07 0 4.4500000000000003e-07 0]
VRB7 (r_bit7 0) vsource type=pwl wave=[0 0.90000000000000002 4.4900000000000005e-08 0.90000000000000002 4.5000000000000006e-08 0.90000000000000002 1.2490000000000001e-07 0.90000000000000002 1.2500000000000002e-07 0 2.0490000000000001e-07 0 2.0500000000000002e-07 0.90000000000000002 2.8490000000000002e-07 0.90000000000000002 2.8500000000000002e-07 0 3.6489999999999999e-07 0 3.65e-07 0.90000000000000002 4.4490000000000002e-07 0.90000000000000002 4.4500000000000003e-07 0.90000000000000002]
XREF (r_bit0 r_bit1 r_bit2 r_bit3 r_bit4 r_bit5 r_bit6 r_bit7 r_gnn0 r_gnn1 r_gnn2 r_gnn3 r_gnn4 r_gnn5 r_gnn6 r_gnn7 r_gpn0 r_gpn1 r_gpn2 r_gpn3 r_gpn4 r_gpn5 r_gpn6 r_gpn7 VDD! 0 r_reset) sar8i_refword
XRLOAD (r_gnn0 r_gnn1 r_gnn2 r_gnn3 r_gnn4 r_gnn5 r_gnn6 r_gnn7 r_gpn0 r_gpn1 r_gpn2 r_gpn3 r_gpn4 r_gpn5 r_gpn6 r_gpn7 r_n r_p VDD! r_rn r_rp 0) sar8j_r1_cdac
VRRN (r_rns 0) vsource dc=0
VRRP (r_rps 0) vsource dc=0.9
RRRN (r_rns r_rn) resistor r=50
RRRP (r_rps r_rp) resistor r=50
CRRN (r_rn 0) capacitor c=4p
CRRP (r_rp 0) capacitor c=4p
RRNLEAK (r_n 0) resistor r=1e12
RRPLEAK (r_p 0) resistor r=1e12

// BEGIN SARADC RNL
// @RNL(author="saradc topology") {
// #VRRESET @SET-SYMBOL $VOLTAGE_SOURCE;
// #VRRESET @PLACE(-70,0) => @ORIENT("R0");
// #VRRESET @TEXT("VRRESET",key="name",size=1.3,halign="start") => @PLACE(-67,3);
// #VRRESET @TEXT("",key="value",size=0.9,halign="start") => @PLACE(-67,-4);
// #VRRESET @TEXT("",key="model");
// #VRPHI @SET-SYMBOL $VOLTAGE_SOURCE;
// #VRPHI @PLACE(-70,-33) => @ORIENT("R0");
// #VRPHI @TEXT("VRPHI",key="name",size=1.3,halign="start") => @PLACE(-67,-30);
// #VRPHI @TEXT("",key="value",size=0.9,halign="start") => @PLACE(-67,-37);
// #VRPHI @TEXT("",key="model");
// #VRB0 @SET-SYMBOL $VOLTAGE_SOURCE;
// #VRB0 @PLACE(-70,-66) => @ORIENT("R0");
// #VRB0 @TEXT("VRB0",key="name",size=1.3,halign="start") => @PLACE(-67,-63);
// #VRB0 @TEXT("",key="value",size=0.9,halign="start") => @PLACE(-67,-70);
// #VRB0 @TEXT("",key="model");
// #VRB1 @SET-SYMBOL $VOLTAGE_SOURCE;
// #VRB1 @PLACE(-70,-99) => @ORIENT("R0");
// #VRB1 @TEXT("VRB1",key="name",size=1.3,halign="start") => @PLACE(-67,-96);
// #VRB1 @TEXT("",key="value",size=0.9,halign="start") => @PLACE(-67,-103);
// #VRB1 @TEXT("",key="model");
// #VRB2 @SET-SYMBOL $VOLTAGE_SOURCE;
// #VRB2 @PLACE(-70,-132) => @ORIENT("R0");
// #VRB2 @TEXT("VRB2",key="name",size=1.3,halign="start") => @PLACE(-67,-129);
// #VRB2 @TEXT("",key="value",size=0.9,halign="start") => @PLACE(-67,-136);
// #VRB2 @TEXT("",key="model");
// #VRB3 @SET-SYMBOL $VOLTAGE_SOURCE;
// #VRB3 @PLACE(-70,-165) => @ORIENT("R0");
// #VRB3 @TEXT("VRB3",key="name",size=1.3,halign="start") => @PLACE(-67,-162);
// #VRB3 @TEXT("",key="value",size=0.9,halign="start") => @PLACE(-67,-169);
// #VRB3 @TEXT("",key="model");
// #VRB4 @SET-SYMBOL $VOLTAGE_SOURCE;
// #VRB4 @PLACE(-70,-198) => @ORIENT("R0");
// #VRB4 @TEXT("VRB4",key="name",size=1.3,halign="start") => @PLACE(-67,-195);
// #VRB4 @TEXT("",key="value",size=0.9,halign="start") => @PLACE(-67,-202);
// #VRB4 @TEXT("",key="model");
// #VRB5 @SET-SYMBOL $VOLTAGE_SOURCE;
// #VRB5 @PLACE(-70,-231) => @ORIENT("R0");
// #VRB5 @TEXT("VRB5",key="name",size=1.3,halign="start") => @PLACE(-67,-228);
// #VRB5 @TEXT("",key="value",size=0.9,halign="start") => @PLACE(-67,-235);
// #VRB5 @TEXT("",key="model");
// #VRB6 @SET-SYMBOL $VOLTAGE_SOURCE;
// #VRB6 @PLACE(-70,-264) => @ORIENT("R0");
// #VRB6 @TEXT("VRB6",key="name",size=1.3,halign="start") => @PLACE(-67,-261);
// #VRB6 @TEXT("",key="value",size=0.9,halign="start") => @PLACE(-67,-268);
// #VRB6 @TEXT("",key="model");
// #VRB7 @SET-SYMBOL $VOLTAGE_SOURCE;
// #VRB7 @PLACE(-70,-297) => @ORIENT("R0");
// #VRB7 @TEXT("VRB7",key="name",size=1.3,halign="start") => @PLACE(-67,-294);
// #VRB7 @TEXT("",key="value",size=0.9,halign="start") => @PLACE(-67,-301);
// #VRB7 @TEXT("",key="model");
// #VRRN @SET-SYMBOL $VOLTAGE_SOURCE;
// #VRRN @PLACE(-70,-330) => @ORIENT("R0");
// #VRRN @TEXT("VRRN",key="name",size=1.3,halign="start") => @PLACE(-67,-327);
// #VRRN @TEXT("",key="value",size=0.9,halign="start") => @PLACE(-67,-334);
// #VRRN @TEXT("",key="model");
// #VRRP @SET-SYMBOL $VOLTAGE_SOURCE;
// #VRRP @PLACE(-70,-363) => @ORIENT("R0");
// #VRRP @TEXT("VRRP",key="name",size=1.3,halign="start") => @PLACE(-67,-360);
// #VRRP @TEXT("",key="value",size=0.9,halign="start") => @PLACE(-67,-367);
// #VRRP @TEXT("",key="model");
// #XREF @SET-SYMBOL $S_sar8i_refword;
// #XREF @PLACE(0,0) => @ORIENT("R0");
// #XRLOAD @SET-SYMBOL $S_sar8j_r1_cdac;
// #XRLOAD @PLACE(0,-33) => @ORIENT("R0");
// #RRRN @SET-SYMBOL $RESISTOR;
// #RRRN @PLACE(90,0) => @ORIENT("R0");
// #RRRN @TEXT("RRRN",key="name",size=1.3,halign="start") => @PLACE(93,3);
// #RRRN @TEXT("r=50",key="value",size=0.9,halign="start") => @PLACE(93,-4);
// #RRRN @TEXT("",key="model");
// #RRRP @SET-SYMBOL $RESISTOR;
// #RRRP @PLACE(90,-33) => @ORIENT("R0");
// #RRRP @TEXT("RRRP",key="name",size=1.3,halign="start") => @PLACE(93,-30);
// #RRRP @TEXT("r=50",key="value",size=0.9,halign="start") => @PLACE(93,-37);
// #RRRP @TEXT("",key="model");
// #CRRN @SET-SYMBOL $CAPACITOR;
// #CRRN @PLACE(90,-66) => @ORIENT("R0");
// #CRRN @TEXT("CRRN",key="name",size=1.3,halign="start") => @PLACE(93,-63);
// #CRRN @TEXT("c=4p",key="value",size=0.9,halign="start") => @PLACE(93,-70);
// #CRRN @TEXT("",key="model");
// #CRRP @SET-SYMBOL $CAPACITOR;
// #CRRP @PLACE(90,-99) => @ORIENT("R0");
// #CRRP @TEXT("CRRP",key="name",size=1.3,halign="start") => @PLACE(93,-96);
// #CRRP @TEXT("c=4p",key="value",size=0.9,halign="start") => @PLACE(93,-103);
// #CRRP @TEXT("",key="model");
// #RRNLEAK @SET-SYMBOL $RESISTOR;
// #RRNLEAK @PLACE(90,-132) => @ORIENT("R0");
// #RRNLEAK @TEXT("RRNLEAK",key="name",size=1.3,halign="start") => @PLACE(93,-129);
// #RRNLEAK @TEXT("r=1e12",key="value",size=0.9,halign="start") => @PLACE(93,-136);
// #RRNLEAK @TEXT("",key="model");
// #RRPLEAK @SET-SYMBOL $RESISTOR;
// #RRPLEAK @PLACE(90,-165) => @ORIENT("R0");
// #RRPLEAK @TEXT("RRPLEAK",key="name",size=1.3,halign="start") => @PLACE(93,-162);
// #RRPLEAK @TEXT("r=1e12",key="value",size=0.9,halign="start") => @PLACE(93,-169);
// #RRPLEAK @TEXT("",key="model");
// &"r_reset" @WIRE(mode="straight",linecolor="#30485d",linewidth=0.16) {#VRRESET:1 (-42.5,2) (-42.5,0) #XREF:27};
// &"r_n" @WIRE(mode="straight",linecolor="#30485d",linewidth=0.16) {#XRLOAD:17 (49,-25) (49,-130) #RRNLEAK:1};
// (-89,30) @TEXT("tb_reference / source-derived connections",size=1.4,halign="start",textcolor="#223d52");
// &"0" @WIRE(mode="straight",linecolor="#30485d",linewidth=0.16) {#VRRESET:2 (-70,-5)};
// (-70,-5.4) @TEXT("0",size=1.1,halign="middle",valign="top");
// &"r_phi" @WIRE(mode="straight",linecolor="#30485d",linewidth=0.16) {#VRPHI:1 (-70,-28)};
// (-70,-27.6) @TEXT("r_phi",size=1.1,halign="middle",valign="bottom");
// &"0" @WIRE(mode="straight",linecolor="#30485d",linewidth=0.16) {#VRPHI:2 (-70,-38)};
// (-70,-38.4) @TEXT("0",size=1.1,halign="middle",valign="top");
// &"r_bit0" @WIRE(mode="straight",linecolor="#30485d",linewidth=0.16) {#VRB0:1 (-70,-61)};
// (-70,-60.6) @TEXT("r_bit0",size=1.1,halign="middle",valign="bottom");
// &"0" @WIRE(mode="straight",linecolor="#30485d",linewidth=0.16) {#VRB0:2 (-70,-71)};
// (-70,-71.4) @TEXT("0",size=1.1,halign="middle",valign="top");
// &"r_bit1" @WIRE(mode="straight",linecolor="#30485d",linewidth=0.16) {#VRB1:1 (-70,-94)};
// (-70,-93.6) @TEXT("r_bit1",size=1.1,halign="middle",valign="bottom");
// &"0" @WIRE(mode="straight",linecolor="#30485d",linewidth=0.16) {#VRB1:2 (-70,-104)};
// (-70,-104.4) @TEXT("0",size=1.1,halign="middle",valign="top");
// &"r_bit2" @WIRE(mode="straight",linecolor="#30485d",linewidth=0.16) {#VRB2:1 (-70,-127)};
// (-70,-126.6) @TEXT("r_bit2",size=1.1,halign="middle",valign="bottom");
// &"0" @WIRE(mode="straight",linecolor="#30485d",linewidth=0.16) {#VRB2:2 (-70,-137)};
// (-70,-137.4) @TEXT("0",size=1.1,halign="middle",valign="top");
// &"r_bit3" @WIRE(mode="straight",linecolor="#30485d",linewidth=0.16) {#VRB3:1 (-70,-160)};
// (-70,-159.6) @TEXT("r_bit3",size=1.1,halign="middle",valign="bottom");
// &"0" @WIRE(mode="straight",linecolor="#30485d",linewidth=0.16) {#VRB3:2 (-70,-170)};
// (-70,-170.4) @TEXT("0",size=1.1,halign="middle",valign="top");
// &"r_bit4" @WIRE(mode="straight",linecolor="#30485d",linewidth=0.16) {#VRB4:1 (-70,-193)};
// (-70,-192.6) @TEXT("r_bit4",size=1.1,halign="middle",valign="bottom");
// &"0" @WIRE(mode="straight",linecolor="#30485d",linewidth=0.16) {#VRB4:2 (-70,-203)};
// (-70,-203.4) @TEXT("0",size=1.1,halign="middle",valign="top");
// &"r_bit5" @WIRE(mode="straight",linecolor="#30485d",linewidth=0.16) {#VRB5:1 (-70,-226)};
// (-70,-225.6) @TEXT("r_bit5",size=1.1,halign="middle",valign="bottom");
// &"0" @WIRE(mode="straight",linecolor="#30485d",linewidth=0.16) {#VRB5:2 (-70,-236)};
// (-70,-236.4) @TEXT("0",size=1.1,halign="middle",valign="top");
// &"r_bit6" @WIRE(mode="straight",linecolor="#30485d",linewidth=0.16) {#VRB6:1 (-70,-259)};
// (-70,-258.6) @TEXT("r_bit6",size=1.1,halign="middle",valign="bottom");
// &"0" @WIRE(mode="straight",linecolor="#30485d",linewidth=0.16) {#VRB6:2 (-70,-269)};
// (-70,-269.4) @TEXT("0",size=1.1,halign="middle",valign="top");
// &"r_bit7" @WIRE(mode="straight",linecolor="#30485d",linewidth=0.16) {#VRB7:1 (-70,-292)};
// (-70,-291.6) @TEXT("r_bit7",size=1.1,halign="middle",valign="bottom");
// &"0" @WIRE(mode="straight",linecolor="#30485d",linewidth=0.16) {#VRB7:2 (-70,-302)};
// (-70,-302.4) @TEXT("0",size=1.1,halign="middle",valign="top");
// {&"r_bit0" &"r_bit1" &"r_bit2" &"r_bit3" &"r_bit4" &"r_bit5" &"r_bit6" &"r_bit7"} @WIRE(mode="straight",linewidth=0.3) {#XREF:1 (18,0)};
// (18.4,0) @TEXT("r_bit[7:0]",size=1.1,halign="start",valign="middle");
// {&"r_gnn0" &"r_gnn1" &"r_gnn2" &"r_gnn3" &"r_gnn4" &"r_gnn5" &"r_gnn6" &"r_gnn7"} @WIRE(mode="straight",linewidth=0.3) {#XREF:9 (-8,11)};
// (-8,11.4) @TEXT("r_gnn[7:0]",size=1.1,halign="middle",valign="bottom");
// {&"r_gpn0" &"r_gpn1" &"r_gpn2" &"r_gpn3" &"r_gpn4" &"r_gpn5" &"r_gpn6" &"r_gpn7"} @WIRE(mode="straight",linewidth=0.3) {#XREF:17 (8,11)};
// (8,11.4) @TEXT("r_gpn[7:0]",size=1.1,halign="middle",valign="bottom");
// &"VDD!" @WIRE(mode="straight",linecolor="#30485d",linewidth=0.16) {#XREF:25 (0,11)};
// (0,11.4) @TEXT("VDD!",size=1.1,halign="middle",valign="bottom");
// &"0" @WIRE(mode="straight",linecolor="#30485d",linewidth=0.16) {#XREF:26 (0,-11)};
// (0,-11.4) @TEXT("0",size=1.1,halign="middle",valign="top");
// {&"r_gnn0" &"r_gnn1" &"r_gnn2" &"r_gnn3" &"r_gnn4" &"r_gnn5" &"r_gnn6" &"r_gnn7"} @WIRE(mode="straight",linewidth=0.3) {#XRLOAD:1 (-8,-44)};
// (-8,-44.4) @TEXT("r_gnn[7:0]",size=1.1,halign="middle",valign="top");
// {&"r_gpn0" &"r_gpn1" &"r_gpn2" &"r_gpn3" &"r_gpn4" &"r_gpn5" &"r_gpn6" &"r_gpn7"} @WIRE(mode="straight",linewidth=0.3) {#XRLOAD:9 (8,-44)};
// (8,-44.4) @TEXT("r_gpn[7:0]",size=1.1,halign="middle",valign="top");
// &"r_p" @WIRE(mode="straight",linecolor="#30485d",linewidth=0.16) {#XRLOAD:18 (-8,-22)};
// (-8,-21.6) @TEXT("r_p",size=1.1,halign="middle",valign="bottom");
// &"VDD!" @WIRE(mode="straight",linecolor="#30485d",linewidth=0.16) {#XRLOAD:19 (0,-22)};
// (0,-21.6) @TEXT("VDD!",size=1.1,halign="middle",valign="bottom");
// &"r_rn" @WIRE(mode="straight",linecolor="#30485d",linewidth=0.16) {#XRLOAD:20 (-18,-34.65)};
// (-18.4,-34.65) @TEXT("r_rn",size=1.1,halign="end",valign="middle");
// &"r_rp" @WIRE(mode="straight",linecolor="#30485d",linewidth=0.16) {#XRLOAD:21 (-18,-31.35)};
// (-18.4,-31.35) @TEXT("r_rp",size=1.1,halign="end",valign="middle");
// &"0" @WIRE(mode="straight",linecolor="#30485d",linewidth=0.16) {#XRLOAD:22 (0,-44)};
// (0,-44.4) @TEXT("0",size=1.1,halign="middle",valign="top");
// &"r_rns" @WIRE(mode="straight",linecolor="#30485d",linewidth=0.16) {#VRRN:1 (-70,-325)};
// (-70,-324.6) @TEXT("r_rns",size=1.1,halign="middle",valign="bottom");
// &"0" @WIRE(mode="straight",linecolor="#30485d",linewidth=0.16) {#VRRN:2 (-70,-335)};
// (-70,-335.4) @TEXT("0",size=1.1,halign="middle",valign="top");
// &"r_rps" @WIRE(mode="straight",linecolor="#30485d",linewidth=0.16) {#VRRP:1 (-70,-358)};
// (-70,-357.6) @TEXT("r_rps",size=1.1,halign="middle",valign="bottom");
// &"0" @WIRE(mode="straight",linecolor="#30485d",linewidth=0.16) {#VRRP:2 (-70,-368)};
// (-70,-368.4) @TEXT("0",size=1.1,halign="middle",valign="top");
// &"r_rns" @WIRE(mode="straight",linecolor="#30485d",linewidth=0.16) {#RRRN:1 (90,5)};
// (90,5.4) @TEXT("r_rns",size=1.1,halign="middle",valign="bottom");
// &"r_rn" @WIRE(mode="straight",linecolor="#30485d",linewidth=0.16) {#RRRN:2 (90,-5)};
// (90,-5.4) @TEXT("r_rn",size=1.1,halign="middle",valign="top");
// &"r_rps" @WIRE(mode="straight",linecolor="#30485d",linewidth=0.16) {#RRRP:1 (90,-28)};
// (90,-27.6) @TEXT("r_rps",size=1.1,halign="middle",valign="bottom");
// &"r_rp" @WIRE(mode="straight",linecolor="#30485d",linewidth=0.16) {#RRRP:2 (90,-38)};
// (90,-38.4) @TEXT("r_rp",size=1.1,halign="middle",valign="top");
// &"r_rn" @WIRE(mode="straight",linecolor="#30485d",linewidth=0.16) {#CRRN:1 (90,-61)};
// (90,-60.6) @TEXT("r_rn",size=1.1,halign="middle",valign="bottom");
// &"0" @WIRE(mode="straight",linecolor="#30485d",linewidth=0.16) {#CRRN:2 (90,-71)};
// (90,-71.4) @TEXT("0",size=1.1,halign="middle",valign="top");
// &"r_rp" @WIRE(mode="straight",linecolor="#30485d",linewidth=0.16) {#CRRP:1 (90,-94)};
// (90,-93.6) @TEXT("r_rp",size=1.1,halign="middle",valign="bottom");
// &"0" @WIRE(mode="straight",linecolor="#30485d",linewidth=0.16) {#CRRP:2 (90,-104)};
// (90,-104.4) @TEXT("0",size=1.1,halign="middle",valign="top");
// &"0" @WIRE(mode="straight",linecolor="#30485d",linewidth=0.16) {#RRNLEAK:2 (90,-137)};
// (90,-137.4) @TEXT("0",size=1.1,halign="middle",valign="top");
// &"r_p" @WIRE(mode="straight",linecolor="#30485d",linewidth=0.16) {#RRPLEAK:1 (90,-160)};
// (90,-159.6) @TEXT("r_p",size=1.1,halign="middle",valign="bottom");
// &"0" @WIRE(mode="straight",linecolor="#30485d",linewidth=0.16) {#RRPLEAK:2 (90,-170)};
// (90,-170.4) @TEXT("0",size=1.1,halign="middle",valign="top");
// }
// END SARADC RNL
ends tb_reference

subckt tb_sampler
// Standalone sampler: normal initial 60 ns low / 40 ns high, 50 ohm source.
VBCLOCK (b_clock 0) vsource type=pulse val0=0 val1=0.9 delay=60n rise=100p fall=100p width=39.9n period=100n
VBIN (b_source 0) vsource type=pwl wave=[0 0.2 120n 0.2 120.1n 0.8]
RBIN (b_source b_in) resistor r=50
XBOOT (b_clock b_hold b_in) sar_bootstrap_flat_8b_p
CBLOAD (b_hold 0) cfmom_2t nr=8 lr=2u w=50n s=50n stm=1 spm=3 multi=256 mismatchflag=1

// BEGIN SARADC RNL
// @RNL(author="saradc topology") {
// #VBCLOCK @SET-SYMBOL $VOLTAGE_SOURCE;
// #VBCLOCK @PLACE(-70,0) => @ORIENT("R0");
// #VBCLOCK @TEXT("VBCLOCK",key="name",size=1.3,halign="start") => @PLACE(-67,3);
// #VBCLOCK @TEXT("",key="value",size=0.9,halign="start") => @PLACE(-67,-4);
// #VBCLOCK @TEXT("",key="model");
// #VBIN @SET-SYMBOL $VOLTAGE_SOURCE;
// #VBIN @PLACE(-70,-33) => @ORIENT("R0");
// #VBIN @TEXT("VBIN",key="name",size=1.3,halign="start") => @PLACE(-67,-30);
// #VBIN @TEXT("",key="value",size=0.9,halign="start") => @PLACE(-67,-37);
// #VBIN @TEXT("",key="model");
// #XBOOT @SET-SYMBOL $S_sar_bootstrap_flat_8b_p;
// #XBOOT @PLACE(0,0) => @ORIENT("R0");
// #RBIN @SET-SYMBOL $RESISTOR;
// #RBIN @PLACE(90,0) => @ORIENT("R0");
// #RBIN @TEXT("RBIN",key="name",size=1.3,halign="start") => @PLACE(93,3);
// #RBIN @TEXT("r=50",key="value",size=0.9,halign="start") => @PLACE(93,-4);
// #RBIN @TEXT("",key="model");
// #CBLOAD @SET-SYMBOL $CAPACITOR;
// #CBLOAD @PLACE(90,-33) => @ORIENT("R0");
// #CBLOAD @TEXT("CBLOAD",key="name",size=1.3,halign="start") => @PLACE(93,-30);
// #CBLOAD @TEXT("nr=8 lr=2u w=50n multi=256",key="value",size=0.9,halign="start") => @PLACE(93,-37);
// #CBLOAD @TEXT("",key="model");
// &"b_clock" @WIRE(mode="straight",linecolor="#30485d",linewidth=0.16) {#VBCLOCK:1 (-42.5,2) (-42.5,1.65) #XBOOT:1};
// &"b_in" @WIRE(mode="straight",linecolor="#30485d",linewidth=0.16) {#RBIN:2 (37.5,-2) (37.5,-1.65) #XBOOT:3};
// &"b_hold" @WIRE(mode="straight",linecolor="#30485d",linewidth=0.16) {#XBOOT:2 (52.5,0) (52.5,-31) #CBLOAD:1};
// (-89,30) @TEXT("tb_sampler / source-derived connections",size=1.4,halign="start",textcolor="#223d52");
// &"0" @WIRE(mode="straight",linecolor="#30485d",linewidth=0.16) {#VBCLOCK:2 (-70,-5)};
// (-70,-5.4) @TEXT("0",size=1.1,halign="middle",valign="top");
// &"b_source" @WIRE(mode="straight",linecolor="#30485d",linewidth=0.16) {#VBIN:1 (-70,-28)};
// (-70,-27.6) @TEXT("b_source",size=1.1,halign="middle",valign="bottom");
// &"0" @WIRE(mode="straight",linecolor="#30485d",linewidth=0.16) {#VBIN:2 (-70,-38)};
// (-70,-38.4) @TEXT("0",size=1.1,halign="middle",valign="top");
// &"b_source" @WIRE(mode="straight",linecolor="#30485d",linewidth=0.16) {#RBIN:1 (90,5)};
// (90,5.4) @TEXT("b_source",size=1.1,halign="middle",valign="bottom");
// &"0" @WIRE(mode="straight",linecolor="#30485d",linewidth=0.16) {#CBLOAD:2 (90,-38)};
// (90,-38.4) @TEXT("0",size=1.1,halign="middle",valign="top");
// }
// END SARADC RNL
ends tb_sampler

subckt tb_sar
// Native SAR and native delays; electrical VA sampler/CDAC/reference/comparator provide the environment.
VSCLOCK (s_clock 0) vsource type=pulse val0=0 val1=0.9 delay=60n rise=100p fall=100p width=39.9n period=100n
VSs_ps (s_ps 0) vsource type=pwl wave=[0 0.0017578125000000111 1.5980000000000001e-07 0.0017578125000000111 1.5990000000000002e-07 0.0439453125 2.5979999999999998e-07 0.0439453125 2.5989999999999999e-07 0.4482421875 3.5979999999999998e-07 0.4482421875 3.5989999999999999e-07 0.45175781250000002 4.5979999999999997e-07 0.45175781250000002 4.5989999999999998e-07 0.85605468750000002 5.5980000000000002e-07 0.85605468750000002 5.5990000000000003e-07 0.89824218750000007]
VSs_ns (s_ns 0) vsource type=pwl wave=[0 0.89824218749999996 1.5980000000000001e-07 0.89824218749999996 1.5990000000000002e-07 0.85605468750000002 2.5979999999999998e-07 0.85605468750000002 2.5989999999999999e-07 0.45175781250000002 3.5979999999999998e-07 0.45175781250000002 3.5989999999999999e-07 0.4482421875 4.5979999999999997e-07 0.4482421875 4.5989999999999998e-07 0.0439453125 5.5980000000000002e-07 0.0439453125 5.5990000000000003e-07 0.0017578124999999556]
XSAR (s_d0 s_d1 s_d2 s_d3 s_d4 s_d5 s_d6 s_d7 s_clock VDD! s_n s_p s_rn s_rp 0) tb_sar_top
RSIN (s_ns s_n) resistor r=50
RSIP (s_ps s_p) resistor r=50
VSRN (s_rns 0) vsource dc=0
VSRP (s_rps 0) vsource dc=0.9
RSRN (s_rns s_rn) resistor r=50
RSRP (s_rps s_rp) resistor r=50
CSRN (s_rn 0) capacitor c=4p
CSRP (s_rp 0) capacitor c=4p
XSPROBE (s_d0 s_d1 s_d2 s_d3 s_d4 s_d5 s_d6 s_d7 s_clock VDD! 0) b_behavior_observer model_id=901
CSL0 (s_d0 0) capacitor c=5f
CSL1 (s_d1 0) capacitor c=5f
CSL2 (s_d2 0) capacitor c=5f
CSL3 (s_d3 0) capacitor c=5f
CSL4 (s_d4 0) capacitor c=5f
CSL5 (s_d5 0) capacitor c=5f
CSL6 (s_d6 0) capacitor c=5f
CSL7 (s_d7 0) capacitor c=5f
// A second real SAR receives no comparator response. A new acquisition must
// clear it without a false write/update; this adds no watchdog to the design.
XSTALLED (f_d0 f_d1 f_d2 f_d3 f_d4 f_d5 f_d6 f_d7 s_clock VDD! f_n f_p f_rn f_rp 0) tb_sar_stalled_top
RFIN (s_ns f_n) resistor r=50
RFIP (s_ps f_p) resistor r=50
VFRN (f_rns 0) vsource dc=0
VFRP (f_rps 0) vsource dc=0.9
RFRN (f_rns f_rn) resistor r=50
RFRP (f_rps f_rp) resistor r=50
CFRN (f_rn 0) capacitor c=4p
CFRP (f_rp 0) capacitor c=4p
CFL0 (f_d0 0) capacitor c=5f
CFL1 (f_d1 0) capacitor c=5f
CFL2 (f_d2 0) capacitor c=5f
CFL3 (f_d3 0) capacitor c=5f
CFL4 (f_d4 0) capacitor c=5f
CFL5 (f_d5 0) capacitor c=5f
CFL6 (f_d6 0) capacitor c=5f
CFL7 (f_d7 0) capacitor c=5f

// BEGIN SARADC RNL
// @RNL(author="saradc topology") {
// #VSCLOCK @SET-SYMBOL $VOLTAGE_SOURCE;
// #VSCLOCK @PLACE(-70,0) => @ORIENT("R0");
// #VSCLOCK @TEXT("VSCLOCK",key="name",size=1.3,halign="start") => @PLACE(-67,3);
// #VSCLOCK @TEXT("",key="value",size=0.9,halign="start") => @PLACE(-67,-4);
// #VSCLOCK @TEXT("",key="model");
// #VSs_ps @SET-SYMBOL $VOLTAGE_SOURCE;
// #VSs_ps @PLACE(-70,-33) => @ORIENT("R0");
// #VSs_ps @TEXT("VSs_ps",key="name",size=1.3,halign="start") => @PLACE(-67,-30);
// #VSs_ps @TEXT("",key="value",size=0.9,halign="start") => @PLACE(-67,-37);
// #VSs_ps @TEXT("",key="model");
// #VSs_ns @SET-SYMBOL $VOLTAGE_SOURCE;
// #VSs_ns @PLACE(-70,-66) => @ORIENT("R0");
// #VSs_ns @TEXT("VSs_ns",key="name",size=1.3,halign="start") => @PLACE(-67,-63);
// #VSs_ns @TEXT("",key="value",size=0.9,halign="start") => @PLACE(-67,-70);
// #VSs_ns @TEXT("",key="model");
// #VSRN @SET-SYMBOL $VOLTAGE_SOURCE;
// #VSRN @PLACE(-70,-99) => @ORIENT("R0");
// #VSRN @TEXT("VSRN",key="name",size=1.3,halign="start") => @PLACE(-67,-96);
// #VSRN @TEXT("",key="value",size=0.9,halign="start") => @PLACE(-67,-103);
// #VSRN @TEXT("",key="model");
// #VSRP @SET-SYMBOL $VOLTAGE_SOURCE;
// #VSRP @PLACE(-70,-132) => @ORIENT("R0");
// #VSRP @TEXT("VSRP",key="name",size=1.3,halign="start") => @PLACE(-67,-129);
// #VSRP @TEXT("",key="value",size=0.9,halign="start") => @PLACE(-67,-136);
// #VSRP @TEXT("",key="model");
// #VFRN @SET-SYMBOL $VOLTAGE_SOURCE;
// #VFRN @PLACE(-70,-165) => @ORIENT("R0");
// #VFRN @TEXT("VFRN",key="name",size=1.3,halign="start") => @PLACE(-67,-162);
// #VFRN @TEXT("",key="value",size=0.9,halign="start") => @PLACE(-67,-169);
// #VFRN @TEXT("",key="model");
// #VFRP @SET-SYMBOL $VOLTAGE_SOURCE;
// #VFRP @PLACE(-70,-198) => @ORIENT("R0");
// #VFRP @TEXT("VFRP",key="name",size=1.3,halign="start") => @PLACE(-67,-195);
// #VFRP @TEXT("",key="value",size=0.9,halign="start") => @PLACE(-67,-202);
// #VFRP @TEXT("",key="model");
// #XSAR @SET-SYMBOL $S_tb_sar_top;
// #XSAR @PLACE(0,0) => @ORIENT("R0");
// #XSPROBE @SET-SYMBOL $S_b_behavior_observer;
// #XSPROBE @PLACE(0,-33) => @ORIENT("R0");
// #XSTALLED @SET-SYMBOL $S_tb_sar_stalled_top;
// #XSTALLED @PLACE(0,-66) => @ORIENT("R0");
// #RSIN @SET-SYMBOL $RESISTOR;
// #RSIN @PLACE(90,0) => @ORIENT("R0");
// #RSIN @TEXT("RSIN",key="name",size=1.3,halign="start") => @PLACE(93,3);
// #RSIN @TEXT("r=50",key="value",size=0.9,halign="start") => @PLACE(93,-4);
// #RSIN @TEXT("",key="model");
// #RSIP @SET-SYMBOL $RESISTOR;
// #RSIP @PLACE(90,-33) => @ORIENT("R0");
// #RSIP @TEXT("RSIP",key="name",size=1.3,halign="start") => @PLACE(93,-30);
// #RSIP @TEXT("r=50",key="value",size=0.9,halign="start") => @PLACE(93,-37);
// #RSIP @TEXT("",key="model");
// #RSRN @SET-SYMBOL $RESISTOR;
// #RSRN @PLACE(90,-66) => @ORIENT("R0");
// #RSRN @TEXT("RSRN",key="name",size=1.3,halign="start") => @PLACE(93,-63);
// #RSRN @TEXT("r=50",key="value",size=0.9,halign="start") => @PLACE(93,-70);
// #RSRN @TEXT("",key="model");
// #RSRP @SET-SYMBOL $RESISTOR;
// #RSRP @PLACE(90,-99) => @ORIENT("R0");
// #RSRP @TEXT("RSRP",key="name",size=1.3,halign="start") => @PLACE(93,-96);
// #RSRP @TEXT("r=50",key="value",size=0.9,halign="start") => @PLACE(93,-103);
// #RSRP @TEXT("",key="model");
// #CSRN @SET-SYMBOL $CAPACITOR;
// #CSRN @PLACE(90,-132) => @ORIENT("R0");
// #CSRN @TEXT("CSRN",key="name",size=1.3,halign="start") => @PLACE(93,-129);
// #CSRN @TEXT("c=4p",key="value",size=0.9,halign="start") => @PLACE(93,-136);
// #CSRN @TEXT("",key="model");
// #CSRP @SET-SYMBOL $CAPACITOR;
// #CSRP @PLACE(90,-165) => @ORIENT("R0");
// #CSRP @TEXT("CSRP",key="name",size=1.3,halign="start") => @PLACE(93,-162);
// #CSRP @TEXT("c=4p",key="value",size=0.9,halign="start") => @PLACE(93,-169);
// #CSRP @TEXT("",key="model");
// #CSL0 @SET-SYMBOL $CAPACITOR;
// #CSL0 @PLACE(90,-198) => @ORIENT("R0");
// #CSL0 @TEXT("CSL0",key="name",size=1.3,halign="start") => @PLACE(93,-195);
// #CSL0 @TEXT("c=5f",key="value",size=0.9,halign="start") => @PLACE(93,-202);
// #CSL0 @TEXT("",key="model");
// #CSL1 @SET-SYMBOL $CAPACITOR;
// #CSL1 @PLACE(90,-231) => @ORIENT("R0");
// #CSL1 @TEXT("CSL1",key="name",size=1.3,halign="start") => @PLACE(93,-228);
// #CSL1 @TEXT("c=5f",key="value",size=0.9,halign="start") => @PLACE(93,-235);
// #CSL1 @TEXT("",key="model");
// #CSL2 @SET-SYMBOL $CAPACITOR;
// #CSL2 @PLACE(90,-264) => @ORIENT("R0");
// #CSL2 @TEXT("CSL2",key="name",size=1.3,halign="start") => @PLACE(93,-261);
// #CSL2 @TEXT("c=5f",key="value",size=0.9,halign="start") => @PLACE(93,-268);
// #CSL2 @TEXT("",key="model");
// #CSL3 @SET-SYMBOL $CAPACITOR;
// #CSL3 @PLACE(90,-297) => @ORIENT("R0");
// #CSL3 @TEXT("CSL3",key="name",size=1.3,halign="start") => @PLACE(93,-294);
// #CSL3 @TEXT("c=5f",key="value",size=0.9,halign="start") => @PLACE(93,-301);
// #CSL3 @TEXT("",key="model");
// #CSL4 @SET-SYMBOL $CAPACITOR;
// #CSL4 @PLACE(90,-330) => @ORIENT("R0");
// #CSL4 @TEXT("CSL4",key="name",size=1.3,halign="start") => @PLACE(93,-327);
// #CSL4 @TEXT("c=5f",key="value",size=0.9,halign="start") => @PLACE(93,-334);
// #CSL4 @TEXT("",key="model");
// #CSL5 @SET-SYMBOL $CAPACITOR;
// #CSL5 @PLACE(90,-363) => @ORIENT("R0");
// #CSL5 @TEXT("CSL5",key="name",size=1.3,halign="start") => @PLACE(93,-360);
// #CSL5 @TEXT("c=5f",key="value",size=0.9,halign="start") => @PLACE(93,-367);
// #CSL5 @TEXT("",key="model");
// #CSL6 @SET-SYMBOL $CAPACITOR;
// #CSL6 @PLACE(145,0) => @ORIENT("R0");
// #CSL6 @TEXT("CSL6",key="name",size=1.3,halign="start") => @PLACE(148,3);
// #CSL6 @TEXT("c=5f",key="value",size=0.9,halign="start") => @PLACE(148,-4);
// #CSL6 @TEXT("",key="model");
// #CSL7 @SET-SYMBOL $CAPACITOR;
// #CSL7 @PLACE(145,-33) => @ORIENT("R0");
// #CSL7 @TEXT("CSL7",key="name",size=1.3,halign="start") => @PLACE(148,-30);
// #CSL7 @TEXT("c=5f",key="value",size=0.9,halign="start") => @PLACE(148,-37);
// #CSL7 @TEXT("",key="model");
// #RFIN @SET-SYMBOL $RESISTOR;
// #RFIN @PLACE(145,-66) => @ORIENT("R0");
// #RFIN @TEXT("RFIN",key="name",size=1.3,halign="start") => @PLACE(148,-63);
// #RFIN @TEXT("r=50",key="value",size=0.9,halign="start") => @PLACE(148,-70);
// #RFIN @TEXT("",key="model");
// #RFIP @SET-SYMBOL $RESISTOR;
// #RFIP @PLACE(145,-99) => @ORIENT("R0");
// #RFIP @TEXT("RFIP",key="name",size=1.3,halign="start") => @PLACE(148,-96);
// #RFIP @TEXT("r=50",key="value",size=0.9,halign="start") => @PLACE(148,-103);
// #RFIP @TEXT("",key="model");
// #RFRN @SET-SYMBOL $RESISTOR;
// #RFRN @PLACE(145,-132) => @ORIENT("R0");
// #RFRN @TEXT("RFRN",key="name",size=1.3,halign="start") => @PLACE(148,-129);
// #RFRN @TEXT("r=50",key="value",size=0.9,halign="start") => @PLACE(148,-136);
// #RFRN @TEXT("",key="model");
// #RFRP @SET-SYMBOL $RESISTOR;
// #RFRP @PLACE(145,-165) => @ORIENT("R0");
// #RFRP @TEXT("RFRP",key="name",size=1.3,halign="start") => @PLACE(148,-162);
// #RFRP @TEXT("r=50",key="value",size=0.9,halign="start") => @PLACE(148,-169);
// #RFRP @TEXT("",key="model");
// #CFRN @SET-SYMBOL $CAPACITOR;
// #CFRN @PLACE(145,-198) => @ORIENT("R0");
// #CFRN @TEXT("CFRN",key="name",size=1.3,halign="start") => @PLACE(148,-195);
// #CFRN @TEXT("c=4p",key="value",size=0.9,halign="start") => @PLACE(148,-202);
// #CFRN @TEXT("",key="model");
// #CFRP @SET-SYMBOL $CAPACITOR;
// #CFRP @PLACE(145,-231) => @ORIENT("R0");
// #CFRP @TEXT("CFRP",key="name",size=1.3,halign="start") => @PLACE(148,-228);
// #CFRP @TEXT("c=4p",key="value",size=0.9,halign="start") => @PLACE(148,-235);
// #CFRP @TEXT("",key="model");
// #CFL0 @SET-SYMBOL $CAPACITOR;
// #CFL0 @PLACE(145,-264) => @ORIENT("R0");
// #CFL0 @TEXT("CFL0",key="name",size=1.3,halign="start") => @PLACE(148,-261);
// #CFL0 @TEXT("c=5f",key="value",size=0.9,halign="start") => @PLACE(148,-268);
// #CFL0 @TEXT("",key="model");
// #CFL1 @SET-SYMBOL $CAPACITOR;
// #CFL1 @PLACE(145,-297) => @ORIENT("R0");
// #CFL1 @TEXT("CFL1",key="name",size=1.3,halign="start") => @PLACE(148,-294);
// #CFL1 @TEXT("c=5f",key="value",size=0.9,halign="start") => @PLACE(148,-301);
// #CFL1 @TEXT("",key="model");
// #CFL2 @SET-SYMBOL $CAPACITOR;
// #CFL2 @PLACE(145,-330) => @ORIENT("R0");
// #CFL2 @TEXT("CFL2",key="name",size=1.3,halign="start") => @PLACE(148,-327);
// #CFL2 @TEXT("c=5f",key="value",size=0.9,halign="start") => @PLACE(148,-334);
// #CFL2 @TEXT("",key="model");
// #CFL3 @SET-SYMBOL $CAPACITOR;
// #CFL3 @PLACE(145,-363) => @ORIENT("R0");
// #CFL3 @TEXT("CFL3",key="name",size=1.3,halign="start") => @PLACE(148,-360);
// #CFL3 @TEXT("c=5f",key="value",size=0.9,halign="start") => @PLACE(148,-367);
// #CFL3 @TEXT("",key="model");
// #CFL4 @SET-SYMBOL $CAPACITOR;
// #CFL4 @PLACE(200,0) => @ORIENT("R0");
// #CFL4 @TEXT("CFL4",key="name",size=1.3,halign="start") => @PLACE(203,3);
// #CFL4 @TEXT("c=5f",key="value",size=0.9,halign="start") => @PLACE(203,-4);
// #CFL4 @TEXT("",key="model");
// #CFL5 @SET-SYMBOL $CAPACITOR;
// #CFL5 @PLACE(200,-33) => @ORIENT("R0");
// #CFL5 @TEXT("CFL5",key="name",size=1.3,halign="start") => @PLACE(203,-30);
// #CFL5 @TEXT("c=5f",key="value",size=0.9,halign="start") => @PLACE(203,-37);
// #CFL5 @TEXT("",key="model");
// #CFL6 @SET-SYMBOL $CAPACITOR;
// #CFL6 @PLACE(200,-66) => @ORIENT("R0");
// #CFL6 @TEXT("CFL6",key="name",size=1.3,halign="start") => @PLACE(203,-63);
// #CFL6 @TEXT("c=5f",key="value",size=0.9,halign="start") => @PLACE(203,-70);
// #CFL6 @TEXT("",key="model");
// #CFL7 @SET-SYMBOL $CAPACITOR;
// #CFL7 @PLACE(200,-99) => @ORIENT("R0");
// #CFL7 @TEXT("CFL7",key="name",size=1.3,halign="start") => @PLACE(203,-96);
// #CFL7 @TEXT("c=5f",key="value",size=0.9,halign="start") => @PLACE(203,-103);
// #CFL7 @TEXT("",key="model");
// &"s_n" @WIRE(mode="straight",linecolor="#30485d",linewidth=0.16) {#XSAR:11 (38.5,3.3) (38.5,-2) #RSIN:2};
// &"s_p" @WIRE(mode="straight",linecolor="#30485d",linewidth=0.16) {#XSAR:12 (38.5,0) (38.5,-35) #RSIP:2};
// (-89,30) @TEXT("tb_sar / source-derived connections",size=1.4,halign="start",textcolor="#223d52");
// &"s_clock" @WIRE(mode="straight",linecolor="#30485d",linewidth=0.16) {#VSCLOCK:1 (-70,5)};
// (-70,5.4) @TEXT("s_clock",size=1.1,halign="middle",valign="bottom");
// &"0" @WIRE(mode="straight",linecolor="#30485d",linewidth=0.16) {#VSCLOCK:2 (-70,-5)};
// (-70,-5.4) @TEXT("0",size=1.1,halign="middle",valign="top");
// &"s_ps" @WIRE(mode="straight",linecolor="#30485d",linewidth=0.16) {#VSs_ps:1 (-70,-28)};
// (-70,-27.6) @TEXT("s_ps",size=1.1,halign="middle",valign="bottom");
// &"0" @WIRE(mode="straight",linecolor="#30485d",linewidth=0.16) {#VSs_ps:2 (-70,-38)};
// (-70,-38.4) @TEXT("0",size=1.1,halign="middle",valign="top");
// &"s_ns" @WIRE(mode="straight",linecolor="#30485d",linewidth=0.16) {#VSs_ns:1 (-70,-61)};
// (-70,-60.6) @TEXT("s_ns",size=1.1,halign="middle",valign="bottom");
// &"0" @WIRE(mode="straight",linecolor="#30485d",linewidth=0.16) {#VSs_ns:2 (-70,-71)};
// (-70,-71.4) @TEXT("0",size=1.1,halign="middle",valign="top");
// {&"s_d0" &"s_d1" &"s_d2" &"s_d3" &"s_d4" &"s_d5" &"s_d6" &"s_d7"} @WIRE(mode="straight",linewidth=0.3) {#XSAR:1 (16,0)};
// (16.4,0) @TEXT("s_d[7:0]",size=1.1,halign="start",valign="middle");
// &"s_clock" @WIRE(mode="straight",linecolor="#30485d",linewidth=0.16) {#XSAR:9 (-16,6.6)};
// (-16.4,6.6) @TEXT("s_clock",size=1.1,halign="end",valign="middle");
// &"VDD!" @WIRE(mode="straight",linecolor="#30485d",linewidth=0.16) {#XSAR:10 (0,14.9)};
// (0,15.3) @TEXT("VDD!",size=1.1,halign="middle",valign="bottom");
// &"s_rn" @WIRE(mode="straight",linecolor="#30485d",linewidth=0.16) {#XSAR:13 (-16,-3.3)};
// (-16.4,-3.3) @TEXT("s_rn",size=1.1,halign="end",valign="middle");
// &"s_rp" @WIRE(mode="straight",linecolor="#30485d",linewidth=0.16) {#XSAR:14 (-16,-6.6)};
// (-16.4,-6.6) @TEXT("s_rp",size=1.1,halign="end",valign="middle");
// &"0" @WIRE(mode="straight",linecolor="#30485d",linewidth=0.16) {#XSAR:15 (0,-14.9)};
// (0,-15.3) @TEXT("0",size=1.1,halign="middle",valign="top");
// &"s_ns" @WIRE(mode="straight",linecolor="#30485d",linewidth=0.16) {#RSIN:1 (90,5)};
// (90,5.4) @TEXT("s_ns",size=1.1,halign="middle",valign="bottom");
// &"s_ps" @WIRE(mode="straight",linecolor="#30485d",linewidth=0.16) {#RSIP:1 (90,-28)};
// (90,-27.6) @TEXT("s_ps",size=1.1,halign="middle",valign="bottom");
// &"s_rns" @WIRE(mode="straight",linecolor="#30485d",linewidth=0.16) {#VSRN:1 (-70,-94)};
// (-70,-93.6) @TEXT("s_rns",size=1.1,halign="middle",valign="bottom");
// &"0" @WIRE(mode="straight",linecolor="#30485d",linewidth=0.16) {#VSRN:2 (-70,-104)};
// (-70,-104.4) @TEXT("0",size=1.1,halign="middle",valign="top");
// &"s_rps" @WIRE(mode="straight",linecolor="#30485d",linewidth=0.16) {#VSRP:1 (-70,-127)};
// (-70,-126.6) @TEXT("s_rps",size=1.1,halign="middle",valign="bottom");
// &"0" @WIRE(mode="straight",linecolor="#30485d",linewidth=0.16) {#VSRP:2 (-70,-137)};
// (-70,-137.4) @TEXT("0",size=1.1,halign="middle",valign="top");
// &"s_rns" @WIRE(mode="straight",linecolor="#30485d",linewidth=0.16) {#RSRN:1 (90,-61)};
// (90,-60.6) @TEXT("s_rns",size=1.1,halign="middle",valign="bottom");
// &"s_rn" @WIRE(mode="straight",linecolor="#30485d",linewidth=0.16) {#RSRN:2 (90,-71)};
// (90,-71.4) @TEXT("s_rn",size=1.1,halign="middle",valign="top");
// &"s_rps" @WIRE(mode="straight",linecolor="#30485d",linewidth=0.16) {#RSRP:1 (90,-94)};
// (90,-93.6) @TEXT("s_rps",size=1.1,halign="middle",valign="bottom");
// &"s_rp" @WIRE(mode="straight",linecolor="#30485d",linewidth=0.16) {#RSRP:2 (90,-104)};
// (90,-104.4) @TEXT("s_rp",size=1.1,halign="middle",valign="top");
// &"s_rn" @WIRE(mode="straight",linecolor="#30485d",linewidth=0.16) {#CSRN:1 (90,-127)};
// (90,-126.6) @TEXT("s_rn",size=1.1,halign="middle",valign="bottom");
// &"0" @WIRE(mode="straight",linecolor="#30485d",linewidth=0.16) {#CSRN:2 (90,-137)};
// (90,-137.4) @TEXT("0",size=1.1,halign="middle",valign="top");
// &"s_rp" @WIRE(mode="straight",linecolor="#30485d",linewidth=0.16) {#CSRP:1 (90,-160)};
// (90,-159.6) @TEXT("s_rp",size=1.1,halign="middle",valign="bottom");
// &"0" @WIRE(mode="straight",linecolor="#30485d",linewidth=0.16) {#CSRP:2 (90,-170)};
// (90,-170.4) @TEXT("0",size=1.1,halign="middle",valign="top");
// {&"s_d0" &"s_d1" &"s_d2" &"s_d3" &"s_d4" &"s_d5" &"s_d6" &"s_d7"} @WIRE(mode="straight",linewidth=0.3) {#XSPROBE:1 (16,-33)};
// (16.4,-33) @TEXT("s_d[7:0]",size=1.1,halign="start",valign="middle");
// &"s_clock" @WIRE(mode="straight",linecolor="#30485d",linewidth=0.16) {#XSPROBE:9 (-16,-33)};
// (-16.4,-33) @TEXT("s_clock",size=1.1,halign="end",valign="middle");
// &"VDD!" @WIRE(mode="straight",linecolor="#30485d",linewidth=0.16) {#XSPROBE:10 (0,-22)};
// (0,-21.6) @TEXT("VDD!",size=1.1,halign="middle",valign="bottom");
// &"0" @WIRE(mode="straight",linecolor="#30485d",linewidth=0.16) {#XSPROBE:11 (0,-44)};
// (0,-44.4) @TEXT("0",size=1.1,halign="middle",valign="top");
// &"s_d0" @WIRE(mode="straight",linecolor="#30485d",linewidth=0.16) {#CSL0:1 (90,-193)};
// (90,-192.6) @TEXT("s_d0",size=1.1,halign="middle",valign="bottom");
// &"0" @WIRE(mode="straight",linecolor="#30485d",linewidth=0.16) {#CSL0:2 (90,-203)};
// (90,-203.4) @TEXT("0",size=1.1,halign="middle",valign="top");
// &"s_d1" @WIRE(mode="straight",linecolor="#30485d",linewidth=0.16) {#CSL1:1 (90,-226)};
// (90,-225.6) @TEXT("s_d1",size=1.1,halign="middle",valign="bottom");
// &"0" @WIRE(mode="straight",linecolor="#30485d",linewidth=0.16) {#CSL1:2 (90,-236)};
// (90,-236.4) @TEXT("0",size=1.1,halign="middle",valign="top");
// &"s_d2" @WIRE(mode="straight",linecolor="#30485d",linewidth=0.16) {#CSL2:1 (90,-259)};
// (90,-258.6) @TEXT("s_d2",size=1.1,halign="middle",valign="bottom");
// &"0" @WIRE(mode="straight",linecolor="#30485d",linewidth=0.16) {#CSL2:2 (90,-269)};
// (90,-269.4) @TEXT("0",size=1.1,halign="middle",valign="top");
// &"s_d3" @WIRE(mode="straight",linecolor="#30485d",linewidth=0.16) {#CSL3:1 (90,-292)};
// (90,-291.6) @TEXT("s_d3",size=1.1,halign="middle",valign="bottom");
// &"0" @WIRE(mode="straight",linecolor="#30485d",linewidth=0.16) {#CSL3:2 (90,-302)};
// (90,-302.4) @TEXT("0",size=1.1,halign="middle",valign="top");
// &"s_d4" @WIRE(mode="straight",linecolor="#30485d",linewidth=0.16) {#CSL4:1 (90,-325)};
// (90,-324.6) @TEXT("s_d4",size=1.1,halign="middle",valign="bottom");
// &"0" @WIRE(mode="straight",linecolor="#30485d",linewidth=0.16) {#CSL4:2 (90,-335)};
// (90,-335.4) @TEXT("0",size=1.1,halign="middle",valign="top");
// &"s_d5" @WIRE(mode="straight",linecolor="#30485d",linewidth=0.16) {#CSL5:1 (90,-358)};
// (90,-357.6) @TEXT("s_d5",size=1.1,halign="middle",valign="bottom");
// &"0" @WIRE(mode="straight",linecolor="#30485d",linewidth=0.16) {#CSL5:2 (90,-368)};
// (90,-368.4) @TEXT("0",size=1.1,halign="middle",valign="top");
// &"s_d6" @WIRE(mode="straight",linecolor="#30485d",linewidth=0.16) {#CSL6:1 (145,5)};
// (145,5.4) @TEXT("s_d6",size=1.1,halign="middle",valign="bottom");
// &"0" @WIRE(mode="straight",linecolor="#30485d",linewidth=0.16) {#CSL6:2 (145,-5)};
// (145,-5.4) @TEXT("0",size=1.1,halign="middle",valign="top");
// &"s_d7" @WIRE(mode="straight",linecolor="#30485d",linewidth=0.16) {#CSL7:1 (145,-28)};
// (145,-27.6) @TEXT("s_d7",size=1.1,halign="middle",valign="bottom");
// &"0" @WIRE(mode="straight",linecolor="#30485d",linewidth=0.16) {#CSL7:2 (145,-38)};
// (145,-38.4) @TEXT("0",size=1.1,halign="middle",valign="top");
// {&"f_d0" &"f_d1" &"f_d2" &"f_d3" &"f_d4" &"f_d5" &"f_d6" &"f_d7"} @WIRE(mode="straight",linewidth=0.3) {#XSTALLED:1 (16,-66)};
// (16.4,-66) @TEXT("f_d[7:0]",size=1.1,halign="start",valign="middle");
// &"s_clock" @WIRE(mode="straight",linecolor="#30485d",linewidth=0.16) {#XSTALLED:9 (-16,-59.4)};
// (-16.4,-59.4) @TEXT("s_clock",size=1.1,halign="end",valign="middle");
// &"VDD!" @WIRE(mode="straight",linecolor="#30485d",linewidth=0.16) {#XSTALLED:10 (0,-51.1)};
// (0,-50.7) @TEXT("VDD!",size=1.1,halign="middle",valign="bottom");
// &"f_n" @WIRE(mode="straight",linecolor="#30485d",linewidth=0.16) {#XSTALLED:11 (-16,-62.7)};
// (-16.4,-62.7) @TEXT("f_n",size=1.1,halign="end",valign="middle");
// &"f_p" @WIRE(mode="straight",linecolor="#30485d",linewidth=0.16) {#XSTALLED:12 (-16,-66)};
// (-16.4,-66) @TEXT("f_p",size=1.1,halign="end",valign="middle");
// &"f_rn" @WIRE(mode="straight",linecolor="#30485d",linewidth=0.16) {#XSTALLED:13 (-16,-69.3)};
// (-16.4,-69.3) @TEXT("f_rn",size=1.1,halign="end",valign="middle");
// &"f_rp" @WIRE(mode="straight",linecolor="#30485d",linewidth=0.16) {#XSTALLED:14 (-16,-72.6)};
// (-16.4,-72.6) @TEXT("f_rp",size=1.1,halign="end",valign="middle");
// &"0" @WIRE(mode="straight",linecolor="#30485d",linewidth=0.16) {#XSTALLED:15 (0,-80.9)};
// (0,-81.3) @TEXT("0",size=1.1,halign="middle",valign="top");
// &"s_ns" @WIRE(mode="straight",linecolor="#30485d",linewidth=0.16) {#RFIN:1 (145,-61)};
// (145,-60.6) @TEXT("s_ns",size=1.1,halign="middle",valign="bottom");
// &"f_n" @WIRE(mode="straight",linecolor="#30485d",linewidth=0.16) {#RFIN:2 (145,-71)};
// (145,-71.4) @TEXT("f_n",size=1.1,halign="middle",valign="top");
// &"s_ps" @WIRE(mode="straight",linecolor="#30485d",linewidth=0.16) {#RFIP:1 (145,-94)};
// (145,-93.6) @TEXT("s_ps",size=1.1,halign="middle",valign="bottom");
// &"f_p" @WIRE(mode="straight",linecolor="#30485d",linewidth=0.16) {#RFIP:2 (145,-104)};
// (145,-104.4) @TEXT("f_p",size=1.1,halign="middle",valign="top");
// &"f_rns" @WIRE(mode="straight",linecolor="#30485d",linewidth=0.16) {#VFRN:1 (-70,-160)};
// (-70,-159.6) @TEXT("f_rns",size=1.1,halign="middle",valign="bottom");
// &"0" @WIRE(mode="straight",linecolor="#30485d",linewidth=0.16) {#VFRN:2 (-70,-170)};
// (-70,-170.4) @TEXT("0",size=1.1,halign="middle",valign="top");
// &"f_rps" @WIRE(mode="straight",linecolor="#30485d",linewidth=0.16) {#VFRP:1 (-70,-193)};
// (-70,-192.6) @TEXT("f_rps",size=1.1,halign="middle",valign="bottom");
// &"0" @WIRE(mode="straight",linecolor="#30485d",linewidth=0.16) {#VFRP:2 (-70,-203)};
// (-70,-203.4) @TEXT("0",size=1.1,halign="middle",valign="top");
// &"f_rns" @WIRE(mode="straight",linecolor="#30485d",linewidth=0.16) {#RFRN:1 (145,-127)};
// (145,-126.6) @TEXT("f_rns",size=1.1,halign="middle",valign="bottom");
// &"f_rn" @WIRE(mode="straight",linecolor="#30485d",linewidth=0.16) {#RFRN:2 (145,-137)};
// (145,-137.4) @TEXT("f_rn",size=1.1,halign="middle",valign="top");
// &"f_rps" @WIRE(mode="straight",linecolor="#30485d",linewidth=0.16) {#RFRP:1 (145,-160)};
// (145,-159.6) @TEXT("f_rps",size=1.1,halign="middle",valign="bottom");
// &"f_rp" @WIRE(mode="straight",linecolor="#30485d",linewidth=0.16) {#RFRP:2 (145,-170)};
// (145,-170.4) @TEXT("f_rp",size=1.1,halign="middle",valign="top");
// &"f_rn" @WIRE(mode="straight",linecolor="#30485d",linewidth=0.16) {#CFRN:1 (145,-193)};
// (145,-192.6) @TEXT("f_rn",size=1.1,halign="middle",valign="bottom");
// &"0" @WIRE(mode="straight",linecolor="#30485d",linewidth=0.16) {#CFRN:2 (145,-203)};
// (145,-203.4) @TEXT("0",size=1.1,halign="middle",valign="top");
// &"f_rp" @WIRE(mode="straight",linecolor="#30485d",linewidth=0.16) {#CFRP:1 (145,-226)};
// (145,-225.6) @TEXT("f_rp",size=1.1,halign="middle",valign="bottom");
// &"0" @WIRE(mode="straight",linecolor="#30485d",linewidth=0.16) {#CFRP:2 (145,-236)};
// (145,-236.4) @TEXT("0",size=1.1,halign="middle",valign="top");
// &"f_d0" @WIRE(mode="straight",linecolor="#30485d",linewidth=0.16) {#CFL0:1 (145,-259)};
// (145,-258.6) @TEXT("f_d0",size=1.1,halign="middle",valign="bottom");
// &"0" @WIRE(mode="straight",linecolor="#30485d",linewidth=0.16) {#CFL0:2 (145,-269)};
// (145,-269.4) @TEXT("0",size=1.1,halign="middle",valign="top");
// &"f_d1" @WIRE(mode="straight",linecolor="#30485d",linewidth=0.16) {#CFL1:1 (145,-292)};
// (145,-291.6) @TEXT("f_d1",size=1.1,halign="middle",valign="bottom");
// &"0" @WIRE(mode="straight",linecolor="#30485d",linewidth=0.16) {#CFL1:2 (145,-302)};
// (145,-302.4) @TEXT("0",size=1.1,halign="middle",valign="top");
// &"f_d2" @WIRE(mode="straight",linecolor="#30485d",linewidth=0.16) {#CFL2:1 (145,-325)};
// (145,-324.6) @TEXT("f_d2",size=1.1,halign="middle",valign="bottom");
// &"0" @WIRE(mode="straight",linecolor="#30485d",linewidth=0.16) {#CFL2:2 (145,-335)};
// (145,-335.4) @TEXT("0",size=1.1,halign="middle",valign="top");
// &"f_d3" @WIRE(mode="straight",linecolor="#30485d",linewidth=0.16) {#CFL3:1 (145,-358)};
// (145,-357.6) @TEXT("f_d3",size=1.1,halign="middle",valign="bottom");
// &"0" @WIRE(mode="straight",linecolor="#30485d",linewidth=0.16) {#CFL3:2 (145,-368)};
// (145,-368.4) @TEXT("0",size=1.1,halign="middle",valign="top");
// &"f_d4" @WIRE(mode="straight",linecolor="#30485d",linewidth=0.16) {#CFL4:1 (200,5)};
// (200,5.4) @TEXT("f_d4",size=1.1,halign="middle",valign="bottom");
// &"0" @WIRE(mode="straight",linecolor="#30485d",linewidth=0.16) {#CFL4:2 (200,-5)};
// (200,-5.4) @TEXT("0",size=1.1,halign="middle",valign="top");
// &"f_d5" @WIRE(mode="straight",linecolor="#30485d",linewidth=0.16) {#CFL5:1 (200,-28)};
// (200,-27.6) @TEXT("f_d5",size=1.1,halign="middle",valign="bottom");
// &"0" @WIRE(mode="straight",linecolor="#30485d",linewidth=0.16) {#CFL5:2 (200,-38)};
// (200,-38.4) @TEXT("0",size=1.1,halign="middle",valign="top");
// &"f_d6" @WIRE(mode="straight",linecolor="#30485d",linewidth=0.16) {#CFL6:1 (200,-61)};
// (200,-60.6) @TEXT("f_d6",size=1.1,halign="middle",valign="bottom");
// &"0" @WIRE(mode="straight",linecolor="#30485d",linewidth=0.16) {#CFL6:2 (200,-71)};
// (200,-71.4) @TEXT("0",size=1.1,halign="middle",valign="top");
// &"f_d7" @WIRE(mode="straight",linecolor="#30485d",linewidth=0.16) {#CFL7:1 (200,-94)};
// (200,-93.6) @TEXT("f_d7",size=1.1,halign="middle",valign="bottom");
// &"0" @WIRE(mode="straight",linecolor="#30485d",linewidth=0.16) {#CFL7:2 (200,-104)};
// (200,-104.4) @TEXT("0",size=1.1,halign="middle",valign="top");
// }
// END SARADC RNL
ends tb_sar

subckt tb_sar_top D0 D1 D2 D3 D4 D5 D6 D7 SAMPLE VDD! VINN VINP  VREFN VREFP 0
    XSEQ (SAMPLE_INT VDD! 0 SEQ_SAMPLE) sar8_se_acquire
    XDONE (ACTIVE DONE VDD! 0) INVD1BWP12T30P140
    XPRESET (DONE SEQ_SAMPLE PRESET VDD! 0) OR2D1BWP12T30P140
    XSAMPLE (SAMPLE SAMPLE_INT VDD! 0) CKBD1BWP12T30P140
    XBOOTN (SEQ_SAMPLE TOPN VINN) b_sampler_bridge
    XBOOTP (SEQ_SAMPLE TOPP VINP) b_sampler_bridge
    XCDAC (GNN0 GNN1 GNN2 GNN3 GNN4 GNN5 GNN6 GNN7 GNP0 GNP1 GNP2 GNP3 GNP4 GNP5 GNP6 GNP7 GPN0 GPN1 GPN2 GPN3 GPN4 GPN5 GPN6 GPN7 GPP0 GPP1 GPP2 GPP3 GPP4 GPP5 GPP6 GPP7 TOPN TOPP VDD! VREFN VREFP 0)  b_cdac
    XCTRL (CMP_CLK CODE0 CODE1 CODE2 CODE3 CODE4 CODE5 CODE6 CODE7 COMP_N  COMP_P D0 D1 D2 D3 D4 D5 D6 D7 PHI_U SEQ_SAMPLE VDD! 0 ACTIVE) sar8_se_ctrl
    XREF (CODE0 CODE1 CODE2 CODE3 CODE4 CODE5 CODE6 CODE7 D0 D1 D2 D3 D4 D5 D6 D7 GNN0 GNN1 GNN2 GNN3 GNN4 GNN5 GNN6 GNN7 GNP0 GNP1 GNP2 GNP3 GNP4 GNP5 GNP6 GNP7 GPN0 GPN1 GPN2 GPN3 GPN4 GPN5 GPN6 GPN7 GPP0 GPP1 GPP2 GPP3 GPP4 GPP5 GPP6 GPP7 PHI_U SAMPLE_INT VDD! 0 RST_DONE PRESET)  b_reference
    XCOMP (CMP_CLK COMP_N COMP_P VDD! TOPN TOPP 0) b_comparator
    CL_COMP_N (COMP_N 0) cfmom_2t nr=8 lr=2.5u w=50n s=50n stm=1 spm=3  multi=2 mismatchflag=1
    CL_COMP_P (COMP_P 0) cfmom_2t nr=8 lr=2.5u w=50n s=50n stm=1 spm=3  multi=2 mismatchflag=1
    CL_CMP_CLK (CMP_CLK 0) cfmom_2t nr=8 lr=2.5u w=50n s=50n stm=1 spm=3  multi=2 mismatchflag=1
// BEGIN SARADC RNL
// @RNL(author="saradc topology") {
// #XSEQ @SET-SYMBOL $S_sar8_se_acquire;
// #XSEQ @PLACE(0,0) => @ORIENT("R0");
// #XDONE @SET-SYMBOL $S_INVD1BWP12T30P140;
// #XDONE @PLACE(0,-33) => @ORIENT("R0");
// #XPRESET @SET-SYMBOL $S_OR2D1BWP12T30P140;
// #XPRESET @PLACE(0,-66) => @ORIENT("R0");
// #XSAMPLE @SET-SYMBOL $S_CKBD1BWP12T30P140;
// #XSAMPLE @PLACE(0,-99) => @ORIENT("R0");
// #XBOOTN @SET-SYMBOL $S_b_sampler_bridge;
// #XBOOTN @PLACE(0,-132) => @ORIENT("R0");
// #XBOOTP @SET-SYMBOL $S_b_sampler_bridge;
// #XBOOTP @PLACE(0,-165) => @ORIENT("R0");
// #XCDAC @SET-SYMBOL $S_b_cdac;
// #XCDAC @PLACE(0,-198) => @ORIENT("R0");
// #XCTRL @SET-SYMBOL $S_sar8_se_ctrl;
// #XCTRL @PLACE(0,-231) => @ORIENT("R0");
// #XREF @SET-SYMBOL $S_b_reference;
// #XREF @PLACE(0,-264) => @ORIENT("R0");
// #XCOMP @SET-SYMBOL $S_b_comparator;
// #XCOMP @PLACE(0,-297) => @ORIENT("R0");
// #CL_COMP_N @SET-SYMBOL $CAPACITOR;
// #CL_COMP_N @PLACE(90,0) => @ORIENT("R0");
// #CL_COMP_N @TEXT("CL_COMP_N",key="name",size=1.3,halign="start") => @PLACE(93,3);
// #CL_COMP_N @TEXT("nr=8 lr=2.5u w=50n multi=2",key="value",size=0.9,halign="start") => @PLACE(93,-4);
// #CL_COMP_N @TEXT("",key="model");
// #CL_COMP_P @SET-SYMBOL $CAPACITOR;
// #CL_COMP_P @PLACE(90,-33) => @ORIENT("R0");
// #CL_COMP_P @TEXT("CL_COMP_P",key="name",size=1.3,halign="start") => @PLACE(93,-30);
// #CL_COMP_P @TEXT("nr=8 lr=2.5u w=50n multi=2",key="value",size=0.9,halign="start") => @PLACE(93,-37);
// #CL_COMP_P @TEXT("",key="model");
// #CL_CMP_CLK @SET-SYMBOL $CAPACITOR;
// #CL_CMP_CLK @PLACE(90,-66) => @ORIENT("R0");
// #CL_CMP_CLK @TEXT("CL_CMP_CLK",key="name",size=1.3,halign="start") => @PLACE(93,-63);
// #CL_CMP_CLK @TEXT("nr=8 lr=2.5u w=50n multi=2",key="value",size=0.9,halign="start") => @PLACE(93,-70);
// #CL_CMP_CLK @TEXT("",key="model");
// &"DONE" @WIRE(mode="straight",linecolor="#30485d",linewidth=0.16) {#XDONE:2 (0,-33) (0,-64.3) #XPRESET:1};
// &"PHI_U" @WIRE(mode="straight",linecolor="#30485d",linewidth=0.16) {#XCTRL:20 (1,-234.3) (1,-265.65) #XREF:49};
// (-89,30) @TEXT("tb_sar_top / source-derived connections",size=1.4,halign="start",textcolor="#223d52");
// &"SAMPLE_INT" @WIRE(mode="straight",linecolor="#30485d",linewidth=0.16) {#XSEQ:1 (-16,0)};
// (-16.4,0) @TEXT("SAMPLE_INT",size=1.1,halign="end",valign="middle");
// &"VDD!" @WIRE(mode="straight",linecolor="#30485d",linewidth=0.16) {#XSEQ:2 (0,11)};
// (0,11.4) @TEXT("VDD!",size=1.1,halign="middle",valign="bottom");
// &"0" @WIRE(mode="straight",linecolor="#30485d",linewidth=0.16) {#XSEQ:3 (0,-11)};
// (0,-11.4) @TEXT("0",size=1.1,halign="middle",valign="top");
// &"SEQ_SAMPLE" @WIRE(mode="straight",linecolor="#30485d",linewidth=0.16) {#XSEQ:4 (16,0)};
// (16.4,0) @TEXT("SEQ_SAMPLE",size=1.1,halign="start",valign="middle");
// &"ACTIVE" @WIRE(mode="straight",linecolor="#30485d",linewidth=0.16) {#XDONE:1 (-10,-33)};
// (-10.4,-33) @TEXT("ACTIVE",size=1.1,halign="end",valign="middle");
// &"VDD!" @WIRE(mode="straight",linecolor="#30485d",linewidth=0.16) {#XDONE:3 (0,-23)};
// (0,-22.6) @TEXT("VDD!",size=1.1,halign="middle",valign="bottom");
// &"0" @WIRE(mode="straight",linecolor="#30485d",linewidth=0.16) {#XDONE:4 (0,-43)};
// (0,-43.4) @TEXT("0",size=1.1,halign="middle",valign="top");
// &"SEQ_SAMPLE" @WIRE(mode="straight",linecolor="#30485d",linewidth=0.16) {#XPRESET:2 (-10,-67.7)};
// (-10.4,-67.7) @TEXT("SEQ_SAMPLE",size=1.1,halign="end",valign="middle");
// &"PRESET" @WIRE(mode="straight",linecolor="#30485d",linewidth=0.16) {#XPRESET:3 (10,-66)};
// (10.4,-66) @TEXT("PRESET",size=1.1,halign="start",valign="middle");
// &"VDD!" @WIRE(mode="straight",linecolor="#30485d",linewidth=0.16) {#XPRESET:4 (0,-56)};
// (0,-55.6) @TEXT("VDD!",size=1.1,halign="middle",valign="bottom");
// &"0" @WIRE(mode="straight",linecolor="#30485d",linewidth=0.16) {#XPRESET:5 (0,-76)};
// (0,-76.4) @TEXT("0",size=1.1,halign="middle",valign="top");
// &"SAMPLE" @WIRE(mode="straight",linecolor="#30485d",linewidth=0.16) {#XSAMPLE:1 (-16,-99)};
// (-16.4,-99) @TEXT("SAMPLE",size=1.1,halign="end",valign="middle");
// &"SAMPLE_INT" @WIRE(mode="straight",linecolor="#30485d",linewidth=0.16) {#XSAMPLE:2 (16,-99)};
// (16.4,-99) @TEXT("SAMPLE_INT",size=1.1,halign="start",valign="middle");
// &"VDD!" @WIRE(mode="straight",linecolor="#30485d",linewidth=0.16) {#XSAMPLE:3 (0,-88)};
// (0,-87.6) @TEXT("VDD!",size=1.1,halign="middle",valign="bottom");
// &"0" @WIRE(mode="straight",linecolor="#30485d",linewidth=0.16) {#XSAMPLE:4 (0,-110)};
// (0,-110.4) @TEXT("0",size=1.1,halign="middle",valign="top");
// &"SEQ_SAMPLE" @WIRE(mode="straight",linecolor="#30485d",linewidth=0.16) {#XBOOTN:1 (-16,-130.35)};
// (-16.4,-130.35) @TEXT("SEQ_SAMPLE",size=1.1,halign="end",valign="middle");
// &"TOPN" @WIRE(mode="straight",linecolor="#30485d",linewidth=0.16) {#XBOOTN:2 (16,-132)};
// (16.4,-132) @TEXT("TOPN",size=1.1,halign="start",valign="middle");
// &"VINN" @WIRE(mode="straight",linecolor="#30485d",linewidth=0.16) {#XBOOTN:3 (-16,-133.65)};
// (-16.4,-133.65) @TEXT("VINN",size=1.1,halign="end",valign="middle");
// &"SEQ_SAMPLE" @WIRE(mode="straight",linecolor="#30485d",linewidth=0.16) {#XBOOTP:1 (-16,-163.35)};
// (-16.4,-163.35) @TEXT("SEQ_SAMPLE",size=1.1,halign="end",valign="middle");
// &"TOPP" @WIRE(mode="straight",linecolor="#30485d",linewidth=0.16) {#XBOOTP:2 (16,-165)};
// (16.4,-165) @TEXT("TOPP",size=1.1,halign="start",valign="middle");
// &"VINP" @WIRE(mode="straight",linecolor="#30485d",linewidth=0.16) {#XBOOTP:3 (-16,-166.65)};
// (-16.4,-166.65) @TEXT("VINP",size=1.1,halign="end",valign="middle");
// {&"GNN0" &"GNN1" &"GNN2" &"GNN3" &"GNN4" &"GNN5" &"GNN6" &"GNN7"} @WIRE(mode="straight",linewidth=0.3) {#XCDAC:1 (-16,-189.75)};
// (-16.4,-189.75) @TEXT("GNN[7:0]",size=1.1,halign="end",valign="middle");
// {&"GNP0" &"GNP1" &"GNP2" &"GNP3" &"GNP4" &"GNP5" &"GNP6" &"GNP7"} @WIRE(mode="straight",linewidth=0.3) {#XCDAC:9 (-16,-193.05)};
// (-16.4,-193.05) @TEXT("GNP[7:0]",size=1.1,halign="end",valign="middle");
// {&"GPN0" &"GPN1" &"GPN2" &"GPN3" &"GPN4" &"GPN5" &"GPN6" &"GPN7"} @WIRE(mode="straight",linewidth=0.3) {#XCDAC:17 (-16,-196.35)};
// (-16.4,-196.35) @TEXT("GPN[7:0]",size=1.1,halign="end",valign="middle");
// {&"GPP0" &"GPP1" &"GPP2" &"GPP3" &"GPP4" &"GPP5" &"GPP6" &"GPP7"} @WIRE(mode="straight",linewidth=0.3) {#XCDAC:25 (-16,-199.65)};
// (-16.4,-199.65) @TEXT("GPP[7:0]",size=1.1,halign="end",valign="middle");
// &"TOPN" @WIRE(mode="straight",linecolor="#30485d",linewidth=0.16) {#XCDAC:33 (16,-196.35)};
// (16.4,-196.35) @TEXT("TOPN",size=1.1,halign="start",valign="middle");
// &"TOPP" @WIRE(mode="straight",linecolor="#30485d",linewidth=0.16) {#XCDAC:34 (16,-199.65)};
// (16.4,-199.65) @TEXT("TOPP",size=1.1,halign="start",valign="middle");
// &"VDD!" @WIRE(mode="straight",linecolor="#30485d",linewidth=0.16) {#XCDAC:35 (0,-181.45)};
// (0,-181.05) @TEXT("VDD!",size=1.1,halign="middle",valign="bottom");
// &"VREFN" @WIRE(mode="straight",linecolor="#30485d",linewidth=0.16) {#XCDAC:36 (-16,-202.95)};
// (-16.4,-202.95) @TEXT("VREFN",size=1.1,halign="end",valign="middle");
// &"VREFP" @WIRE(mode="straight",linecolor="#30485d",linewidth=0.16) {#XCDAC:37 (-16,-206.25)};
// (-16.4,-206.25) @TEXT("VREFP",size=1.1,halign="end",valign="middle");
// &"0" @WIRE(mode="straight",linecolor="#30485d",linewidth=0.16) {#XCDAC:38 (0,-214.55)};
// (0,-214.95) @TEXT("0",size=1.1,halign="middle",valign="top");
// &"CMP_CLK" @WIRE(mode="straight",linecolor="#30485d",linewidth=0.16) {#XCTRL:1 (-4,-219.4)};
// (-4,-219) @TEXT("CMP_CLK",size=1.1,halign="middle",valign="bottom");
// {&"CODE0" &"CODE1" &"CODE2" &"CODE3" &"CODE4" &"CODE5" &"CODE6" &"CODE7"} @WIRE(mode="straight",linewidth=0.3) {#XCTRL:2 (-4,-242.6)};
// (-4,-243) @TEXT("CODE[7:0]",size=1.1,halign="middle",valign="top");
// &"COMP_N" @WIRE(mode="straight",linecolor="#30485d",linewidth=0.16) {#XCTRL:10 (-18,-231)};
// (-18.4,-231) @TEXT("COMP_N",size=1.1,halign="end",valign="middle");
// &"COMP_P" @WIRE(mode="straight",linecolor="#30485d",linewidth=0.16) {#XCTRL:11 (-18,-227.7)};
// (-18.4,-227.7) @TEXT("COMP_P",size=1.1,halign="end",valign="middle");
// {&"D0" &"D1" &"D2" &"D3" &"D4" &"D5" &"D6" &"D7"} @WIRE(mode="straight",linewidth=0.3) {#XCTRL:12 (18,-227.7)};
// (18.4,-227.7) @TEXT("D[7:0]",size=1.1,halign="start",valign="middle");
// &"SEQ_SAMPLE" @WIRE(mode="straight",linecolor="#30485d",linewidth=0.16) {#XCTRL:21 (-18,-234.3)};
// (-18.4,-234.3) @TEXT("SEQ_SAMPLE",size=1.1,halign="end",valign="middle");
// &"VDD!" @WIRE(mode="straight",linecolor="#30485d",linewidth=0.16) {#XCTRL:22 (4,-219.4)};
// (4,-219) @TEXT("VDD!",size=1.1,halign="middle",valign="bottom");
// &"0" @WIRE(mode="straight",linecolor="#30485d",linewidth=0.16) {#XCTRL:23 (4,-242.6)};
// (4,-243) @TEXT("0",size=1.1,halign="middle",valign="top");
// &"ACTIVE" @WIRE(mode="straight",linecolor="#30485d",linewidth=0.16) {#XCTRL:24 (18,-231)};
// (18.4,-231) @TEXT("ACTIVE",size=1.1,halign="start",valign="middle");
// {&"CODE0" &"CODE1" &"CODE2" &"CODE3" &"CODE4" &"CODE5" &"CODE6" &"CODE7"} @WIRE(mode="straight",linewidth=0.3) {#XREF:1 (-16,-259.05)};
// (-16.4,-259.05) @TEXT("CODE[7:0]",size=1.1,halign="end",valign="middle");
// {&"D0" &"D1" &"D2" &"D3" &"D4" &"D5" &"D6" &"D7"} @WIRE(mode="straight",linewidth=0.3) {#XREF:9 (-16,-262.35)};
// (-16.4,-262.35) @TEXT("D[7:0]",size=1.1,halign="end",valign="middle");
// {&"GNN0" &"GNN1" &"GNN2" &"GNN3" &"GNN4" &"GNN5" &"GNN6" &"GNN7"} @WIRE(mode="straight",linewidth=0.3) {#XREF:17 (16,-255.75)};
// (16.4,-255.75) @TEXT("GNN[7:0]",size=1.1,halign="start",valign="middle");
// {&"GNP0" &"GNP1" &"GNP2" &"GNP3" &"GNP4" &"GNP5" &"GNP6" &"GNP7"} @WIRE(mode="straight",linewidth=0.3) {#XREF:25 (16,-259.05)};
// (16.4,-259.05) @TEXT("GNP[7:0]",size=1.1,halign="start",valign="middle");
// {&"GPN0" &"GPN1" &"GPN2" &"GPN3" &"GPN4" &"GPN5" &"GPN6" &"GPN7"} @WIRE(mode="straight",linewidth=0.3) {#XREF:33 (16,-262.35)};
// (16.4,-262.35) @TEXT("GPN[7:0]",size=1.1,halign="start",valign="middle");
// {&"GPP0" &"GPP1" &"GPP2" &"GPP3" &"GPP4" &"GPP5" &"GPP6" &"GPP7"} @WIRE(mode="straight",linewidth=0.3) {#XREF:41 (16,-265.65)};
// (16.4,-265.65) @TEXT("GPP[7:0]",size=1.1,halign="start",valign="middle");
// &"SAMPLE_INT" @WIRE(mode="straight",linecolor="#30485d",linewidth=0.16) {#XREF:50 (-16,-268.95)};
// (-16.4,-268.95) @TEXT("SAMPLE_INT",size=1.1,halign="end",valign="middle");
// &"VDD!" @WIRE(mode="straight",linecolor="#30485d",linewidth=0.16) {#XREF:51 (0,-247.45)};
// (0,-247.05) @TEXT("VDD!",size=1.1,halign="middle",valign="bottom");
// &"0" @WIRE(mode="straight",linecolor="#30485d",linewidth=0.16) {#XREF:52 (0,-280.55)};
// (0,-280.95) @TEXT("0",size=1.1,halign="middle",valign="top");
// &"RST_DONE" @WIRE(mode="straight",linecolor="#30485d",linewidth=0.16) {#XREF:53 (16,-268.95)};
// (16.4,-268.95) @TEXT("RST_DONE",size=1.1,halign="start",valign="middle");
// &"PRESET" @WIRE(mode="straight",linecolor="#30485d",linewidth=0.16) {#XREF:54 (16,-272.25)};
// (16.4,-272.25) @TEXT("PRESET",size=1.1,halign="start",valign="middle");
// &"CMP_CLK" @WIRE(mode="straight",linecolor="#30485d",linewidth=0.16) {#XCOMP:1 (-16,-293.7)};
// (-16.4,-293.7) @TEXT("CMP_CLK",size=1.1,halign="end",valign="middle");
// &"COMP_N" @WIRE(mode="straight",linecolor="#30485d",linewidth=0.16) {#XCOMP:2 (16,-295.35)};
// (16.4,-295.35) @TEXT("COMP_N",size=1.1,halign="start",valign="middle");
// &"COMP_P" @WIRE(mode="straight",linecolor="#30485d",linewidth=0.16) {#XCOMP:3 (16,-298.65)};
// (16.4,-298.65) @TEXT("COMP_P",size=1.1,halign="start",valign="middle");
// &"VDD!" @WIRE(mode="straight",linecolor="#30485d",linewidth=0.16) {#XCOMP:4 (0,-285.4)};
// (0,-285) @TEXT("VDD!",size=1.1,halign="middle",valign="bottom");
// &"TOPN" @WIRE(mode="straight",linecolor="#30485d",linewidth=0.16) {#XCOMP:5 (-16,-297)};
// (-16.4,-297) @TEXT("TOPN",size=1.1,halign="end",valign="middle");
// &"TOPP" @WIRE(mode="straight",linecolor="#30485d",linewidth=0.16) {#XCOMP:6 (-16,-300.3)};
// (-16.4,-300.3) @TEXT("TOPP",size=1.1,halign="end",valign="middle");
// &"0" @WIRE(mode="straight",linecolor="#30485d",linewidth=0.16) {#XCOMP:7 (0,-308.6)};
// (0,-309) @TEXT("0",size=1.1,halign="middle",valign="top");
// &"COMP_N" @WIRE(mode="straight",linecolor="#30485d",linewidth=0.16) {#CL_COMP_N:1 (90,5)};
// (90,5.4) @TEXT("COMP_N",size=1.1,halign="middle",valign="bottom");
// &"0" @WIRE(mode="straight",linecolor="#30485d",linewidth=0.16) {#CL_COMP_N:2 (90,-5)};
// (90,-5.4) @TEXT("0",size=1.1,halign="middle",valign="top");
// &"COMP_P" @WIRE(mode="straight",linecolor="#30485d",linewidth=0.16) {#CL_COMP_P:1 (90,-28)};
// (90,-27.6) @TEXT("COMP_P",size=1.1,halign="middle",valign="bottom");
// &"0" @WIRE(mode="straight",linecolor="#30485d",linewidth=0.16) {#CL_COMP_P:2 (90,-38)};
// (90,-38.4) @TEXT("0",size=1.1,halign="middle",valign="top");
// &"CMP_CLK" @WIRE(mode="straight",linecolor="#30485d",linewidth=0.16) {#CL_CMP_CLK:1 (90,-61)};
// (90,-60.6) @TEXT("CMP_CLK",size=1.1,halign="middle",valign="bottom");
// &"0" @WIRE(mode="straight",linecolor="#30485d",linewidth=0.16) {#CL_CMP_CLK:2 (90,-71)};
// (90,-71.4) @TEXT("0",size=1.1,halign="middle",valign="top");
// }
// END SARADC RNL
ends tb_sar_top

subckt tb_sar_stalled_top D0 D1 D2 D3 D4 D5 D6 D7 SAMPLE VDD! VINN VINP  VREFN VREFP 0
    XSEQ (SAMPLE_INT VDD! 0 SEQ_SAMPLE) sar8_se_acquire
    XDONE (ACTIVE DONE VDD! 0) INVD1BWP12T30P140
    XPRESET (DONE SEQ_SAMPLE PRESET VDD! 0) OR2D1BWP12T30P140
    XSAMPLE (SAMPLE SAMPLE_INT VDD! 0) CKBD1BWP12T30P140
    XBOOTN (SEQ_SAMPLE TOPN VINN) b_sampler_bridge
    XBOOTP (SEQ_SAMPLE TOPP VINP) b_sampler_bridge
    XCDAC (GNN0 GNN1 GNN2 GNN3 GNN4 GNN5 GNN6 GNN7 GNP0 GNP1 GNP2 GNP3 GNP4 GNP5 GNP6 GNP7 GPN0 GPN1 GPN2 GPN3 GPN4 GPN5 GPN6 GPN7 GPP0 GPP1 GPP2 GPP3 GPP4 GPP5 GPP6 GPP7 TOPN TOPP VDD! VREFN VREFP 0)  b_cdac
    XCTRL (CMP_CLK CODE0 CODE1 CODE2 CODE3 CODE4 CODE5 CODE6 CODE7 COMP_N  COMP_P D0 D1 D2 D3 D4 D5 D6 D7 PHI_U SEQ_SAMPLE VDD! 0 ACTIVE) sar8_se_ctrl
    XREF (CODE0 CODE1 CODE2 CODE3 CODE4 CODE5 CODE6 CODE7 D0 D1 D2 D3 D4 D5 D6 D7 GNN0 GNN1 GNN2 GNN3 GNN4 GNN5 GNN6 GNN7 GNP0 GNP1 GNP2 GNP3 GNP4 GNP5 GNP6 GNP7 GPN0 GPN1 GPN2 GPN3 GPN4 GPN5 GPN6 GPN7 GPP0 GPP1 GPP2 GPP3 GPP4 GPP5 GPP6 GPP7 PHI_U SAMPLE_INT VDD! 0 RST_DONE PRESET)  b_reference
    XCOMP (CMP_CLK COMP_N COMP_P VDD! TOPN TOPP 0) b_comparator force_stuck=1
    CL_COMP_N (COMP_N 0) cfmom_2t nr=8 lr=2.5u w=50n s=50n stm=1 spm=3  multi=2 mismatchflag=1
    CL_COMP_P (COMP_P 0) cfmom_2t nr=8 lr=2.5u w=50n s=50n stm=1 spm=3  multi=2 mismatchflag=1
    CL_CMP_CLK (CMP_CLK 0) cfmom_2t nr=8 lr=2.5u w=50n s=50n stm=1 spm=3  multi=2 mismatchflag=1
// BEGIN SARADC RNL
// @RNL(author="saradc topology") {
// #XSEQ @SET-SYMBOL $S_sar8_se_acquire;
// #XSEQ @PLACE(0,0) => @ORIENT("R0");
// #XDONE @SET-SYMBOL $S_INVD1BWP12T30P140;
// #XDONE @PLACE(0,-33) => @ORIENT("R0");
// #XPRESET @SET-SYMBOL $S_OR2D1BWP12T30P140;
// #XPRESET @PLACE(0,-66) => @ORIENT("R0");
// #XSAMPLE @SET-SYMBOL $S_CKBD1BWP12T30P140;
// #XSAMPLE @PLACE(0,-99) => @ORIENT("R0");
// #XBOOTN @SET-SYMBOL $S_b_sampler_bridge;
// #XBOOTN @PLACE(0,-132) => @ORIENT("R0");
// #XBOOTP @SET-SYMBOL $S_b_sampler_bridge;
// #XBOOTP @PLACE(0,-165) => @ORIENT("R0");
// #XCDAC @SET-SYMBOL $S_b_cdac;
// #XCDAC @PLACE(0,-198) => @ORIENT("R0");
// #XCTRL @SET-SYMBOL $S_sar8_se_ctrl;
// #XCTRL @PLACE(0,-231) => @ORIENT("R0");
// #XREF @SET-SYMBOL $S_b_reference;
// #XREF @PLACE(0,-264) => @ORIENT("R0");
// #XCOMP @SET-SYMBOL $S_b_comparator;
// #XCOMP @PLACE(0,-297) => @ORIENT("R0");
// #CL_COMP_N @SET-SYMBOL $CAPACITOR;
// #CL_COMP_N @PLACE(90,0) => @ORIENT("R0");
// #CL_COMP_N @TEXT("CL_COMP_N",key="name",size=1.3,halign="start") => @PLACE(93,3);
// #CL_COMP_N @TEXT("nr=8 lr=2.5u w=50n multi=2",key="value",size=0.9,halign="start") => @PLACE(93,-4);
// #CL_COMP_N @TEXT("",key="model");
// #CL_COMP_P @SET-SYMBOL $CAPACITOR;
// #CL_COMP_P @PLACE(90,-33) => @ORIENT("R0");
// #CL_COMP_P @TEXT("CL_COMP_P",key="name",size=1.3,halign="start") => @PLACE(93,-30);
// #CL_COMP_P @TEXT("nr=8 lr=2.5u w=50n multi=2",key="value",size=0.9,halign="start") => @PLACE(93,-37);
// #CL_COMP_P @TEXT("",key="model");
// #CL_CMP_CLK @SET-SYMBOL $CAPACITOR;
// #CL_CMP_CLK @PLACE(90,-66) => @ORIENT("R0");
// #CL_CMP_CLK @TEXT("CL_CMP_CLK",key="name",size=1.3,halign="start") => @PLACE(93,-63);
// #CL_CMP_CLK @TEXT("nr=8 lr=2.5u w=50n multi=2",key="value",size=0.9,halign="start") => @PLACE(93,-70);
// #CL_CMP_CLK @TEXT("",key="model");
// &"DONE" @WIRE(mode="straight",linecolor="#30485d",linewidth=0.16) {#XDONE:2 (0,-33) (0,-64.3) #XPRESET:1};
// &"PHI_U" @WIRE(mode="straight",linecolor="#30485d",linewidth=0.16) {#XCTRL:20 (1,-234.3) (1,-265.65) #XREF:49};
// (-89,30) @TEXT("tb_sar_stalled_top / source-derived connections",size=1.4,halign="start",textcolor="#223d52");
// &"SAMPLE_INT" @WIRE(mode="straight",linecolor="#30485d",linewidth=0.16) {#XSEQ:1 (-16,0)};
// (-16.4,0) @TEXT("SAMPLE_INT",size=1.1,halign="end",valign="middle");
// &"VDD!" @WIRE(mode="straight",linecolor="#30485d",linewidth=0.16) {#XSEQ:2 (0,11)};
// (0,11.4) @TEXT("VDD!",size=1.1,halign="middle",valign="bottom");
// &"0" @WIRE(mode="straight",linecolor="#30485d",linewidth=0.16) {#XSEQ:3 (0,-11)};
// (0,-11.4) @TEXT("0",size=1.1,halign="middle",valign="top");
// &"SEQ_SAMPLE" @WIRE(mode="straight",linecolor="#30485d",linewidth=0.16) {#XSEQ:4 (16,0)};
// (16.4,0) @TEXT("SEQ_SAMPLE",size=1.1,halign="start",valign="middle");
// &"ACTIVE" @WIRE(mode="straight",linecolor="#30485d",linewidth=0.16) {#XDONE:1 (-10,-33)};
// (-10.4,-33) @TEXT("ACTIVE",size=1.1,halign="end",valign="middle");
// &"VDD!" @WIRE(mode="straight",linecolor="#30485d",linewidth=0.16) {#XDONE:3 (0,-23)};
// (0,-22.6) @TEXT("VDD!",size=1.1,halign="middle",valign="bottom");
// &"0" @WIRE(mode="straight",linecolor="#30485d",linewidth=0.16) {#XDONE:4 (0,-43)};
// (0,-43.4) @TEXT("0",size=1.1,halign="middle",valign="top");
// &"SEQ_SAMPLE" @WIRE(mode="straight",linecolor="#30485d",linewidth=0.16) {#XPRESET:2 (-10,-67.7)};
// (-10.4,-67.7) @TEXT("SEQ_SAMPLE",size=1.1,halign="end",valign="middle");
// &"PRESET" @WIRE(mode="straight",linecolor="#30485d",linewidth=0.16) {#XPRESET:3 (10,-66)};
// (10.4,-66) @TEXT("PRESET",size=1.1,halign="start",valign="middle");
// &"VDD!" @WIRE(mode="straight",linecolor="#30485d",linewidth=0.16) {#XPRESET:4 (0,-56)};
// (0,-55.6) @TEXT("VDD!",size=1.1,halign="middle",valign="bottom");
// &"0" @WIRE(mode="straight",linecolor="#30485d",linewidth=0.16) {#XPRESET:5 (0,-76)};
// (0,-76.4) @TEXT("0",size=1.1,halign="middle",valign="top");
// &"SAMPLE" @WIRE(mode="straight",linecolor="#30485d",linewidth=0.16) {#XSAMPLE:1 (-16,-99)};
// (-16.4,-99) @TEXT("SAMPLE",size=1.1,halign="end",valign="middle");
// &"SAMPLE_INT" @WIRE(mode="straight",linecolor="#30485d",linewidth=0.16) {#XSAMPLE:2 (16,-99)};
// (16.4,-99) @TEXT("SAMPLE_INT",size=1.1,halign="start",valign="middle");
// &"VDD!" @WIRE(mode="straight",linecolor="#30485d",linewidth=0.16) {#XSAMPLE:3 (0,-88)};
// (0,-87.6) @TEXT("VDD!",size=1.1,halign="middle",valign="bottom");
// &"0" @WIRE(mode="straight",linecolor="#30485d",linewidth=0.16) {#XSAMPLE:4 (0,-110)};
// (0,-110.4) @TEXT("0",size=1.1,halign="middle",valign="top");
// &"SEQ_SAMPLE" @WIRE(mode="straight",linecolor="#30485d",linewidth=0.16) {#XBOOTN:1 (-16,-130.35)};
// (-16.4,-130.35) @TEXT("SEQ_SAMPLE",size=1.1,halign="end",valign="middle");
// &"TOPN" @WIRE(mode="straight",linecolor="#30485d",linewidth=0.16) {#XBOOTN:2 (16,-132)};
// (16.4,-132) @TEXT("TOPN",size=1.1,halign="start",valign="middle");
// &"VINN" @WIRE(mode="straight",linecolor="#30485d",linewidth=0.16) {#XBOOTN:3 (-16,-133.65)};
// (-16.4,-133.65) @TEXT("VINN",size=1.1,halign="end",valign="middle");
// &"SEQ_SAMPLE" @WIRE(mode="straight",linecolor="#30485d",linewidth=0.16) {#XBOOTP:1 (-16,-163.35)};
// (-16.4,-163.35) @TEXT("SEQ_SAMPLE",size=1.1,halign="end",valign="middle");
// &"TOPP" @WIRE(mode="straight",linecolor="#30485d",linewidth=0.16) {#XBOOTP:2 (16,-165)};
// (16.4,-165) @TEXT("TOPP",size=1.1,halign="start",valign="middle");
// &"VINP" @WIRE(mode="straight",linecolor="#30485d",linewidth=0.16) {#XBOOTP:3 (-16,-166.65)};
// (-16.4,-166.65) @TEXT("VINP",size=1.1,halign="end",valign="middle");
// {&"GNN0" &"GNN1" &"GNN2" &"GNN3" &"GNN4" &"GNN5" &"GNN6" &"GNN7"} @WIRE(mode="straight",linewidth=0.3) {#XCDAC:1 (-16,-189.75)};
// (-16.4,-189.75) @TEXT("GNN[7:0]",size=1.1,halign="end",valign="middle");
// {&"GNP0" &"GNP1" &"GNP2" &"GNP3" &"GNP4" &"GNP5" &"GNP6" &"GNP7"} @WIRE(mode="straight",linewidth=0.3) {#XCDAC:9 (-16,-193.05)};
// (-16.4,-193.05) @TEXT("GNP[7:0]",size=1.1,halign="end",valign="middle");
// {&"GPN0" &"GPN1" &"GPN2" &"GPN3" &"GPN4" &"GPN5" &"GPN6" &"GPN7"} @WIRE(mode="straight",linewidth=0.3) {#XCDAC:17 (-16,-196.35)};
// (-16.4,-196.35) @TEXT("GPN[7:0]",size=1.1,halign="end",valign="middle");
// {&"GPP0" &"GPP1" &"GPP2" &"GPP3" &"GPP4" &"GPP5" &"GPP6" &"GPP7"} @WIRE(mode="straight",linewidth=0.3) {#XCDAC:25 (-16,-199.65)};
// (-16.4,-199.65) @TEXT("GPP[7:0]",size=1.1,halign="end",valign="middle");
// &"TOPN" @WIRE(mode="straight",linecolor="#30485d",linewidth=0.16) {#XCDAC:33 (16,-196.35)};
// (16.4,-196.35) @TEXT("TOPN",size=1.1,halign="start",valign="middle");
// &"TOPP" @WIRE(mode="straight",linecolor="#30485d",linewidth=0.16) {#XCDAC:34 (16,-199.65)};
// (16.4,-199.65) @TEXT("TOPP",size=1.1,halign="start",valign="middle");
// &"VDD!" @WIRE(mode="straight",linecolor="#30485d",linewidth=0.16) {#XCDAC:35 (0,-181.45)};
// (0,-181.05) @TEXT("VDD!",size=1.1,halign="middle",valign="bottom");
// &"VREFN" @WIRE(mode="straight",linecolor="#30485d",linewidth=0.16) {#XCDAC:36 (-16,-202.95)};
// (-16.4,-202.95) @TEXT("VREFN",size=1.1,halign="end",valign="middle");
// &"VREFP" @WIRE(mode="straight",linecolor="#30485d",linewidth=0.16) {#XCDAC:37 (-16,-206.25)};
// (-16.4,-206.25) @TEXT("VREFP",size=1.1,halign="end",valign="middle");
// &"0" @WIRE(mode="straight",linecolor="#30485d",linewidth=0.16) {#XCDAC:38 (0,-214.55)};
// (0,-214.95) @TEXT("0",size=1.1,halign="middle",valign="top");
// &"CMP_CLK" @WIRE(mode="straight",linecolor="#30485d",linewidth=0.16) {#XCTRL:1 (-4,-219.4)};
// (-4,-219) @TEXT("CMP_CLK",size=1.1,halign="middle",valign="bottom");
// {&"CODE0" &"CODE1" &"CODE2" &"CODE3" &"CODE4" &"CODE5" &"CODE6" &"CODE7"} @WIRE(mode="straight",linewidth=0.3) {#XCTRL:2 (-4,-242.6)};
// (-4,-243) @TEXT("CODE[7:0]",size=1.1,halign="middle",valign="top");
// &"COMP_N" @WIRE(mode="straight",linecolor="#30485d",linewidth=0.16) {#XCTRL:10 (-18,-231)};
// (-18.4,-231) @TEXT("COMP_N",size=1.1,halign="end",valign="middle");
// &"COMP_P" @WIRE(mode="straight",linecolor="#30485d",linewidth=0.16) {#XCTRL:11 (-18,-227.7)};
// (-18.4,-227.7) @TEXT("COMP_P",size=1.1,halign="end",valign="middle");
// {&"D0" &"D1" &"D2" &"D3" &"D4" &"D5" &"D6" &"D7"} @WIRE(mode="straight",linewidth=0.3) {#XCTRL:12 (18,-227.7)};
// (18.4,-227.7) @TEXT("D[7:0]",size=1.1,halign="start",valign="middle");
// &"SEQ_SAMPLE" @WIRE(mode="straight",linecolor="#30485d",linewidth=0.16) {#XCTRL:21 (-18,-234.3)};
// (-18.4,-234.3) @TEXT("SEQ_SAMPLE",size=1.1,halign="end",valign="middle");
// &"VDD!" @WIRE(mode="straight",linecolor="#30485d",linewidth=0.16) {#XCTRL:22 (4,-219.4)};
// (4,-219) @TEXT("VDD!",size=1.1,halign="middle",valign="bottom");
// &"0" @WIRE(mode="straight",linecolor="#30485d",linewidth=0.16) {#XCTRL:23 (4,-242.6)};
// (4,-243) @TEXT("0",size=1.1,halign="middle",valign="top");
// &"ACTIVE" @WIRE(mode="straight",linecolor="#30485d",linewidth=0.16) {#XCTRL:24 (18,-231)};
// (18.4,-231) @TEXT("ACTIVE",size=1.1,halign="start",valign="middle");
// {&"CODE0" &"CODE1" &"CODE2" &"CODE3" &"CODE4" &"CODE5" &"CODE6" &"CODE7"} @WIRE(mode="straight",linewidth=0.3) {#XREF:1 (-16,-259.05)};
// (-16.4,-259.05) @TEXT("CODE[7:0]",size=1.1,halign="end",valign="middle");
// {&"D0" &"D1" &"D2" &"D3" &"D4" &"D5" &"D6" &"D7"} @WIRE(mode="straight",linewidth=0.3) {#XREF:9 (-16,-262.35)};
// (-16.4,-262.35) @TEXT("D[7:0]",size=1.1,halign="end",valign="middle");
// {&"GNN0" &"GNN1" &"GNN2" &"GNN3" &"GNN4" &"GNN5" &"GNN6" &"GNN7"} @WIRE(mode="straight",linewidth=0.3) {#XREF:17 (16,-255.75)};
// (16.4,-255.75) @TEXT("GNN[7:0]",size=1.1,halign="start",valign="middle");
// {&"GNP0" &"GNP1" &"GNP2" &"GNP3" &"GNP4" &"GNP5" &"GNP6" &"GNP7"} @WIRE(mode="straight",linewidth=0.3) {#XREF:25 (16,-259.05)};
// (16.4,-259.05) @TEXT("GNP[7:0]",size=1.1,halign="start",valign="middle");
// {&"GPN0" &"GPN1" &"GPN2" &"GPN3" &"GPN4" &"GPN5" &"GPN6" &"GPN7"} @WIRE(mode="straight",linewidth=0.3) {#XREF:33 (16,-262.35)};
// (16.4,-262.35) @TEXT("GPN[7:0]",size=1.1,halign="start",valign="middle");
// {&"GPP0" &"GPP1" &"GPP2" &"GPP3" &"GPP4" &"GPP5" &"GPP6" &"GPP7"} @WIRE(mode="straight",linewidth=0.3) {#XREF:41 (16,-265.65)};
// (16.4,-265.65) @TEXT("GPP[7:0]",size=1.1,halign="start",valign="middle");
// &"SAMPLE_INT" @WIRE(mode="straight",linecolor="#30485d",linewidth=0.16) {#XREF:50 (-16,-268.95)};
// (-16.4,-268.95) @TEXT("SAMPLE_INT",size=1.1,halign="end",valign="middle");
// &"VDD!" @WIRE(mode="straight",linecolor="#30485d",linewidth=0.16) {#XREF:51 (0,-247.45)};
// (0,-247.05) @TEXT("VDD!",size=1.1,halign="middle",valign="bottom");
// &"0" @WIRE(mode="straight",linecolor="#30485d",linewidth=0.16) {#XREF:52 (0,-280.55)};
// (0,-280.95) @TEXT("0",size=1.1,halign="middle",valign="top");
// &"RST_DONE" @WIRE(mode="straight",linecolor="#30485d",linewidth=0.16) {#XREF:53 (16,-268.95)};
// (16.4,-268.95) @TEXT("RST_DONE",size=1.1,halign="start",valign="middle");
// &"PRESET" @WIRE(mode="straight",linecolor="#30485d",linewidth=0.16) {#XREF:54 (16,-272.25)};
// (16.4,-272.25) @TEXT("PRESET",size=1.1,halign="start",valign="middle");
// &"CMP_CLK" @WIRE(mode="straight",linecolor="#30485d",linewidth=0.16) {#XCOMP:1 (-16,-293.7)};
// (-16.4,-293.7) @TEXT("CMP_CLK",size=1.1,halign="end",valign="middle");
// &"COMP_N" @WIRE(mode="straight",linecolor="#30485d",linewidth=0.16) {#XCOMP:2 (16,-295.35)};
// (16.4,-295.35) @TEXT("COMP_N",size=1.1,halign="start",valign="middle");
// &"COMP_P" @WIRE(mode="straight",linecolor="#30485d",linewidth=0.16) {#XCOMP:3 (16,-298.65)};
// (16.4,-298.65) @TEXT("COMP_P",size=1.1,halign="start",valign="middle");
// &"VDD!" @WIRE(mode="straight",linecolor="#30485d",linewidth=0.16) {#XCOMP:4 (0,-285.4)};
// (0,-285) @TEXT("VDD!",size=1.1,halign="middle",valign="bottom");
// &"TOPN" @WIRE(mode="straight",linecolor="#30485d",linewidth=0.16) {#XCOMP:5 (-16,-297)};
// (-16.4,-297) @TEXT("TOPN",size=1.1,halign="end",valign="middle");
// &"TOPP" @WIRE(mode="straight",linecolor="#30485d",linewidth=0.16) {#XCOMP:6 (-16,-300.3)};
// (-16.4,-300.3) @TEXT("TOPP",size=1.1,halign="end",valign="middle");
// &"0" @WIRE(mode="straight",linecolor="#30485d",linewidth=0.16) {#XCOMP:7 (0,-308.6)};
// (0,-309) @TEXT("0",size=1.1,halign="middle",valign="top");
// &"COMP_N" @WIRE(mode="straight",linecolor="#30485d",linewidth=0.16) {#CL_COMP_N:1 (90,5)};
// (90,5.4) @TEXT("COMP_N",size=1.1,halign="middle",valign="bottom");
// &"0" @WIRE(mode="straight",linecolor="#30485d",linewidth=0.16) {#CL_COMP_N:2 (90,-5)};
// (90,-5.4) @TEXT("0",size=1.1,halign="middle",valign="top");
// &"COMP_P" @WIRE(mode="straight",linecolor="#30485d",linewidth=0.16) {#CL_COMP_P:1 (90,-28)};
// (90,-27.6) @TEXT("COMP_P",size=1.1,halign="middle",valign="bottom");
// &"0" @WIRE(mode="straight",linecolor="#30485d",linewidth=0.16) {#CL_COMP_P:2 (90,-38)};
// (90,-38.4) @TEXT("0",size=1.1,halign="middle",valign="top");
// &"CMP_CLK" @WIRE(mode="straight",linecolor="#30485d",linewidth=0.16) {#CL_CMP_CLK:1 (90,-61)};
// (90,-60.6) @TEXT("CMP_CLK",size=1.1,halign="middle",valign="bottom");
// &"0" @WIRE(mode="straight",linecolor="#30485d",linewidth=0.16) {#CL_CMP_CLK:2 (90,-71)};
// (90,-71.4) @TEXT("0",size=1.1,halign="middle",valign="top");
// }
// END SARADC RNL
ends tb_sar_stalled_top

subckt INVD1BWP12T30P140 A Y VDD VSS
// BEGIN SARADC RNL
// @RNL(author="saradc topology") {
// (-89,30) @TEXT("INVD1BWP12T30P140 / source-derived connections",size=1.4,halign="start",textcolor="#223d52");
// (-20,5) @TEXT("Interface view only - no transistor body is distributed here.",size=1.2,halign="start",textcolor="#223d52");
// (-20,-2) @TEXT("Ports: A, Y, VDD, VSS",size=0.9,halign="start",textcolor="#223d52");
// }
// END SARADC RNL
ends INVD1BWP12T30P140

subckt INVD2BWP12T30P140 I ZN VDD VSS
// BEGIN SARADC RNL
// @RNL(author="saradc topology") {
// (-89,30) @TEXT("INVD2BWP12T30P140 / source-derived connections",size=1.4,halign="start",textcolor="#223d52");
// (-20,5) @TEXT("Interface view only - no transistor body is distributed here.",size=1.2,halign="start",textcolor="#223d52");
// (-20,-2) @TEXT("Ports: I, ZN, VDD, VSS",size=0.9,halign="start",textcolor="#223d52");
// }
// END SARADC RNL
ends INVD2BWP12T30P140

subckt OR2D1BWP12T30P140 A1 A2 Z VDD VSS
// BEGIN SARADC RNL
// @RNL(author="saradc topology") {
// (-89,30) @TEXT("OR2D1BWP12T30P140 / source-derived connections",size=1.4,halign="start",textcolor="#223d52");
// (-20,5) @TEXT("Interface view only - no transistor body is distributed here.",size=1.2,halign="start",textcolor="#223d52");
// (-20,-2) @TEXT("Ports: A1, A2, Z, VDD, VSS",size=0.9,halign="start",textcolor="#223d52");
// }
// END SARADC RNL
ends OR2D1BWP12T30P140

subckt ND2D1BWP12T30P140 A B Y VDD VSS
// BEGIN SARADC RNL
// @RNL(author="saradc topology") {
// (-89,30) @TEXT("ND2D1BWP12T30P140 / source-derived connections",size=1.4,halign="start",textcolor="#223d52");
// (-20,5) @TEXT("Interface view only - no transistor body is distributed here.",size=1.2,halign="start",textcolor="#223d52");
// (-20,-2) @TEXT("Ports: A, B, Y, VDD, VSS",size=0.9,halign="start",textcolor="#223d52");
// }
// END SARADC RNL
ends ND2D1BWP12T30P140

subckt DFCNQD1BWP12T30P140 D CK RN Q VDD VSS
// BEGIN SARADC RNL
// @RNL(author="saradc topology") {
// (-89,30) @TEXT("DFCNQD1BWP12T30P140 / source-derived connections",size=1.4,halign="start",textcolor="#223d52");
// (-20,5) @TEXT("Interface view only - no transistor body is distributed here.",size=1.2,halign="start",textcolor="#223d52");
// (-20,-2) @TEXT("Ports: D, CK, RN, Q, VDD, VSS",size=0.9,halign="start",textcolor="#223d52");
// }
// END SARADC RNL
ends DFCNQD1BWP12T30P140

subckt AN2D1BWP12T30P140 A1 A2 Z VDD VSS
// BEGIN SARADC RNL
// @RNL(author="saradc topology") {
// (-89,30) @TEXT("AN2D1BWP12T30P140 / source-derived connections",size=1.4,halign="start",textcolor="#223d52");
// (-20,5) @TEXT("Interface view only - no transistor body is distributed here.",size=1.2,halign="start",textcolor="#223d52");
// (-20,-2) @TEXT("Ports: A1, A2, Z, VDD, VSS",size=0.9,halign="start",textcolor="#223d52");
// }
// END SARADC RNL
ends AN2D1BWP12T30P140

subckt XOR2D1BWP12T30P140 A1 A2 Z VDD VSS
// BEGIN SARADC RNL
// @RNL(author="saradc topology") {
// (-89,30) @TEXT("XOR2D1BWP12T30P140 / source-derived connections",size=1.4,halign="start",textcolor="#223d52");
// (-20,5) @TEXT("Interface view only - no transistor body is distributed here.",size=1.2,halign="start",textcolor="#223d52");
// (-20,-2) @TEXT("Ports: A1, A2, Z, VDD, VSS",size=0.9,halign="start",textcolor="#223d52");
// }
// END SARADC RNL
ends XOR2D1BWP12T30P140

subckt MUX2D1BWP12T30P140 I0 I1 S Z VDD VSS
// BEGIN SARADC RNL
// @RNL(author="saradc topology") {
// (-89,30) @TEXT("MUX2D1BWP12T30P140 / source-derived connections",size=1.4,halign="start",textcolor="#223d52");
// (-20,5) @TEXT("Interface view only - no transistor body is distributed here.",size=1.2,halign="start",textcolor="#223d52");
// (-20,-2) @TEXT("Ports: I0, I1, S, Z, VDD, VSS",size=0.9,halign="start",textcolor="#223d52");
// }
// END SARADC RNL
ends MUX2D1BWP12T30P140

subckt BUFFD1BWP12T30P140 I Z VDD VSS
// BEGIN SARADC RNL
// @RNL(author="saradc topology") {
// (-89,30) @TEXT("BUFFD1BWP12T30P140 / source-derived connections",size=1.4,halign="start",textcolor="#223d52");
// (-20,5) @TEXT("Interface view only - no transistor body is distributed here.",size=1.2,halign="start",textcolor="#223d52");
// (-20,-2) @TEXT("Ports: I, Z, VDD, VSS",size=0.9,halign="start",textcolor="#223d52");
// }
// END SARADC RNL
ends BUFFD1BWP12T30P140

subckt BUFFD2BWP12T30P140 I Z VDD VSS
// BEGIN SARADC RNL
// @RNL(author="saradc topology") {
// (-89,30) @TEXT("BUFFD2BWP12T30P140 / source-derived connections",size=1.4,halign="start",textcolor="#223d52");
// (-20,5) @TEXT("Interface view only - no transistor body is distributed here.",size=1.2,halign="start",textcolor="#223d52");
// (-20,-2) @TEXT("Ports: I, Z, VDD, VSS",size=0.9,halign="start",textcolor="#223d52");
// }
// END SARADC RNL
ends BUFFD2BWP12T30P140

subckt CKBD1BWP12T30P140 I Z VDD VSS
// BEGIN SARADC RNL
// @RNL(author="saradc topology") {
// (-89,30) @TEXT("CKBD1BWP12T30P140 / source-derived connections",size=1.4,halign="start",textcolor="#223d52");
// (-20,5) @TEXT("Interface view only - no transistor body is distributed here.",size=1.2,halign="start",textcolor="#223d52");
// (-20,-2) @TEXT("Ports: I, Z, VDD, VSS",size=0.9,halign="start",textcolor="#223d52");
// }
// END SARADC RNL
ends CKBD1BWP12T30P140

subckt LHCNDQD1BWP12T30P140 D E CDN Q VDD VSS
// BEGIN SARADC RNL
// @RNL(author="saradc topology") {
// (-89,30) @TEXT("LHCNDQD1BWP12T30P140 / source-derived connections",size=1.4,halign="start",textcolor="#223d52");
// (-20,5) @TEXT("Interface view only - no transistor body is distributed here.",size=1.2,halign="start",textcolor="#223d52");
// (-20,-2) @TEXT("Ports: D, E, CDN, Q, VDD, VSS",size=0.9,halign="start",textcolor="#223d52");
// }
// END SARADC RNL
ends LHCNDQD1BWP12T30P140

subckt TIEHBWP12T30P140 Z VDD VSS
// BEGIN SARADC RNL
// @RNL(author="saradc topology") {
// (-89,30) @TEXT("TIEHBWP12T30P140 / source-derived connections",size=1.4,halign="start",textcolor="#223d52");
// (-20,5) @TEXT("Interface view only - no transistor body is distributed here.",size=1.2,halign="start",textcolor="#223d52");
// (-20,-2) @TEXT("Ports: Z, VDD, VSS",size=0.9,halign="start",textcolor="#223d52");
// }
// END SARADC RNL
ends TIEHBWP12T30P140

subckt iprobe p n
// BEGIN SARADC RNL
// @RNL(author="saradc topology") {
// (-89,30) @TEXT("iprobe / source-derived connections",size=1.4,halign="start",textcolor="#223d52");
// (-20,5) @TEXT("Interface view only - no transistor body is distributed here.",size=1.2,halign="start",textcolor="#223d52");
// (-20,-2) @TEXT("Ports: p, n",size=0.9,halign="start",textcolor="#223d52");
// }
// END SARADC RNL
ends iprobe

subckt DEL025D1BWP12T30P140 I Z VDD VSS
// BEGIN SARADC RNL
// @RNL(author="saradc topology") {
// (-89,30) @TEXT("DEL025D1BWP12T30P140 / source-derived connections",size=1.4,halign="start",textcolor="#223d52");
// (-20,5) @TEXT("Interface view only - no transistor body is distributed here.",size=1.2,halign="start",textcolor="#223d52");
// (-20,-2) @TEXT("Ports: I, Z, VDD, VSS",size=0.9,halign="start",textcolor="#223d52");
// }
// END SARADC RNL
ends DEL025D1BWP12T30P140

subckt DEL050D1BWP12T30P140 I Z VDD VSS
// BEGIN SARADC RNL
// @RNL(author="saradc topology") {
// (-89,30) @TEXT("DEL050D1BWP12T30P140 / source-derived connections",size=1.4,halign="start",textcolor="#223d52");
// (-20,5) @TEXT("Interface view only - no transistor body is distributed here.",size=1.2,halign="start",textcolor="#223d52");
// (-20,-2) @TEXT("Ports: I, Z, VDD, VSS",size=0.9,halign="start",textcolor="#223d52");
// }
// END SARADC RNL
ends DEL050D1BWP12T30P140

subckt DEL075D1BWP12T30P140 I Z VDD VSS
// BEGIN SARADC RNL
// @RNL(author="saradc topology") {
// (-89,30) @TEXT("DEL075D1BWP12T30P140 / source-derived connections",size=1.4,halign="start",textcolor="#223d52");
// (-20,5) @TEXT("Interface view only - no transistor body is distributed here.",size=1.2,halign="start",textcolor="#223d52");
// (-20,-2) @TEXT("Ports: I, Z, VDD, VSS",size=0.9,halign="start",textcolor="#223d52");
// }
// END SARADC RNL
ends DEL075D1BWP12T30P140

subckt DEL100D1BWP12T30P140 I Z VDD VSS
// BEGIN SARADC RNL
// @RNL(author="saradc topology") {
// (-89,30) @TEXT("DEL100D1BWP12T30P140 / source-derived connections",size=1.4,halign="start",textcolor="#223d52");
// (-20,5) @TEXT("Interface view only - no transistor body is distributed here.",size=1.2,halign="start",textcolor="#223d52");
// (-20,-2) @TEXT("Ports: I, Z, VDD, VSS",size=0.9,halign="start",textcolor="#223d52");
// }
// END SARADC RNL
ends DEL100D1BWP12T30P140

subckt DEL150D1BWP12T30P140 I Z VDD VSS
// BEGIN SARADC RNL
// @RNL(author="saradc topology") {
// (-89,30) @TEXT("DEL150D1BWP12T30P140 / source-derived connections",size=1.4,halign="start",textcolor="#223d52");
// (-20,5) @TEXT("Interface view only - no transistor body is distributed here.",size=1.2,halign="start",textcolor="#223d52");
// (-20,-2) @TEXT("Ports: I, Z, VDD, VSS",size=0.9,halign="start",textcolor="#223d52");
// }
// END SARADC RNL
ends DEL150D1BWP12T30P140

subckt DEL200D1BWP12T30P140 I Z VDD VSS
// BEGIN SARADC RNL
// @RNL(author="saradc topology") {
// (-89,30) @TEXT("DEL200D1BWP12T30P140 / source-derived connections",size=1.4,halign="start",textcolor="#223d52");
// (-20,5) @TEXT("Interface view only - no transistor body is distributed here.",size=1.2,halign="start",textcolor="#223d52");
// (-20,-2) @TEXT("Ports: I, Z, VDD, VSS",size=0.9,halign="start",textcolor="#223d52");
// }
// END SARADC RNL
ends DEL200D1BWP12T30P140

subckt DEL250D1BWP12T30P140 I Z VDD VSS
// BEGIN SARADC RNL
// @RNL(author="saradc topology") {
// (-89,30) @TEXT("DEL250D1BWP12T30P140 / source-derived connections",size=1.4,halign="start",textcolor="#223d52");
// (-20,5) @TEXT("Interface view only - no transistor body is distributed here.",size=1.2,halign="start",textcolor="#223d52");
// (-20,-2) @TEXT("Ports: I, Z, VDD, VSS",size=0.9,halign="start",textcolor="#223d52");
// }
// END SARADC RNL
ends DEL250D1BWP12T30P140

subckt b_cdac GNN0 GNN1 GNN2 GNN3 GNN4 GNN5 GNN6 GNN7 GNP0 GNP1 GNP2 GNP3 GNP4 GNP5 GNP6 GNP7 GPN0 GPN1 GPN2 GPN3 GPN4 GPN5 GPN6 GPN7 GPP0 GPP1 GPP2 GPP3 GPP4 GPP5 GPP6 GPP7 TOPN TOPP VDD VREFN VREFP VSS
// BEGIN SARADC RNL
// @RNL(author="saradc topology") {
// (-89,30) @TEXT("b_cdac / source-derived connections",size=1.4,halign="start",textcolor="#223d52");
// (-20,5) @TEXT("Interface view only - no transistor body is distributed here.",size=1.2,halign="start",textcolor="#223d52");
// (-20,-2) @TEXT("Ports: GNN0, GNN1, GNN2, GNN3, GNN4, GNN5, GNN6, GNN7, GNP0, GNP1, GNP2, GNP3, GNP4, GNP5, GNP6, GNP7, GPN0, GPN1, GPN2, GPN3, GPN4, GPN5, GPN6, GPN7, GPP0, GPP1, GPP2, GPP3, GPP4, GPP5, GPP6, GPP7, TOPN, TOPP, VDD, VREFN, VREFP, VSS",size=0.9,halign="start",textcolor="#223d52");
// }
// END SARADC RNL
ends b_cdac

subckt b_cdac_bit GNN GNP GPN GPP TOPN TOPP VREFN VREFP VDD VSS
// BEGIN SARADC RNL
// @RNL(author="saradc topology") {
// (-89,30) @TEXT("b_cdac_bit / source-derived connections",size=1.4,halign="start",textcolor="#223d52");
// (-20,5) @TEXT("Interface view only - no transistor body is distributed here.",size=1.2,halign="start",textcolor="#223d52");
// (-20,-2) @TEXT("Ports: GNN, GNP, GPN, GPP, TOPN, TOPP, VREFN, VREFP, VDD, VSS",size=0.9,halign="start",textcolor="#223d52");
// }
// END SARADC RNL
ends b_cdac_bit

subckt b_comparator CLK OUTN OUTP VDD VINN VINP VSS
// BEGIN SARADC RNL
// @RNL(author="saradc topology") {
// (-89,30) @TEXT("b_comparator / source-derived connections",size=1.4,halign="start",textcolor="#223d52");
// (-20,5) @TEXT("Interface view only - no transistor body is distributed here.",size=1.2,halign="start",textcolor="#223d52");
// (-20,-2) @TEXT("Ports: CLK, OUTN, OUTP, VDD, VINN, VINP, VSS",size=0.9,halign="start",textcolor="#223d52");
// }
// END SARADC RNL
ends b_comparator

subckt b_reference CODE0 CODE1 CODE2 CODE3 CODE4 CODE5 CODE6 CODE7 D0 D1 D2 D3 D4 D5 D6 D7 GNN0 GNN1 GNN2 GNN3 GNN4 GNN5 GNN6 GNN7 GNP0 GNP1 GNP2 GNP3 GNP4 GNP5 GNP6 GNP7 GPN0 GPN1 GPN2 GPN3 GPN4 GPN5 GPN6 GPN7 GPP0 GPP1 GPP2 GPP3 GPP4 GPP5 GPP6 GPP7 PHI_U SAMPLE VDD VSS RST_DONE PRESET
// BEGIN SARADC RNL
// @RNL(author="saradc topology") {
// (-89,30) @TEXT("b_reference / source-derived connections",size=1.4,halign="start",textcolor="#223d52");
// (-20,5) @TEXT("Interface view only - no transistor body is distributed here.",size=1.2,halign="start",textcolor="#223d52");
// (-20,-2) @TEXT("Ports: CODE0, CODE1, CODE2, CODE3, CODE4, CODE5, CODE6, CODE7, D0, D1, D2, D3, D4, D5, D6, D7, GNN0, GNN1, GNN2, GNN3, GNN4, GNN5, GNN6, GNN7, GNP0, GNP1, GNP2, GNP3, GNP4, GNP5, GNP6, GNP7, GPN0, GPN1, GPN2, GPN3, GPN4, GPN5, GPN6, GPN7, GPP0, GPP1, GPP2, GPP3, GPP4, GPP5, GPP6, GPP7, PHI_U, SAMPLE, VDD, VSS, RST_DONE, PRESET",size=0.9,halign="start",textcolor="#223d52");
// }
// END SARADC RNL
ends b_reference

subckt b_edge A VDD VSS Y
// BEGIN SARADC RNL
// @RNL(author="saradc topology") {
// (-89,30) @TEXT("b_edge / source-derived connections",size=1.4,halign="start",textcolor="#223d52");
// (-20,5) @TEXT("Interface view only - no transistor body is distributed here.",size=1.2,halign="start",textcolor="#223d52");
// (-20,-2) @TEXT("Ports: A, VDD, VSS, Y",size=0.9,halign="start",textcolor="#223d52");
// }
// END SARADC RNL
ends b_edge

subckt b_idle ACTIVE SAMPLE VDD VSS PRESET SAMPLE_MATCH
// BEGIN SARADC RNL
// @RNL(author="saradc topology") {
// (-89,30) @TEXT("b_idle / source-derived connections",size=1.4,halign="start",textcolor="#223d52");
// (-20,5) @TEXT("Interface view only - no transistor body is distributed here.",size=1.2,halign="start",textcolor="#223d52");
// (-20,-2) @TEXT("Ports: ACTIVE, SAMPLE, VDD, VSS, PRESET, SAMPLE_MATCH",size=0.9,halign="start",textcolor="#223d52");
// }
// END SARADC RNL
ends b_idle

subckt b_sampler CLKS VOUT VIN VDD VSS
// BEGIN SARADC RNL
// @RNL(author="saradc topology") {
// (-89,30) @TEXT("b_sampler / source-derived connections",size=1.4,halign="start",textcolor="#223d52");
// (-20,5) @TEXT("Interface view only - no transistor body is distributed here.",size=1.2,halign="start",textcolor="#223d52");
// (-20,-2) @TEXT("Ports: CLKS, VOUT, VIN, VDD, VSS",size=0.9,halign="start",textcolor="#223d52");
// }
// END SARADC RNL
ends b_sampler

subckt b_sar CMP_CLK CODE0 CODE1 CODE2 CODE3 CODE4 CODE5 CODE6 CODE7 COMP_N COMP_P D0 D1 D2 D3 D4 D5 D6 D7 PHI_U SAMPLE VDD VSS ACTIVE
// BEGIN SARADC RNL
// @RNL(author="saradc topology") {
// (-89,30) @TEXT("b_sar / source-derived connections",size=1.4,halign="start",textcolor="#223d52");
// (-20,5) @TEXT("Interface view only - no transistor body is distributed here.",size=1.2,halign="start",textcolor="#223d52");
// (-20,-2) @TEXT("Ports: CMP_CLK, CODE0, CODE1, CODE2, CODE3, CODE4, CODE5, CODE6, CODE7, COMP_N, COMP_P, D0, D1, D2, D3, D4, D5, D6, D7, PHI_U, SAMPLE, VDD, VSS, ACTIVE",size=0.9,halign="start",textcolor="#223d52");
// }
// END SARADC RNL
ends b_sar

subckt sar_adc_b D0 D1 D2 D3 D4 D5 D6 D7 SAMPLE VDD VINN VINP VREFN VREFP VSS
// BEGIN SARADC RNL
// @RNL(author="saradc topology") {
// (-89,30) @TEXT("sar_adc_b / source-derived connections",size=1.4,halign="start",textcolor="#223d52");
// (-20,5) @TEXT("Interface view only - no transistor body is distributed here.",size=1.2,halign="start",textcolor="#223d52");
// (-20,-2) @TEXT("Ports: D0, D1, D2, D3, D4, D5, D6, D7, SAMPLE, VDD, VINN, VINP, VREFN, VREFP, VSS",size=0.9,halign="start",textcolor="#223d52");
// }
// END SARADC RNL
ends sar_adc_b

subckt b_delay A VDD VSS Y
// BEGIN SARADC RNL
// @RNL(author="saradc topology") {
// (-89,30) @TEXT("b_delay / source-derived connections",size=1.4,halign="start",textcolor="#223d52");
// (-20,5) @TEXT("Interface view only - no transistor body is distributed here.",size=1.2,halign="start",textcolor="#223d52");
// (-20,-2) @TEXT("Ports: A, VDD, VSS, Y",size=0.9,halign="start",textcolor="#223d52");
// }
// END SARADC RNL
ends b_delay

subckt b_behavior_observer D0 D1 D2 D3 D4 D5 D6 D7 SAMPLE VDD VSS
// BEGIN SARADC RNL
// @RNL(author="saradc topology") {
// (-89,30) @TEXT("b_behavior_observer / source-derived connections",size=1.4,halign="start",textcolor="#223d52");
// (-20,5) @TEXT("Interface view only - no transistor body is distributed here.",size=1.2,halign="start",textcolor="#223d52");
// (-20,-2) @TEXT("Ports: D0, D1, D2, D3, D4, D5, D6, D7, SAMPLE, VDD, VSS",size=0.9,halign="start",textcolor="#223d52");
// }
// END SARADC RNL
ends b_behavior_observer

subckt b_tb_switch A B EN VDD VSS
// BEGIN SARADC RNL
// @RNL(author="saradc topology") {
// (-89,30) @TEXT("b_tb_switch / source-derived connections",size=1.4,halign="start",textcolor="#223d52");
// (-20,5) @TEXT("Interface view only - no transistor body is distributed here.",size=1.2,halign="start",textcolor="#223d52");
// (-20,-2) @TEXT("Ports: A, B, EN, VDD, VSS",size=0.9,halign="start",textcolor="#223d52");
// }
// END SARADC RNL
ends b_tb_switch

subckt b_sampler_bridge CLKS VOUT Vin
// BEGIN SARADC RNL
// @RNL(author="saradc topology") {
// (-89,30) @TEXT("b_sampler_bridge / source-derived connections",size=1.4,halign="start",textcolor="#223d52");
// (-20,5) @TEXT("Interface view only - no transistor body is distributed here.",size=1.2,halign="start",textcolor="#223d52");
// (-20,-2) @TEXT("Ports: CLKS, VOUT, Vin",size=0.9,halign="start",textcolor="#223d52");
// }
// END SARADC RNL
ends b_sampler_bridge
