// Display-only drawings for unannotated native files, fixtures and external interfaces.

// BEGIN SARADC RNL
// @RNL(type="header") { @VERSION("0.3");
// @USE-PACKAGE(name="sar8",version="0.1",path="sar8.rnl");
// @USE-PACKAGE(name="rnl-std-fill") {}; }
// END SARADC RNL

simulator lang=spectre

subckt sar8p_delay_valid A VDD VSS Y
XD1 (A D1 VDD VSS) DEL200D1BWP12T30P140
XQUAL1 (A D1 VDD VSS Y) sar8p_and2
// BEGIN SARADC RNL
// @RNL(author="saradc topology") {
// #XD1 @SET-SYMBOL $S_DEL200D1BWP12T30P140;
// #XD1 @PLACE(0,0) => @ORIENT("R0");
// #XQUAL1 @SET-SYMBOL $S_sar8p_and2;
// #XQUAL1 @PLACE(0,-33) => @ORIENT("R0");
// &"A" @WIRE(mode="straight",linecolor="#30485d",linewidth=0.16) {#XD1:1 (-10,1.65) (-10,-31.3) #XQUAL1:1};
// &"D1" @WIRE(mode="straight",linecolor="#30485d",linewidth=0.16) {#XD1:2 (-10,-1.65) (-10,-34.7) #XQUAL1:2};
// (-89,30) @TEXT("sar8p_delay_valid / source-derived connections",size=1.4,halign="start",textcolor="#223d52");
// &"VDD" @WIRE(mode="straight",linecolor="#30485d",linewidth=0.16) {#XD1:3 (0,11)};
// (0,11.4) @TEXT("VDD",size=1.1,halign="middle",valign="bottom");
// &"VSS" @WIRE(mode="straight",linecolor="#30485d",linewidth=0.16) {#XD1:4 (0,-11)};
// (0,-11.4) @TEXT("VSS",size=1.1,halign="middle",valign="top");
// &"VDD" @WIRE(mode="straight",linecolor="#30485d",linewidth=0.16) {#XQUAL1:3 (0,-23)};
// (0,-22.6) @TEXT("VDD",size=1.1,halign="middle",valign="bottom");
// &"VSS" @WIRE(mode="straight",linecolor="#30485d",linewidth=0.16) {#XQUAL1:4 (0,-43)};
// (0,-43.4) @TEXT("VSS",size=1.1,halign="middle",valign="top");
// &"Y" @WIRE(mode="straight",linecolor="#30485d",linewidth=0.16) {#XQUAL1:5 (10,-33)};
// (10.4,-33) @TEXT("Y",size=1.1,halign="start",valign="middle");
// }
// END SARADC RNL
ends sar8p_delay_valid

subckt sar8p_delay_write A VDD VSS Y
XD1 (A D1 VDD VSS) DEL250D1BWP12T30P140
XD2 (D1 D2 VDD VSS) DEL250D1BWP12T30P140
XQUAL2 (A D2 VDD VSS Q2) sar8p_and2
XD3 (Q2 D3 VDD VSS) DEL075D1BWP12T30P140
XQUAL3 (A D3 VDD VSS Y) sar8p_and2
// BEGIN SARADC RNL
// @RNL(author="saradc topology") {
// #XD1 @SET-SYMBOL $S_DEL250D1BWP12T30P140;
// #XD1 @PLACE(0,0) => @ORIENT("R0");
// #XD2 @SET-SYMBOL $S_DEL250D1BWP12T30P140;
// #XD2 @PLACE(0,-33) => @ORIENT("R0");
// #XQUAL2 @SET-SYMBOL $S_sar8p_and2;
// #XQUAL2 @PLACE(0,-66) => @ORIENT("R0");
// #XD3 @SET-SYMBOL $S_DEL075D1BWP12T30P140;
// #XD3 @PLACE(0,-99) => @ORIENT("R0");
// #XQUAL3 @SET-SYMBOL $S_sar8p_and2;
// #XQUAL3 @PLACE(0,-132) => @ORIENT("R0");
// &"D1" @WIRE(mode="straight",linecolor="#30485d",linewidth=0.16) {#XD1:2 (-13,-1.65) (-13,-31.35) #XD2:1};
// &"D2" @WIRE(mode="straight",linecolor="#30485d",linewidth=0.16) {#XD2:2 (-10,-34.65) (-10,-67.7) #XQUAL2:2};
// &"Q2" @WIRE(mode="straight",linecolor="#30485d",linewidth=0.16) {#XQUAL2:5 (-3,-66) (-3,-97.35) #XD3:1};
// &"D3" @WIRE(mode="straight",linecolor="#30485d",linewidth=0.16) {#XD3:2 (-10,-100.65) (-10,-133.7) #XQUAL3:2};
// (-89,30) @TEXT("sar8p_delay_write / source-derived connections",size=1.4,halign="start",textcolor="#223d52");
// &"A" @WIRE(mode="straight",linecolor="#30485d",linewidth=0.16) {#XD1:1 (-16,1.65)};
// (-16.4,1.65) @TEXT("A",size=1.1,halign="end",valign="middle");
// &"VDD" @WIRE(mode="straight",linecolor="#30485d",linewidth=0.16) {#XD1:3 (0,11)};
// (0,11.4) @TEXT("VDD",size=1.1,halign="middle",valign="bottom");
// &"VSS" @WIRE(mode="straight",linecolor="#30485d",linewidth=0.16) {#XD1:4 (0,-11)};
// (0,-11.4) @TEXT("VSS",size=1.1,halign="middle",valign="top");
// &"VDD" @WIRE(mode="straight",linecolor="#30485d",linewidth=0.16) {#XD2:3 (0,-22)};
// (0,-21.6) @TEXT("VDD",size=1.1,halign="middle",valign="bottom");
// &"VSS" @WIRE(mode="straight",linecolor="#30485d",linewidth=0.16) {#XD2:4 (0,-44)};
// (0,-44.4) @TEXT("VSS",size=1.1,halign="middle",valign="top");
// &"A" @WIRE(mode="straight",linecolor="#30485d",linewidth=0.16) {#XQUAL2:1 (-10,-64.3)};
// (-10.4,-64.3) @TEXT("A",size=1.1,halign="end",valign="middle");
// &"VDD" @WIRE(mode="straight",linecolor="#30485d",linewidth=0.16) {#XQUAL2:3 (0,-56)};
// (0,-55.6) @TEXT("VDD",size=1.1,halign="middle",valign="bottom");
// &"VSS" @WIRE(mode="straight",linecolor="#30485d",linewidth=0.16) {#XQUAL2:4 (0,-76)};
// (0,-76.4) @TEXT("VSS",size=1.1,halign="middle",valign="top");
// &"VDD" @WIRE(mode="straight",linecolor="#30485d",linewidth=0.16) {#XD3:3 (0,-88)};
// (0,-87.6) @TEXT("VDD",size=1.1,halign="middle",valign="bottom");
// &"VSS" @WIRE(mode="straight",linecolor="#30485d",linewidth=0.16) {#XD3:4 (0,-110)};
// (0,-110.4) @TEXT("VSS",size=1.1,halign="middle",valign="top");
// &"A" @WIRE(mode="straight",linecolor="#30485d",linewidth=0.16) {#XQUAL3:1 (-10,-130.3)};
// (-10.4,-130.3) @TEXT("A",size=1.1,halign="end",valign="middle");
// &"VDD" @WIRE(mode="straight",linecolor="#30485d",linewidth=0.16) {#XQUAL3:3 (0,-122)};
// (0,-121.6) @TEXT("VDD",size=1.1,halign="middle",valign="bottom");
// &"VSS" @WIRE(mode="straight",linecolor="#30485d",linewidth=0.16) {#XQUAL3:4 (0,-142)};
// (0,-142.4) @TEXT("VSS",size=1.1,halign="middle",valign="top");
// &"Y" @WIRE(mode="straight",linecolor="#30485d",linewidth=0.16) {#XQUAL3:5 (10,-132)};
// (10.4,-132) @TEXT("Y",size=1.1,halign="start",valign="middle");
// }
// END SARADC RNL
ends sar8p_delay_write

subckt sar8p_delay_quiet A VDD VSS Y
XD1 (A D1 VDD VSS) DEL250D1BWP12T30P140
XD2 (D1 D2 VDD VSS) DEL250D1BWP12T30P140
XQUAL2 (A D2 VDD VSS Q2) sar8p_and2
XD3 (Q2 D3 VDD VSS) DEL250D1BWP12T30P140
XD4 (D3 D4 VDD VSS) DEL250D1BWP12T30P140
XQUAL4 (A D4 VDD VSS Q4) sar8p_and2
XD5 (Q4 D5 VDD VSS) DEL250D1BWP12T30P140
XD6 (D5 D6 VDD VSS) DEL250D1BWP12T30P140
XQUAL6 (A D6 VDD VSS Q6) sar8p_and2
XD7 (Q6 D7 VDD VSS) DEL250D1BWP12T30P140
XD8 (D7 D8 VDD VSS) DEL250D1BWP12T30P140
XQUAL8 (A D8 VDD VSS Q8) sar8p_and2
XD9 (Q8 D9 VDD VSS) DEL250D1BWP12T30P140
XQUAL9 (A D9 VDD VSS Y) sar8p_and2
// BEGIN SARADC RNL
// @RNL(author="saradc topology") {
// #XD1 @SET-SYMBOL $S_DEL250D1BWP12T30P140;
// #XD1 @PLACE(0,0) => @ORIENT("R0");
// #XD2 @SET-SYMBOL $S_DEL250D1BWP12T30P140;
// #XD2 @PLACE(0,-33) => @ORIENT("R0");
// #XQUAL2 @SET-SYMBOL $S_sar8p_and2;
// #XQUAL2 @PLACE(0,-66) => @ORIENT("R0");
// #XD3 @SET-SYMBOL $S_DEL250D1BWP12T30P140;
// #XD3 @PLACE(0,-99) => @ORIENT("R0");
// #XD4 @SET-SYMBOL $S_DEL250D1BWP12T30P140;
// #XD4 @PLACE(0,-132) => @ORIENT("R0");
// #XQUAL4 @SET-SYMBOL $S_sar8p_and2;
// #XQUAL4 @PLACE(0,-165) => @ORIENT("R0");
// #XD5 @SET-SYMBOL $S_DEL250D1BWP12T30P140;
// #XD5 @PLACE(0,-198) => @ORIENT("R0");
// #XD6 @SET-SYMBOL $S_DEL250D1BWP12T30P140;
// #XD6 @PLACE(0,-231) => @ORIENT("R0");
// #XQUAL6 @SET-SYMBOL $S_sar8p_and2;
// #XQUAL6 @PLACE(0,-264) => @ORIENT("R0");
// #XD7 @SET-SYMBOL $S_DEL250D1BWP12T30P140;
// #XD7 @PLACE(0,-297) => @ORIENT("R0");
// #XD8 @SET-SYMBOL $S_DEL250D1BWP12T30P140;
// #XD8 @PLACE(0,-330) => @ORIENT("R0");
// #XQUAL8 @SET-SYMBOL $S_sar8p_and2;
// #XQUAL8 @PLACE(0,-363) => @ORIENT("R0");
// #XD9 @SET-SYMBOL $S_DEL250D1BWP12T30P140;
// #XD9 @PLACE(55,0) => @ORIENT("R0");
// #XQUAL9 @SET-SYMBOL $S_sar8p_and2;
// #XQUAL9 @PLACE(55,-33) => @ORIENT("R0");
// &"D1" @WIRE(mode="straight",linecolor="#30485d",linewidth=0.16) {#XD1:2 (-13,-1.65) (-13,-31.35) #XD2:1};
// &"D2" @WIRE(mode="straight",linecolor="#30485d",linewidth=0.16) {#XD2:2 (-10,-34.65) (-10,-67.7) #XQUAL2:2};
// &"Q2" @WIRE(mode="straight",linecolor="#30485d",linewidth=0.16) {#XQUAL2:5 (-3,-66) (-3,-97.35) #XD3:1};
// &"D3" @WIRE(mode="straight",linecolor="#30485d",linewidth=0.16) {#XD3:2 (-13,-100.65) (-13,-130.35) #XD4:1};
// &"D4" @WIRE(mode="straight",linecolor="#30485d",linewidth=0.16) {#XD4:2 (-10,-133.65) (-10,-166.7) #XQUAL4:2};
// &"Q4" @WIRE(mode="straight",linecolor="#30485d",linewidth=0.16) {#XQUAL4:5 (-3,-165) (-3,-196.35) #XD5:1};
// &"D5" @WIRE(mode="straight",linecolor="#30485d",linewidth=0.16) {#XD5:2 (-13,-199.65) (-13,-229.35) #XD6:1};
// &"D6" @WIRE(mode="straight",linecolor="#30485d",linewidth=0.16) {#XD6:2 (-10,-232.65) (-10,-265.7) #XQUAL6:2};
// &"Q6" @WIRE(mode="straight",linecolor="#30485d",linewidth=0.16) {#XQUAL6:5 (-3,-264) (-3,-295.35) #XD7:1};
// &"D7" @WIRE(mode="straight",linecolor="#30485d",linewidth=0.16) {#XD7:2 (-13,-298.65) (-13,-328.35) #XD8:1};
// &"D8" @WIRE(mode="straight",linecolor="#30485d",linewidth=0.16) {#XD8:2 (-10,-331.65) (-10,-364.7) #XQUAL8:2};
// &"D9" @WIRE(mode="straight",linecolor="#30485d",linewidth=0.16) {#XD9:2 (45,-1.65) (45,-34.7) #XQUAL9:2};
// (-89,30) @TEXT("sar8p_delay_quiet / source-derived connections",size=1.4,halign="start",textcolor="#223d52");
// &"A" @WIRE(mode="straight",linecolor="#30485d",linewidth=0.16) {#XD1:1 (-16,1.65)};
// (-16.4,1.65) @TEXT("A",size=1.1,halign="end",valign="middle");
// &"VDD" @WIRE(mode="straight",linecolor="#30485d",linewidth=0.16) {#XD1:3 (0,11)};
// (0,11.4) @TEXT("VDD",size=1.1,halign="middle",valign="bottom");
// &"VSS" @WIRE(mode="straight",linecolor="#30485d",linewidth=0.16) {#XD1:4 (0,-11)};
// (0,-11.4) @TEXT("VSS",size=1.1,halign="middle",valign="top");
// &"VDD" @WIRE(mode="straight",linecolor="#30485d",linewidth=0.16) {#XD2:3 (0,-22)};
// (0,-21.6) @TEXT("VDD",size=1.1,halign="middle",valign="bottom");
// &"VSS" @WIRE(mode="straight",linecolor="#30485d",linewidth=0.16) {#XD2:4 (0,-44)};
// (0,-44.4) @TEXT("VSS",size=1.1,halign="middle",valign="top");
// &"A" @WIRE(mode="straight",linecolor="#30485d",linewidth=0.16) {#XQUAL2:1 (-10,-64.3)};
// (-10.4,-64.3) @TEXT("A",size=1.1,halign="end",valign="middle");
// &"VDD" @WIRE(mode="straight",linecolor="#30485d",linewidth=0.16) {#XQUAL2:3 (0,-56)};
// (0,-55.6) @TEXT("VDD",size=1.1,halign="middle",valign="bottom");
// &"VSS" @WIRE(mode="straight",linecolor="#30485d",linewidth=0.16) {#XQUAL2:4 (0,-76)};
// (0,-76.4) @TEXT("VSS",size=1.1,halign="middle",valign="top");
// &"VDD" @WIRE(mode="straight",linecolor="#30485d",linewidth=0.16) {#XD3:3 (0,-88)};
// (0,-87.6) @TEXT("VDD",size=1.1,halign="middle",valign="bottom");
// &"VSS" @WIRE(mode="straight",linecolor="#30485d",linewidth=0.16) {#XD3:4 (0,-110)};
// (0,-110.4) @TEXT("VSS",size=1.1,halign="middle",valign="top");
// &"VDD" @WIRE(mode="straight",linecolor="#30485d",linewidth=0.16) {#XD4:3 (0,-121)};
// (0,-120.6) @TEXT("VDD",size=1.1,halign="middle",valign="bottom");
// &"VSS" @WIRE(mode="straight",linecolor="#30485d",linewidth=0.16) {#XD4:4 (0,-143)};
// (0,-143.4) @TEXT("VSS",size=1.1,halign="middle",valign="top");
// &"A" @WIRE(mode="straight",linecolor="#30485d",linewidth=0.16) {#XQUAL4:1 (-10,-163.3)};
// (-10.4,-163.3) @TEXT("A",size=1.1,halign="end",valign="middle");
// &"VDD" @WIRE(mode="straight",linecolor="#30485d",linewidth=0.16) {#XQUAL4:3 (0,-155)};
// (0,-154.6) @TEXT("VDD",size=1.1,halign="middle",valign="bottom");
// &"VSS" @WIRE(mode="straight",linecolor="#30485d",linewidth=0.16) {#XQUAL4:4 (0,-175)};
// (0,-175.4) @TEXT("VSS",size=1.1,halign="middle",valign="top");
// &"VDD" @WIRE(mode="straight",linecolor="#30485d",linewidth=0.16) {#XD5:3 (0,-187)};
// (0,-186.6) @TEXT("VDD",size=1.1,halign="middle",valign="bottom");
// &"VSS" @WIRE(mode="straight",linecolor="#30485d",linewidth=0.16) {#XD5:4 (0,-209)};
// (0,-209.4) @TEXT("VSS",size=1.1,halign="middle",valign="top");
// &"VDD" @WIRE(mode="straight",linecolor="#30485d",linewidth=0.16) {#XD6:3 (0,-220)};
// (0,-219.6) @TEXT("VDD",size=1.1,halign="middle",valign="bottom");
// &"VSS" @WIRE(mode="straight",linecolor="#30485d",linewidth=0.16) {#XD6:4 (0,-242)};
// (0,-242.4) @TEXT("VSS",size=1.1,halign="middle",valign="top");
// &"A" @WIRE(mode="straight",linecolor="#30485d",linewidth=0.16) {#XQUAL6:1 (-10,-262.3)};
// (-10.4,-262.3) @TEXT("A",size=1.1,halign="end",valign="middle");
// &"VDD" @WIRE(mode="straight",linecolor="#30485d",linewidth=0.16) {#XQUAL6:3 (0,-254)};
// (0,-253.6) @TEXT("VDD",size=1.1,halign="middle",valign="bottom");
// &"VSS" @WIRE(mode="straight",linecolor="#30485d",linewidth=0.16) {#XQUAL6:4 (0,-274)};
// (0,-274.4) @TEXT("VSS",size=1.1,halign="middle",valign="top");
// &"VDD" @WIRE(mode="straight",linecolor="#30485d",linewidth=0.16) {#XD7:3 (0,-286)};
// (0,-285.6) @TEXT("VDD",size=1.1,halign="middle",valign="bottom");
// &"VSS" @WIRE(mode="straight",linecolor="#30485d",linewidth=0.16) {#XD7:4 (0,-308)};
// (0,-308.4) @TEXT("VSS",size=1.1,halign="middle",valign="top");
// &"VDD" @WIRE(mode="straight",linecolor="#30485d",linewidth=0.16) {#XD8:3 (0,-319)};
// (0,-318.6) @TEXT("VDD",size=1.1,halign="middle",valign="bottom");
// &"VSS" @WIRE(mode="straight",linecolor="#30485d",linewidth=0.16) {#XD8:4 (0,-341)};
// (0,-341.4) @TEXT("VSS",size=1.1,halign="middle",valign="top");
// &"A" @WIRE(mode="straight",linecolor="#30485d",linewidth=0.16) {#XQUAL8:1 (-10,-361.3)};
// (-10.4,-361.3) @TEXT("A",size=1.1,halign="end",valign="middle");
// &"VDD" @WIRE(mode="straight",linecolor="#30485d",linewidth=0.16) {#XQUAL8:3 (0,-353)};
// (0,-352.6) @TEXT("VDD",size=1.1,halign="middle",valign="bottom");
// &"VSS" @WIRE(mode="straight",linecolor="#30485d",linewidth=0.16) {#XQUAL8:4 (0,-373)};
// (0,-373.4) @TEXT("VSS",size=1.1,halign="middle",valign="top");
// &"Q8" @WIRE(mode="straight",linecolor="#30485d",linewidth=0.16) {#XQUAL8:5 (10,-363)};
// (10.4,-363) @TEXT("Q8",size=1.1,halign="start",valign="middle");
// &"Q8" @WIRE(mode="straight",linecolor="#30485d",linewidth=0.16) {#XD9:1 (39,1.65)};
// (38.6,1.65) @TEXT("Q8",size=1.1,halign="end",valign="middle");
// &"VDD" @WIRE(mode="straight",linecolor="#30485d",linewidth=0.16) {#XD9:3 (55,11)};
// (55,11.4) @TEXT("VDD",size=1.1,halign="middle",valign="bottom");
// &"VSS" @WIRE(mode="straight",linecolor="#30485d",linewidth=0.16) {#XD9:4 (55,-11)};
// (55,-11.4) @TEXT("VSS",size=1.1,halign="middle",valign="top");
// &"A" @WIRE(mode="straight",linecolor="#30485d",linewidth=0.16) {#XQUAL9:1 (45,-31.3)};
// (44.6,-31.3) @TEXT("A",size=1.1,halign="end",valign="middle");
// &"VDD" @WIRE(mode="straight",linecolor="#30485d",linewidth=0.16) {#XQUAL9:3 (55,-23)};
// (55,-22.6) @TEXT("VDD",size=1.1,halign="middle",valign="bottom");
// &"VSS" @WIRE(mode="straight",linecolor="#30485d",linewidth=0.16) {#XQUAL9:4 (55,-43)};
// (55,-43.4) @TEXT("VSS",size=1.1,halign="middle",valign="top");
// &"Y" @WIRE(mode="straight",linecolor="#30485d",linewidth=0.16) {#XQUAL9:5 (65,-33)};
// (65.4,-33) @TEXT("Y",size=1.1,halign="start",valign="middle");
// }
// END SARADC RNL
ends sar8p_delay_quiet

subckt sar8p_delay_capture A VDD VSS Y
XD1 (A D1 VDD VSS) DEL250D1BWP12T30P140
XD2 (D1 D2 VDD VSS) DEL250D1BWP12T30P140
XQUAL2 (A D2 VDD VSS Q2) sar8p_and2
XD3 (Q2 D3 VDD VSS) DEL250D1BWP12T30P140
XD4 (D3 D4 VDD VSS) DEL250D1BWP12T30P140
XQUAL4 (A D4 VDD VSS Q4) sar8p_and2
XD5 (Q4 D5 VDD VSS) DEL250D1BWP12T30P140
XD6 (D5 D6 VDD VSS) DEL050D1BWP12T30P140
XQUAL6 (A D6 VDD VSS Y) sar8p_and2
// BEGIN SARADC RNL
// @RNL(author="saradc topology") {
// #XD1 @SET-SYMBOL $S_DEL250D1BWP12T30P140;
// #XD1 @PLACE(0,0) => @ORIENT("R0");
// #XD2 @SET-SYMBOL $S_DEL250D1BWP12T30P140;
// #XD2 @PLACE(0,-33) => @ORIENT("R0");
// #XQUAL2 @SET-SYMBOL $S_sar8p_and2;
// #XQUAL2 @PLACE(0,-66) => @ORIENT("R0");
// #XD3 @SET-SYMBOL $S_DEL250D1BWP12T30P140;
// #XD3 @PLACE(0,-99) => @ORIENT("R0");
// #XD4 @SET-SYMBOL $S_DEL250D1BWP12T30P140;
// #XD4 @PLACE(0,-132) => @ORIENT("R0");
// #XQUAL4 @SET-SYMBOL $S_sar8p_and2;
// #XQUAL4 @PLACE(0,-165) => @ORIENT("R0");
// #XD5 @SET-SYMBOL $S_DEL250D1BWP12T30P140;
// #XD5 @PLACE(0,-198) => @ORIENT("R0");
// #XD6 @SET-SYMBOL $S_DEL050D1BWP12T30P140;
// #XD6 @PLACE(0,-231) => @ORIENT("R0");
// #XQUAL6 @SET-SYMBOL $S_sar8p_and2;
// #XQUAL6 @PLACE(0,-264) => @ORIENT("R0");
// &"D1" @WIRE(mode="straight",linecolor="#30485d",linewidth=0.16) {#XD1:2 (-13,-1.65) (-13,-31.35) #XD2:1};
// &"D2" @WIRE(mode="straight",linecolor="#30485d",linewidth=0.16) {#XD2:2 (-10,-34.65) (-10,-67.7) #XQUAL2:2};
// &"Q2" @WIRE(mode="straight",linecolor="#30485d",linewidth=0.16) {#XQUAL2:5 (-3,-66) (-3,-97.35) #XD3:1};
// &"D3" @WIRE(mode="straight",linecolor="#30485d",linewidth=0.16) {#XD3:2 (-13,-100.65) (-13,-130.35) #XD4:1};
// &"D4" @WIRE(mode="straight",linecolor="#30485d",linewidth=0.16) {#XD4:2 (-10,-133.65) (-10,-166.7) #XQUAL4:2};
// &"Q4" @WIRE(mode="straight",linecolor="#30485d",linewidth=0.16) {#XQUAL4:5 (-3,-165) (-3,-196.35) #XD5:1};
// &"D5" @WIRE(mode="straight",linecolor="#30485d",linewidth=0.16) {#XD5:2 (-13,-199.65) (-13,-229.35) #XD6:1};
// &"D6" @WIRE(mode="straight",linecolor="#30485d",linewidth=0.16) {#XD6:2 (-10,-232.65) (-10,-265.7) #XQUAL6:2};
// (-89,30) @TEXT("sar8p_delay_capture / source-derived connections",size=1.4,halign="start",textcolor="#223d52");
// &"A" @WIRE(mode="straight",linecolor="#30485d",linewidth=0.16) {#XD1:1 (-16,1.65)};
// (-16.4,1.65) @TEXT("A",size=1.1,halign="end",valign="middle");
// &"VDD" @WIRE(mode="straight",linecolor="#30485d",linewidth=0.16) {#XD1:3 (0,11)};
// (0,11.4) @TEXT("VDD",size=1.1,halign="middle",valign="bottom");
// &"VSS" @WIRE(mode="straight",linecolor="#30485d",linewidth=0.16) {#XD1:4 (0,-11)};
// (0,-11.4) @TEXT("VSS",size=1.1,halign="middle",valign="top");
// &"VDD" @WIRE(mode="straight",linecolor="#30485d",linewidth=0.16) {#XD2:3 (0,-22)};
// (0,-21.6) @TEXT("VDD",size=1.1,halign="middle",valign="bottom");
// &"VSS" @WIRE(mode="straight",linecolor="#30485d",linewidth=0.16) {#XD2:4 (0,-44)};
// (0,-44.4) @TEXT("VSS",size=1.1,halign="middle",valign="top");
// &"A" @WIRE(mode="straight",linecolor="#30485d",linewidth=0.16) {#XQUAL2:1 (-10,-64.3)};
// (-10.4,-64.3) @TEXT("A",size=1.1,halign="end",valign="middle");
// &"VDD" @WIRE(mode="straight",linecolor="#30485d",linewidth=0.16) {#XQUAL2:3 (0,-56)};
// (0,-55.6) @TEXT("VDD",size=1.1,halign="middle",valign="bottom");
// &"VSS" @WIRE(mode="straight",linecolor="#30485d",linewidth=0.16) {#XQUAL2:4 (0,-76)};
// (0,-76.4) @TEXT("VSS",size=1.1,halign="middle",valign="top");
// &"VDD" @WIRE(mode="straight",linecolor="#30485d",linewidth=0.16) {#XD3:3 (0,-88)};
// (0,-87.6) @TEXT("VDD",size=1.1,halign="middle",valign="bottom");
// &"VSS" @WIRE(mode="straight",linecolor="#30485d",linewidth=0.16) {#XD3:4 (0,-110)};
// (0,-110.4) @TEXT("VSS",size=1.1,halign="middle",valign="top");
// &"VDD" @WIRE(mode="straight",linecolor="#30485d",linewidth=0.16) {#XD4:3 (0,-121)};
// (0,-120.6) @TEXT("VDD",size=1.1,halign="middle",valign="bottom");
// &"VSS" @WIRE(mode="straight",linecolor="#30485d",linewidth=0.16) {#XD4:4 (0,-143)};
// (0,-143.4) @TEXT("VSS",size=1.1,halign="middle",valign="top");
// &"A" @WIRE(mode="straight",linecolor="#30485d",linewidth=0.16) {#XQUAL4:1 (-10,-163.3)};
// (-10.4,-163.3) @TEXT("A",size=1.1,halign="end",valign="middle");
// &"VDD" @WIRE(mode="straight",linecolor="#30485d",linewidth=0.16) {#XQUAL4:3 (0,-155)};
// (0,-154.6) @TEXT("VDD",size=1.1,halign="middle",valign="bottom");
// &"VSS" @WIRE(mode="straight",linecolor="#30485d",linewidth=0.16) {#XQUAL4:4 (0,-175)};
// (0,-175.4) @TEXT("VSS",size=1.1,halign="middle",valign="top");
// &"VDD" @WIRE(mode="straight",linecolor="#30485d",linewidth=0.16) {#XD5:3 (0,-187)};
// (0,-186.6) @TEXT("VDD",size=1.1,halign="middle",valign="bottom");
// &"VSS" @WIRE(mode="straight",linecolor="#30485d",linewidth=0.16) {#XD5:4 (0,-209)};
// (0,-209.4) @TEXT("VSS",size=1.1,halign="middle",valign="top");
// &"VDD" @WIRE(mode="straight",linecolor="#30485d",linewidth=0.16) {#XD6:3 (0,-220)};
// (0,-219.6) @TEXT("VDD",size=1.1,halign="middle",valign="bottom");
// &"VSS" @WIRE(mode="straight",linecolor="#30485d",linewidth=0.16) {#XD6:4 (0,-242)};
// (0,-242.4) @TEXT("VSS",size=1.1,halign="middle",valign="top");
// &"A" @WIRE(mode="straight",linecolor="#30485d",linewidth=0.16) {#XQUAL6:1 (-10,-262.3)};
// (-10.4,-262.3) @TEXT("A",size=1.1,halign="end",valign="middle");
// &"VDD" @WIRE(mode="straight",linecolor="#30485d",linewidth=0.16) {#XQUAL6:3 (0,-254)};
// (0,-253.6) @TEXT("VDD",size=1.1,halign="middle",valign="bottom");
// &"VSS" @WIRE(mode="straight",linecolor="#30485d",linewidth=0.16) {#XQUAL6:4 (0,-274)};
// (0,-274.4) @TEXT("VSS",size=1.1,halign="middle",valign="top");
// &"Y" @WIRE(mode="straight",linecolor="#30485d",linewidth=0.16) {#XQUAL6:5 (10,-264)};
// (10.4,-264) @TEXT("Y",size=1.1,halign="start",valign="middle");
// }
// END SARADC RNL
ends sar8p_delay_capture

subckt sar8p_delay_bbm A VDD VSS Y
XD1 (A D1 VDD VSS) DEL200D1BWP12T30P140
XQUAL1 (A D1 VDD VSS Y) sar8p_and2
// BEGIN SARADC RNL
// @RNL(author="saradc topology") {
// #XD1 @SET-SYMBOL $S_DEL200D1BWP12T30P140;
// #XD1 @PLACE(0,0) => @ORIENT("R0");
// #XQUAL1 @SET-SYMBOL $S_sar8p_and2;
// #XQUAL1 @PLACE(0,-33) => @ORIENT("R0");
// &"A" @WIRE(mode="straight",linecolor="#30485d",linewidth=0.16) {#XD1:1 (-10,1.65) (-10,-31.3) #XQUAL1:1};
// &"D1" @WIRE(mode="straight",linecolor="#30485d",linewidth=0.16) {#XD1:2 (-10,-1.65) (-10,-34.7) #XQUAL1:2};
// (-89,30) @TEXT("sar8p_delay_bbm / source-derived connections",size=1.4,halign="start",textcolor="#223d52");
// &"VDD" @WIRE(mode="straight",linecolor="#30485d",linewidth=0.16) {#XD1:3 (0,11)};
// (0,11.4) @TEXT("VDD",size=1.1,halign="middle",valign="bottom");
// &"VSS" @WIRE(mode="straight",linecolor="#30485d",linewidth=0.16) {#XD1:4 (0,-11)};
// (0,-11.4) @TEXT("VSS",size=1.1,halign="middle",valign="top");
// &"VDD" @WIRE(mode="straight",linecolor="#30485d",linewidth=0.16) {#XQUAL1:3 (0,-23)};
// (0,-22.6) @TEXT("VDD",size=1.1,halign="middle",valign="bottom");
// &"VSS" @WIRE(mode="straight",linecolor="#30485d",linewidth=0.16) {#XQUAL1:4 (0,-43)};
// (0,-43.4) @TEXT("VSS",size=1.1,halign="middle",valign="top");
// &"Y" @WIRE(mode="straight",linecolor="#30485d",linewidth=0.16) {#XQUAL1:5 (10,-33)};
// (10.4,-33) @TEXT("Y",size=1.1,halign="start",valign="middle");
// }
// END SARADC RNL
ends sar8p_delay_bbm

subckt sar8r_delay A VDD VSS Y
XD1 (A D1 VDD VSS) DEL250D1BWP12T30P140
XD2 (D1 D2 VDD VSS) DEL250D1BWP12T30P140
XQUAL2 (A D2 VDD VSS Q2) sar8p_and2
XD3 (Q2 D3 VDD VSS) DEL250D1BWP12T30P140
XD4 (D3 D4 VDD VSS) DEL250D1BWP12T30P140
XQUAL4 (A D4 VDD VSS Q4) sar8p_and2
XD5 (Q4 D5 VDD VSS) DEL250D1BWP12T30P140
XD6 (D5 D6 VDD VSS) DEL250D1BWP12T30P140
XQUAL6 (A D6 VDD VSS Q6) sar8p_and2
XD7 (Q6 D7 VDD VSS) DEL250D1BWP12T30P140
XD8 (D7 D8 VDD VSS) DEL250D1BWP12T30P140
XQUAL8 (A D8 VDD VSS Q8) sar8p_and2
XD9 (Q8 D9 VDD VSS) DEL250D1BWP12T30P140
XD10 (D9 D10 VDD VSS) DEL250D1BWP12T30P140
XQUAL10 (A D10 VDD VSS Y) sar8p_and2
// BEGIN SARADC RNL
// @RNL(author="saradc topology") {
// #XD1 @SET-SYMBOL $S_DEL250D1BWP12T30P140;
// #XD1 @PLACE(0,0) => @ORIENT("R0");
// #XD2 @SET-SYMBOL $S_DEL250D1BWP12T30P140;
// #XD2 @PLACE(0,-33) => @ORIENT("R0");
// #XQUAL2 @SET-SYMBOL $S_sar8p_and2;
// #XQUAL2 @PLACE(0,-66) => @ORIENT("R0");
// #XD3 @SET-SYMBOL $S_DEL250D1BWP12T30P140;
// #XD3 @PLACE(0,-99) => @ORIENT("R0");
// #XD4 @SET-SYMBOL $S_DEL250D1BWP12T30P140;
// #XD4 @PLACE(0,-132) => @ORIENT("R0");
// #XQUAL4 @SET-SYMBOL $S_sar8p_and2;
// #XQUAL4 @PLACE(0,-165) => @ORIENT("R0");
// #XD5 @SET-SYMBOL $S_DEL250D1BWP12T30P140;
// #XD5 @PLACE(0,-198) => @ORIENT("R0");
// #XD6 @SET-SYMBOL $S_DEL250D1BWP12T30P140;
// #XD6 @PLACE(0,-231) => @ORIENT("R0");
// #XQUAL6 @SET-SYMBOL $S_sar8p_and2;
// #XQUAL6 @PLACE(0,-264) => @ORIENT("R0");
// #XD7 @SET-SYMBOL $S_DEL250D1BWP12T30P140;
// #XD7 @PLACE(0,-297) => @ORIENT("R0");
// #XD8 @SET-SYMBOL $S_DEL250D1BWP12T30P140;
// #XD8 @PLACE(0,-330) => @ORIENT("R0");
// #XQUAL8 @SET-SYMBOL $S_sar8p_and2;
// #XQUAL8 @PLACE(0,-363) => @ORIENT("R0");
// #XD9 @SET-SYMBOL $S_DEL250D1BWP12T30P140;
// #XD9 @PLACE(55,0) => @ORIENT("R0");
// #XD10 @SET-SYMBOL $S_DEL250D1BWP12T30P140;
// #XD10 @PLACE(55,-33) => @ORIENT("R0");
// #XQUAL10 @SET-SYMBOL $S_sar8p_and2;
// #XQUAL10 @PLACE(55,-66) => @ORIENT("R0");
// &"D1" @WIRE(mode="straight",linecolor="#30485d",linewidth=0.16) {#XD1:2 (-13,-1.65) (-13,-31.35) #XD2:1};
// &"D2" @WIRE(mode="straight",linecolor="#30485d",linewidth=0.16) {#XD2:2 (-10,-34.65) (-10,-67.7) #XQUAL2:2};
// &"Q2" @WIRE(mode="straight",linecolor="#30485d",linewidth=0.16) {#XQUAL2:5 (-3,-66) (-3,-97.35) #XD3:1};
// &"D3" @WIRE(mode="straight",linecolor="#30485d",linewidth=0.16) {#XD3:2 (-13,-100.65) (-13,-130.35) #XD4:1};
// &"D4" @WIRE(mode="straight",linecolor="#30485d",linewidth=0.16) {#XD4:2 (-10,-133.65) (-10,-166.7) #XQUAL4:2};
// &"Q4" @WIRE(mode="straight",linecolor="#30485d",linewidth=0.16) {#XQUAL4:5 (-3,-165) (-3,-196.35) #XD5:1};
// &"D5" @WIRE(mode="straight",linecolor="#30485d",linewidth=0.16) {#XD5:2 (-13,-199.65) (-13,-229.35) #XD6:1};
// &"D6" @WIRE(mode="straight",linecolor="#30485d",linewidth=0.16) {#XD6:2 (-10,-232.65) (-10,-265.7) #XQUAL6:2};
// &"Q6" @WIRE(mode="straight",linecolor="#30485d",linewidth=0.16) {#XQUAL6:5 (-3,-264) (-3,-295.35) #XD7:1};
// &"D7" @WIRE(mode="straight",linecolor="#30485d",linewidth=0.16) {#XD7:2 (-13,-298.65) (-13,-328.35) #XD8:1};
// &"D8" @WIRE(mode="straight",linecolor="#30485d",linewidth=0.16) {#XD8:2 (-10,-331.65) (-10,-364.7) #XQUAL8:2};
// &"D9" @WIRE(mode="straight",linecolor="#30485d",linewidth=0.16) {#XD9:2 (42,-1.65) (42,-31.35) #XD10:1};
// &"D10" @WIRE(mode="straight",linecolor="#30485d",linewidth=0.16) {#XD10:2 (45,-34.65) (45,-67.7) #XQUAL10:2};
// (-89,30) @TEXT("sar8r_delay / source-derived connections",size=1.4,halign="start",textcolor="#223d52");
// &"A" @WIRE(mode="straight",linecolor="#30485d",linewidth=0.16) {#XD1:1 (-16,1.65)};
// (-16.4,1.65) @TEXT("A",size=1.1,halign="end",valign="middle");
// &"VDD" @WIRE(mode="straight",linecolor="#30485d",linewidth=0.16) {#XD1:3 (0,11)};
// (0,11.4) @TEXT("VDD",size=1.1,halign="middle",valign="bottom");
// &"VSS" @WIRE(mode="straight",linecolor="#30485d",linewidth=0.16) {#XD1:4 (0,-11)};
// (0,-11.4) @TEXT("VSS",size=1.1,halign="middle",valign="top");
// &"VDD" @WIRE(mode="straight",linecolor="#30485d",linewidth=0.16) {#XD2:3 (0,-22)};
// (0,-21.6) @TEXT("VDD",size=1.1,halign="middle",valign="bottom");
// &"VSS" @WIRE(mode="straight",linecolor="#30485d",linewidth=0.16) {#XD2:4 (0,-44)};
// (0,-44.4) @TEXT("VSS",size=1.1,halign="middle",valign="top");
// &"A" @WIRE(mode="straight",linecolor="#30485d",linewidth=0.16) {#XQUAL2:1 (-10,-64.3)};
// (-10.4,-64.3) @TEXT("A",size=1.1,halign="end",valign="middle");
// &"VDD" @WIRE(mode="straight",linecolor="#30485d",linewidth=0.16) {#XQUAL2:3 (0,-56)};
// (0,-55.6) @TEXT("VDD",size=1.1,halign="middle",valign="bottom");
// &"VSS" @WIRE(mode="straight",linecolor="#30485d",linewidth=0.16) {#XQUAL2:4 (0,-76)};
// (0,-76.4) @TEXT("VSS",size=1.1,halign="middle",valign="top");
// &"VDD" @WIRE(mode="straight",linecolor="#30485d",linewidth=0.16) {#XD3:3 (0,-88)};
// (0,-87.6) @TEXT("VDD",size=1.1,halign="middle",valign="bottom");
// &"VSS" @WIRE(mode="straight",linecolor="#30485d",linewidth=0.16) {#XD3:4 (0,-110)};
// (0,-110.4) @TEXT("VSS",size=1.1,halign="middle",valign="top");
// &"VDD" @WIRE(mode="straight",linecolor="#30485d",linewidth=0.16) {#XD4:3 (0,-121)};
// (0,-120.6) @TEXT("VDD",size=1.1,halign="middle",valign="bottom");
// &"VSS" @WIRE(mode="straight",linecolor="#30485d",linewidth=0.16) {#XD4:4 (0,-143)};
// (0,-143.4) @TEXT("VSS",size=1.1,halign="middle",valign="top");
// &"A" @WIRE(mode="straight",linecolor="#30485d",linewidth=0.16) {#XQUAL4:1 (-10,-163.3)};
// (-10.4,-163.3) @TEXT("A",size=1.1,halign="end",valign="middle");
// &"VDD" @WIRE(mode="straight",linecolor="#30485d",linewidth=0.16) {#XQUAL4:3 (0,-155)};
// (0,-154.6) @TEXT("VDD",size=1.1,halign="middle",valign="bottom");
// &"VSS" @WIRE(mode="straight",linecolor="#30485d",linewidth=0.16) {#XQUAL4:4 (0,-175)};
// (0,-175.4) @TEXT("VSS",size=1.1,halign="middle",valign="top");
// &"VDD" @WIRE(mode="straight",linecolor="#30485d",linewidth=0.16) {#XD5:3 (0,-187)};
// (0,-186.6) @TEXT("VDD",size=1.1,halign="middle",valign="bottom");
// &"VSS" @WIRE(mode="straight",linecolor="#30485d",linewidth=0.16) {#XD5:4 (0,-209)};
// (0,-209.4) @TEXT("VSS",size=1.1,halign="middle",valign="top");
// &"VDD" @WIRE(mode="straight",linecolor="#30485d",linewidth=0.16) {#XD6:3 (0,-220)};
// (0,-219.6) @TEXT("VDD",size=1.1,halign="middle",valign="bottom");
// &"VSS" @WIRE(mode="straight",linecolor="#30485d",linewidth=0.16) {#XD6:4 (0,-242)};
// (0,-242.4) @TEXT("VSS",size=1.1,halign="middle",valign="top");
// &"A" @WIRE(mode="straight",linecolor="#30485d",linewidth=0.16) {#XQUAL6:1 (-10,-262.3)};
// (-10.4,-262.3) @TEXT("A",size=1.1,halign="end",valign="middle");
// &"VDD" @WIRE(mode="straight",linecolor="#30485d",linewidth=0.16) {#XQUAL6:3 (0,-254)};
// (0,-253.6) @TEXT("VDD",size=1.1,halign="middle",valign="bottom");
// &"VSS" @WIRE(mode="straight",linecolor="#30485d",linewidth=0.16) {#XQUAL6:4 (0,-274)};
// (0,-274.4) @TEXT("VSS",size=1.1,halign="middle",valign="top");
// &"VDD" @WIRE(mode="straight",linecolor="#30485d",linewidth=0.16) {#XD7:3 (0,-286)};
// (0,-285.6) @TEXT("VDD",size=1.1,halign="middle",valign="bottom");
// &"VSS" @WIRE(mode="straight",linecolor="#30485d",linewidth=0.16) {#XD7:4 (0,-308)};
// (0,-308.4) @TEXT("VSS",size=1.1,halign="middle",valign="top");
// &"VDD" @WIRE(mode="straight",linecolor="#30485d",linewidth=0.16) {#XD8:3 (0,-319)};
// (0,-318.6) @TEXT("VDD",size=1.1,halign="middle",valign="bottom");
// &"VSS" @WIRE(mode="straight",linecolor="#30485d",linewidth=0.16) {#XD8:4 (0,-341)};
// (0,-341.4) @TEXT("VSS",size=1.1,halign="middle",valign="top");
// &"A" @WIRE(mode="straight",linecolor="#30485d",linewidth=0.16) {#XQUAL8:1 (-10,-361.3)};
// (-10.4,-361.3) @TEXT("A",size=1.1,halign="end",valign="middle");
// &"VDD" @WIRE(mode="straight",linecolor="#30485d",linewidth=0.16) {#XQUAL8:3 (0,-353)};
// (0,-352.6) @TEXT("VDD",size=1.1,halign="middle",valign="bottom");
// &"VSS" @WIRE(mode="straight",linecolor="#30485d",linewidth=0.16) {#XQUAL8:4 (0,-373)};
// (0,-373.4) @TEXT("VSS",size=1.1,halign="middle",valign="top");
// &"Q8" @WIRE(mode="straight",linecolor="#30485d",linewidth=0.16) {#XQUAL8:5 (10,-363)};
// (10.4,-363) @TEXT("Q8",size=1.1,halign="start",valign="middle");
// &"Q8" @WIRE(mode="straight",linecolor="#30485d",linewidth=0.16) {#XD9:1 (39,1.65)};
// (38.6,1.65) @TEXT("Q8",size=1.1,halign="end",valign="middle");
// &"VDD" @WIRE(mode="straight",linecolor="#30485d",linewidth=0.16) {#XD9:3 (55,11)};
// (55,11.4) @TEXT("VDD",size=1.1,halign="middle",valign="bottom");
// &"VSS" @WIRE(mode="straight",linecolor="#30485d",linewidth=0.16) {#XD9:4 (55,-11)};
// (55,-11.4) @TEXT("VSS",size=1.1,halign="middle",valign="top");
// &"VDD" @WIRE(mode="straight",linecolor="#30485d",linewidth=0.16) {#XD10:3 (55,-22)};
// (55,-21.6) @TEXT("VDD",size=1.1,halign="middle",valign="bottom");
// &"VSS" @WIRE(mode="straight",linecolor="#30485d",linewidth=0.16) {#XD10:4 (55,-44)};
// (55,-44.4) @TEXT("VSS",size=1.1,halign="middle",valign="top");
// &"A" @WIRE(mode="straight",linecolor="#30485d",linewidth=0.16) {#XQUAL10:1 (45,-64.3)};
// (44.6,-64.3) @TEXT("A",size=1.1,halign="end",valign="middle");
// &"VDD" @WIRE(mode="straight",linecolor="#30485d",linewidth=0.16) {#XQUAL10:3 (55,-56)};
// (55,-55.6) @TEXT("VDD",size=1.1,halign="middle",valign="bottom");
// &"VSS" @WIRE(mode="straight",linecolor="#30485d",linewidth=0.16) {#XQUAL10:4 (55,-76)};
// (55,-76.4) @TEXT("VSS",size=1.1,halign="middle",valign="top");
// &"Y" @WIRE(mode="straight",linecolor="#30485d",linewidth=0.16) {#XQUAL10:5 (65,-66)};
// (65.4,-66) @TEXT("Y",size=1.1,halign="start",valign="middle");
// }
// END SARADC RNL
ends sar8r_delay

subckt sar8r_edge A VDD VSS Y
    XD (A VDD VSS AD) sar8r_delay
    XA (A AD VDD VSS QUAL) sar8p_and2
    XB (QUAL VDD VSS Y) sar8p_clkbuf
// BEGIN SARADC RNL
// @RNL(author="saradc topology") {
// #XD @SET-SYMBOL $S_sar8r_delay;
// #XD @PLACE(0,-20) => @ORIENT("R0");
// #XA @SET-SYMBOL $S_sar8p_and2;
// #XA @PLACE(43,0) => @ORIENT("R0");
// #XB @SET-SYMBOL $S_sar8p_clkbuf;
// #XB @PLACE(80,0) => @ORIENT("R0");
// &"A" @WIRE(mode="straight",linecolor="#30485d",linewidth=0.16) {#XD:1 (11.5,-20) (11.5,1.7) #XA:1};
// &"AD" @WIRE(mode="straight",linecolor="#30485d",linewidth=0.16) {#XD:4 (24.5,-20) (24.5,-1.7) #XA:2};
// &"QUAL" @WIRE(mode="straight",linecolor="#30485d",linewidth=0.16) {#XA:5 (61.5,0) (61.5,0) #XB:1};
// (-16,46) @TEXT("sar8r_edge / native standard-cell composition",size=1.3,halign="start",textcolor="#223d52");
// &"VDD" @WIRE(mode="straight",linecolor="#30485d",linewidth=0.16) {#XD:2 (0,-9)};
// (0,-8.6) @TEXT("VDD",size=1.1,halign="middle",valign="bottom");
// &"VSS" @WIRE(mode="straight",linecolor="#30485d",linewidth=0.16) {#XD:3 (0,-31)};
// (0,-31.4) @TEXT("VSS",size=1.1,halign="middle",valign="top");
// &"VDD" @WIRE(mode="straight",linecolor="#30485d",linewidth=0.16) {#XA:3 (43,10)};
// (43,10.4) @TEXT("VDD",size=1.1,halign="middle",valign="bottom");
// &"VSS" @WIRE(mode="straight",linecolor="#30485d",linewidth=0.16) {#XA:4 (43,-10)};
// (43,-10.4) @TEXT("VSS",size=1.1,halign="middle",valign="top");
// &"VDD" @WIRE(mode="straight",linecolor="#30485d",linewidth=0.16) {#XB:2 (80,10)};
// (80,10.4) @TEXT("VDD",size=1.1,halign="middle",valign="bottom");
// &"VSS" @WIRE(mode="straight",linecolor="#30485d",linewidth=0.16) {#XB:3 (80,-10)};
// (80,-10.4) @TEXT("VSS",size=1.1,halign="middle",valign="top");
// &"Y" @WIRE(mode="straight",linecolor="#30485d",linewidth=0.16) {#XB:4 (90,0)};
// (90.4,0) @TEXT("Y",size=1.1,halign="start",valign="middle");
// }
// END SARADC RNL
ends sar8r_edge

subckt sar8s_step A VDD VSS Y
XD1 (A D1 VDD VSS) DEL250D1BWP12T30P140
XD2 (D1 D2 VDD VSS) DEL250D1BWP12T30P140
XQUAL2 (A D2 VDD VSS Q2) sar8p_and2
XD3 (Q2 D3 VDD VSS) DEL250D1BWP12T30P140
XD4 (D3 D4 VDD VSS) DEL075D1BWP12T30P140
XQUAL4 (A D4 VDD VSS Y) sar8p_and2
// BEGIN SARADC RNL
// @RNL(author="saradc topology") {
// #XD1 @SET-SYMBOL $S_DEL250D1BWP12T30P140;
// #XD1 @PLACE(0,0) => @ORIENT("R0");
// #XD2 @SET-SYMBOL $S_DEL250D1BWP12T30P140;
// #XD2 @PLACE(0,-33) => @ORIENT("R0");
// #XQUAL2 @SET-SYMBOL $S_sar8p_and2;
// #XQUAL2 @PLACE(0,-66) => @ORIENT("R0");
// #XD3 @SET-SYMBOL $S_DEL250D1BWP12T30P140;
// #XD3 @PLACE(0,-99) => @ORIENT("R0");
// #XD4 @SET-SYMBOL $S_DEL075D1BWP12T30P140;
// #XD4 @PLACE(0,-132) => @ORIENT("R0");
// #XQUAL4 @SET-SYMBOL $S_sar8p_and2;
// #XQUAL4 @PLACE(0,-165) => @ORIENT("R0");
// &"D1" @WIRE(mode="straight",linecolor="#30485d",linewidth=0.16) {#XD1:2 (-13,-1.65) (-13,-31.35) #XD2:1};
// &"D2" @WIRE(mode="straight",linecolor="#30485d",linewidth=0.16) {#XD2:2 (-10,-34.65) (-10,-67.7) #XQUAL2:2};
// &"Q2" @WIRE(mode="straight",linecolor="#30485d",linewidth=0.16) {#XQUAL2:5 (-3,-66) (-3,-97.35) #XD3:1};
// &"D3" @WIRE(mode="straight",linecolor="#30485d",linewidth=0.16) {#XD3:2 (-13,-100.65) (-13,-130.35) #XD4:1};
// &"D4" @WIRE(mode="straight",linecolor="#30485d",linewidth=0.16) {#XD4:2 (-10,-133.65) (-10,-166.7) #XQUAL4:2};
// (-89,30) @TEXT("sar8s_step / source-derived connections",size=1.4,halign="start",textcolor="#223d52");
// &"A" @WIRE(mode="straight",linecolor="#30485d",linewidth=0.16) {#XD1:1 (-16,1.65)};
// (-16.4,1.65) @TEXT("A",size=1.1,halign="end",valign="middle");
// &"VDD" @WIRE(mode="straight",linecolor="#30485d",linewidth=0.16) {#XD1:3 (0,11)};
// (0,11.4) @TEXT("VDD",size=1.1,halign="middle",valign="bottom");
// &"VSS" @WIRE(mode="straight",linecolor="#30485d",linewidth=0.16) {#XD1:4 (0,-11)};
// (0,-11.4) @TEXT("VSS",size=1.1,halign="middle",valign="top");
// &"VDD" @WIRE(mode="straight",linecolor="#30485d",linewidth=0.16) {#XD2:3 (0,-22)};
// (0,-21.6) @TEXT("VDD",size=1.1,halign="middle",valign="bottom");
// &"VSS" @WIRE(mode="straight",linecolor="#30485d",linewidth=0.16) {#XD2:4 (0,-44)};
// (0,-44.4) @TEXT("VSS",size=1.1,halign="middle",valign="top");
// &"A" @WIRE(mode="straight",linecolor="#30485d",linewidth=0.16) {#XQUAL2:1 (-10,-64.3)};
// (-10.4,-64.3) @TEXT("A",size=1.1,halign="end",valign="middle");
// &"VDD" @WIRE(mode="straight",linecolor="#30485d",linewidth=0.16) {#XQUAL2:3 (0,-56)};
// (0,-55.6) @TEXT("VDD",size=1.1,halign="middle",valign="bottom");
// &"VSS" @WIRE(mode="straight",linecolor="#30485d",linewidth=0.16) {#XQUAL2:4 (0,-76)};
// (0,-76.4) @TEXT("VSS",size=1.1,halign="middle",valign="top");
// &"VDD" @WIRE(mode="straight",linecolor="#30485d",linewidth=0.16) {#XD3:3 (0,-88)};
// (0,-87.6) @TEXT("VDD",size=1.1,halign="middle",valign="bottom");
// &"VSS" @WIRE(mode="straight",linecolor="#30485d",linewidth=0.16) {#XD3:4 (0,-110)};
// (0,-110.4) @TEXT("VSS",size=1.1,halign="middle",valign="top");
// &"VDD" @WIRE(mode="straight",linecolor="#30485d",linewidth=0.16) {#XD4:3 (0,-121)};
// (0,-120.6) @TEXT("VDD",size=1.1,halign="middle",valign="bottom");
// &"VSS" @WIRE(mode="straight",linecolor="#30485d",linewidth=0.16) {#XD4:4 (0,-143)};
// (0,-143.4) @TEXT("VSS",size=1.1,halign="middle",valign="top");
// &"A" @WIRE(mode="straight",linecolor="#30485d",linewidth=0.16) {#XQUAL4:1 (-10,-163.3)};
// (-10.4,-163.3) @TEXT("A",size=1.1,halign="end",valign="middle");
// &"VDD" @WIRE(mode="straight",linecolor="#30485d",linewidth=0.16) {#XQUAL4:3 (0,-155)};
// (0,-154.6) @TEXT("VDD",size=1.1,halign="middle",valign="bottom");
// &"VSS" @WIRE(mode="straight",linecolor="#30485d",linewidth=0.16) {#XQUAL4:4 (0,-175)};
// (0,-175.4) @TEXT("VSS",size=1.1,halign="middle",valign="top");
// &"Y" @WIRE(mode="straight",linecolor="#30485d",linewidth=0.16) {#XQUAL4:5 (10,-165)};
// (10.4,-165) @TEXT("Y",size=1.1,halign="start",valign="middle");
// }
// END SARADC RNL
ends sar8s_step

subckt sar8i_guard A VDD VSS Y
XD1 (A D1 VDD VSS) DEL250D1BWP12T30P140
XD2 (D1 D2 VDD VSS) DEL250D1BWP12T30P140
XQUAL2 (A D2 VDD VSS Q2) sar8p_and2
XD3 (Q2 D3 VDD VSS) DEL250D1BWP12T30P140
XD4 (D3 D4 VDD VSS) DEL250D1BWP12T30P140
XQUAL4 (A D4 VDD VSS Q4) sar8p_and2
XD5 (Q4 D5 VDD VSS) DEL250D1BWP12T30P140
XD6 (D5 D6 VDD VSS) DEL250D1BWP12T30P140
XQUAL6 (A D6 VDD VSS Q6) sar8p_and2
XD7 (Q6 D7 VDD VSS) DEL250D1BWP12T30P140
XD8 (D7 D8 VDD VSS) DEL250D1BWP12T30P140
XQUAL8 (A D8 VDD VSS Q8) sar8p_and2
XD9 (Q8 D9 VDD VSS) DEL250D1BWP12T30P140
XD10 (D9 D10 VDD VSS) DEL250D1BWP12T30P140
XQUAL10 (A D10 VDD VSS Q10) sar8p_and2
XD11 (Q10 D11 VDD VSS) DEL250D1BWP12T30P140
XD12 (D11 D12 VDD VSS) DEL250D1BWP12T30P140
XQUAL12 (A D12 VDD VSS Q12) sar8p_and2
XD13 (Q12 D13 VDD VSS) DEL250D1BWP12T30P140
XD14 (D13 D14 VDD VSS) DEL250D1BWP12T30P140
XQUAL14 (A D14 VDD VSS Q14) sar8p_and2
XD15 (Q14 D15 VDD VSS) DEL250D1BWP12T30P140
XD16 (D15 D16 VDD VSS) DEL250D1BWP12T30P140
XQUAL16 (A D16 VDD VSS Q16) sar8p_and2
XD17 (Q16 D17 VDD VSS) DEL250D1BWP12T30P140
XD18 (D17 D18 VDD VSS) DEL250D1BWP12T30P140
XQUAL18 (A D18 VDD VSS Q18) sar8p_and2
XD19 (Q18 D19 VDD VSS) DEL250D1BWP12T30P140
XD20 (D19 D20 VDD VSS) DEL250D1BWP12T30P140
XQUAL20 (A D20 VDD VSS Q20) sar8p_and2
XD21 (Q20 D21 VDD VSS) DEL250D1BWP12T30P140
XD22 (D21 D22 VDD VSS) DEL250D1BWP12T30P140
XQUAL22 (A D22 VDD VSS Q22) sar8p_and2
XD23 (Q22 D23 VDD VSS) DEL250D1BWP12T30P140
XD24 (D23 D24 VDD VSS) DEL250D1BWP12T30P140
XQUAL24 (A D24 VDD VSS Q24) sar8p_and2
XD25 (Q24 D25 VDD VSS) DEL250D1BWP12T30P140
XD26 (D25 D26 VDD VSS) DEL250D1BWP12T30P140
XQUAL26 (A D26 VDD VSS Q26) sar8p_and2
XD27 (Q26 D27 VDD VSS) DEL250D1BWP12T30P140
XD28 (D27 D28 VDD VSS) DEL250D1BWP12T30P140
XQUAL28 (A D28 VDD VSS Q28) sar8p_and2
XD29 (Q28 D29 VDD VSS) DEL250D1BWP12T30P140
XQUAL29 (A D29 VDD VSS Y) sar8p_and2
// BEGIN SARADC RNL
// @RNL(author="saradc topology") {
// #XD1 @SET-SYMBOL $S_DEL250D1BWP12T30P140;
// #XD1 @PLACE(0,0) => @ORIENT("R0");
// #XD2 @SET-SYMBOL $S_DEL250D1BWP12T30P140;
// #XD2 @PLACE(0,-33) => @ORIENT("R0");
// #XQUAL2 @SET-SYMBOL $S_sar8p_and2;
// #XQUAL2 @PLACE(0,-66) => @ORIENT("R0");
// #XD3 @SET-SYMBOL $S_DEL250D1BWP12T30P140;
// #XD3 @PLACE(0,-99) => @ORIENT("R0");
// #XD4 @SET-SYMBOL $S_DEL250D1BWP12T30P140;
// #XD4 @PLACE(0,-132) => @ORIENT("R0");
// #XQUAL4 @SET-SYMBOL $S_sar8p_and2;
// #XQUAL4 @PLACE(0,-165) => @ORIENT("R0");
// #XD5 @SET-SYMBOL $S_DEL250D1BWP12T30P140;
// #XD5 @PLACE(0,-198) => @ORIENT("R0");
// #XD6 @SET-SYMBOL $S_DEL250D1BWP12T30P140;
// #XD6 @PLACE(0,-231) => @ORIENT("R0");
// #XQUAL6 @SET-SYMBOL $S_sar8p_and2;
// #XQUAL6 @PLACE(0,-264) => @ORIENT("R0");
// #XD7 @SET-SYMBOL $S_DEL250D1BWP12T30P140;
// #XD7 @PLACE(0,-297) => @ORIENT("R0");
// #XD8 @SET-SYMBOL $S_DEL250D1BWP12T30P140;
// #XD8 @PLACE(0,-330) => @ORIENT("R0");
// #XQUAL8 @SET-SYMBOL $S_sar8p_and2;
// #XQUAL8 @PLACE(0,-363) => @ORIENT("R0");
// #XD9 @SET-SYMBOL $S_DEL250D1BWP12T30P140;
// #XD9 @PLACE(55,0) => @ORIENT("R0");
// #XD10 @SET-SYMBOL $S_DEL250D1BWP12T30P140;
// #XD10 @PLACE(55,-33) => @ORIENT("R0");
// #XQUAL10 @SET-SYMBOL $S_sar8p_and2;
// #XQUAL10 @PLACE(55,-66) => @ORIENT("R0");
// #XD11 @SET-SYMBOL $S_DEL250D1BWP12T30P140;
// #XD11 @PLACE(55,-99) => @ORIENT("R0");
// #XD12 @SET-SYMBOL $S_DEL250D1BWP12T30P140;
// #XD12 @PLACE(55,-132) => @ORIENT("R0");
// #XQUAL12 @SET-SYMBOL $S_sar8p_and2;
// #XQUAL12 @PLACE(55,-165) => @ORIENT("R0");
// #XD13 @SET-SYMBOL $S_DEL250D1BWP12T30P140;
// #XD13 @PLACE(55,-198) => @ORIENT("R0");
// #XD14 @SET-SYMBOL $S_DEL250D1BWP12T30P140;
// #XD14 @PLACE(55,-231) => @ORIENT("R0");
// #XQUAL14 @SET-SYMBOL $S_sar8p_and2;
// #XQUAL14 @PLACE(55,-264) => @ORIENT("R0");
// #XD15 @SET-SYMBOL $S_DEL250D1BWP12T30P140;
// #XD15 @PLACE(55,-297) => @ORIENT("R0");
// #XD16 @SET-SYMBOL $S_DEL250D1BWP12T30P140;
// #XD16 @PLACE(55,-330) => @ORIENT("R0");
// #XQUAL16 @SET-SYMBOL $S_sar8p_and2;
// #XQUAL16 @PLACE(55,-363) => @ORIENT("R0");
// #XD17 @SET-SYMBOL $S_DEL250D1BWP12T30P140;
// #XD17 @PLACE(110,0) => @ORIENT("R0");
// #XD18 @SET-SYMBOL $S_DEL250D1BWP12T30P140;
// #XD18 @PLACE(110,-33) => @ORIENT("R0");
// #XQUAL18 @SET-SYMBOL $S_sar8p_and2;
// #XQUAL18 @PLACE(110,-66) => @ORIENT("R0");
// #XD19 @SET-SYMBOL $S_DEL250D1BWP12T30P140;
// #XD19 @PLACE(110,-99) => @ORIENT("R0");
// #XD20 @SET-SYMBOL $S_DEL250D1BWP12T30P140;
// #XD20 @PLACE(110,-132) => @ORIENT("R0");
// #XQUAL20 @SET-SYMBOL $S_sar8p_and2;
// #XQUAL20 @PLACE(110,-165) => @ORIENT("R0");
// #XD21 @SET-SYMBOL $S_DEL250D1BWP12T30P140;
// #XD21 @PLACE(110,-198) => @ORIENT("R0");
// #XD22 @SET-SYMBOL $S_DEL250D1BWP12T30P140;
// #XD22 @PLACE(110,-231) => @ORIENT("R0");
// #XQUAL22 @SET-SYMBOL $S_sar8p_and2;
// #XQUAL22 @PLACE(110,-264) => @ORIENT("R0");
// #XD23 @SET-SYMBOL $S_DEL250D1BWP12T30P140;
// #XD23 @PLACE(110,-297) => @ORIENT("R0");
// #XD24 @SET-SYMBOL $S_DEL250D1BWP12T30P140;
// #XD24 @PLACE(110,-330) => @ORIENT("R0");
// #XQUAL24 @SET-SYMBOL $S_sar8p_and2;
// #XQUAL24 @PLACE(110,-363) => @ORIENT("R0");
// #XD25 @SET-SYMBOL $S_DEL250D1BWP12T30P140;
// #XD25 @PLACE(165,0) => @ORIENT("R0");
// #XD26 @SET-SYMBOL $S_DEL250D1BWP12T30P140;
// #XD26 @PLACE(165,-33) => @ORIENT("R0");
// #XQUAL26 @SET-SYMBOL $S_sar8p_and2;
// #XQUAL26 @PLACE(165,-66) => @ORIENT("R0");
// #XD27 @SET-SYMBOL $S_DEL250D1BWP12T30P140;
// #XD27 @PLACE(165,-99) => @ORIENT("R0");
// #XD28 @SET-SYMBOL $S_DEL250D1BWP12T30P140;
// #XD28 @PLACE(165,-132) => @ORIENT("R0");
// #XQUAL28 @SET-SYMBOL $S_sar8p_and2;
// #XQUAL28 @PLACE(165,-165) => @ORIENT("R0");
// #XD29 @SET-SYMBOL $S_DEL250D1BWP12T30P140;
// #XD29 @PLACE(165,-198) => @ORIENT("R0");
// #XQUAL29 @SET-SYMBOL $S_sar8p_and2;
// #XQUAL29 @PLACE(165,-231) => @ORIENT("R0");
// &"D1" @WIRE(mode="straight",linecolor="#30485d",linewidth=0.16) {#XD1:2 (-13,-1.65) (-13,-31.35) #XD2:1};
// &"D2" @WIRE(mode="straight",linecolor="#30485d",linewidth=0.16) {#XD2:2 (-10,-34.65) (-10,-67.7) #XQUAL2:2};
// &"Q2" @WIRE(mode="straight",linecolor="#30485d",linewidth=0.16) {#XQUAL2:5 (-3,-66) (-3,-97.35) #XD3:1};
// &"D3" @WIRE(mode="straight",linecolor="#30485d",linewidth=0.16) {#XD3:2 (-13,-100.65) (-13,-130.35) #XD4:1};
// &"D4" @WIRE(mode="straight",linecolor="#30485d",linewidth=0.16) {#XD4:2 (-10,-133.65) (-10,-166.7) #XQUAL4:2};
// &"Q4" @WIRE(mode="straight",linecolor="#30485d",linewidth=0.16) {#XQUAL4:5 (-3,-165) (-3,-196.35) #XD5:1};
// &"D5" @WIRE(mode="straight",linecolor="#30485d",linewidth=0.16) {#XD5:2 (-13,-199.65) (-13,-229.35) #XD6:1};
// &"D6" @WIRE(mode="straight",linecolor="#30485d",linewidth=0.16) {#XD6:2 (-10,-232.65) (-10,-265.7) #XQUAL6:2};
// &"Q6" @WIRE(mode="straight",linecolor="#30485d",linewidth=0.16) {#XQUAL6:5 (-3,-264) (-3,-295.35) #XD7:1};
// &"D7" @WIRE(mode="straight",linecolor="#30485d",linewidth=0.16) {#XD7:2 (-13,-298.65) (-13,-328.35) #XD8:1};
// &"D8" @WIRE(mode="straight",linecolor="#30485d",linewidth=0.16) {#XD8:2 (-10,-331.65) (-10,-364.7) #XQUAL8:2};
// &"D9" @WIRE(mode="straight",linecolor="#30485d",linewidth=0.16) {#XD9:2 (42,-1.65) (42,-31.35) #XD10:1};
// &"D10" @WIRE(mode="straight",linecolor="#30485d",linewidth=0.16) {#XD10:2 (45,-34.65) (45,-67.7) #XQUAL10:2};
// &"Q10" @WIRE(mode="straight",linecolor="#30485d",linewidth=0.16) {#XQUAL10:5 (52,-66) (52,-97.35) #XD11:1};
// &"D11" @WIRE(mode="straight",linecolor="#30485d",linewidth=0.16) {#XD11:2 (42,-100.65) (42,-130.35) #XD12:1};
// &"D12" @WIRE(mode="straight",linecolor="#30485d",linewidth=0.16) {#XD12:2 (45,-133.65) (45,-166.7) #XQUAL12:2};
// &"Q12" @WIRE(mode="straight",linecolor="#30485d",linewidth=0.16) {#XQUAL12:5 (52,-165) (52,-196.35) #XD13:1};
// &"D13" @WIRE(mode="straight",linecolor="#30485d",linewidth=0.16) {#XD13:2 (42,-199.65) (42,-229.35) #XD14:1};
// &"D14" @WIRE(mode="straight",linecolor="#30485d",linewidth=0.16) {#XD14:2 (45,-232.65) (45,-265.7) #XQUAL14:2};
// &"Q14" @WIRE(mode="straight",linecolor="#30485d",linewidth=0.16) {#XQUAL14:5 (52,-264) (52,-295.35) #XD15:1};
// &"D15" @WIRE(mode="straight",linecolor="#30485d",linewidth=0.16) {#XD15:2 (42,-298.65) (42,-328.35) #XD16:1};
// &"D16" @WIRE(mode="straight",linecolor="#30485d",linewidth=0.16) {#XD16:2 (45,-331.65) (45,-364.7) #XQUAL16:2};
// &"D17" @WIRE(mode="straight",linecolor="#30485d",linewidth=0.16) {#XD17:2 (97,-1.65) (97,-31.35) #XD18:1};
// &"D18" @WIRE(mode="straight",linecolor="#30485d",linewidth=0.16) {#XD18:2 (100,-34.65) (100,-67.7) #XQUAL18:2};
// &"Q18" @WIRE(mode="straight",linecolor="#30485d",linewidth=0.16) {#XQUAL18:5 (107,-66) (107,-97.35) #XD19:1};
// &"D19" @WIRE(mode="straight",linecolor="#30485d",linewidth=0.16) {#XD19:2 (97,-100.65) (97,-130.35) #XD20:1};
// &"D20" @WIRE(mode="straight",linecolor="#30485d",linewidth=0.16) {#XD20:2 (100,-133.65) (100,-166.7) #XQUAL20:2};
// &"Q20" @WIRE(mode="straight",linecolor="#30485d",linewidth=0.16) {#XQUAL20:5 (107,-165) (107,-196.35) #XD21:1};
// &"D21" @WIRE(mode="straight",linecolor="#30485d",linewidth=0.16) {#XD21:2 (97,-199.65) (97,-229.35) #XD22:1};
// &"D22" @WIRE(mode="straight",linecolor="#30485d",linewidth=0.16) {#XD22:2 (100,-232.65) (100,-265.7) #XQUAL22:2};
// &"Q22" @WIRE(mode="straight",linecolor="#30485d",linewidth=0.16) {#XQUAL22:5 (107,-264) (107,-295.35) #XD23:1};
// &"D23" @WIRE(mode="straight",linecolor="#30485d",linewidth=0.16) {#XD23:2 (97,-298.65) (97,-328.35) #XD24:1};
// &"D24" @WIRE(mode="straight",linecolor="#30485d",linewidth=0.16) {#XD24:2 (100,-331.65) (100,-364.7) #XQUAL24:2};
// &"D25" @WIRE(mode="straight",linecolor="#30485d",linewidth=0.16) {#XD25:2 (152,-1.65) (152,-31.35) #XD26:1};
// &"D26" @WIRE(mode="straight",linecolor="#30485d",linewidth=0.16) {#XD26:2 (155,-34.65) (155,-67.7) #XQUAL26:2};
// &"Q26" @WIRE(mode="straight",linecolor="#30485d",linewidth=0.16) {#XQUAL26:5 (162,-66) (162,-97.35) #XD27:1};
// &"D27" @WIRE(mode="straight",linecolor="#30485d",linewidth=0.16) {#XD27:2 (152,-100.65) (152,-130.35) #XD28:1};
// &"D28" @WIRE(mode="straight",linecolor="#30485d",linewidth=0.16) {#XD28:2 (155,-133.65) (155,-166.7) #XQUAL28:2};
// &"Q28" @WIRE(mode="straight",linecolor="#30485d",linewidth=0.16) {#XQUAL28:5 (162,-165) (162,-196.35) #XD29:1};
// &"D29" @WIRE(mode="straight",linecolor="#30485d",linewidth=0.16) {#XD29:2 (155,-199.65) (155,-232.7) #XQUAL29:2};
// (-89,30) @TEXT("sar8i_guard / source-derived connections",size=1.4,halign="start",textcolor="#223d52");
// &"A" @WIRE(mode="straight",linecolor="#30485d",linewidth=0.16) {#XD1:1 (-16,1.65)};
// (-16.4,1.65) @TEXT("A",size=1.1,halign="end",valign="middle");
// &"VDD" @WIRE(mode="straight",linecolor="#30485d",linewidth=0.16) {#XD1:3 (0,11)};
// (0,11.4) @TEXT("VDD",size=1.1,halign="middle",valign="bottom");
// &"VSS" @WIRE(mode="straight",linecolor="#30485d",linewidth=0.16) {#XD1:4 (0,-11)};
// (0,-11.4) @TEXT("VSS",size=1.1,halign="middle",valign="top");
// &"VDD" @WIRE(mode="straight",linecolor="#30485d",linewidth=0.16) {#XD2:3 (0,-22)};
// (0,-21.6) @TEXT("VDD",size=1.1,halign="middle",valign="bottom");
// &"VSS" @WIRE(mode="straight",linecolor="#30485d",linewidth=0.16) {#XD2:4 (0,-44)};
// (0,-44.4) @TEXT("VSS",size=1.1,halign="middle",valign="top");
// &"A" @WIRE(mode="straight",linecolor="#30485d",linewidth=0.16) {#XQUAL2:1 (-10,-64.3)};
// (-10.4,-64.3) @TEXT("A",size=1.1,halign="end",valign="middle");
// &"VDD" @WIRE(mode="straight",linecolor="#30485d",linewidth=0.16) {#XQUAL2:3 (0,-56)};
// (0,-55.6) @TEXT("VDD",size=1.1,halign="middle",valign="bottom");
// &"VSS" @WIRE(mode="straight",linecolor="#30485d",linewidth=0.16) {#XQUAL2:4 (0,-76)};
// (0,-76.4) @TEXT("VSS",size=1.1,halign="middle",valign="top");
// &"VDD" @WIRE(mode="straight",linecolor="#30485d",linewidth=0.16) {#XD3:3 (0,-88)};
// (0,-87.6) @TEXT("VDD",size=1.1,halign="middle",valign="bottom");
// &"VSS" @WIRE(mode="straight",linecolor="#30485d",linewidth=0.16) {#XD3:4 (0,-110)};
// (0,-110.4) @TEXT("VSS",size=1.1,halign="middle",valign="top");
// &"VDD" @WIRE(mode="straight",linecolor="#30485d",linewidth=0.16) {#XD4:3 (0,-121)};
// (0,-120.6) @TEXT("VDD",size=1.1,halign="middle",valign="bottom");
// &"VSS" @WIRE(mode="straight",linecolor="#30485d",linewidth=0.16) {#XD4:4 (0,-143)};
// (0,-143.4) @TEXT("VSS",size=1.1,halign="middle",valign="top");
// &"A" @WIRE(mode="straight",linecolor="#30485d",linewidth=0.16) {#XQUAL4:1 (-10,-163.3)};
// (-10.4,-163.3) @TEXT("A",size=1.1,halign="end",valign="middle");
// &"VDD" @WIRE(mode="straight",linecolor="#30485d",linewidth=0.16) {#XQUAL4:3 (0,-155)};
// (0,-154.6) @TEXT("VDD",size=1.1,halign="middle",valign="bottom");
// &"VSS" @WIRE(mode="straight",linecolor="#30485d",linewidth=0.16) {#XQUAL4:4 (0,-175)};
// (0,-175.4) @TEXT("VSS",size=1.1,halign="middle",valign="top");
// &"VDD" @WIRE(mode="straight",linecolor="#30485d",linewidth=0.16) {#XD5:3 (0,-187)};
// (0,-186.6) @TEXT("VDD",size=1.1,halign="middle",valign="bottom");
// &"VSS" @WIRE(mode="straight",linecolor="#30485d",linewidth=0.16) {#XD5:4 (0,-209)};
// (0,-209.4) @TEXT("VSS",size=1.1,halign="middle",valign="top");
// &"VDD" @WIRE(mode="straight",linecolor="#30485d",linewidth=0.16) {#XD6:3 (0,-220)};
// (0,-219.6) @TEXT("VDD",size=1.1,halign="middle",valign="bottom");
// &"VSS" @WIRE(mode="straight",linecolor="#30485d",linewidth=0.16) {#XD6:4 (0,-242)};
// (0,-242.4) @TEXT("VSS",size=1.1,halign="middle",valign="top");
// &"A" @WIRE(mode="straight",linecolor="#30485d",linewidth=0.16) {#XQUAL6:1 (-10,-262.3)};
// (-10.4,-262.3) @TEXT("A",size=1.1,halign="end",valign="middle");
// &"VDD" @WIRE(mode="straight",linecolor="#30485d",linewidth=0.16) {#XQUAL6:3 (0,-254)};
// (0,-253.6) @TEXT("VDD",size=1.1,halign="middle",valign="bottom");
// &"VSS" @WIRE(mode="straight",linecolor="#30485d",linewidth=0.16) {#XQUAL6:4 (0,-274)};
// (0,-274.4) @TEXT("VSS",size=1.1,halign="middle",valign="top");
// &"VDD" @WIRE(mode="straight",linecolor="#30485d",linewidth=0.16) {#XD7:3 (0,-286)};
// (0,-285.6) @TEXT("VDD",size=1.1,halign="middle",valign="bottom");
// &"VSS" @WIRE(mode="straight",linecolor="#30485d",linewidth=0.16) {#XD7:4 (0,-308)};
// (0,-308.4) @TEXT("VSS",size=1.1,halign="middle",valign="top");
// &"VDD" @WIRE(mode="straight",linecolor="#30485d",linewidth=0.16) {#XD8:3 (0,-319)};
// (0,-318.6) @TEXT("VDD",size=1.1,halign="middle",valign="bottom");
// &"VSS" @WIRE(mode="straight",linecolor="#30485d",linewidth=0.16) {#XD8:4 (0,-341)};
// (0,-341.4) @TEXT("VSS",size=1.1,halign="middle",valign="top");
// &"A" @WIRE(mode="straight",linecolor="#30485d",linewidth=0.16) {#XQUAL8:1 (-10,-361.3)};
// (-10.4,-361.3) @TEXT("A",size=1.1,halign="end",valign="middle");
// &"VDD" @WIRE(mode="straight",linecolor="#30485d",linewidth=0.16) {#XQUAL8:3 (0,-353)};
// (0,-352.6) @TEXT("VDD",size=1.1,halign="middle",valign="bottom");
// &"VSS" @WIRE(mode="straight",linecolor="#30485d",linewidth=0.16) {#XQUAL8:4 (0,-373)};
// (0,-373.4) @TEXT("VSS",size=1.1,halign="middle",valign="top");
// &"Q8" @WIRE(mode="straight",linecolor="#30485d",linewidth=0.16) {#XQUAL8:5 (10,-363)};
// (10.4,-363) @TEXT("Q8",size=1.1,halign="start",valign="middle");
// &"Q8" @WIRE(mode="straight",linecolor="#30485d",linewidth=0.16) {#XD9:1 (39,1.65)};
// (38.6,1.65) @TEXT("Q8",size=1.1,halign="end",valign="middle");
// &"VDD" @WIRE(mode="straight",linecolor="#30485d",linewidth=0.16) {#XD9:3 (55,11)};
// (55,11.4) @TEXT("VDD",size=1.1,halign="middle",valign="bottom");
// &"VSS" @WIRE(mode="straight",linecolor="#30485d",linewidth=0.16) {#XD9:4 (55,-11)};
// (55,-11.4) @TEXT("VSS",size=1.1,halign="middle",valign="top");
// &"VDD" @WIRE(mode="straight",linecolor="#30485d",linewidth=0.16) {#XD10:3 (55,-22)};
// (55,-21.6) @TEXT("VDD",size=1.1,halign="middle",valign="bottom");
// &"VSS" @WIRE(mode="straight",linecolor="#30485d",linewidth=0.16) {#XD10:4 (55,-44)};
// (55,-44.4) @TEXT("VSS",size=1.1,halign="middle",valign="top");
// &"A" @WIRE(mode="straight",linecolor="#30485d",linewidth=0.16) {#XQUAL10:1 (45,-64.3)};
// (44.6,-64.3) @TEXT("A",size=1.1,halign="end",valign="middle");
// &"VDD" @WIRE(mode="straight",linecolor="#30485d",linewidth=0.16) {#XQUAL10:3 (55,-56)};
// (55,-55.6) @TEXT("VDD",size=1.1,halign="middle",valign="bottom");
// &"VSS" @WIRE(mode="straight",linecolor="#30485d",linewidth=0.16) {#XQUAL10:4 (55,-76)};
// (55,-76.4) @TEXT("VSS",size=1.1,halign="middle",valign="top");
// &"VDD" @WIRE(mode="straight",linecolor="#30485d",linewidth=0.16) {#XD11:3 (55,-88)};
// (55,-87.6) @TEXT("VDD",size=1.1,halign="middle",valign="bottom");
// &"VSS" @WIRE(mode="straight",linecolor="#30485d",linewidth=0.16) {#XD11:4 (55,-110)};
// (55,-110.4) @TEXT("VSS",size=1.1,halign="middle",valign="top");
// &"VDD" @WIRE(mode="straight",linecolor="#30485d",linewidth=0.16) {#XD12:3 (55,-121)};
// (55,-120.6) @TEXT("VDD",size=1.1,halign="middle",valign="bottom");
// &"VSS" @WIRE(mode="straight",linecolor="#30485d",linewidth=0.16) {#XD12:4 (55,-143)};
// (55,-143.4) @TEXT("VSS",size=1.1,halign="middle",valign="top");
// &"A" @WIRE(mode="straight",linecolor="#30485d",linewidth=0.16) {#XQUAL12:1 (45,-163.3)};
// (44.6,-163.3) @TEXT("A",size=1.1,halign="end",valign="middle");
// &"VDD" @WIRE(mode="straight",linecolor="#30485d",linewidth=0.16) {#XQUAL12:3 (55,-155)};
// (55,-154.6) @TEXT("VDD",size=1.1,halign="middle",valign="bottom");
// &"VSS" @WIRE(mode="straight",linecolor="#30485d",linewidth=0.16) {#XQUAL12:4 (55,-175)};
// (55,-175.4) @TEXT("VSS",size=1.1,halign="middle",valign="top");
// &"VDD" @WIRE(mode="straight",linecolor="#30485d",linewidth=0.16) {#XD13:3 (55,-187)};
// (55,-186.6) @TEXT("VDD",size=1.1,halign="middle",valign="bottom");
// &"VSS" @WIRE(mode="straight",linecolor="#30485d",linewidth=0.16) {#XD13:4 (55,-209)};
// (55,-209.4) @TEXT("VSS",size=1.1,halign="middle",valign="top");
// &"VDD" @WIRE(mode="straight",linecolor="#30485d",linewidth=0.16) {#XD14:3 (55,-220)};
// (55,-219.6) @TEXT("VDD",size=1.1,halign="middle",valign="bottom");
// &"VSS" @WIRE(mode="straight",linecolor="#30485d",linewidth=0.16) {#XD14:4 (55,-242)};
// (55,-242.4) @TEXT("VSS",size=1.1,halign="middle",valign="top");
// &"A" @WIRE(mode="straight",linecolor="#30485d",linewidth=0.16) {#XQUAL14:1 (45,-262.3)};
// (44.6,-262.3) @TEXT("A",size=1.1,halign="end",valign="middle");
// &"VDD" @WIRE(mode="straight",linecolor="#30485d",linewidth=0.16) {#XQUAL14:3 (55,-254)};
// (55,-253.6) @TEXT("VDD",size=1.1,halign="middle",valign="bottom");
// &"VSS" @WIRE(mode="straight",linecolor="#30485d",linewidth=0.16) {#XQUAL14:4 (55,-274)};
// (55,-274.4) @TEXT("VSS",size=1.1,halign="middle",valign="top");
// &"VDD" @WIRE(mode="straight",linecolor="#30485d",linewidth=0.16) {#XD15:3 (55,-286)};
// (55,-285.6) @TEXT("VDD",size=1.1,halign="middle",valign="bottom");
// &"VSS" @WIRE(mode="straight",linecolor="#30485d",linewidth=0.16) {#XD15:4 (55,-308)};
// (55,-308.4) @TEXT("VSS",size=1.1,halign="middle",valign="top");
// &"VDD" @WIRE(mode="straight",linecolor="#30485d",linewidth=0.16) {#XD16:3 (55,-319)};
// (55,-318.6) @TEXT("VDD",size=1.1,halign="middle",valign="bottom");
// &"VSS" @WIRE(mode="straight",linecolor="#30485d",linewidth=0.16) {#XD16:4 (55,-341)};
// (55,-341.4) @TEXT("VSS",size=1.1,halign="middle",valign="top");
// &"A" @WIRE(mode="straight",linecolor="#30485d",linewidth=0.16) {#XQUAL16:1 (45,-361.3)};
// (44.6,-361.3) @TEXT("A",size=1.1,halign="end",valign="middle");
// &"VDD" @WIRE(mode="straight",linecolor="#30485d",linewidth=0.16) {#XQUAL16:3 (55,-353)};
// (55,-352.6) @TEXT("VDD",size=1.1,halign="middle",valign="bottom");
// &"VSS" @WIRE(mode="straight",linecolor="#30485d",linewidth=0.16) {#XQUAL16:4 (55,-373)};
// (55,-373.4) @TEXT("VSS",size=1.1,halign="middle",valign="top");
// &"Q16" @WIRE(mode="straight",linecolor="#30485d",linewidth=0.16) {#XQUAL16:5 (65,-363)};
// (65.4,-363) @TEXT("Q16",size=1.1,halign="start",valign="middle");
// &"Q16" @WIRE(mode="straight",linecolor="#30485d",linewidth=0.16) {#XD17:1 (94,1.65)};
// (93.6,1.65) @TEXT("Q16",size=1.1,halign="end",valign="middle");
// &"VDD" @WIRE(mode="straight",linecolor="#30485d",linewidth=0.16) {#XD17:3 (110,11)};
// (110,11.4) @TEXT("VDD",size=1.1,halign="middle",valign="bottom");
// &"VSS" @WIRE(mode="straight",linecolor="#30485d",linewidth=0.16) {#XD17:4 (110,-11)};
// (110,-11.4) @TEXT("VSS",size=1.1,halign="middle",valign="top");
// &"VDD" @WIRE(mode="straight",linecolor="#30485d",linewidth=0.16) {#XD18:3 (110,-22)};
// (110,-21.6) @TEXT("VDD",size=1.1,halign="middle",valign="bottom");
// &"VSS" @WIRE(mode="straight",linecolor="#30485d",linewidth=0.16) {#XD18:4 (110,-44)};
// (110,-44.4) @TEXT("VSS",size=1.1,halign="middle",valign="top");
// &"A" @WIRE(mode="straight",linecolor="#30485d",linewidth=0.16) {#XQUAL18:1 (100,-64.3)};
// (99.6,-64.3) @TEXT("A",size=1.1,halign="end",valign="middle");
// &"VDD" @WIRE(mode="straight",linecolor="#30485d",linewidth=0.16) {#XQUAL18:3 (110,-56)};
// (110,-55.6) @TEXT("VDD",size=1.1,halign="middle",valign="bottom");
// &"VSS" @WIRE(mode="straight",linecolor="#30485d",linewidth=0.16) {#XQUAL18:4 (110,-76)};
// (110,-76.4) @TEXT("VSS",size=1.1,halign="middle",valign="top");
// &"VDD" @WIRE(mode="straight",linecolor="#30485d",linewidth=0.16) {#XD19:3 (110,-88)};
// (110,-87.6) @TEXT("VDD",size=1.1,halign="middle",valign="bottom");
// &"VSS" @WIRE(mode="straight",linecolor="#30485d",linewidth=0.16) {#XD19:4 (110,-110)};
// (110,-110.4) @TEXT("VSS",size=1.1,halign="middle",valign="top");
// &"VDD" @WIRE(mode="straight",linecolor="#30485d",linewidth=0.16) {#XD20:3 (110,-121)};
// (110,-120.6) @TEXT("VDD",size=1.1,halign="middle",valign="bottom");
// &"VSS" @WIRE(mode="straight",linecolor="#30485d",linewidth=0.16) {#XD20:4 (110,-143)};
// (110,-143.4) @TEXT("VSS",size=1.1,halign="middle",valign="top");
// &"A" @WIRE(mode="straight",linecolor="#30485d",linewidth=0.16) {#XQUAL20:1 (100,-163.3)};
// (99.6,-163.3) @TEXT("A",size=1.1,halign="end",valign="middle");
// &"VDD" @WIRE(mode="straight",linecolor="#30485d",linewidth=0.16) {#XQUAL20:3 (110,-155)};
// (110,-154.6) @TEXT("VDD",size=1.1,halign="middle",valign="bottom");
// &"VSS" @WIRE(mode="straight",linecolor="#30485d",linewidth=0.16) {#XQUAL20:4 (110,-175)};
// (110,-175.4) @TEXT("VSS",size=1.1,halign="middle",valign="top");
// &"VDD" @WIRE(mode="straight",linecolor="#30485d",linewidth=0.16) {#XD21:3 (110,-187)};
// (110,-186.6) @TEXT("VDD",size=1.1,halign="middle",valign="bottom");
// &"VSS" @WIRE(mode="straight",linecolor="#30485d",linewidth=0.16) {#XD21:4 (110,-209)};
// (110,-209.4) @TEXT("VSS",size=1.1,halign="middle",valign="top");
// &"VDD" @WIRE(mode="straight",linecolor="#30485d",linewidth=0.16) {#XD22:3 (110,-220)};
// (110,-219.6) @TEXT("VDD",size=1.1,halign="middle",valign="bottom");
// &"VSS" @WIRE(mode="straight",linecolor="#30485d",linewidth=0.16) {#XD22:4 (110,-242)};
// (110,-242.4) @TEXT("VSS",size=1.1,halign="middle",valign="top");
// &"A" @WIRE(mode="straight",linecolor="#30485d",linewidth=0.16) {#XQUAL22:1 (100,-262.3)};
// (99.6,-262.3) @TEXT("A",size=1.1,halign="end",valign="middle");
// &"VDD" @WIRE(mode="straight",linecolor="#30485d",linewidth=0.16) {#XQUAL22:3 (110,-254)};
// (110,-253.6) @TEXT("VDD",size=1.1,halign="middle",valign="bottom");
// &"VSS" @WIRE(mode="straight",linecolor="#30485d",linewidth=0.16) {#XQUAL22:4 (110,-274)};
// (110,-274.4) @TEXT("VSS",size=1.1,halign="middle",valign="top");
// &"VDD" @WIRE(mode="straight",linecolor="#30485d",linewidth=0.16) {#XD23:3 (110,-286)};
// (110,-285.6) @TEXT("VDD",size=1.1,halign="middle",valign="bottom");
// &"VSS" @WIRE(mode="straight",linecolor="#30485d",linewidth=0.16) {#XD23:4 (110,-308)};
// (110,-308.4) @TEXT("VSS",size=1.1,halign="middle",valign="top");
// &"VDD" @WIRE(mode="straight",linecolor="#30485d",linewidth=0.16) {#XD24:3 (110,-319)};
// (110,-318.6) @TEXT("VDD",size=1.1,halign="middle",valign="bottom");
// &"VSS" @WIRE(mode="straight",linecolor="#30485d",linewidth=0.16) {#XD24:4 (110,-341)};
// (110,-341.4) @TEXT("VSS",size=1.1,halign="middle",valign="top");
// &"A" @WIRE(mode="straight",linecolor="#30485d",linewidth=0.16) {#XQUAL24:1 (100,-361.3)};
// (99.6,-361.3) @TEXT("A",size=1.1,halign="end",valign="middle");
// &"VDD" @WIRE(mode="straight",linecolor="#30485d",linewidth=0.16) {#XQUAL24:3 (110,-353)};
// (110,-352.6) @TEXT("VDD",size=1.1,halign="middle",valign="bottom");
// &"VSS" @WIRE(mode="straight",linecolor="#30485d",linewidth=0.16) {#XQUAL24:4 (110,-373)};
// (110,-373.4) @TEXT("VSS",size=1.1,halign="middle",valign="top");
// &"Q24" @WIRE(mode="straight",linecolor="#30485d",linewidth=0.16) {#XQUAL24:5 (120,-363)};
// (120.4,-363) @TEXT("Q24",size=1.1,halign="start",valign="middle");
// &"Q24" @WIRE(mode="straight",linecolor="#30485d",linewidth=0.16) {#XD25:1 (149,1.65)};
// (148.6,1.65) @TEXT("Q24",size=1.1,halign="end",valign="middle");
// &"VDD" @WIRE(mode="straight",linecolor="#30485d",linewidth=0.16) {#XD25:3 (165,11)};
// (165,11.4) @TEXT("VDD",size=1.1,halign="middle",valign="bottom");
// &"VSS" @WIRE(mode="straight",linecolor="#30485d",linewidth=0.16) {#XD25:4 (165,-11)};
// (165,-11.4) @TEXT("VSS",size=1.1,halign="middle",valign="top");
// &"VDD" @WIRE(mode="straight",linecolor="#30485d",linewidth=0.16) {#XD26:3 (165,-22)};
// (165,-21.6) @TEXT("VDD",size=1.1,halign="middle",valign="bottom");
// &"VSS" @WIRE(mode="straight",linecolor="#30485d",linewidth=0.16) {#XD26:4 (165,-44)};
// (165,-44.4) @TEXT("VSS",size=1.1,halign="middle",valign="top");
// &"A" @WIRE(mode="straight",linecolor="#30485d",linewidth=0.16) {#XQUAL26:1 (155,-64.3)};
// (154.6,-64.3) @TEXT("A",size=1.1,halign="end",valign="middle");
// &"VDD" @WIRE(mode="straight",linecolor="#30485d",linewidth=0.16) {#XQUAL26:3 (165,-56)};
// (165,-55.6) @TEXT("VDD",size=1.1,halign="middle",valign="bottom");
// &"VSS" @WIRE(mode="straight",linecolor="#30485d",linewidth=0.16) {#XQUAL26:4 (165,-76)};
// (165,-76.4) @TEXT("VSS",size=1.1,halign="middle",valign="top");
// &"VDD" @WIRE(mode="straight",linecolor="#30485d",linewidth=0.16) {#XD27:3 (165,-88)};
// (165,-87.6) @TEXT("VDD",size=1.1,halign="middle",valign="bottom");
// &"VSS" @WIRE(mode="straight",linecolor="#30485d",linewidth=0.16) {#XD27:4 (165,-110)};
// (165,-110.4) @TEXT("VSS",size=1.1,halign="middle",valign="top");
// &"VDD" @WIRE(mode="straight",linecolor="#30485d",linewidth=0.16) {#XD28:3 (165,-121)};
// (165,-120.6) @TEXT("VDD",size=1.1,halign="middle",valign="bottom");
// &"VSS" @WIRE(mode="straight",linecolor="#30485d",linewidth=0.16) {#XD28:4 (165,-143)};
// (165,-143.4) @TEXT("VSS",size=1.1,halign="middle",valign="top");
// &"A" @WIRE(mode="straight",linecolor="#30485d",linewidth=0.16) {#XQUAL28:1 (155,-163.3)};
// (154.6,-163.3) @TEXT("A",size=1.1,halign="end",valign="middle");
// &"VDD" @WIRE(mode="straight",linecolor="#30485d",linewidth=0.16) {#XQUAL28:3 (165,-155)};
// (165,-154.6) @TEXT("VDD",size=1.1,halign="middle",valign="bottom");
// &"VSS" @WIRE(mode="straight",linecolor="#30485d",linewidth=0.16) {#XQUAL28:4 (165,-175)};
// (165,-175.4) @TEXT("VSS",size=1.1,halign="middle",valign="top");
// &"VDD" @WIRE(mode="straight",linecolor="#30485d",linewidth=0.16) {#XD29:3 (165,-187)};
// (165,-186.6) @TEXT("VDD",size=1.1,halign="middle",valign="bottom");
// &"VSS" @WIRE(mode="straight",linecolor="#30485d",linewidth=0.16) {#XD29:4 (165,-209)};
// (165,-209.4) @TEXT("VSS",size=1.1,halign="middle",valign="top");
// &"A" @WIRE(mode="straight",linecolor="#30485d",linewidth=0.16) {#XQUAL29:1 (155,-229.3)};
// (154.6,-229.3) @TEXT("A",size=1.1,halign="end",valign="middle");
// &"VDD" @WIRE(mode="straight",linecolor="#30485d",linewidth=0.16) {#XQUAL29:3 (165,-221)};
// (165,-220.6) @TEXT("VDD",size=1.1,halign="middle",valign="bottom");
// &"VSS" @WIRE(mode="straight",linecolor="#30485d",linewidth=0.16) {#XQUAL29:4 (165,-241)};
// (165,-241.4) @TEXT("VSS",size=1.1,halign="middle",valign="top");
// &"Y" @WIRE(mode="straight",linecolor="#30485d",linewidth=0.16) {#XQUAL29:5 (175,-231)};
// (175.4,-231) @TEXT("Y",size=1.1,halign="start",valign="middle");
// }
// END SARADC RNL
ends sar8i_guard

subckt sar8i_refword CODE0 CODE1 CODE2 CODE3 CODE4 CODE5 CODE6 CODE7 D0 D1  D2 D3 D4 D5 D6 D7 GNN0 GNN1 GNN2 GNN3 GNN4 GNN5 GNN6 GNN7 GNP0  GNP1 GNP2 GNP3 GNP4 GNP5 GNP6 GNP7 GPN0 GPN1 GPN2 GPN3 GPN4 GPN5  GPN6 GPN7 GPP0 GPP1 GPP2 GPP3 GPP4 GPP5 GPP6 GPP7 PHI_U SAMPLE VDD  VSS RST_DONE PRESET
XPRESET_N (PRESET VDD VSS RUN) sar8p_inv
XINITIAL0 (CODE0 RUN VDD VSS QN0) sar8p_nand2
XPN0 (QN0 VDD VSS GPN0) sar8p_inv
XNN0 (QN0 VDD VSS GNN0) sar8p_buf
WNP0 (GNN0 GNP0) iprobe
WPP0 (GPN0 GPP0) iprobe
XINITIAL1 (CODE1 RUN VDD VSS QN1) sar8p_nand2
XPN1 (QN1 VDD VSS GPN1) sar8p_inv
XNN1 (QN1 VDD VSS GNN1) sar8p_buf
WNP1 (GNN1 GNP1) iprobe
WPP1 (GPN1 GPP1) iprobe
XINITIAL2 (CODE2 RUN VDD VSS QN2) sar8p_nand2
XPN2 (QN2 VDD VSS GPN2) sar8p_inv
XNN2 (QN2 VDD VSS GNN2) sar8p_buf
WNP2 (GNN2 GNP2) iprobe
WPP2 (GPN2 GPP2) iprobe
XINITIAL3 (CODE3 RUN VDD VSS QN3) sar8p_nand2
XPN3 (QN3 VDD VSS GPN3) sar8p_inv
XNN3 (QN3 VDD VSS GNN3) sar8p_buf
WNP3 (GNN3 GNP3) iprobe
WPP3 (GPN3 GPP3) iprobe
XINITIAL4 (CODE4 RUN VDD VSS QN4) sar8p_nand2
XPN4 (QN4 VDD VSS GPN4) sar8p_inv
XNN4 (QN4 VDD VSS GNN4) sar8p_buf
WNP4 (GNN4 GNP4) iprobe
WPP4 (GPN4 GPP4) iprobe
XINITIAL5 (CODE5 RUN VDD VSS QN5) sar8p_nand2
XPN5 (QN5 VDD VSS GPN5) sar8p_inv
XNN5 (QN5 VDD VSS GNN5) sar8p_buf
WNP5 (GNN5 GNP5) iprobe
WPP5 (GPN5 GPP5) iprobe
XINITIAL6 (CODE6 RUN VDD VSS QN6) sar8p_nand2
XPN6 (QN6 VDD VSS GPN6) sar8p_inv
XNN6 (QN6 VDD VSS GNN6) sar8p_buf
WNP6 (GNN6 GNP6) iprobe
WPP6 (GPN6 GPP6) iprobe
XINITIAL7 (CODE7 PRESET VDD VSS Q7) sar8p_or2
XINV7 (Q7 VDD VSS QN7) sar8p_inv
XPN7 (QN7 GPN7 VDD VSS) INVD2BWP12T30P140
XNN7 (QN7 VDD VSS GNN7) sar8ref_buf_d2
WNP7 (GNN7 GNP7) iprobe
WPP7 (GPN7 GPP7) iprobe
WUNUSED (RST_DONE VSS) iprobe
// BEGIN SARADC RNL
// @RNL(author="saradc topology") {
// #XPRESET_N @SET-SYMBOL $S_sar8p_inv;
// #XPRESET_N @PLACE(0,0) => @ORIENT("R0");
// #XINITIAL0 @SET-SYMBOL $S_sar8p_nand2;
// #XINITIAL0 @PLACE(0,-33) => @ORIENT("R0");
// #XPN0 @SET-SYMBOL $S_sar8p_inv;
// #XPN0 @PLACE(0,-66) => @ORIENT("R0");
// #XNN0 @SET-SYMBOL $S_sar8p_buf;
// #XNN0 @PLACE(0,-99) => @ORIENT("R0");
// #WNP0 @SET-SYMBOL $S_iprobe;
// #WNP0 @PLACE(0,-132) => @ORIENT("R0");
// #WPP0 @SET-SYMBOL $S_iprobe;
// #WPP0 @PLACE(0,-165) => @ORIENT("R0");
// #XINITIAL1 @SET-SYMBOL $S_sar8p_nand2;
// #XINITIAL1 @PLACE(0,-198) => @ORIENT("R0");
// #XPN1 @SET-SYMBOL $S_sar8p_inv;
// #XPN1 @PLACE(0,-231) => @ORIENT("R0");
// #XNN1 @SET-SYMBOL $S_sar8p_buf;
// #XNN1 @PLACE(0,-264) => @ORIENT("R0");
// #WNP1 @SET-SYMBOL $S_iprobe;
// #WNP1 @PLACE(0,-297) => @ORIENT("R0");
// #WPP1 @SET-SYMBOL $S_iprobe;
// #WPP1 @PLACE(0,-330) => @ORIENT("R0");
// #XINITIAL2 @SET-SYMBOL $S_sar8p_nand2;
// #XINITIAL2 @PLACE(0,-363) => @ORIENT("R0");
// #XPN2 @SET-SYMBOL $S_sar8p_inv;
// #XPN2 @PLACE(55,0) => @ORIENT("R0");
// #XNN2 @SET-SYMBOL $S_sar8p_buf;
// #XNN2 @PLACE(55,-33) => @ORIENT("R0");
// #WNP2 @SET-SYMBOL $S_iprobe;
// #WNP2 @PLACE(55,-66) => @ORIENT("R0");
// #WPP2 @SET-SYMBOL $S_iprobe;
// #WPP2 @PLACE(55,-99) => @ORIENT("R0");
// #XINITIAL3 @SET-SYMBOL $S_sar8p_nand2;
// #XINITIAL3 @PLACE(55,-132) => @ORIENT("R0");
// #XPN3 @SET-SYMBOL $S_sar8p_inv;
// #XPN3 @PLACE(55,-165) => @ORIENT("R0");
// #XNN3 @SET-SYMBOL $S_sar8p_buf;
// #XNN3 @PLACE(55,-198) => @ORIENT("R0");
// #WNP3 @SET-SYMBOL $S_iprobe;
// #WNP3 @PLACE(55,-231) => @ORIENT("R0");
// #WPP3 @SET-SYMBOL $S_iprobe;
// #WPP3 @PLACE(55,-264) => @ORIENT("R0");
// #XINITIAL4 @SET-SYMBOL $S_sar8p_nand2;
// #XINITIAL4 @PLACE(55,-297) => @ORIENT("R0");
// #XPN4 @SET-SYMBOL $S_sar8p_inv;
// #XPN4 @PLACE(55,-330) => @ORIENT("R0");
// #XNN4 @SET-SYMBOL $S_sar8p_buf;
// #XNN4 @PLACE(55,-363) => @ORIENT("R0");
// #WNP4 @SET-SYMBOL $S_iprobe;
// #WNP4 @PLACE(110,0) => @ORIENT("R0");
// #WPP4 @SET-SYMBOL $S_iprobe;
// #WPP4 @PLACE(110,-33) => @ORIENT("R0");
// #XINITIAL5 @SET-SYMBOL $S_sar8p_nand2;
// #XINITIAL5 @PLACE(110,-66) => @ORIENT("R0");
// #XPN5 @SET-SYMBOL $S_sar8p_inv;
// #XPN5 @PLACE(110,-99) => @ORIENT("R0");
// #XNN5 @SET-SYMBOL $S_sar8p_buf;
// #XNN5 @PLACE(110,-132) => @ORIENT("R0");
// #WNP5 @SET-SYMBOL $S_iprobe;
// #WNP5 @PLACE(110,-165) => @ORIENT("R0");
// #WPP5 @SET-SYMBOL $S_iprobe;
// #WPP5 @PLACE(110,-198) => @ORIENT("R0");
// #XINITIAL6 @SET-SYMBOL $S_sar8p_nand2;
// #XINITIAL6 @PLACE(110,-231) => @ORIENT("R0");
// #XPN6 @SET-SYMBOL $S_sar8p_inv;
// #XPN6 @PLACE(110,-264) => @ORIENT("R0");
// #XNN6 @SET-SYMBOL $S_sar8p_buf;
// #XNN6 @PLACE(110,-297) => @ORIENT("R0");
// #WNP6 @SET-SYMBOL $S_iprobe;
// #WNP6 @PLACE(110,-330) => @ORIENT("R0");
// #WPP6 @SET-SYMBOL $S_iprobe;
// #WPP6 @PLACE(110,-363) => @ORIENT("R0");
// #XINITIAL7 @SET-SYMBOL $S_sar8p_or2;
// #XINITIAL7 @PLACE(165,0) => @ORIENT("R0");
// #XINV7 @SET-SYMBOL $S_sar8p_inv;
// #XINV7 @PLACE(165,-33) => @ORIENT("R0");
// #XPN7 @SET-SYMBOL $S_INVD2BWP12T30P140;
// #XPN7 @PLACE(165,-66) => @ORIENT("R0");
// #XNN7 @SET-SYMBOL $S_sar8ref_buf_d2;
// #XNN7 @PLACE(165,-99) => @ORIENT("R0");
// #WNP7 @SET-SYMBOL $S_iprobe;
// #WNP7 @PLACE(165,-132) => @ORIENT("R0");
// #WPP7 @SET-SYMBOL $S_iprobe;
// #WPP7 @PLACE(165,-165) => @ORIENT("R0");
// #WUNUSED @SET-SYMBOL $S_iprobe;
// #WUNUSED @PLACE(165,-198) => @ORIENT("R0");
// &"GPN0" @WIRE(mode="straight",linecolor="#30485d",linewidth=0.16) {#XPN0:4 (-3,-66) (-3,-163.35) #WPP0:1};
// &"GNN0" @WIRE(mode="straight",linecolor="#30485d",linewidth=0.16) {#XNN0:4 (-3,-99) (-3,-130.35) #WNP0:1};
// &"GPN1" @WIRE(mode="straight",linecolor="#30485d",linewidth=0.16) {#XPN1:4 (-3,-231) (-3,-328.35) #WPP1:1};
// &"GNN1" @WIRE(mode="straight",linecolor="#30485d",linewidth=0.16) {#XNN1:4 (-3,-264) (-3,-295.35) #WNP1:1};
// &"GPN2" @WIRE(mode="straight",linecolor="#30485d",linewidth=0.16) {#XPN2:4 (52,0) (52,-97.35) #WPP2:1};
// &"GNN2" @WIRE(mode="straight",linecolor="#30485d",linewidth=0.16) {#XNN2:4 (52,-33) (52,-64.35) #WNP2:1};
// &"GPN3" @WIRE(mode="straight",linecolor="#30485d",linewidth=0.16) {#XPN3:4 (52,-165) (52,-262.35) #WPP3:1};
// &"GNN3" @WIRE(mode="straight",linecolor="#30485d",linewidth=0.16) {#XNN3:4 (52,-198) (52,-229.35) #WNP3:1};
// &"GPN5" @WIRE(mode="straight",linecolor="#30485d",linewidth=0.16) {#XPN5:4 (107,-99) (107,-196.35) #WPP5:1};
// &"GNN5" @WIRE(mode="straight",linecolor="#30485d",linewidth=0.16) {#XNN5:4 (107,-132) (107,-163.35) #WNP5:1};
// &"GPN6" @WIRE(mode="straight",linecolor="#30485d",linewidth=0.16) {#XPN6:4 (107,-264) (107,-361.35) #WPP6:1};
// &"GNN6" @WIRE(mode="straight",linecolor="#30485d",linewidth=0.16) {#XNN6:4 (107,-297) (107,-328.35) #WNP6:1};
// &"Q7" @WIRE(mode="straight",linecolor="#30485d",linewidth=0.16) {#XINITIAL7:5 (165,0) (165,-33) #XINV7:1};
// &"GPN7" @WIRE(mode="straight",linecolor="#30485d",linewidth=0.16) {#XPN7:2 (152,-67.65) (152,-163.35) #WPP7:1};
// &"GNN7" @WIRE(mode="straight",linecolor="#30485d",linewidth=0.16) {#XNN7:4 (165,-99) (165,-130.35) #WNP7:1};
// (-89,30) @TEXT("sar8i_refword / source-derived connections",size=1.4,halign="start",textcolor="#223d52");
// &"PRESET" @WIRE(mode="straight",linecolor="#30485d",linewidth=0.16) {#XPRESET_N:1 (-10,0)};
// (-10.4,0) @TEXT("PRESET",size=1.1,halign="end",valign="middle");
// &"VDD" @WIRE(mode="straight",linecolor="#30485d",linewidth=0.16) {#XPRESET_N:2 (0,10)};
// (0,10.4) @TEXT("VDD",size=1.1,halign="middle",valign="bottom");
// &"VSS" @WIRE(mode="straight",linecolor="#30485d",linewidth=0.16) {#XPRESET_N:3 (0,-10)};
// (0,-10.4) @TEXT("VSS",size=1.1,halign="middle",valign="top");
// &"RUN" @WIRE(mode="straight",linecolor="#30485d",linewidth=0.16) {#XPRESET_N:4 (10,0)};
// (10.4,0) @TEXT("RUN",size=1.1,halign="start",valign="middle");
// &"CODE0" @WIRE(mode="straight",linecolor="#30485d",linewidth=0.16) {#XINITIAL0:1 (-10,-31.3)};
// (-10.4,-31.3) @TEXT("CODE0",size=1.1,halign="end",valign="middle");
// &"RUN" @WIRE(mode="straight",linecolor="#30485d",linewidth=0.16) {#XINITIAL0:2 (-10,-34.7)};
// (-10.4,-34.7) @TEXT("RUN",size=1.1,halign="end",valign="middle");
// &"VDD" @WIRE(mode="straight",linecolor="#30485d",linewidth=0.16) {#XINITIAL0:3 (0,-23)};
// (0,-22.6) @TEXT("VDD",size=1.1,halign="middle",valign="bottom");
// &"VSS" @WIRE(mode="straight",linecolor="#30485d",linewidth=0.16) {#XINITIAL0:4 (0,-43)};
// (0,-43.4) @TEXT("VSS",size=1.1,halign="middle",valign="top");
// &"QN0" @WIRE(mode="straight",linecolor="#30485d",linewidth=0.16) {#XINITIAL0:5 (10,-33)};
// (10.4,-33) @TEXT("QN0",size=1.1,halign="start",valign="middle");
// &"QN0" @WIRE(mode="straight",linecolor="#30485d",linewidth=0.16) {#XPN0:1 (-10,-66)};
// (-10.4,-66) @TEXT("QN0",size=1.1,halign="end",valign="middle");
// &"VDD" @WIRE(mode="straight",linecolor="#30485d",linewidth=0.16) {#XPN0:2 (0,-56)};
// (0,-55.6) @TEXT("VDD",size=1.1,halign="middle",valign="bottom");
// &"VSS" @WIRE(mode="straight",linecolor="#30485d",linewidth=0.16) {#XPN0:3 (0,-76)};
// (0,-76.4) @TEXT("VSS",size=1.1,halign="middle",valign="top");
// &"QN0" @WIRE(mode="straight",linecolor="#30485d",linewidth=0.16) {#XNN0:1 (-10,-99)};
// (-10.4,-99) @TEXT("QN0",size=1.1,halign="end",valign="middle");
// &"VDD" @WIRE(mode="straight",linecolor="#30485d",linewidth=0.16) {#XNN0:2 (0,-89)};
// (0,-88.6) @TEXT("VDD",size=1.1,halign="middle",valign="bottom");
// &"VSS" @WIRE(mode="straight",linecolor="#30485d",linewidth=0.16) {#XNN0:3 (0,-109)};
// (0,-109.4) @TEXT("VSS",size=1.1,halign="middle",valign="top");
// &"GNP0" @WIRE(mode="straight",linecolor="#30485d",linewidth=0.16) {#WNP0:2 (-16,-133.65)};
// (-16.4,-133.65) @TEXT("GNP0",size=1.1,halign="end",valign="middle");
// &"GPP0" @WIRE(mode="straight",linecolor="#30485d",linewidth=0.16) {#WPP0:2 (-16,-166.65)};
// (-16.4,-166.65) @TEXT("GPP0",size=1.1,halign="end",valign="middle");
// &"CODE1" @WIRE(mode="straight",linecolor="#30485d",linewidth=0.16) {#XINITIAL1:1 (-10,-196.3)};
// (-10.4,-196.3) @TEXT("CODE1",size=1.1,halign="end",valign="middle");
// &"RUN" @WIRE(mode="straight",linecolor="#30485d",linewidth=0.16) {#XINITIAL1:2 (-10,-199.7)};
// (-10.4,-199.7) @TEXT("RUN",size=1.1,halign="end",valign="middle");
// &"VDD" @WIRE(mode="straight",linecolor="#30485d",linewidth=0.16) {#XINITIAL1:3 (0,-188)};
// (0,-187.6) @TEXT("VDD",size=1.1,halign="middle",valign="bottom");
// &"VSS" @WIRE(mode="straight",linecolor="#30485d",linewidth=0.16) {#XINITIAL1:4 (0,-208)};
// (0,-208.4) @TEXT("VSS",size=1.1,halign="middle",valign="top");
// &"QN1" @WIRE(mode="straight",linecolor="#30485d",linewidth=0.16) {#XINITIAL1:5 (10,-198)};
// (10.4,-198) @TEXT("QN1",size=1.1,halign="start",valign="middle");
// &"QN1" @WIRE(mode="straight",linecolor="#30485d",linewidth=0.16) {#XPN1:1 (-10,-231)};
// (-10.4,-231) @TEXT("QN1",size=1.1,halign="end",valign="middle");
// &"VDD" @WIRE(mode="straight",linecolor="#30485d",linewidth=0.16) {#XPN1:2 (0,-221)};
// (0,-220.6) @TEXT("VDD",size=1.1,halign="middle",valign="bottom");
// &"VSS" @WIRE(mode="straight",linecolor="#30485d",linewidth=0.16) {#XPN1:3 (0,-241)};
// (0,-241.4) @TEXT("VSS",size=1.1,halign="middle",valign="top");
// &"QN1" @WIRE(mode="straight",linecolor="#30485d",linewidth=0.16) {#XNN1:1 (-10,-264)};
// (-10.4,-264) @TEXT("QN1",size=1.1,halign="end",valign="middle");
// &"VDD" @WIRE(mode="straight",linecolor="#30485d",linewidth=0.16) {#XNN1:2 (0,-254)};
// (0,-253.6) @TEXT("VDD",size=1.1,halign="middle",valign="bottom");
// &"VSS" @WIRE(mode="straight",linecolor="#30485d",linewidth=0.16) {#XNN1:3 (0,-274)};
// (0,-274.4) @TEXT("VSS",size=1.1,halign="middle",valign="top");
// &"GNP1" @WIRE(mode="straight",linecolor="#30485d",linewidth=0.16) {#WNP1:2 (-16,-298.65)};
// (-16.4,-298.65) @TEXT("GNP1",size=1.1,halign="end",valign="middle");
// &"GPP1" @WIRE(mode="straight",linecolor="#30485d",linewidth=0.16) {#WPP1:2 (-16,-331.65)};
// (-16.4,-331.65) @TEXT("GPP1",size=1.1,halign="end",valign="middle");
// &"CODE2" @WIRE(mode="straight",linecolor="#30485d",linewidth=0.16) {#XINITIAL2:1 (-10,-361.3)};
// (-10.4,-361.3) @TEXT("CODE2",size=1.1,halign="end",valign="middle");
// &"RUN" @WIRE(mode="straight",linecolor="#30485d",linewidth=0.16) {#XINITIAL2:2 (-10,-364.7)};
// (-10.4,-364.7) @TEXT("RUN",size=1.1,halign="end",valign="middle");
// &"VDD" @WIRE(mode="straight",linecolor="#30485d",linewidth=0.16) {#XINITIAL2:3 (0,-353)};
// (0,-352.6) @TEXT("VDD",size=1.1,halign="middle",valign="bottom");
// &"VSS" @WIRE(mode="straight",linecolor="#30485d",linewidth=0.16) {#XINITIAL2:4 (0,-373)};
// (0,-373.4) @TEXT("VSS",size=1.1,halign="middle",valign="top");
// &"QN2" @WIRE(mode="straight",linecolor="#30485d",linewidth=0.16) {#XINITIAL2:5 (10,-363)};
// (10.4,-363) @TEXT("QN2",size=1.1,halign="start",valign="middle");
// &"QN2" @WIRE(mode="straight",linecolor="#30485d",linewidth=0.16) {#XPN2:1 (45,0)};
// (44.6,0) @TEXT("QN2",size=1.1,halign="end",valign="middle");
// &"VDD" @WIRE(mode="straight",linecolor="#30485d",linewidth=0.16) {#XPN2:2 (55,10)};
// (55,10.4) @TEXT("VDD",size=1.1,halign="middle",valign="bottom");
// &"VSS" @WIRE(mode="straight",linecolor="#30485d",linewidth=0.16) {#XPN2:3 (55,-10)};
// (55,-10.4) @TEXT("VSS",size=1.1,halign="middle",valign="top");
// &"QN2" @WIRE(mode="straight",linecolor="#30485d",linewidth=0.16) {#XNN2:1 (45,-33)};
// (44.6,-33) @TEXT("QN2",size=1.1,halign="end",valign="middle");
// &"VDD" @WIRE(mode="straight",linecolor="#30485d",linewidth=0.16) {#XNN2:2 (55,-23)};
// (55,-22.6) @TEXT("VDD",size=1.1,halign="middle",valign="bottom");
// &"VSS" @WIRE(mode="straight",linecolor="#30485d",linewidth=0.16) {#XNN2:3 (55,-43)};
// (55,-43.4) @TEXT("VSS",size=1.1,halign="middle",valign="top");
// &"GNP2" @WIRE(mode="straight",linecolor="#30485d",linewidth=0.16) {#WNP2:2 (39,-67.65)};
// (38.6,-67.65) @TEXT("GNP2",size=1.1,halign="end",valign="middle");
// &"GPP2" @WIRE(mode="straight",linecolor="#30485d",linewidth=0.16) {#WPP2:2 (39,-100.65)};
// (38.6,-100.65) @TEXT("GPP2",size=1.1,halign="end",valign="middle");
// &"CODE3" @WIRE(mode="straight",linecolor="#30485d",linewidth=0.16) {#XINITIAL3:1 (45,-130.3)};
// (44.6,-130.3) @TEXT("CODE3",size=1.1,halign="end",valign="middle");
// &"RUN" @WIRE(mode="straight",linecolor="#30485d",linewidth=0.16) {#XINITIAL3:2 (45,-133.7)};
// (44.6,-133.7) @TEXT("RUN",size=1.1,halign="end",valign="middle");
// &"VDD" @WIRE(mode="straight",linecolor="#30485d",linewidth=0.16) {#XINITIAL3:3 (55,-122)};
// (55,-121.6) @TEXT("VDD",size=1.1,halign="middle",valign="bottom");
// &"VSS" @WIRE(mode="straight",linecolor="#30485d",linewidth=0.16) {#XINITIAL3:4 (55,-142)};
// (55,-142.4) @TEXT("VSS",size=1.1,halign="middle",valign="top");
// &"QN3" @WIRE(mode="straight",linecolor="#30485d",linewidth=0.16) {#XINITIAL3:5 (65,-132)};
// (65.4,-132) @TEXT("QN3",size=1.1,halign="start",valign="middle");
// &"QN3" @WIRE(mode="straight",linecolor="#30485d",linewidth=0.16) {#XPN3:1 (45,-165)};
// (44.6,-165) @TEXT("QN3",size=1.1,halign="end",valign="middle");
// &"VDD" @WIRE(mode="straight",linecolor="#30485d",linewidth=0.16) {#XPN3:2 (55,-155)};
// (55,-154.6) @TEXT("VDD",size=1.1,halign="middle",valign="bottom");
// &"VSS" @WIRE(mode="straight",linecolor="#30485d",linewidth=0.16) {#XPN3:3 (55,-175)};
// (55,-175.4) @TEXT("VSS",size=1.1,halign="middle",valign="top");
// &"QN3" @WIRE(mode="straight",linecolor="#30485d",linewidth=0.16) {#XNN3:1 (45,-198)};
// (44.6,-198) @TEXT("QN3",size=1.1,halign="end",valign="middle");
// &"VDD" @WIRE(mode="straight",linecolor="#30485d",linewidth=0.16) {#XNN3:2 (55,-188)};
// (55,-187.6) @TEXT("VDD",size=1.1,halign="middle",valign="bottom");
// &"VSS" @WIRE(mode="straight",linecolor="#30485d",linewidth=0.16) {#XNN3:3 (55,-208)};
// (55,-208.4) @TEXT("VSS",size=1.1,halign="middle",valign="top");
// &"GNP3" @WIRE(mode="straight",linecolor="#30485d",linewidth=0.16) {#WNP3:2 (39,-232.65)};
// (38.6,-232.65) @TEXT("GNP3",size=1.1,halign="end",valign="middle");
// &"GPP3" @WIRE(mode="straight",linecolor="#30485d",linewidth=0.16) {#WPP3:2 (39,-265.65)};
// (38.6,-265.65) @TEXT("GPP3",size=1.1,halign="end",valign="middle");
// &"CODE4" @WIRE(mode="straight",linecolor="#30485d",linewidth=0.16) {#XINITIAL4:1 (45,-295.3)};
// (44.6,-295.3) @TEXT("CODE4",size=1.1,halign="end",valign="middle");
// &"RUN" @WIRE(mode="straight",linecolor="#30485d",linewidth=0.16) {#XINITIAL4:2 (45,-298.7)};
// (44.6,-298.7) @TEXT("RUN",size=1.1,halign="end",valign="middle");
// &"VDD" @WIRE(mode="straight",linecolor="#30485d",linewidth=0.16) {#XINITIAL4:3 (55,-287)};
// (55,-286.6) @TEXT("VDD",size=1.1,halign="middle",valign="bottom");
// &"VSS" @WIRE(mode="straight",linecolor="#30485d",linewidth=0.16) {#XINITIAL4:4 (55,-307)};
// (55,-307.4) @TEXT("VSS",size=1.1,halign="middle",valign="top");
// &"QN4" @WIRE(mode="straight",linecolor="#30485d",linewidth=0.16) {#XINITIAL4:5 (65,-297)};
// (65.4,-297) @TEXT("QN4",size=1.1,halign="start",valign="middle");
// &"QN4" @WIRE(mode="straight",linecolor="#30485d",linewidth=0.16) {#XPN4:1 (45,-330)};
// (44.6,-330) @TEXT("QN4",size=1.1,halign="end",valign="middle");
// &"VDD" @WIRE(mode="straight",linecolor="#30485d",linewidth=0.16) {#XPN4:2 (55,-320)};
// (55,-319.6) @TEXT("VDD",size=1.1,halign="middle",valign="bottom");
// &"VSS" @WIRE(mode="straight",linecolor="#30485d",linewidth=0.16) {#XPN4:3 (55,-340)};
// (55,-340.4) @TEXT("VSS",size=1.1,halign="middle",valign="top");
// &"GPN4" @WIRE(mode="straight",linecolor="#30485d",linewidth=0.16) {#XPN4:4 (65,-330)};
// (65.4,-330) @TEXT("GPN4",size=1.1,halign="start",valign="middle");
// &"QN4" @WIRE(mode="straight",linecolor="#30485d",linewidth=0.16) {#XNN4:1 (45,-363)};
// (44.6,-363) @TEXT("QN4",size=1.1,halign="end",valign="middle");
// &"VDD" @WIRE(mode="straight",linecolor="#30485d",linewidth=0.16) {#XNN4:2 (55,-353)};
// (55,-352.6) @TEXT("VDD",size=1.1,halign="middle",valign="bottom");
// &"VSS" @WIRE(mode="straight",linecolor="#30485d",linewidth=0.16) {#XNN4:3 (55,-373)};
// (55,-373.4) @TEXT("VSS",size=1.1,halign="middle",valign="top");
// &"GNN4" @WIRE(mode="straight",linecolor="#30485d",linewidth=0.16) {#XNN4:4 (65,-363)};
// (65.4,-363) @TEXT("GNN4",size=1.1,halign="start",valign="middle");
// &"GNN4" @WIRE(mode="straight",linecolor="#30485d",linewidth=0.16) {#WNP4:1 (94,1.65)};
// (93.6,1.65) @TEXT("GNN4",size=1.1,halign="end",valign="middle");
// &"GNP4" @WIRE(mode="straight",linecolor="#30485d",linewidth=0.16) {#WNP4:2 (94,-1.65)};
// (93.6,-1.65) @TEXT("GNP4",size=1.1,halign="end",valign="middle");
// &"GPN4" @WIRE(mode="straight",linecolor="#30485d",linewidth=0.16) {#WPP4:1 (94,-31.35)};
// (93.6,-31.35) @TEXT("GPN4",size=1.1,halign="end",valign="middle");
// &"GPP4" @WIRE(mode="straight",linecolor="#30485d",linewidth=0.16) {#WPP4:2 (94,-34.65)};
// (93.6,-34.65) @TEXT("GPP4",size=1.1,halign="end",valign="middle");
// &"CODE5" @WIRE(mode="straight",linecolor="#30485d",linewidth=0.16) {#XINITIAL5:1 (100,-64.3)};
// (99.6,-64.3) @TEXT("CODE5",size=1.1,halign="end",valign="middle");
// &"RUN" @WIRE(mode="straight",linecolor="#30485d",linewidth=0.16) {#XINITIAL5:2 (100,-67.7)};
// (99.6,-67.7) @TEXT("RUN",size=1.1,halign="end",valign="middle");
// &"VDD" @WIRE(mode="straight",linecolor="#30485d",linewidth=0.16) {#XINITIAL5:3 (110,-56)};
// (110,-55.6) @TEXT("VDD",size=1.1,halign="middle",valign="bottom");
// &"VSS" @WIRE(mode="straight",linecolor="#30485d",linewidth=0.16) {#XINITIAL5:4 (110,-76)};
// (110,-76.4) @TEXT("VSS",size=1.1,halign="middle",valign="top");
// &"QN5" @WIRE(mode="straight",linecolor="#30485d",linewidth=0.16) {#XINITIAL5:5 (120,-66)};
// (120.4,-66) @TEXT("QN5",size=1.1,halign="start",valign="middle");
// &"QN5" @WIRE(mode="straight",linecolor="#30485d",linewidth=0.16) {#XPN5:1 (100,-99)};
// (99.6,-99) @TEXT("QN5",size=1.1,halign="end",valign="middle");
// &"VDD" @WIRE(mode="straight",linecolor="#30485d",linewidth=0.16) {#XPN5:2 (110,-89)};
// (110,-88.6) @TEXT("VDD",size=1.1,halign="middle",valign="bottom");
// &"VSS" @WIRE(mode="straight",linecolor="#30485d",linewidth=0.16) {#XPN5:3 (110,-109)};
// (110,-109.4) @TEXT("VSS",size=1.1,halign="middle",valign="top");
// &"QN5" @WIRE(mode="straight",linecolor="#30485d",linewidth=0.16) {#XNN5:1 (100,-132)};
// (99.6,-132) @TEXT("QN5",size=1.1,halign="end",valign="middle");
// &"VDD" @WIRE(mode="straight",linecolor="#30485d",linewidth=0.16) {#XNN5:2 (110,-122)};
// (110,-121.6) @TEXT("VDD",size=1.1,halign="middle",valign="bottom");
// &"VSS" @WIRE(mode="straight",linecolor="#30485d",linewidth=0.16) {#XNN5:3 (110,-142)};
// (110,-142.4) @TEXT("VSS",size=1.1,halign="middle",valign="top");
// &"GNP5" @WIRE(mode="straight",linecolor="#30485d",linewidth=0.16) {#WNP5:2 (94,-166.65)};
// (93.6,-166.65) @TEXT("GNP5",size=1.1,halign="end",valign="middle");
// &"GPP5" @WIRE(mode="straight",linecolor="#30485d",linewidth=0.16) {#WPP5:2 (94,-199.65)};
// (93.6,-199.65) @TEXT("GPP5",size=1.1,halign="end",valign="middle");
// &"CODE6" @WIRE(mode="straight",linecolor="#30485d",linewidth=0.16) {#XINITIAL6:1 (100,-229.3)};
// (99.6,-229.3) @TEXT("CODE6",size=1.1,halign="end",valign="middle");
// &"RUN" @WIRE(mode="straight",linecolor="#30485d",linewidth=0.16) {#XINITIAL6:2 (100,-232.7)};
// (99.6,-232.7) @TEXT("RUN",size=1.1,halign="end",valign="middle");
// &"VDD" @WIRE(mode="straight",linecolor="#30485d",linewidth=0.16) {#XINITIAL6:3 (110,-221)};
// (110,-220.6) @TEXT("VDD",size=1.1,halign="middle",valign="bottom");
// &"VSS" @WIRE(mode="straight",linecolor="#30485d",linewidth=0.16) {#XINITIAL6:4 (110,-241)};
// (110,-241.4) @TEXT("VSS",size=1.1,halign="middle",valign="top");
// &"QN6" @WIRE(mode="straight",linecolor="#30485d",linewidth=0.16) {#XINITIAL6:5 (120,-231)};
// (120.4,-231) @TEXT("QN6",size=1.1,halign="start",valign="middle");
// &"QN6" @WIRE(mode="straight",linecolor="#30485d",linewidth=0.16) {#XPN6:1 (100,-264)};
// (99.6,-264) @TEXT("QN6",size=1.1,halign="end",valign="middle");
// &"VDD" @WIRE(mode="straight",linecolor="#30485d",linewidth=0.16) {#XPN6:2 (110,-254)};
// (110,-253.6) @TEXT("VDD",size=1.1,halign="middle",valign="bottom");
// &"VSS" @WIRE(mode="straight",linecolor="#30485d",linewidth=0.16) {#XPN6:3 (110,-274)};
// (110,-274.4) @TEXT("VSS",size=1.1,halign="middle",valign="top");
// &"QN6" @WIRE(mode="straight",linecolor="#30485d",linewidth=0.16) {#XNN6:1 (100,-297)};
// (99.6,-297) @TEXT("QN6",size=1.1,halign="end",valign="middle");
// &"VDD" @WIRE(mode="straight",linecolor="#30485d",linewidth=0.16) {#XNN6:2 (110,-287)};
// (110,-286.6) @TEXT("VDD",size=1.1,halign="middle",valign="bottom");
// &"VSS" @WIRE(mode="straight",linecolor="#30485d",linewidth=0.16) {#XNN6:3 (110,-307)};
// (110,-307.4) @TEXT("VSS",size=1.1,halign="middle",valign="top");
// &"GNP6" @WIRE(mode="straight",linecolor="#30485d",linewidth=0.16) {#WNP6:2 (94,-331.65)};
// (93.6,-331.65) @TEXT("GNP6",size=1.1,halign="end",valign="middle");
// &"GPP6" @WIRE(mode="straight",linecolor="#30485d",linewidth=0.16) {#WPP6:2 (94,-364.65)};
// (93.6,-364.65) @TEXT("GPP6",size=1.1,halign="end",valign="middle");
// &"CODE7" @WIRE(mode="straight",linecolor="#30485d",linewidth=0.16) {#XINITIAL7:1 (155,1.7)};
// (154.6,1.7) @TEXT("CODE7",size=1.1,halign="end",valign="middle");
// &"PRESET" @WIRE(mode="straight",linecolor="#30485d",linewidth=0.16) {#XINITIAL7:2 (155,-1.7)};
// (154.6,-1.7) @TEXT("PRESET",size=1.1,halign="end",valign="middle");
// &"VDD" @WIRE(mode="straight",linecolor="#30485d",linewidth=0.16) {#XINITIAL7:3 (165,10)};
// (165,10.4) @TEXT("VDD",size=1.1,halign="middle",valign="bottom");
// &"VSS" @WIRE(mode="straight",linecolor="#30485d",linewidth=0.16) {#XINITIAL7:4 (165,-10)};
// (165,-10.4) @TEXT("VSS",size=1.1,halign="middle",valign="top");
// &"VDD" @WIRE(mode="straight",linecolor="#30485d",linewidth=0.16) {#XINV7:2 (165,-23)};
// (165,-22.6) @TEXT("VDD",size=1.1,halign="middle",valign="bottom");
// &"VSS" @WIRE(mode="straight",linecolor="#30485d",linewidth=0.16) {#XINV7:3 (165,-43)};
// (165,-43.4) @TEXT("VSS",size=1.1,halign="middle",valign="top");
// &"QN7" @WIRE(mode="straight",linecolor="#30485d",linewidth=0.16) {#XINV7:4 (175,-33)};
// (175.4,-33) @TEXT("QN7",size=1.1,halign="start",valign="middle");
// &"QN7" @WIRE(mode="straight",linecolor="#30485d",linewidth=0.16) {#XPN7:1 (149,-64.35)};
// (148.6,-64.35) @TEXT("QN7",size=1.1,halign="end",valign="middle");
// &"VDD" @WIRE(mode="straight",linecolor="#30485d",linewidth=0.16) {#XPN7:3 (165,-55)};
// (165,-54.6) @TEXT("VDD",size=1.1,halign="middle",valign="bottom");
// &"VSS" @WIRE(mode="straight",linecolor="#30485d",linewidth=0.16) {#XPN7:4 (165,-77)};
// (165,-77.4) @TEXT("VSS",size=1.1,halign="middle",valign="top");
// &"QN7" @WIRE(mode="straight",linecolor="#30485d",linewidth=0.16) {#XNN7:1 (149,-99)};
// (148.6,-99) @TEXT("QN7",size=1.1,halign="end",valign="middle");
// &"VDD" @WIRE(mode="straight",linecolor="#30485d",linewidth=0.16) {#XNN7:2 (165,-88)};
// (165,-87.6) @TEXT("VDD",size=1.1,halign="middle",valign="bottom");
// &"VSS" @WIRE(mode="straight",linecolor="#30485d",linewidth=0.16) {#XNN7:3 (165,-110)};
// (165,-110.4) @TEXT("VSS",size=1.1,halign="middle",valign="top");
// &"GNP7" @WIRE(mode="straight",linecolor="#30485d",linewidth=0.16) {#WNP7:2 (149,-133.65)};
// (148.6,-133.65) @TEXT("GNP7",size=1.1,halign="end",valign="middle");
// &"GPP7" @WIRE(mode="straight",linecolor="#30485d",linewidth=0.16) {#WPP7:2 (149,-166.65)};
// (148.6,-166.65) @TEXT("GPP7",size=1.1,halign="end",valign="middle");
// &"RST_DONE" @WIRE(mode="straight",linecolor="#30485d",linewidth=0.16) {#WUNUSED:1 (149,-196.35)};
// (148.6,-196.35) @TEXT("RST_DONE",size=1.1,halign="end",valign="middle");
// &"VSS" @WIRE(mode="straight",linecolor="#30485d",linewidth=0.16) {#WUNUSED:2 (149,-199.65)};
// (148.6,-199.65) @TEXT("VSS",size=1.1,halign="end",valign="middle");
// }
// END SARADC RNL
ends sar8i_refword

subckt sar8i_idle ACTIVE SAMPLE VDD VSS PRESET SAMPLE_MATCH
    XN (ACTIVE VDD VSS IDLE) sar8p_inv
    XD (IDLE VDD VSS IDLE_D) sar8i_guard
    XP (SAMPLE IDLE_D VDD VSS PRESET) sar8p_or2
    XA (SAMPLE SAMPLE VDD VSS SAMPLE_AND) sar8p_and2
    XB (SAMPLE_AND VDD VSS SAMPLE_MATCH) sar8p_buf
// BEGIN SARADC RNL
// @RNL(author="saradc topology") {
// #XN @SET-SYMBOL $S_sar8p_inv;
// #XN @PLACE(0,18) => @ORIENT("R0");
// #XD @SET-SYMBOL $S_sar8i_guard;
// #XD @PLACE(42,18) => @ORIENT("R0");
// #XP @SET-SYMBOL $S_sar8p_or2;
// #XP @PLACE(84,18) => @ORIENT("R0");
// #XA @SET-SYMBOL $S_sar8p_and2;
// #XA @PLACE(0,-24) => @ORIENT("R0");
// #XB @SET-SYMBOL $S_sar8p_buf;
// #XB @PLACE(42,-24) => @ORIENT("R0");
// &"IDLE" @WIRE(mode="straight",linecolor="#30485d",linewidth=0.16) {#XN:4 (18,18) (18,18) #XD:1};
// &"IDLE_D" @WIRE(mode="straight",linecolor="#30485d",linewidth=0.16) {#XD:4 (66,18) (66,16.3) #XP:2};
// &"SAMPLE_AND" @WIRE(mode="straight",linecolor="#30485d",linewidth=0.16) {#XA:5 (21,-24) (21,-24) #XB:1};
// &"SAMPLE" @WIRE(mode="straight",linecolor="#30485d",linewidth=0.16) {(-12,-25.7) (-12,-22.3) (-12,19.7)};
// &"SAMPLE" @WIRE(mode="straight",linecolor="#30485d",linewidth=0.16) {#XP:1 (-12,19.7)};
// $JUNCTION @ATTACH (-12,19.7);
// &"SAMPLE" @WIRE(mode="straight",linecolor="#30485d",linewidth=0.16) {#XA:1 (-12,-22.3)};
// $JUNCTION @ATTACH (-12,-22.3);
// &"SAMPLE" @WIRE(mode="straight",linecolor="#30485d",linewidth=0.16) {#XA:2 (-12,-25.7)};
// $JUNCTION @ATTACH (-12,-25.7);
// (-16,46) @TEXT("sar8i_idle / native standard-cell composition",size=1.3,halign="start",textcolor="#223d52");
// &"ACTIVE" @WIRE(mode="straight",linecolor="#30485d",linewidth=0.16) {#XN:1 (-10,18)};
// (-10.4,18) @TEXT("ACTIVE",size=1.1,halign="end",valign="middle");
// &"VDD" @WIRE(mode="straight",linecolor="#30485d",linewidth=0.16) {#XN:2 (0,28)};
// (0,28.4) @TEXT("VDD",size=1.1,halign="middle",valign="bottom");
// &"VSS" @WIRE(mode="straight",linecolor="#30485d",linewidth=0.16) {#XN:3 (0,8)};
// (0,7.6) @TEXT("VSS",size=1.1,halign="middle",valign="top");
// &"VDD" @WIRE(mode="straight",linecolor="#30485d",linewidth=0.16) {#XD:2 (42,29)};
// (42,29.4) @TEXT("VDD",size=1.1,halign="middle",valign="bottom");
// &"VSS" @WIRE(mode="straight",linecolor="#30485d",linewidth=0.16) {#XD:3 (42,7)};
// (42,6.6) @TEXT("VSS",size=1.1,halign="middle",valign="top");
// &"VDD" @WIRE(mode="straight",linecolor="#30485d",linewidth=0.16) {#XP:3 (84,28)};
// (84,28.4) @TEXT("VDD",size=1.1,halign="middle",valign="bottom");
// &"VSS" @WIRE(mode="straight",linecolor="#30485d",linewidth=0.16) {#XP:4 (84,8)};
// (84,7.6) @TEXT("VSS",size=1.1,halign="middle",valign="top");
// &"PRESET" @WIRE(mode="straight",linecolor="#30485d",linewidth=0.16) {#XP:5 (94,18)};
// (94.4,18) @TEXT("PRESET",size=1.1,halign="start",valign="middle");
// &"VDD" @WIRE(mode="straight",linecolor="#30485d",linewidth=0.16) {#XA:3 (0,-14)};
// (0,-13.6) @TEXT("VDD",size=1.1,halign="middle",valign="bottom");
// &"VSS" @WIRE(mode="straight",linecolor="#30485d",linewidth=0.16) {#XA:4 (0,-34)};
// (0,-34.4) @TEXT("VSS",size=1.1,halign="middle",valign="top");
// &"VDD" @WIRE(mode="straight",linecolor="#30485d",linewidth=0.16) {#XB:2 (42,-14)};
// (42,-13.6) @TEXT("VDD",size=1.1,halign="middle",valign="bottom");
// &"VSS" @WIRE(mode="straight",linecolor="#30485d",linewidth=0.16) {#XB:3 (42,-34)};
// (42,-34.4) @TEXT("VSS",size=1.1,halign="middle",valign="top");
// &"SAMPLE_MATCH" @WIRE(mode="straight",linecolor="#30485d",linewidth=0.16) {#XB:4 (52,-24)};
// (52.4,-24) @TEXT("SAMPLE_MATCH",size=1.1,halign="start",valign="middle");
// }
// END SARADC RNL
ends sar8i_idle

subckt sar8ref_buf_d2 A VDD VSS Y
    X000 (A VDD VSS N) sar8p_inv
    XFINAL (N Y VDD VSS) INVD2BWP12T30P140
// BEGIN SARADC RNL
// @RNL(author="saradc topology") {
// #X000 @SET-SYMBOL $S_sar8p_inv;
// #X000 @PLACE(0,0) => @ORIENT("R0");
// #XFINAL @SET-SYMBOL $S_INVD2BWP12T30P140;
// #XFINAL @PLACE(0,-33) => @ORIENT("R0");
// &"N" @WIRE(mode="straight",linecolor="#30485d",linewidth=0.16) {#X000:4 (-3,0) (-3,-31.35) #XFINAL:1};
// (-89,30) @TEXT("sar8ref_buf_d2 / source-derived connections",size=1.4,halign="start",textcolor="#223d52");
// &"A" @WIRE(mode="straight",linecolor="#30485d",linewidth=0.16) {#X000:1 (-10,0)};
// (-10.4,0) @TEXT("A",size=1.1,halign="end",valign="middle");
// &"VDD" @WIRE(mode="straight",linecolor="#30485d",linewidth=0.16) {#X000:2 (0,10)};
// (0,10.4) @TEXT("VDD",size=1.1,halign="middle",valign="bottom");
// &"VSS" @WIRE(mode="straight",linecolor="#30485d",linewidth=0.16) {#X000:3 (0,-10)};
// (0,-10.4) @TEXT("VSS",size=1.1,halign="middle",valign="top");
// &"Y" @WIRE(mode="straight",linecolor="#30485d",linewidth=0.16) {#XFINAL:2 (-16,-34.65)};
// (-16.4,-34.65) @TEXT("Y",size=1.1,halign="end",valign="middle");
// &"VDD" @WIRE(mode="straight",linecolor="#30485d",linewidth=0.16) {#XFINAL:3 (0,-22)};
// (0,-21.6) @TEXT("VDD",size=1.1,halign="middle",valign="bottom");
// &"VSS" @WIRE(mode="straight",linecolor="#30485d",linewidth=0.16) {#XFINAL:4 (0,-44)};
// (0,-44.4) @TEXT("VSS",size=1.1,halign="middle",valign="top");
// }
// END SARADC RNL
ends sar8ref_buf_d2

subckt sar8p_timing ACTIVE CMP_CLK COMP_N COMP_P DATA PHI_U PHI_W SAMPLE          VDD VSS
    X017 (PHI_U VDD VSS UN) sar8p_inv
    X016 (PHI_W VDD VSS WN) sar8p_inv
    X015 (CMP_CLK VDD VSS CN) sar8p_inv
    X004 (NR VDD VSS NRB) sar8p_inv
    X000 (SAMPLE VDD VSS SN) sar8p_inv
    X022 (QUIET_D VDD VSS CLOCK_SET) sar8p_buf
    X020 (Q1 LIVE VDD VSS QUIET) sar8p_and2
    X019 (Q0 UN VDD VSS Q1) sar8p_and2
    X018 (CN WN VDD VSS Q0) sar8p_and2
    X014 (UD SN VDD VSS PHI_U) sar8p_and2
    X013 (PHI_W WRITE_D VDD VSS UD) sar8p_and2
    X010 (WD SN VDD VSS WRITE_REQ) sar8p_and2
    X009 (DEC CMP_CLK VDD VSS WD) sar8p_and2
    X008 (RAW_D VDD VSS DEC) sar8p_buf
    X005 (PR NRB VDD VSS DATA) sar8p_and2
    X001 (SN ACTIVE VDD VSS LIVE) sar8p_and2
    X025 (CLOCK_Q VDD VSS CMP_CLK) sar8p_buf
    X003 (COMP_N VDD VSS NR) sar8p_buf
    X002 (COMP_P VDD VSS PR) sar8p_buf
    X006 (PR NR VDD VSS RAW) sar8p_xor2
    XD_RAW_D (RAW VDD VSS RAW_D) sar8p_delay_valid
    X011 (WRITE_REQ VDD VSS PHI_W) sar8p_clkbuf
    XD_WRITE_D (PHI_W VDD VSS WRITE_D) sar8p_delay_write
    XD_QUIET_D (QUIET VDD VSS QUIET_D) sar8p_delay_quiet
    X023 (SAMPLE PHI_U VDD VSS CLOCK_RESET) sar8p_or2
    XCLOCK (CLOCK_Q CLOCK_RESET CLOCK_SET VDD VSS) sar8p_sr
// BEGIN SARADC RNL
// @RNL(author="saradc topology") {
// (-18,73) @TEXT("Asynchronous completion / write / update / quiet / comparator clock",size=1.5,halign="start",textcolor="#223d52");
// #X002 @SET-SYMBOL $S_sar8p_buf;
// #X002 @PLACE(0,36) => @ORIENT("R0");
// #X003 @SET-SYMBOL $S_sar8p_buf;
// #X003 @PLACE(0,0) => @ORIENT("R0");
// #X004 @SET-SYMBOL $S_sar8p_inv;
// #X004 @PLACE(35,0) => @ORIENT("R0");
// #X005 @SET-SYMBOL $S_sar8p_and2;
// #X005 @PLACE(72,36) => @ORIENT("R0");
// #X006 @SET-SYMBOL $S_sar8p_xor2;
// #X006 @PLACE(110,0) => @ORIENT("R0");
// #XD_RAW_D @SET-SYMBOL $S_sar8p_delay_valid;
// #XD_RAW_D @PLACE(151,-21) => @ORIENT("R0");
// #X008 @SET-SYMBOL $S_sar8p_buf;
// #X008 @PLACE(196,0) => @ORIENT("R0");
// #X009 @SET-SYMBOL $S_sar8p_and2;
// #X009 @PLACE(232,0) => @ORIENT("R0");
// #X010 @SET-SYMBOL $S_sar8p_and2;
// #X010 @PLACE(268,0) => @ORIENT("R0");
// #X011 @SET-SYMBOL $S_sar8p_clkbuf;
// #X011 @PLACE(306,0) => @ORIENT("R0");
// #XD_WRITE_D @SET-SYMBOL $S_sar8p_delay_write;
// #XD_WRITE_D @PLACE(349,-21) => @ORIENT("R0");
// #X013 @SET-SYMBOL $S_sar8p_and2;
// #X013 @PLACE(394,0) => @ORIENT("R0");
// #X014 @SET-SYMBOL $S_sar8p_and2;
// #X014 @PLACE(433,0) => @ORIENT("R0");
// #X000 @SET-SYMBOL $S_sar8p_inv;
// #X000 @PLACE(0,-72) => @ORIENT("R0");
// #X001 @SET-SYMBOL $S_sar8p_and2;
// #X001 @PLACE(36,-72) => @ORIENT("R0");
// #X015 @SET-SYMBOL $S_sar8p_inv;
// #X015 @PLACE(80,-72) => @ORIENT("R0");
// #X016 @SET-SYMBOL $S_sar8p_inv;
// #X016 @PLACE(80,-112) => @ORIENT("R0");
// #X017 @SET-SYMBOL $S_sar8p_inv;
// #X017 @PLACE(121,-112) => @ORIENT("R0");
// #X018 @SET-SYMBOL $S_sar8p_and2;
// #X018 @PLACE(121,-72) => @ORIENT("R0");
// #X019 @SET-SYMBOL $S_sar8p_and2;
// #X019 @PLACE(161,-72) => @ORIENT("R0");
// #X020 @SET-SYMBOL $S_sar8p_and2;
// #X020 @PLACE(201,-72) => @ORIENT("R0");
// #XD_QUIET_D @SET-SYMBOL $S_sar8p_delay_quiet;
// #XD_QUIET_D @PLACE(243,-93) => @ORIENT("R0");
// #X022 @SET-SYMBOL $S_sar8p_buf;
// #X022 @PLACE(288,-72) => @ORIENT("R0");
// #X023 @SET-SYMBOL $S_sar8p_or2;
// #X023 @PLACE(329,-112) => @ORIENT("R0");
// #XCLOCK @SET-SYMBOL $S_sar8p_sr;
// #XCLOCK @PLACE(372,-72) => @ORIENT("R0");
// #X025 @SET-SYMBOL $S_sar8p_buf;
// #X025 @PLACE(417,-72) => @ORIENT("R0");
// &"UN" @WIRE(mode="straight",linecolor="#30485d",linewidth=0.16) {#X017:4 (141,-112) (141,-73.7) #X019:2};
// &"WN" @WIRE(mode="straight",linecolor="#30485d",linewidth=0.16) {#X016:4 (100.5,-112) (100.5,-73.7) #X018:2};
// &"CN" @WIRE(mode="straight",linecolor="#30485d",linewidth=0.16) {#X015:4 (100.5,-72) (100.5,-70.3) #X018:1};
// &"NRB" @WIRE(mode="straight",linecolor="#30485d",linewidth=0.16) {#X004:4 (53.5,0) (53.5,34.3) #X005:2};
// &"QUIET_D" @WIRE(mode="straight",linecolor="#30485d",linewidth=0.16) {#X022:1 (268.5,-72) (268.5,-93) #XD_QUIET_D:4};
// &"CLOCK_SET" @WIRE(mode="straight",linecolor="#30485d",linewidth=0.16) {#X022:4 (327,-72) (327,-73.65) #XCLOCK:3};
// &"Q1" @WIRE(mode="straight",linecolor="#30485d",linewidth=0.16) {#X020:1 (181,-70.3) (181,-72) #X019:5};
// &"QUIET" @WIRE(mode="straight",linecolor="#30485d",linewidth=0.16) {#X020:5 (219,-72) (219,-93) #XD_QUIET_D:1};
// &"Q0" @WIRE(mode="straight",linecolor="#30485d",linewidth=0.16) {#X019:1 (141,-70.3) (141,-72) #X018:5};
// &"UD" @WIRE(mode="straight",linecolor="#30485d",linewidth=0.16) {#X014:1 (413.5,1.7) (413.5,0) #X013:5};
// &"WRITE_D" @WIRE(mode="straight",linecolor="#30485d",linewidth=0.16) {#X013:2 (374.5,-1.7) (374.5,-21) #XD_WRITE_D:4};
// &"WD" @WIRE(mode="straight",linecolor="#30485d",linewidth=0.16) {#X010:1 (250,1.7) (250,0) #X009:5};
// &"WRITE_REQ" @WIRE(mode="straight",linecolor="#30485d",linewidth=0.16) {#X010:5 (287,0) (287,0) #X011:1};
// &"DEC" @WIRE(mode="straight",linecolor="#30485d",linewidth=0.16) {#X009:1 (214,1.7) (214,0) #X008:4};
// &"RAW_D" @WIRE(mode="straight",linecolor="#30485d",linewidth=0.16) {#X008:1 (176.5,0) (176.5,-21) #XD_RAW_D:4};
// &"CLOCK_Q" @WIRE(mode="straight",linecolor="#30485d",linewidth=0.16) {#X025:1 (397.5,-72) (397.5,-72) #XCLOCK:1};
// &"RAW" @WIRE(mode="straight",linecolor="#30485d",linewidth=0.16) {#X006:5 (127.5,0) (127.5,-21) #XD_RAW_D:1};
// &"CLOCK_RESET" @WIRE(mode="straight",linecolor="#30485d",linewidth=0.16) {#X023:5 (347.5,-112) (347.5,-70.35) #XCLOCK:2};
// (109,49) @TEXT("VALID -> WRITE -> UPDATE",size=1.3,halign="start",textcolor="#223d52");
// (78,-46) @TEXT("QUIET detection -> SET / RESET latch -> CMP_CLK",size=1.3,halign="start",textcolor="#223d52");
// (-18,-140) @TEXT("Expand the delay and clock latch instances to inspect the timing path.",size=1,halign="start",textcolor="#223d52");
// &"PHI_U" @WIRE(mode="straight",linecolor="#30485d",linewidth=0.16) {#X017:1 (111,-112)};
// (110.6,-112) @TEXT("PHI_U",size=1.1,halign="end",valign="middle");
// &"VDD" @WIRE(mode="straight",linecolor="#30485d",linewidth=0.16) {#X017:2 (121,-102)};
// (121,-101.6) @TEXT("VDD",size=1.1,halign="middle",valign="bottom");
// &"VSS" @WIRE(mode="straight",linecolor="#30485d",linewidth=0.16) {#X017:3 (121,-122)};
// (121,-122.4) @TEXT("VSS",size=1.1,halign="middle",valign="top");
// &"PHI_W" @WIRE(mode="straight",linecolor="#30485d",linewidth=0.16) {#X016:1 (70,-112)};
// (69.6,-112) @TEXT("PHI_W",size=1.1,halign="end",valign="middle");
// &"VDD" @WIRE(mode="straight",linecolor="#30485d",linewidth=0.16) {#X016:2 (80,-102)};
// (80,-101.6) @TEXT("VDD",size=1.1,halign="middle",valign="bottom");
// &"VSS" @WIRE(mode="straight",linecolor="#30485d",linewidth=0.16) {#X016:3 (80,-122)};
// (80,-122.4) @TEXT("VSS",size=1.1,halign="middle",valign="top");
// &"CMP_CLK" @WIRE(mode="straight",linecolor="#30485d",linewidth=0.16) {#X015:1 (70,-72)};
// (69.6,-72) @TEXT("CMP_CLK",size=1.1,halign="end",valign="middle");
// &"VDD" @WIRE(mode="straight",linecolor="#30485d",linewidth=0.16) {#X015:2 (80,-62)};
// (80,-61.6) @TEXT("VDD",size=1.1,halign="middle",valign="bottom");
// &"VSS" @WIRE(mode="straight",linecolor="#30485d",linewidth=0.16) {#X015:3 (80,-82)};
// (80,-82.4) @TEXT("VSS",size=1.1,halign="middle",valign="top");
// &"NR" @WIRE(mode="straight",linecolor="#30485d",linewidth=0.16) {#X004:1 (25,0)};
// (24.6,0) @TEXT("NR",size=1.1,halign="end",valign="middle");
// &"VDD" @WIRE(mode="straight",linecolor="#30485d",linewidth=0.16) {#X004:2 (35,10)};
// (35,10.4) @TEXT("VDD",size=1.1,halign="middle",valign="bottom");
// &"VSS" @WIRE(mode="straight",linecolor="#30485d",linewidth=0.16) {#X004:3 (35,-10)};
// (35,-10.4) @TEXT("VSS",size=1.1,halign="middle",valign="top");
// &"SAMPLE" @WIRE(mode="straight",linecolor="#30485d",linewidth=0.16) {#X000:1 (-10,-72)};
// (-10.4,-72) @TEXT("SAMPLE",size=1.1,halign="end",valign="middle");
// &"VDD" @WIRE(mode="straight",linecolor="#30485d",linewidth=0.16) {#X000:2 (0,-62)};
// (0,-61.6) @TEXT("VDD",size=1.1,halign="middle",valign="bottom");
// &"VSS" @WIRE(mode="straight",linecolor="#30485d",linewidth=0.16) {#X000:3 (0,-82)};
// (0,-82.4) @TEXT("VSS",size=1.1,halign="middle",valign="top");
// &"SN" @WIRE(mode="straight",linecolor="#30485d",linewidth=0.16) {#X000:4 (10,-72)};
// (10.4,-72) @TEXT("SN",size=1.1,halign="start",valign="middle");
// &"VDD" @WIRE(mode="straight",linecolor="#30485d",linewidth=0.16) {#X022:2 (288,-62)};
// (288,-61.6) @TEXT("VDD",size=1.1,halign="middle",valign="bottom");
// &"VSS" @WIRE(mode="straight",linecolor="#30485d",linewidth=0.16) {#X022:3 (288,-82)};
// (288,-82.4) @TEXT("VSS",size=1.1,halign="middle",valign="top");
// &"LIVE" @WIRE(mode="straight",linecolor="#30485d",linewidth=0.16) {#X020:2 (191,-73.7)};
// (190.6,-73.7) @TEXT("LIVE",size=1.1,halign="end",valign="middle");
// &"VDD" @WIRE(mode="straight",linecolor="#30485d",linewidth=0.16) {#X020:3 (201,-62)};
// (201,-61.6) @TEXT("VDD",size=1.1,halign="middle",valign="bottom");
// &"VSS" @WIRE(mode="straight",linecolor="#30485d",linewidth=0.16) {#X020:4 (201,-82)};
// (201,-82.4) @TEXT("VSS",size=1.1,halign="middle",valign="top");
// &"VDD" @WIRE(mode="straight",linecolor="#30485d",linewidth=0.16) {#X019:3 (161,-62)};
// (161,-61.6) @TEXT("VDD",size=1.1,halign="middle",valign="bottom");
// &"VSS" @WIRE(mode="straight",linecolor="#30485d",linewidth=0.16) {#X019:4 (161,-82)};
// (161,-82.4) @TEXT("VSS",size=1.1,halign="middle",valign="top");
// &"VDD" @WIRE(mode="straight",linecolor="#30485d",linewidth=0.16) {#X018:3 (121,-62)};
// (121,-61.6) @TEXT("VDD",size=1.1,halign="middle",valign="bottom");
// &"VSS" @WIRE(mode="straight",linecolor="#30485d",linewidth=0.16) {#X018:4 (121,-82)};
// (121,-82.4) @TEXT("VSS",size=1.1,halign="middle",valign="top");
// &"SN" @WIRE(mode="straight",linecolor="#30485d",linewidth=0.16) {#X014:2 (423,-1.7)};
// (422.6,-1.7) @TEXT("SN",size=1.1,halign="end",valign="middle");
// &"VDD" @WIRE(mode="straight",linecolor="#30485d",linewidth=0.16) {#X014:3 (433,10)};
// (433,10.4) @TEXT("VDD",size=1.1,halign="middle",valign="bottom");
// &"VSS" @WIRE(mode="straight",linecolor="#30485d",linewidth=0.16) {#X014:4 (433,-10)};
// (433,-10.4) @TEXT("VSS",size=1.1,halign="middle",valign="top");
// &"PHI_U" @WIRE(mode="straight",linecolor="#30485d",linewidth=0.16) {#X014:5 (443,0)};
// (443.4,0) @TEXT("PHI_U",size=1.1,halign="start",valign="middle");
// &"PHI_W" @WIRE(mode="straight",linecolor="#30485d",linewidth=0.16) {#X013:1 (384,1.7)};
// (383.6,1.7) @TEXT("PHI_W",size=1.1,halign="end",valign="middle");
// &"VDD" @WIRE(mode="straight",linecolor="#30485d",linewidth=0.16) {#X013:3 (394,10)};
// (394,10.4) @TEXT("VDD",size=1.1,halign="middle",valign="bottom");
// &"VSS" @WIRE(mode="straight",linecolor="#30485d",linewidth=0.16) {#X013:4 (394,-10)};
// (394,-10.4) @TEXT("VSS",size=1.1,halign="middle",valign="top");
// &"SN" @WIRE(mode="straight",linecolor="#30485d",linewidth=0.16) {#X010:2 (258,-1.7)};
// (257.6,-1.7) @TEXT("SN",size=1.1,halign="end",valign="middle");
// &"VDD" @WIRE(mode="straight",linecolor="#30485d",linewidth=0.16) {#X010:3 (268,10)};
// (268,10.4) @TEXT("VDD",size=1.1,halign="middle",valign="bottom");
// &"VSS" @WIRE(mode="straight",linecolor="#30485d",linewidth=0.16) {#X010:4 (268,-10)};
// (268,-10.4) @TEXT("VSS",size=1.1,halign="middle",valign="top");
// &"CMP_CLK" @WIRE(mode="straight",linecolor="#30485d",linewidth=0.16) {#X009:2 (222,-1.7)};
// (221.6,-1.7) @TEXT("CMP_CLK",size=1.1,halign="end",valign="middle");
// &"VDD" @WIRE(mode="straight",linecolor="#30485d",linewidth=0.16) {#X009:3 (232,10)};
// (232,10.4) @TEXT("VDD",size=1.1,halign="middle",valign="bottom");
// &"VSS" @WIRE(mode="straight",linecolor="#30485d",linewidth=0.16) {#X009:4 (232,-10)};
// (232,-10.4) @TEXT("VSS",size=1.1,halign="middle",valign="top");
// &"VDD" @WIRE(mode="straight",linecolor="#30485d",linewidth=0.16) {#X008:2 (196,10)};
// (196,10.4) @TEXT("VDD",size=1.1,halign="middle",valign="bottom");
// &"VSS" @WIRE(mode="straight",linecolor="#30485d",linewidth=0.16) {#X008:3 (196,-10)};
// (196,-10.4) @TEXT("VSS",size=1.1,halign="middle",valign="top");
// &"PR" @WIRE(mode="straight",linecolor="#30485d",linewidth=0.16) {#X005:1 (62,37.7)};
// (61.6,37.7) @TEXT("PR",size=1.1,halign="end",valign="middle");
// &"VDD" @WIRE(mode="straight",linecolor="#30485d",linewidth=0.16) {#X005:3 (72,46)};
// (72,46.4) @TEXT("VDD",size=1.1,halign="middle",valign="bottom");
// &"VSS" @WIRE(mode="straight",linecolor="#30485d",linewidth=0.16) {#X005:4 (72,26)};
// (72,25.6) @TEXT("VSS",size=1.1,halign="middle",valign="top");
// &"DATA" @WIRE(mode="straight",linecolor="#30485d",linewidth=0.16) {#X005:5 (82,36)};
// (82.4,36) @TEXT("DATA",size=1.1,halign="start",valign="middle");
// &"SN" @WIRE(mode="straight",linecolor="#30485d",linewidth=0.16) {#X001:1 (26,-70.3)};
// (25.6,-70.3) @TEXT("SN",size=1.1,halign="end",valign="middle");
// &"ACTIVE" @WIRE(mode="straight",linecolor="#30485d",linewidth=0.16) {#X001:2 (26,-73.7)};
// (25.6,-73.7) @TEXT("ACTIVE",size=1.1,halign="end",valign="middle");
// &"VDD" @WIRE(mode="straight",linecolor="#30485d",linewidth=0.16) {#X001:3 (36,-62)};
// (36,-61.6) @TEXT("VDD",size=1.1,halign="middle",valign="bottom");
// &"VSS" @WIRE(mode="straight",linecolor="#30485d",linewidth=0.16) {#X001:4 (36,-82)};
// (36,-82.4) @TEXT("VSS",size=1.1,halign="middle",valign="top");
// &"LIVE" @WIRE(mode="straight",linecolor="#30485d",linewidth=0.16) {#X001:5 (46,-72)};
// (46.4,-72) @TEXT("LIVE",size=1.1,halign="start",valign="middle");
// &"VDD" @WIRE(mode="straight",linecolor="#30485d",linewidth=0.16) {#X025:2 (417,-62)};
// (417,-61.6) @TEXT("VDD",size=1.1,halign="middle",valign="bottom");
// &"VSS" @WIRE(mode="straight",linecolor="#30485d",linewidth=0.16) {#X025:3 (417,-82)};
// (417,-82.4) @TEXT("VSS",size=1.1,halign="middle",valign="top");
// &"CMP_CLK" @WIRE(mode="straight",linecolor="#30485d",linewidth=0.16) {#X025:4 (427,-72)};
// (427.4,-72) @TEXT("CMP_CLK",size=1.1,halign="start",valign="middle");
// &"COMP_N" @WIRE(mode="straight",linecolor="#30485d",linewidth=0.16) {#X003:1 (-10,0)};
// (-10.4,0) @TEXT("COMP_N",size=1.1,halign="end",valign="middle");
// &"VDD" @WIRE(mode="straight",linecolor="#30485d",linewidth=0.16) {#X003:2 (0,10)};
// (0,10.4) @TEXT("VDD",size=1.1,halign="middle",valign="bottom");
// &"VSS" @WIRE(mode="straight",linecolor="#30485d",linewidth=0.16) {#X003:3 (0,-10)};
// (0,-10.4) @TEXT("VSS",size=1.1,halign="middle",valign="top");
// &"NR" @WIRE(mode="straight",linecolor="#30485d",linewidth=0.16) {#X003:4 (10,0)};
// (10.4,0) @TEXT("NR",size=1.1,halign="start",valign="middle");
// &"COMP_P" @WIRE(mode="straight",linecolor="#30485d",linewidth=0.16) {#X002:1 (-10,36)};
// (-10.4,36) @TEXT("COMP_P",size=1.1,halign="end",valign="middle");
// &"VDD" @WIRE(mode="straight",linecolor="#30485d",linewidth=0.16) {#X002:2 (0,46)};
// (0,46.4) @TEXT("VDD",size=1.1,halign="middle",valign="bottom");
// &"VSS" @WIRE(mode="straight",linecolor="#30485d",linewidth=0.16) {#X002:3 (0,26)};
// (0,25.6) @TEXT("VSS",size=1.1,halign="middle",valign="top");
// &"PR" @WIRE(mode="straight",linecolor="#30485d",linewidth=0.16) {#X002:4 (10,36)};
// (10.4,36) @TEXT("PR",size=1.1,halign="start",valign="middle");
// &"PR" @WIRE(mode="straight",linecolor="#30485d",linewidth=0.16) {#X006:1 (100,1.7)};
// (99.6,1.7) @TEXT("PR",size=1.1,halign="end",valign="middle");
// &"NR" @WIRE(mode="straight",linecolor="#30485d",linewidth=0.16) {#X006:2 (100,-1.7)};
// (99.6,-1.7) @TEXT("NR",size=1.1,halign="end",valign="middle");
// &"VDD" @WIRE(mode="straight",linecolor="#30485d",linewidth=0.16) {#X006:3 (110,10)};
// (110,10.4) @TEXT("VDD",size=1.1,halign="middle",valign="bottom");
// &"VSS" @WIRE(mode="straight",linecolor="#30485d",linewidth=0.16) {#X006:4 (110,-10)};
// (110,-10.4) @TEXT("VSS",size=1.1,halign="middle",valign="top");
// &"VDD" @WIRE(mode="straight",linecolor="#30485d",linewidth=0.16) {#XD_RAW_D:2 (151,-10)};
// (151,-9.6) @TEXT("VDD",size=1.1,halign="middle",valign="bottom");
// &"VSS" @WIRE(mode="straight",linecolor="#30485d",linewidth=0.16) {#XD_RAW_D:3 (151,-32)};
// (151,-32.4) @TEXT("VSS",size=1.1,halign="middle",valign="top");
// &"VDD" @WIRE(mode="straight",linecolor="#30485d",linewidth=0.16) {#X011:2 (306,10)};
// (306,10.4) @TEXT("VDD",size=1.1,halign="middle",valign="bottom");
// &"VSS" @WIRE(mode="straight",linecolor="#30485d",linewidth=0.16) {#X011:3 (306,-10)};
// (306,-10.4) @TEXT("VSS",size=1.1,halign="middle",valign="top");
// &"PHI_W" @WIRE(mode="straight",linecolor="#30485d",linewidth=0.16) {#X011:4 (316,0)};
// (316.4,0) @TEXT("PHI_W",size=1.1,halign="start",valign="middle");
// &"PHI_W" @WIRE(mode="straight",linecolor="#30485d",linewidth=0.16) {#XD_WRITE_D:1 (333,-21)};
// (332.6,-21) @TEXT("PHI_W",size=1.1,halign="end",valign="middle");
// &"VDD" @WIRE(mode="straight",linecolor="#30485d",linewidth=0.16) {#XD_WRITE_D:2 (349,-10)};
// (349,-9.6) @TEXT("VDD",size=1.1,halign="middle",valign="bottom");
// &"VSS" @WIRE(mode="straight",linecolor="#30485d",linewidth=0.16) {#XD_WRITE_D:3 (349,-32)};
// (349,-32.4) @TEXT("VSS",size=1.1,halign="middle",valign="top");
// &"VDD" @WIRE(mode="straight",linecolor="#30485d",linewidth=0.16) {#XD_QUIET_D:2 (243,-82)};
// (243,-81.6) @TEXT("VDD",size=1.1,halign="middle",valign="bottom");
// &"VSS" @WIRE(mode="straight",linecolor="#30485d",linewidth=0.16) {#XD_QUIET_D:3 (243,-104)};
// (243,-104.4) @TEXT("VSS",size=1.1,halign="middle",valign="top");
// &"SAMPLE" @WIRE(mode="straight",linecolor="#30485d",linewidth=0.16) {#X023:1 (319,-110.3)};
// (318.6,-110.3) @TEXT("SAMPLE",size=1.1,halign="end",valign="middle");
// &"PHI_U" @WIRE(mode="straight",linecolor="#30485d",linewidth=0.16) {#X023:2 (319,-113.7)};
// (318.6,-113.7) @TEXT("PHI_U",size=1.1,halign="end",valign="middle");
// &"VDD" @WIRE(mode="straight",linecolor="#30485d",linewidth=0.16) {#X023:3 (329,-102)};
// (329,-101.6) @TEXT("VDD",size=1.1,halign="middle",valign="bottom");
// &"VSS" @WIRE(mode="straight",linecolor="#30485d",linewidth=0.16) {#X023:4 (329,-122)};
// (329,-122.4) @TEXT("VSS",size=1.1,halign="middle",valign="top");
// &"VDD" @WIRE(mode="straight",linecolor="#30485d",linewidth=0.16) {#XCLOCK:4 (372,-61)};
// (372,-60.6) @TEXT("VDD",size=1.1,halign="middle",valign="bottom");
// &"VSS" @WIRE(mode="straight",linecolor="#30485d",linewidth=0.16) {#XCLOCK:5 (372,-83)};
// (372,-83.4) @TEXT("VSS",size=1.1,halign="middle",valign="top");
// }
// END SARADC RNL
ends sar8p_timing

subckt sar8p_bitseq8 PHI_U SAMPLE T0 T1 T2 T3 T4 T5 T6 T7 VDD VSS
    XF0 (PHI_U T1 T0 SAMPLE VDD VSS) sar8p_dffr
    XF1 (PHI_U T2 T1 SAMPLE VDD VSS) sar8p_dffr
    XF2 (PHI_U T3 T2 SAMPLE VDD VSS) sar8p_dffr
    XF3 (PHI_U T4 T3 SAMPLE VDD VSS) sar8p_dffr
    XF4 (PHI_U T5 T4 SAMPLE VDD VSS) sar8p_dffr
    XF5 (PHI_U T6 T5 SAMPLE VDD VSS) sar8p_dffr
    XF6 (PHI_U T7 T6 SAMPLE VDD VSS) sar8p_dffr
    XF7 (PHI_U VDD NT7 SAMPLE VDD VSS) sar8p_dffr
    X001 (NT7 VDD VSS T7) sar8p_inv
// BEGIN SARADC RNL
// @RNL(author="saradc topology") {
// #XF7 @SET-SYMBOL $S_sar8p_dffr;
// #XF7 @PLACE(0,0) => @ORIENT("R0");
// #XF6 @SET-SYMBOL $S_sar8p_dffr;
// #XF6 @PLACE(43,0) => @ORIENT("R0");
// #XF5 @SET-SYMBOL $S_sar8p_dffr;
// #XF5 @PLACE(86,0) => @ORIENT("R0");
// #XF4 @SET-SYMBOL $S_sar8p_dffr;
// #XF4 @PLACE(129,0) => @ORIENT("R0");
// #XF3 @SET-SYMBOL $S_sar8p_dffr;
// #XF3 @PLACE(172,0) => @ORIENT("R0");
// #XF2 @SET-SYMBOL $S_sar8p_dffr;
// #XF2 @PLACE(215,0) => @ORIENT("R0");
// #XF1 @SET-SYMBOL $S_sar8p_dffr;
// #XF1 @PLACE(258,0) => @ORIENT("R0");
// #XF0 @SET-SYMBOL $S_sar8p_dffr;
// #XF0 @PLACE(301,0) => @ORIENT("R0");
// #X001 @SET-SYMBOL $S_sar8p_inv;
// #X001 @PLACE(22,27) => @ORIENT("R0");
// &"T1" @WIRE(mode="straight",linecolor="#30485d",linewidth=0.16) {#XF0:2 (279.5,0) (279.5,0) #XF1:3};
// &"T2" @WIRE(mode="straight",linecolor="#30485d",linewidth=0.16) {#XF1:2 (236.5,0) (236.5,0) #XF2:3};
// &"T3" @WIRE(mode="straight",linecolor="#30485d",linewidth=0.16) {#XF2:2 (193.5,0) (193.5,0) #XF3:3};
// &"T4" @WIRE(mode="straight",linecolor="#30485d",linewidth=0.16) {#XF3:2 (150.5,0) (150.5,0) #XF4:3};
// &"T5" @WIRE(mode="straight",linecolor="#30485d",linewidth=0.16) {#XF4:2 (107.5,0) (107.5,0) #XF5:3};
// &"T6" @WIRE(mode="straight",linecolor="#30485d",linewidth=0.16) {#XF5:2 (64.5,0) (64.5,0) #XF6:3};
// &"T7" @WIRE(mode="straight",linecolor="#30485d",linewidth=0.16) {#XF6:2 (32.5,0) (32.5,27) #X001:4};
// &"NT7" @WIRE(mode="straight",linecolor="#30485d",linewidth=0.16) {#XF7:3 (11,0) (11,27) #X001:1};
// (-16,50) @TEXT("Token shift / bit 7 -> bit 0 / asynchronous reset",size=1.4,halign="start",textcolor="#223d52");
// &"PHI_U" @WIRE(mode="straight",linecolor="#30485d",linewidth=0.16) {#XF0:1 (291,3.4)};
// (290.6,3.4) @TEXT("PHI_U",size=1.1,halign="end",valign="middle");
// &"T0" @WIRE(mode="straight",linecolor="#30485d",linewidth=0.16) {#XF0:3 (311,0)};
// (311.4,0) @TEXT("T0",size=1.1,halign="start",valign="middle");
// &"SAMPLE" @WIRE(mode="straight",linecolor="#30485d",linewidth=0.16) {#XF0:4 (291,-3.4)};
// (290.6,-3.4) @TEXT("SAMPLE",size=1.1,halign="end",valign="middle");
// &"VDD" @WIRE(mode="straight",linecolor="#30485d",linewidth=0.16) {#XF0:5 (301,10)};
// (301,10.4) @TEXT("VDD",size=1.1,halign="middle",valign="bottom");
// &"VSS" @WIRE(mode="straight",linecolor="#30485d",linewidth=0.16) {#XF0:6 (301,-10)};
// (301,-10.4) @TEXT("VSS",size=1.1,halign="middle",valign="top");
// &"PHI_U" @WIRE(mode="straight",linecolor="#30485d",linewidth=0.16) {#XF1:1 (248,3.4)};
// (247.6,3.4) @TEXT("PHI_U",size=1.1,halign="end",valign="middle");
// &"SAMPLE" @WIRE(mode="straight",linecolor="#30485d",linewidth=0.16) {#XF1:4 (248,-3.4)};
// (247.6,-3.4) @TEXT("SAMPLE",size=1.1,halign="end",valign="middle");
// &"VDD" @WIRE(mode="straight",linecolor="#30485d",linewidth=0.16) {#XF1:5 (258,10)};
// (258,10.4) @TEXT("VDD",size=1.1,halign="middle",valign="bottom");
// &"VSS" @WIRE(mode="straight",linecolor="#30485d",linewidth=0.16) {#XF1:6 (258,-10)};
// (258,-10.4) @TEXT("VSS",size=1.1,halign="middle",valign="top");
// &"PHI_U" @WIRE(mode="straight",linecolor="#30485d",linewidth=0.16) {#XF2:1 (205,3.4)};
// (204.6,3.4) @TEXT("PHI_U",size=1.1,halign="end",valign="middle");
// &"SAMPLE" @WIRE(mode="straight",linecolor="#30485d",linewidth=0.16) {#XF2:4 (205,-3.4)};
// (204.6,-3.4) @TEXT("SAMPLE",size=1.1,halign="end",valign="middle");
// &"VDD" @WIRE(mode="straight",linecolor="#30485d",linewidth=0.16) {#XF2:5 (215,10)};
// (215,10.4) @TEXT("VDD",size=1.1,halign="middle",valign="bottom");
// &"VSS" @WIRE(mode="straight",linecolor="#30485d",linewidth=0.16) {#XF2:6 (215,-10)};
// (215,-10.4) @TEXT("VSS",size=1.1,halign="middle",valign="top");
// &"PHI_U" @WIRE(mode="straight",linecolor="#30485d",linewidth=0.16) {#XF3:1 (162,3.4)};
// (161.6,3.4) @TEXT("PHI_U",size=1.1,halign="end",valign="middle");
// &"SAMPLE" @WIRE(mode="straight",linecolor="#30485d",linewidth=0.16) {#XF3:4 (162,-3.4)};
// (161.6,-3.4) @TEXT("SAMPLE",size=1.1,halign="end",valign="middle");
// &"VDD" @WIRE(mode="straight",linecolor="#30485d",linewidth=0.16) {#XF3:5 (172,10)};
// (172,10.4) @TEXT("VDD",size=1.1,halign="middle",valign="bottom");
// &"VSS" @WIRE(mode="straight",linecolor="#30485d",linewidth=0.16) {#XF3:6 (172,-10)};
// (172,-10.4) @TEXT("VSS",size=1.1,halign="middle",valign="top");
// &"PHI_U" @WIRE(mode="straight",linecolor="#30485d",linewidth=0.16) {#XF4:1 (119,3.4)};
// (118.6,3.4) @TEXT("PHI_U",size=1.1,halign="end",valign="middle");
// &"SAMPLE" @WIRE(mode="straight",linecolor="#30485d",linewidth=0.16) {#XF4:4 (119,-3.4)};
// (118.6,-3.4) @TEXT("SAMPLE",size=1.1,halign="end",valign="middle");
// &"VDD" @WIRE(mode="straight",linecolor="#30485d",linewidth=0.16) {#XF4:5 (129,10)};
// (129,10.4) @TEXT("VDD",size=1.1,halign="middle",valign="bottom");
// &"VSS" @WIRE(mode="straight",linecolor="#30485d",linewidth=0.16) {#XF4:6 (129,-10)};
// (129,-10.4) @TEXT("VSS",size=1.1,halign="middle",valign="top");
// &"PHI_U" @WIRE(mode="straight",linecolor="#30485d",linewidth=0.16) {#XF5:1 (76,3.4)};
// (75.6,3.4) @TEXT("PHI_U",size=1.1,halign="end",valign="middle");
// &"SAMPLE" @WIRE(mode="straight",linecolor="#30485d",linewidth=0.16) {#XF5:4 (76,-3.4)};
// (75.6,-3.4) @TEXT("SAMPLE",size=1.1,halign="end",valign="middle");
// &"VDD" @WIRE(mode="straight",linecolor="#30485d",linewidth=0.16) {#XF5:5 (86,10)};
// (86,10.4) @TEXT("VDD",size=1.1,halign="middle",valign="bottom");
// &"VSS" @WIRE(mode="straight",linecolor="#30485d",linewidth=0.16) {#XF5:6 (86,-10)};
// (86,-10.4) @TEXT("VSS",size=1.1,halign="middle",valign="top");
// &"PHI_U" @WIRE(mode="straight",linecolor="#30485d",linewidth=0.16) {#XF6:1 (33,3.4)};
// (32.6,3.4) @TEXT("PHI_U",size=1.1,halign="end",valign="middle");
// &"SAMPLE" @WIRE(mode="straight",linecolor="#30485d",linewidth=0.16) {#XF6:4 (33,-3.4)};
// (32.6,-3.4) @TEXT("SAMPLE",size=1.1,halign="end",valign="middle");
// &"VDD" @WIRE(mode="straight",linecolor="#30485d",linewidth=0.16) {#XF6:5 (43,10)};
// (43,10.4) @TEXT("VDD",size=1.1,halign="middle",valign="bottom");
// &"VSS" @WIRE(mode="straight",linecolor="#30485d",linewidth=0.16) {#XF6:6 (43,-10)};
// (43,-10.4) @TEXT("VSS",size=1.1,halign="middle",valign="top");
// &"PHI_U" @WIRE(mode="straight",linecolor="#30485d",linewidth=0.16) {#XF7:1 (-10,3.4)};
// (-10.4,3.4) @TEXT("PHI_U",size=1.1,halign="end",valign="middle");
// &"VDD" @WIRE(mode="straight",linecolor="#30485d",linewidth=0.16) {#XF7:2 (-10,0)};
// (-10.4,0) @TEXT("VDD",size=1.1,halign="end",valign="middle");
// &"SAMPLE" @WIRE(mode="straight",linecolor="#30485d",linewidth=0.16) {#XF7:4 (-10,-3.4)};
// (-10.4,-3.4) @TEXT("SAMPLE",size=1.1,halign="end",valign="middle");
// &"VDD" @WIRE(mode="straight",linecolor="#30485d",linewidth=0.16) {#XF7:5 (0,10)};
// (0,10.4) @TEXT("VDD",size=1.1,halign="middle",valign="bottom");
// &"VSS" @WIRE(mode="straight",linecolor="#30485d",linewidth=0.16) {#XF7:6 (0,-10)};
// (0,-10.4) @TEXT("VSS",size=1.1,halign="middle",valign="top");
// &"VDD" @WIRE(mode="straight",linecolor="#30485d",linewidth=0.16) {#X001:2 (22,37)};
// (22,37.4) @TEXT("VDD",size=1.1,halign="middle",valign="bottom");
// &"VSS" @WIRE(mode="straight",linecolor="#30485d",linewidth=0.16) {#X001:3 (22,17)};
// (22,16.6) @TEXT("VSS",size=1.1,halign="middle",valign="top");
// }
// END SARADC RNL
ends sar8p_bitseq8

subckt sar8p_bit CODE D DATA PHI_W SAMPLE TOKEN VDD VSS
    XMUX (D DATA TOKEN VDD VSS NEXT_D) sar8p_mux2
    XRESET_DATA_OR (NEXT_D SAMPLE RESET_D VDD VSS) OR2D1BWP12T30P140
    XSTORE (PHI_W RESET_D D SAMPLE VDD VSS) sar8p_dffr
    X002 (D TOKEN VDD VSS CODE) sar8p_or2
// BEGIN SARADC RNL
// @RNL(author="saradc topology") {
// #XMUX @SET-SYMBOL $S_sar8p_mux2;
// #XMUX @PLACE(0,0) => @ORIENT("R0");
// #XRESET_DATA_OR @SET-SYMBOL $S_OR2D1BWP12T30P140;
// #XRESET_DATA_OR @PLACE(0,-33) => @ORIENT("R0");
// #XSTORE @SET-SYMBOL $S_sar8p_dffr;
// #XSTORE @PLACE(0,-66) => @ORIENT("R0");
// #X002 @SET-SYMBOL $S_sar8p_or2;
// #X002 @PLACE(0,-99) => @ORIENT("R0");
// &"TOKEN" @WIRE(mode="straight",linecolor="#30485d",linewidth=0.16) {#XMUX:3 (-7,-3.4) (-7,-100.7) #X002:2};
// &"NEXT_D" @WIRE(mode="straight",linecolor="#30485d",linewidth=0.16) {#XMUX:6 (-3,0) (-3,-29.7) #XRESET_DATA_OR:1};
// &"SAMPLE" @WIRE(mode="straight",linecolor="#30485d",linewidth=0.16) {#XRESET_DATA_OR:2 (-10,-33) (-10,-69.4) #XSTORE:4};
// &"RESET_D" @WIRE(mode="straight",linecolor="#30485d",linewidth=0.16) {#XRESET_DATA_OR:3 (-10,-36.3) (-10,-66) #XSTORE:2};
// (-89,30) @TEXT("sar8p_bit / source-derived connections",size=1.4,halign="start",textcolor="#223d52");
// &"D" @WIRE(mode="straight",linecolor="#30485d",linewidth=0.16) {#XMUX:1 (-10,3.4)};
// (-10.4,3.4) @TEXT("D",size=1.1,halign="end",valign="middle");
// &"DATA" @WIRE(mode="straight",linecolor="#30485d",linewidth=0.16) {#XMUX:2 (-10,0)};
// (-10.4,0) @TEXT("DATA",size=1.1,halign="end",valign="middle");
// &"VDD" @WIRE(mode="straight",linecolor="#30485d",linewidth=0.16) {#XMUX:4 (0,10)};
// (0,10.4) @TEXT("VDD",size=1.1,halign="middle",valign="bottom");
// &"VSS" @WIRE(mode="straight",linecolor="#30485d",linewidth=0.16) {#XMUX:5 (0,-10)};
// (0,-10.4) @TEXT("VSS",size=1.1,halign="middle",valign="top");
// &"VDD" @WIRE(mode="straight",linecolor="#30485d",linewidth=0.16) {#XRESET_DATA_OR:4 (0,-21.4)};
// (0,-21) @TEXT("VDD",size=1.1,halign="middle",valign="bottom");
// &"VSS" @WIRE(mode="straight",linecolor="#30485d",linewidth=0.16) {#XRESET_DATA_OR:5 (0,-44.6)};
// (0,-45) @TEXT("VSS",size=1.1,halign="middle",valign="top");
// &"PHI_W" @WIRE(mode="straight",linecolor="#30485d",linewidth=0.16) {#XSTORE:1 (-10,-62.6)};
// (-10.4,-62.6) @TEXT("PHI_W",size=1.1,halign="end",valign="middle");
// &"D" @WIRE(mode="straight",linecolor="#30485d",linewidth=0.16) {#XSTORE:3 (10,-66)};
// (10.4,-66) @TEXT("D",size=1.1,halign="start",valign="middle");
// &"VDD" @WIRE(mode="straight",linecolor="#30485d",linewidth=0.16) {#XSTORE:5 (0,-56)};
// (0,-55.6) @TEXT("VDD",size=1.1,halign="middle",valign="bottom");
// &"VSS" @WIRE(mode="straight",linecolor="#30485d",linewidth=0.16) {#XSTORE:6 (0,-76)};
// (0,-76.4) @TEXT("VSS",size=1.1,halign="middle",valign="top");
// &"D" @WIRE(mode="straight",linecolor="#30485d",linewidth=0.16) {#X002:1 (-10,-97.3)};
// (-10.4,-97.3) @TEXT("D",size=1.1,halign="end",valign="middle");
// &"VDD" @WIRE(mode="straight",linecolor="#30485d",linewidth=0.16) {#X002:3 (0,-89)};
// (0,-88.6) @TEXT("VDD",size=1.1,halign="middle",valign="bottom");
// &"VSS" @WIRE(mode="straight",linecolor="#30485d",linewidth=0.16) {#X002:4 (0,-109)};
// (0,-109.4) @TEXT("VSS",size=1.1,halign="middle",valign="top");
// &"CODE" @WIRE(mode="straight",linecolor="#30485d",linewidth=0.16) {#X002:5 (10,-99)};
// (10.4,-99) @TEXT("CODE",size=1.1,halign="start",valign="middle");
// }
// END SARADC RNL
ends sar8p_bit

subckt sar_logic_8b_physical CMP_CLK CODE0 CODE1 CODE2 CODE3 CODE4 CODE5          CODE6 CODE7 COMP_N COMP_P D0 D1 D2 D3 D4 D5 D6 D7 PHI_U SAMPLE VDD          VSS
    XTIM (ACTIVE CMP_CLK COMP_N COMP_P DATA PHI_U PHI_W SAMPLE VDD VSS)          sar8p_timing
    XSEQ (PHI_U SAMPLE T0 T1 T2 T3 T4 T5 T6 T7 VDD VSS) sar8p_bitseq8
    XBIT7 (CODE7 D7 DATA PHI_W SAMPLE T7 VDD VSS) sar8p_bit
    XBIT6 (CODE6 D6 DATA PHI_W SAMPLE T6 VDD VSS) sar8p_bit
    XBIT5 (CODE5 D5 DATA PHI_W SAMPLE T5 VDD VSS) sar8p_bit
    XBIT4 (CODE4 D4 DATA PHI_W SAMPLE T4 VDD VSS) sar8p_bit
    XBIT3 (CODE3 D3 DATA PHI_W SAMPLE T3 VDD VSS) sar8p_bit
    XBIT2 (CODE2 D2 DATA PHI_W SAMPLE T2 VDD VSS) sar8p_bit
    XBIT1 (CODE1 D1 DATA PHI_W SAMPLE T1 VDD VSS) sar8p_bit
    XBIT0 (CODE0 D0 DATA PHI_W SAMPLE T0 VDD VSS) sar8p_bit
    X018 (A01 A23 VDD VSS ACTIVE) sar8p_or2
    X017 (A2 A3 VDD VSS A23) sar8p_or2
    X016 (A0 A1 VDD VSS A01) sar8p_or2
    X015 (T6 T7 VDD VSS A3) sar8p_or2
    X014 (T4 T5 VDD VSS A2) sar8p_or2
    X013 (T2 T3 VDD VSS A1) sar8p_or2
    X012 (T0 T1 VDD VSS A0) sar8p_or2
// BEGIN SARADC RNL
// @RNL(author="saradc topology") {
// (-23,82) @TEXT("8-bit SAR / one token, eight bit stores, asynchronous handshake",size=1.5,halign="start",textcolor="#223d52");
// #XTIM @SET-SYMBOL $S_sar8p_timing;
// #XTIM @PLACE(0,39) => @ORIENT("R0");
// #XSEQ @SET-SYMBOL $S_sar8p_bitseq8;
// #XSEQ @PLACE(0,-17) => @ORIENT("R0");
// #XBIT7 @SET-SYMBOL $S_sar8p_bit;
// #XBIT7 @PLACE(73,0) => @ORIENT("R0");
// #XBIT6 @SET-SYMBOL $S_sar8p_bit;
// #XBIT6 @PLACE(73,-35) => @ORIENT("R0");
// #XBIT5 @SET-SYMBOL $S_sar8p_bit;
// #XBIT5 @PLACE(73,-70) => @ORIENT("R0");
// #XBIT4 @SET-SYMBOL $S_sar8p_bit;
// #XBIT4 @PLACE(73,-105) => @ORIENT("R0");
// #XBIT3 @SET-SYMBOL $S_sar8p_bit;
// #XBIT3 @PLACE(73,-140) => @ORIENT("R0");
// #XBIT2 @SET-SYMBOL $S_sar8p_bit;
// #XBIT2 @PLACE(73,-175) => @ORIENT("R0");
// #XBIT1 @SET-SYMBOL $S_sar8p_bit;
// #XBIT1 @PLACE(73,-210) => @ORIENT("R0");
// #XBIT0 @SET-SYMBOL $S_sar8p_bit;
// #XBIT0 @PLACE(73,-245) => @ORIENT("R0");
// #X012 @SET-SYMBOL $S_sar8p_or2;
// #X012 @PLACE(142,0) => @ORIENT("R0");
// #X013 @SET-SYMBOL $S_sar8p_or2;
// #X013 @PLACE(142,-70) => @ORIENT("R0");
// #X014 @SET-SYMBOL $S_sar8p_or2;
// #X014 @PLACE(142,-140) => @ORIENT("R0");
// #X015 @SET-SYMBOL $S_sar8p_or2;
// #X015 @PLACE(142,-210) => @ORIENT("R0");
// #X016 @SET-SYMBOL $S_sar8p_or2;
// #X016 @PLACE(184,-35) => @ORIENT("R0");
// #X017 @SET-SYMBOL $S_sar8p_or2;
// #X017 @PLACE(184,-175) => @ORIENT("R0");
// #X018 @SET-SYMBOL $S_sar8p_or2;
// #X018 @PLACE(225,-105) => @ORIENT("R0");
// &"A0" @WIRE(mode="straight",linecolor="#30485d",linewidth=0.16) {(163,-33.3) (163,0)};
// &"A0" @WIRE(mode="straight",linecolor="#30485d",linewidth=0.16) {#X016:1 (163,-33.3)};
// $JUNCTION @ATTACH (163,-33.3);
// &"A0" @WIRE(mode="straight",linecolor="#30485d",linewidth=0.16) {#X012:5 (163,0)};
// $JUNCTION @ATTACH (163,0);
// &"A1" @WIRE(mode="straight",linecolor="#30485d",linewidth=0.16) {(163,-70) (163,-36.7)};
// &"A1" @WIRE(mode="straight",linecolor="#30485d",linewidth=0.16) {#X016:2 (163,-36.7)};
// $JUNCTION @ATTACH (163,-36.7);
// &"A1" @WIRE(mode="straight",linecolor="#30485d",linewidth=0.16) {#X013:5 (163,-70)};
// $JUNCTION @ATTACH (163,-70);
// &"A2" @WIRE(mode="straight",linecolor="#30485d",linewidth=0.16) {(163,-173.3) (163,-140)};
// &"A2" @WIRE(mode="straight",linecolor="#30485d",linewidth=0.16) {#X017:1 (163,-173.3)};
// $JUNCTION @ATTACH (163,-173.3);
// &"A2" @WIRE(mode="straight",linecolor="#30485d",linewidth=0.16) {#X014:5 (163,-140)};
// $JUNCTION @ATTACH (163,-140);
// &"A3" @WIRE(mode="straight",linecolor="#30485d",linewidth=0.16) {(163,-210) (163,-176.7)};
// &"A3" @WIRE(mode="straight",linecolor="#30485d",linewidth=0.16) {#X017:2 (163,-176.7)};
// $JUNCTION @ATTACH (163,-176.7);
// &"A3" @WIRE(mode="straight",linecolor="#30485d",linewidth=0.16) {#X015:5 (163,-210)};
// $JUNCTION @ATTACH (163,-210);
// &"A01" @WIRE(mode="straight",linecolor="#30485d",linewidth=0.16) {(204.5,-103.3) (204.5,-35)};
// &"A01" @WIRE(mode="straight",linecolor="#30485d",linewidth=0.16) {#X018:1 (204.5,-103.3)};
// $JUNCTION @ATTACH (204.5,-103.3);
// &"A01" @WIRE(mode="straight",linecolor="#30485d",linewidth=0.16) {#X016:5 (204.5,-35)};
// $JUNCTION @ATTACH (204.5,-35);
// &"A23" @WIRE(mode="straight",linecolor="#30485d",linewidth=0.16) {(204.5,-175) (204.5,-106.7)};
// &"A23" @WIRE(mode="straight",linecolor="#30485d",linewidth=0.16) {#X018:2 (204.5,-106.7)};
// $JUNCTION @ATTACH (204.5,-106.7);
// &"A23" @WIRE(mode="straight",linecolor="#30485d",linewidth=0.16) {#X017:5 (204.5,-175)};
// $JUNCTION @ATTACH (204.5,-175);
// &"ACTIVE" @WIRE(mode="straight",linecolor="#30485d",linewidth=0.16) {(109.5,-105) (109.5,43.95)};
// &"ACTIVE" @WIRE(mode="straight",linecolor="#30485d",linewidth=0.16) {#XTIM:1 (109.5,43.95)};
// $JUNCTION @ATTACH (109.5,43.95);
// &"ACTIVE" @WIRE(mode="straight",linecolor="#30485d",linewidth=0.16) {#X018:5 (109.5,-105)};
// $JUNCTION @ATTACH (109.5,-105);
// &"DATA" @WIRE(mode="straight",linecolor="#30485d",linewidth=0.16) {(33,-240.05) (33,-205.05) (33,-170.05) (33,-135.05) (33,-100.05) (33,-65.05) (33,-30.05) (33,4.95) (33,40.65)};
// &"DATA" @WIRE(mode="straight",linecolor="#30485d",linewidth=0.16) {#XTIM:5 (33,40.65)};
// $JUNCTION @ATTACH (33,40.65);
// &"DATA" @WIRE(mode="straight",linecolor="#30485d",linewidth=0.16) {#XBIT7:3 (33,4.95)};
// $JUNCTION @ATTACH (33,4.95);
// &"DATA" @WIRE(mode="straight",linecolor="#30485d",linewidth=0.16) {#XBIT6:3 (33,-30.05)};
// $JUNCTION @ATTACH (33,-30.05);
// &"DATA" @WIRE(mode="straight",linecolor="#30485d",linewidth=0.16) {#XBIT5:3 (33,-65.05)};
// $JUNCTION @ATTACH (33,-65.05);
// &"DATA" @WIRE(mode="straight",linecolor="#30485d",linewidth=0.16) {#XBIT4:3 (33,-100.05)};
// $JUNCTION @ATTACH (33,-100.05);
// &"DATA" @WIRE(mode="straight",linecolor="#30485d",linewidth=0.16) {#XBIT3:3 (33,-135.05)};
// $JUNCTION @ATTACH (33,-135.05);
// &"DATA" @WIRE(mode="straight",linecolor="#30485d",linewidth=0.16) {#XBIT2:3 (33,-170.05)};
// $JUNCTION @ATTACH (33,-170.05);
// &"DATA" @WIRE(mode="straight",linecolor="#30485d",linewidth=0.16) {#XBIT1:3 (33,-205.05)};
// $JUNCTION @ATTACH (33,-205.05);
// &"DATA" @WIRE(mode="straight",linecolor="#30485d",linewidth=0.16) {#XBIT0:3 (33,-240.05)};
// $JUNCTION @ATTACH (33,-240.05);
// &"PHI_W" @WIRE(mode="straight",linecolor="#94601a",linewidth=0.16) {(38,-243.35) (38,-208.35) (38,-173.35) (38,-138.35) (38,-103.35) (38,-68.35) (38,-33.35) (38,1.65) (38,34.05)};
// &"PHI_W" @WIRE(mode="straight",linecolor="#94601a",linewidth=0.16) {#XTIM:7 (38,34.05)};
// $JUNCTION @ATTACH (38,34.05);
// &"PHI_W" @WIRE(mode="straight",linecolor="#94601a",linewidth=0.16) {#XBIT7:4 (38,1.65)};
// $JUNCTION @ATTACH (38,1.65);
// &"PHI_W" @WIRE(mode="straight",linecolor="#94601a",linewidth=0.16) {#XBIT6:4 (38,-33.35)};
// $JUNCTION @ATTACH (38,-33.35);
// &"PHI_W" @WIRE(mode="straight",linecolor="#94601a",linewidth=0.16) {#XBIT5:4 (38,-68.35)};
// $JUNCTION @ATTACH (38,-68.35);
// &"PHI_W" @WIRE(mode="straight",linecolor="#94601a",linewidth=0.16) {#XBIT4:4 (38,-103.35)};
// $JUNCTION @ATTACH (38,-103.35);
// &"PHI_W" @WIRE(mode="straight",linecolor="#94601a",linewidth=0.16) {#XBIT3:4 (38,-138.35)};
// $JUNCTION @ATTACH (38,-138.35);
// &"PHI_W" @WIRE(mode="straight",linecolor="#94601a",linewidth=0.16) {#XBIT2:4 (38,-173.35)};
// $JUNCTION @ATTACH (38,-173.35);
// &"PHI_W" @WIRE(mode="straight",linecolor="#94601a",linewidth=0.16) {#XBIT1:4 (38,-208.35)};
// $JUNCTION @ATTACH (38,-208.35);
// &"PHI_W" @WIRE(mode="straight",linecolor="#94601a",linewidth=0.16) {#XBIT0:4 (38,-243.35)};
// $JUNCTION @ATTACH (38,-243.35);
// (121,-246) @TEXT("OR reduction -> ACTIVE",size=1.15,halign="start",textcolor="#223d52");
// (-23,-274) @TEXT("T[7:0] selects one bit; CODE is the trial word and D the stored output. SAMPLE resets the controller.",size=0.95,halign="start",textcolor="#223d52");
// &"CMP_CLK" @WIRE(mode="straight",linecolor="#30485d",linewidth=0.16) {#XTIM:2 (16,43.95)};
// (16.4,43.95) @TEXT("CMP_CLK",size=1.1,halign="start",valign="middle");
// &"COMP_N" @WIRE(mode="straight",linecolor="#30485d",linewidth=0.16) {#XTIM:3 (-16,40.65)};
// (-16.4,40.65) @TEXT("COMP_N",size=1.1,halign="end",valign="middle");
// &"COMP_P" @WIRE(mode="straight",linecolor="#30485d",linewidth=0.16) {#XTIM:4 (-16,37.35)};
// (-16.4,37.35) @TEXT("COMP_P",size=1.1,halign="end",valign="middle");
// &"PHI_U" @WIRE(mode="straight",linecolor="#30485d",linewidth=0.16) {#XTIM:6 (16,37.35)};
// (16.4,37.35) @TEXT("PHI_U",size=1.1,halign="start",valign="middle");
// &"SAMPLE" @WIRE(mode="straight",linecolor="#30485d",linewidth=0.16) {#XTIM:8 (-16,34.05)};
// (-16.4,34.05) @TEXT("SAMPLE",size=1.1,halign="end",valign="middle");
// &"VDD" @WIRE(mode="straight",linecolor="#30485d",linewidth=0.16) {#XTIM:9 (0,52.25)};
// (0,52.65) @TEXT("VDD",size=1.1,halign="middle",valign="bottom");
// &"VSS" @WIRE(mode="straight",linecolor="#30485d",linewidth=0.16) {#XTIM:10 (0,25.75)};
// (0,25.35) @TEXT("VSS",size=1.1,halign="middle",valign="top");
// &"PHI_U" @WIRE(mode="straight",linecolor="#30485d",linewidth=0.16) {#XSEQ:1 (-16,-15.35)};
// (-16.4,-15.35) @TEXT("PHI_U",size=1.1,halign="end",valign="middle");
// &"SAMPLE" @WIRE(mode="straight",linecolor="#30485d",linewidth=0.16) {#XSEQ:2 (-16,-18.65)};
// (-16.4,-18.65) @TEXT("SAMPLE",size=1.1,halign="end",valign="middle");
// {&"T0" &"T1" &"T2" &"T3" &"T4" &"T5" &"T6" &"T7"} @WIRE(mode="straight",linewidth=0.3) {#XSEQ:3 (16,-17)};
// (16.4,-17) @TEXT("T[7:0]",size=1.1,halign="start",valign="middle");
// &"VDD" @WIRE(mode="straight",linecolor="#30485d",linewidth=0.16) {#XSEQ:11 (0,-6)};
// (0,-5.6) @TEXT("VDD",size=1.1,halign="middle",valign="bottom");
// &"VSS" @WIRE(mode="straight",linecolor="#30485d",linewidth=0.16) {#XSEQ:12 (0,-28)};
// (0,-28.4) @TEXT("VSS",size=1.1,halign="middle",valign="top");
// &"CODE7" @WIRE(mode="straight",linecolor="#30485d",linewidth=0.16) {#XBIT7:1 (89,1.65)};
// (89.4,1.65) @TEXT("CODE7",size=1.1,halign="start",valign="middle");
// &"D7" @WIRE(mode="straight",linecolor="#30485d",linewidth=0.16) {#XBIT7:2 (89,-1.65)};
// (89.4,-1.65) @TEXT("D7",size=1.1,halign="start",valign="middle");
// &"SAMPLE" @WIRE(mode="straight",linecolor="#30485d",linewidth=0.16) {#XBIT7:5 (57,-1.65)};
// (56.6,-1.65) @TEXT("SAMPLE",size=1.1,halign="end",valign="middle");
// &"T7" @WIRE(mode="straight",linecolor="#30485d",linewidth=0.16) {#XBIT7:6 (57,-4.95)};
// (56.6,-4.95) @TEXT("T7",size=1.1,halign="end",valign="middle");
// &"VDD" @WIRE(mode="straight",linecolor="#30485d",linewidth=0.16) {#XBIT7:7 (73,13.25)};
// (73,13.65) @TEXT("VDD",size=1.1,halign="middle",valign="bottom");
// &"VSS" @WIRE(mode="straight",linecolor="#30485d",linewidth=0.16) {#XBIT7:8 (73,-13.25)};
// (73,-13.65) @TEXT("VSS",size=1.1,halign="middle",valign="top");
// &"CODE6" @WIRE(mode="straight",linecolor="#30485d",linewidth=0.16) {#XBIT6:1 (89,-33.35)};
// (89.4,-33.35) @TEXT("CODE6",size=1.1,halign="start",valign="middle");
// &"D6" @WIRE(mode="straight",linecolor="#30485d",linewidth=0.16) {#XBIT6:2 (89,-36.65)};
// (89.4,-36.65) @TEXT("D6",size=1.1,halign="start",valign="middle");
// &"SAMPLE" @WIRE(mode="straight",linecolor="#30485d",linewidth=0.16) {#XBIT6:5 (57,-36.65)};
// (56.6,-36.65) @TEXT("SAMPLE",size=1.1,halign="end",valign="middle");
// &"T6" @WIRE(mode="straight",linecolor="#30485d",linewidth=0.16) {#XBIT6:6 (57,-39.95)};
// (56.6,-39.95) @TEXT("T6",size=1.1,halign="end",valign="middle");
// &"VDD" @WIRE(mode="straight",linecolor="#30485d",linewidth=0.16) {#XBIT6:7 (73,-21.75)};
// (73,-21.35) @TEXT("VDD",size=1.1,halign="middle",valign="bottom");
// &"VSS" @WIRE(mode="straight",linecolor="#30485d",linewidth=0.16) {#XBIT6:8 (73,-48.25)};
// (73,-48.65) @TEXT("VSS",size=1.1,halign="middle",valign="top");
// &"CODE5" @WIRE(mode="straight",linecolor="#30485d",linewidth=0.16) {#XBIT5:1 (89,-68.35)};
// (89.4,-68.35) @TEXT("CODE5",size=1.1,halign="start",valign="middle");
// &"D5" @WIRE(mode="straight",linecolor="#30485d",linewidth=0.16) {#XBIT5:2 (89,-71.65)};
// (89.4,-71.65) @TEXT("D5",size=1.1,halign="start",valign="middle");
// &"SAMPLE" @WIRE(mode="straight",linecolor="#30485d",linewidth=0.16) {#XBIT5:5 (57,-71.65)};
// (56.6,-71.65) @TEXT("SAMPLE",size=1.1,halign="end",valign="middle");
// &"T5" @WIRE(mode="straight",linecolor="#30485d",linewidth=0.16) {#XBIT5:6 (57,-74.95)};
// (56.6,-74.95) @TEXT("T5",size=1.1,halign="end",valign="middle");
// &"VDD" @WIRE(mode="straight",linecolor="#30485d",linewidth=0.16) {#XBIT5:7 (73,-56.75)};
// (73,-56.35) @TEXT("VDD",size=1.1,halign="middle",valign="bottom");
// &"VSS" @WIRE(mode="straight",linecolor="#30485d",linewidth=0.16) {#XBIT5:8 (73,-83.25)};
// (73,-83.65) @TEXT("VSS",size=1.1,halign="middle",valign="top");
// &"CODE4" @WIRE(mode="straight",linecolor="#30485d",linewidth=0.16) {#XBIT4:1 (89,-103.35)};
// (89.4,-103.35) @TEXT("CODE4",size=1.1,halign="start",valign="middle");
// &"D4" @WIRE(mode="straight",linecolor="#30485d",linewidth=0.16) {#XBIT4:2 (89,-106.65)};
// (89.4,-106.65) @TEXT("D4",size=1.1,halign="start",valign="middle");
// &"SAMPLE" @WIRE(mode="straight",linecolor="#30485d",linewidth=0.16) {#XBIT4:5 (57,-106.65)};
// (56.6,-106.65) @TEXT("SAMPLE",size=1.1,halign="end",valign="middle");
// &"T4" @WIRE(mode="straight",linecolor="#30485d",linewidth=0.16) {#XBIT4:6 (57,-109.95)};
// (56.6,-109.95) @TEXT("T4",size=1.1,halign="end",valign="middle");
// &"VDD" @WIRE(mode="straight",linecolor="#30485d",linewidth=0.16) {#XBIT4:7 (73,-91.75)};
// (73,-91.35) @TEXT("VDD",size=1.1,halign="middle",valign="bottom");
// &"VSS" @WIRE(mode="straight",linecolor="#30485d",linewidth=0.16) {#XBIT4:8 (73,-118.25)};
// (73,-118.65) @TEXT("VSS",size=1.1,halign="middle",valign="top");
// &"CODE3" @WIRE(mode="straight",linecolor="#30485d",linewidth=0.16) {#XBIT3:1 (89,-138.35)};
// (89.4,-138.35) @TEXT("CODE3",size=1.1,halign="start",valign="middle");
// &"D3" @WIRE(mode="straight",linecolor="#30485d",linewidth=0.16) {#XBIT3:2 (89,-141.65)};
// (89.4,-141.65) @TEXT("D3",size=1.1,halign="start",valign="middle");
// &"SAMPLE" @WIRE(mode="straight",linecolor="#30485d",linewidth=0.16) {#XBIT3:5 (57,-141.65)};
// (56.6,-141.65) @TEXT("SAMPLE",size=1.1,halign="end",valign="middle");
// &"T3" @WIRE(mode="straight",linecolor="#30485d",linewidth=0.16) {#XBIT3:6 (57,-144.95)};
// (56.6,-144.95) @TEXT("T3",size=1.1,halign="end",valign="middle");
// &"VDD" @WIRE(mode="straight",linecolor="#30485d",linewidth=0.16) {#XBIT3:7 (73,-126.75)};
// (73,-126.35) @TEXT("VDD",size=1.1,halign="middle",valign="bottom");
// &"VSS" @WIRE(mode="straight",linecolor="#30485d",linewidth=0.16) {#XBIT3:8 (73,-153.25)};
// (73,-153.65) @TEXT("VSS",size=1.1,halign="middle",valign="top");
// &"CODE2" @WIRE(mode="straight",linecolor="#30485d",linewidth=0.16) {#XBIT2:1 (89,-173.35)};
// (89.4,-173.35) @TEXT("CODE2",size=1.1,halign="start",valign="middle");
// &"D2" @WIRE(mode="straight",linecolor="#30485d",linewidth=0.16) {#XBIT2:2 (89,-176.65)};
// (89.4,-176.65) @TEXT("D2",size=1.1,halign="start",valign="middle");
// &"SAMPLE" @WIRE(mode="straight",linecolor="#30485d",linewidth=0.16) {#XBIT2:5 (57,-176.65)};
// (56.6,-176.65) @TEXT("SAMPLE",size=1.1,halign="end",valign="middle");
// &"T2" @WIRE(mode="straight",linecolor="#30485d",linewidth=0.16) {#XBIT2:6 (57,-179.95)};
// (56.6,-179.95) @TEXT("T2",size=1.1,halign="end",valign="middle");
// &"VDD" @WIRE(mode="straight",linecolor="#30485d",linewidth=0.16) {#XBIT2:7 (73,-161.75)};
// (73,-161.35) @TEXT("VDD",size=1.1,halign="middle",valign="bottom");
// &"VSS" @WIRE(mode="straight",linecolor="#30485d",linewidth=0.16) {#XBIT2:8 (73,-188.25)};
// (73,-188.65) @TEXT("VSS",size=1.1,halign="middle",valign="top");
// &"CODE1" @WIRE(mode="straight",linecolor="#30485d",linewidth=0.16) {#XBIT1:1 (89,-208.35)};
// (89.4,-208.35) @TEXT("CODE1",size=1.1,halign="start",valign="middle");
// &"D1" @WIRE(mode="straight",linecolor="#30485d",linewidth=0.16) {#XBIT1:2 (89,-211.65)};
// (89.4,-211.65) @TEXT("D1",size=1.1,halign="start",valign="middle");
// &"SAMPLE" @WIRE(mode="straight",linecolor="#30485d",linewidth=0.16) {#XBIT1:5 (57,-211.65)};
// (56.6,-211.65) @TEXT("SAMPLE",size=1.1,halign="end",valign="middle");
// &"T1" @WIRE(mode="straight",linecolor="#30485d",linewidth=0.16) {#XBIT1:6 (57,-214.95)};
// (56.6,-214.95) @TEXT("T1",size=1.1,halign="end",valign="middle");
// &"VDD" @WIRE(mode="straight",linecolor="#30485d",linewidth=0.16) {#XBIT1:7 (73,-196.75)};
// (73,-196.35) @TEXT("VDD",size=1.1,halign="middle",valign="bottom");
// &"VSS" @WIRE(mode="straight",linecolor="#30485d",linewidth=0.16) {#XBIT1:8 (73,-223.25)};
// (73,-223.65) @TEXT("VSS",size=1.1,halign="middle",valign="top");
// &"CODE0" @WIRE(mode="straight",linecolor="#30485d",linewidth=0.16) {#XBIT0:1 (89,-243.35)};
// (89.4,-243.35) @TEXT("CODE0",size=1.1,halign="start",valign="middle");
// &"D0" @WIRE(mode="straight",linecolor="#30485d",linewidth=0.16) {#XBIT0:2 (89,-246.65)};
// (89.4,-246.65) @TEXT("D0",size=1.1,halign="start",valign="middle");
// &"SAMPLE" @WIRE(mode="straight",linecolor="#30485d",linewidth=0.16) {#XBIT0:5 (57,-246.65)};
// (56.6,-246.65) @TEXT("SAMPLE",size=1.1,halign="end",valign="middle");
// &"T0" @WIRE(mode="straight",linecolor="#30485d",linewidth=0.16) {#XBIT0:6 (57,-249.95)};
// (56.6,-249.95) @TEXT("T0",size=1.1,halign="end",valign="middle");
// &"VDD" @WIRE(mode="straight",linecolor="#30485d",linewidth=0.16) {#XBIT0:7 (73,-231.75)};
// (73,-231.35) @TEXT("VDD",size=1.1,halign="middle",valign="bottom");
// &"VSS" @WIRE(mode="straight",linecolor="#30485d",linewidth=0.16) {#XBIT0:8 (73,-258.25)};
// (73,-258.65) @TEXT("VSS",size=1.1,halign="middle",valign="top");
// &"VDD" @WIRE(mode="straight",linecolor="#30485d",linewidth=0.16) {#X018:3 (225,-95)};
// (225,-94.6) @TEXT("VDD",size=1.1,halign="middle",valign="bottom");
// &"VSS" @WIRE(mode="straight",linecolor="#30485d",linewidth=0.16) {#X018:4 (225,-115)};
// (225,-115.4) @TEXT("VSS",size=1.1,halign="middle",valign="top");
// &"VDD" @WIRE(mode="straight",linecolor="#30485d",linewidth=0.16) {#X017:3 (184,-165)};
// (184,-164.6) @TEXT("VDD",size=1.1,halign="middle",valign="bottom");
// &"VSS" @WIRE(mode="straight",linecolor="#30485d",linewidth=0.16) {#X017:4 (184,-185)};
// (184,-185.4) @TEXT("VSS",size=1.1,halign="middle",valign="top");
// &"VDD" @WIRE(mode="straight",linecolor="#30485d",linewidth=0.16) {#X016:3 (184,-25)};
// (184,-24.6) @TEXT("VDD",size=1.1,halign="middle",valign="bottom");
// &"VSS" @WIRE(mode="straight",linecolor="#30485d",linewidth=0.16) {#X016:4 (184,-45)};
// (184,-45.4) @TEXT("VSS",size=1.1,halign="middle",valign="top");
// &"T6" @WIRE(mode="straight",linecolor="#30485d",linewidth=0.16) {#X015:1 (132,-208.3)};
// (131.6,-208.3) @TEXT("T6",size=1.1,halign="end",valign="middle");
// &"T7" @WIRE(mode="straight",linecolor="#30485d",linewidth=0.16) {#X015:2 (132,-211.7)};
// (131.6,-211.7) @TEXT("T7",size=1.1,halign="end",valign="middle");
// &"VDD" @WIRE(mode="straight",linecolor="#30485d",linewidth=0.16) {#X015:3 (142,-200)};
// (142,-199.6) @TEXT("VDD",size=1.1,halign="middle",valign="bottom");
// &"VSS" @WIRE(mode="straight",linecolor="#30485d",linewidth=0.16) {#X015:4 (142,-220)};
// (142,-220.4) @TEXT("VSS",size=1.1,halign="middle",valign="top");
// &"T4" @WIRE(mode="straight",linecolor="#30485d",linewidth=0.16) {#X014:1 (132,-138.3)};
// (131.6,-138.3) @TEXT("T4",size=1.1,halign="end",valign="middle");
// &"T5" @WIRE(mode="straight",linecolor="#30485d",linewidth=0.16) {#X014:2 (132,-141.7)};
// (131.6,-141.7) @TEXT("T5",size=1.1,halign="end",valign="middle");
// &"VDD" @WIRE(mode="straight",linecolor="#30485d",linewidth=0.16) {#X014:3 (142,-130)};
// (142,-129.6) @TEXT("VDD",size=1.1,halign="middle",valign="bottom");
// &"VSS" @WIRE(mode="straight",linecolor="#30485d",linewidth=0.16) {#X014:4 (142,-150)};
// (142,-150.4) @TEXT("VSS",size=1.1,halign="middle",valign="top");
// &"T2" @WIRE(mode="straight",linecolor="#30485d",linewidth=0.16) {#X013:1 (132,-68.3)};
// (131.6,-68.3) @TEXT("T2",size=1.1,halign="end",valign="middle");
// &"T3" @WIRE(mode="straight",linecolor="#30485d",linewidth=0.16) {#X013:2 (132,-71.7)};
// (131.6,-71.7) @TEXT("T3",size=1.1,halign="end",valign="middle");
// &"VDD" @WIRE(mode="straight",linecolor="#30485d",linewidth=0.16) {#X013:3 (142,-60)};
// (142,-59.6) @TEXT("VDD",size=1.1,halign="middle",valign="bottom");
// &"VSS" @WIRE(mode="straight",linecolor="#30485d",linewidth=0.16) {#X013:4 (142,-80)};
// (142,-80.4) @TEXT("VSS",size=1.1,halign="middle",valign="top");
// &"T0" @WIRE(mode="straight",linecolor="#30485d",linewidth=0.16) {#X012:1 (132,1.7)};
// (131.6,1.7) @TEXT("T0",size=1.1,halign="end",valign="middle");
// &"T1" @WIRE(mode="straight",linecolor="#30485d",linewidth=0.16) {#X012:2 (132,-1.7)};
// (131.6,-1.7) @TEXT("T1",size=1.1,halign="end",valign="middle");
// &"VDD" @WIRE(mode="straight",linecolor="#30485d",linewidth=0.16) {#X012:3 (142,10)};
// (142,10.4) @TEXT("VDD",size=1.1,halign="middle",valign="bottom");
// &"VSS" @WIRE(mode="straight",linecolor="#30485d",linewidth=0.16) {#X012:4 (142,-10)};
// (142,-10.4) @TEXT("VSS",size=1.1,halign="middle",valign="top");
// }
// END SARADC RNL
ends sar_logic_8b_physical

subckt sar8i_ctrl CMP_CLK CODE0 CODE1 CODE2 CODE3 CODE4 CODE5  CODE6 CODE7 COMP_N COMP_P D0 D1 D2 D3 D4 D5 D6 D7 PHI_U SAMPLE VDD  VSS ACTIVE
    XTIM (ACTIVE CMP_CLK COMP_N COMP_P DATA PHI_U PHI_W SAMPLE VDD VSS)  sar8p_timing
    XSEQ (PHI_U SAMPLE T0 T1 T2 T3 T4 T5 T6 T7 VDD VSS) sar8p_bitseq8
    XBIT7 (CODE7 D7 DATA PHI_W SAMPLE T7 VDD VSS) sar8p_bit
    XBIT6 (CODE6 D6 DATA PHI_W SAMPLE T6 VDD VSS) sar8p_bit
    XBIT5 (CODE5 D5 DATA PHI_W SAMPLE T5 VDD VSS) sar8p_bit
    XBIT4 (CODE4 D4 DATA PHI_W SAMPLE T4 VDD VSS) sar8p_bit
    XBIT3 (CODE3 D3 DATA PHI_W SAMPLE T3 VDD VSS) sar8p_bit
    XBIT2 (CODE2 D2 DATA PHI_W SAMPLE T2 VDD VSS) sar8p_bit
    XBIT1 (CODE1 D1 DATA PHI_W SAMPLE T1 VDD VSS) sar8p_bit
    XBIT0 (CODE0 D0 DATA PHI_W SAMPLE T0 VDD VSS) sar8p_bit
    X018 (A01 A23 VDD VSS ACTIVE) sar8p_or2
    X017 (A2 A3 VDD VSS A23) sar8p_or2
    X016 (A0 A1 VDD VSS A01) sar8p_or2
    X015 (T6 T7 VDD VSS A3) sar8p_or2
    X014 (T4 T5 VDD VSS A2) sar8p_or2
    X013 (T2 T3 VDD VSS A1) sar8p_or2
    X012 (T0 T1 VDD VSS A0) sar8p_or2
// BEGIN SARADC RNL
// @RNL(author="saradc topology") {
// (-23,82) @TEXT("8-bit SAR / one token, eight bit stores, asynchronous handshake",size=1.5,halign="start",textcolor="#223d52");
// #XTIM @SET-SYMBOL $S_sar8p_timing;
// #XTIM @PLACE(0,39) => @ORIENT("R0");
// #XSEQ @SET-SYMBOL $S_sar8p_bitseq8;
// #XSEQ @PLACE(0,-17) => @ORIENT("R0");
// #XBIT7 @SET-SYMBOL $S_sar8p_bit;
// #XBIT7 @PLACE(73,0) => @ORIENT("R0");
// #XBIT6 @SET-SYMBOL $S_sar8p_bit;
// #XBIT6 @PLACE(73,-35) => @ORIENT("R0");
// #XBIT5 @SET-SYMBOL $S_sar8p_bit;
// #XBIT5 @PLACE(73,-70) => @ORIENT("R0");
// #XBIT4 @SET-SYMBOL $S_sar8p_bit;
// #XBIT4 @PLACE(73,-105) => @ORIENT("R0");
// #XBIT3 @SET-SYMBOL $S_sar8p_bit;
// #XBIT3 @PLACE(73,-140) => @ORIENT("R0");
// #XBIT2 @SET-SYMBOL $S_sar8p_bit;
// #XBIT2 @PLACE(73,-175) => @ORIENT("R0");
// #XBIT1 @SET-SYMBOL $S_sar8p_bit;
// #XBIT1 @PLACE(73,-210) => @ORIENT("R0");
// #XBIT0 @SET-SYMBOL $S_sar8p_bit;
// #XBIT0 @PLACE(73,-245) => @ORIENT("R0");
// #X012 @SET-SYMBOL $S_sar8p_or2;
// #X012 @PLACE(142,0) => @ORIENT("R0");
// #X013 @SET-SYMBOL $S_sar8p_or2;
// #X013 @PLACE(142,-70) => @ORIENT("R0");
// #X014 @SET-SYMBOL $S_sar8p_or2;
// #X014 @PLACE(142,-140) => @ORIENT("R0");
// #X015 @SET-SYMBOL $S_sar8p_or2;
// #X015 @PLACE(142,-210) => @ORIENT("R0");
// #X016 @SET-SYMBOL $S_sar8p_or2;
// #X016 @PLACE(184,-35) => @ORIENT("R0");
// #X017 @SET-SYMBOL $S_sar8p_or2;
// #X017 @PLACE(184,-175) => @ORIENT("R0");
// #X018 @SET-SYMBOL $S_sar8p_or2;
// #X018 @PLACE(225,-105) => @ORIENT("R0");
// &"A0" @WIRE(mode="straight",linecolor="#30485d",linewidth=0.16) {(163,-33.3) (163,0)};
// &"A0" @WIRE(mode="straight",linecolor="#30485d",linewidth=0.16) {#X016:1 (163,-33.3)};
// $JUNCTION @ATTACH (163,-33.3);
// &"A0" @WIRE(mode="straight",linecolor="#30485d",linewidth=0.16) {#X012:5 (163,0)};
// $JUNCTION @ATTACH (163,0);
// &"A1" @WIRE(mode="straight",linecolor="#30485d",linewidth=0.16) {(163,-70) (163,-36.7)};
// &"A1" @WIRE(mode="straight",linecolor="#30485d",linewidth=0.16) {#X016:2 (163,-36.7)};
// $JUNCTION @ATTACH (163,-36.7);
// &"A1" @WIRE(mode="straight",linecolor="#30485d",linewidth=0.16) {#X013:5 (163,-70)};
// $JUNCTION @ATTACH (163,-70);
// &"A2" @WIRE(mode="straight",linecolor="#30485d",linewidth=0.16) {(163,-173.3) (163,-140)};
// &"A2" @WIRE(mode="straight",linecolor="#30485d",linewidth=0.16) {#X017:1 (163,-173.3)};
// $JUNCTION @ATTACH (163,-173.3);
// &"A2" @WIRE(mode="straight",linecolor="#30485d",linewidth=0.16) {#X014:5 (163,-140)};
// $JUNCTION @ATTACH (163,-140);
// &"A3" @WIRE(mode="straight",linecolor="#30485d",linewidth=0.16) {(163,-210) (163,-176.7)};
// &"A3" @WIRE(mode="straight",linecolor="#30485d",linewidth=0.16) {#X017:2 (163,-176.7)};
// $JUNCTION @ATTACH (163,-176.7);
// &"A3" @WIRE(mode="straight",linecolor="#30485d",linewidth=0.16) {#X015:5 (163,-210)};
// $JUNCTION @ATTACH (163,-210);
// &"A01" @WIRE(mode="straight",linecolor="#30485d",linewidth=0.16) {(204.5,-103.3) (204.5,-35)};
// &"A01" @WIRE(mode="straight",linecolor="#30485d",linewidth=0.16) {#X018:1 (204.5,-103.3)};
// $JUNCTION @ATTACH (204.5,-103.3);
// &"A01" @WIRE(mode="straight",linecolor="#30485d",linewidth=0.16) {#X016:5 (204.5,-35)};
// $JUNCTION @ATTACH (204.5,-35);
// &"A23" @WIRE(mode="straight",linecolor="#30485d",linewidth=0.16) {(204.5,-175) (204.5,-106.7)};
// &"A23" @WIRE(mode="straight",linecolor="#30485d",linewidth=0.16) {#X018:2 (204.5,-106.7)};
// $JUNCTION @ATTACH (204.5,-106.7);
// &"A23" @WIRE(mode="straight",linecolor="#30485d",linewidth=0.16) {#X017:5 (204.5,-175)};
// $JUNCTION @ATTACH (204.5,-175);
// &"ACTIVE" @WIRE(mode="straight",linecolor="#30485d",linewidth=0.16) {(109.5,-105) (109.5,43.95)};
// &"ACTIVE" @WIRE(mode="straight",linecolor="#30485d",linewidth=0.16) {#XTIM:1 (109.5,43.95)};
// $JUNCTION @ATTACH (109.5,43.95);
// &"ACTIVE" @WIRE(mode="straight",linecolor="#30485d",linewidth=0.16) {#X018:5 (109.5,-105)};
// $JUNCTION @ATTACH (109.5,-105);
// &"DATA" @WIRE(mode="straight",linecolor="#30485d",linewidth=0.16) {(33,-240.05) (33,-205.05) (33,-170.05) (33,-135.05) (33,-100.05) (33,-65.05) (33,-30.05) (33,4.95) (33,40.65)};
// &"DATA" @WIRE(mode="straight",linecolor="#30485d",linewidth=0.16) {#XTIM:5 (33,40.65)};
// $JUNCTION @ATTACH (33,40.65);
// &"DATA" @WIRE(mode="straight",linecolor="#30485d",linewidth=0.16) {#XBIT7:3 (33,4.95)};
// $JUNCTION @ATTACH (33,4.95);
// &"DATA" @WIRE(mode="straight",linecolor="#30485d",linewidth=0.16) {#XBIT6:3 (33,-30.05)};
// $JUNCTION @ATTACH (33,-30.05);
// &"DATA" @WIRE(mode="straight",linecolor="#30485d",linewidth=0.16) {#XBIT5:3 (33,-65.05)};
// $JUNCTION @ATTACH (33,-65.05);
// &"DATA" @WIRE(mode="straight",linecolor="#30485d",linewidth=0.16) {#XBIT4:3 (33,-100.05)};
// $JUNCTION @ATTACH (33,-100.05);
// &"DATA" @WIRE(mode="straight",linecolor="#30485d",linewidth=0.16) {#XBIT3:3 (33,-135.05)};
// $JUNCTION @ATTACH (33,-135.05);
// &"DATA" @WIRE(mode="straight",linecolor="#30485d",linewidth=0.16) {#XBIT2:3 (33,-170.05)};
// $JUNCTION @ATTACH (33,-170.05);
// &"DATA" @WIRE(mode="straight",linecolor="#30485d",linewidth=0.16) {#XBIT1:3 (33,-205.05)};
// $JUNCTION @ATTACH (33,-205.05);
// &"DATA" @WIRE(mode="straight",linecolor="#30485d",linewidth=0.16) {#XBIT0:3 (33,-240.05)};
// $JUNCTION @ATTACH (33,-240.05);
// &"PHI_W" @WIRE(mode="straight",linecolor="#94601a",linewidth=0.16) {(38,-243.35) (38,-208.35) (38,-173.35) (38,-138.35) (38,-103.35) (38,-68.35) (38,-33.35) (38,1.65) (38,34.05)};
// &"PHI_W" @WIRE(mode="straight",linecolor="#94601a",linewidth=0.16) {#XTIM:7 (38,34.05)};
// $JUNCTION @ATTACH (38,34.05);
// &"PHI_W" @WIRE(mode="straight",linecolor="#94601a",linewidth=0.16) {#XBIT7:4 (38,1.65)};
// $JUNCTION @ATTACH (38,1.65);
// &"PHI_W" @WIRE(mode="straight",linecolor="#94601a",linewidth=0.16) {#XBIT6:4 (38,-33.35)};
// $JUNCTION @ATTACH (38,-33.35);
// &"PHI_W" @WIRE(mode="straight",linecolor="#94601a",linewidth=0.16) {#XBIT5:4 (38,-68.35)};
// $JUNCTION @ATTACH (38,-68.35);
// &"PHI_W" @WIRE(mode="straight",linecolor="#94601a",linewidth=0.16) {#XBIT4:4 (38,-103.35)};
// $JUNCTION @ATTACH (38,-103.35);
// &"PHI_W" @WIRE(mode="straight",linecolor="#94601a",linewidth=0.16) {#XBIT3:4 (38,-138.35)};
// $JUNCTION @ATTACH (38,-138.35);
// &"PHI_W" @WIRE(mode="straight",linecolor="#94601a",linewidth=0.16) {#XBIT2:4 (38,-173.35)};
// $JUNCTION @ATTACH (38,-173.35);
// &"PHI_W" @WIRE(mode="straight",linecolor="#94601a",linewidth=0.16) {#XBIT1:4 (38,-208.35)};
// $JUNCTION @ATTACH (38,-208.35);
// &"PHI_W" @WIRE(mode="straight",linecolor="#94601a",linewidth=0.16) {#XBIT0:4 (38,-243.35)};
// $JUNCTION @ATTACH (38,-243.35);
// (121,-246) @TEXT("OR reduction -> ACTIVE",size=1.15,halign="start",textcolor="#223d52");
// (-23,-274) @TEXT("T[7:0] selects one bit; CODE is the trial word and D the stored output. SAMPLE resets the controller.",size=0.95,halign="start",textcolor="#223d52");
// &"CMP_CLK" @WIRE(mode="straight",linecolor="#30485d",linewidth=0.16) {#XTIM:2 (16,43.95)};
// (16.4,43.95) @TEXT("CMP_CLK",size=1.1,halign="start",valign="middle");
// &"COMP_N" @WIRE(mode="straight",linecolor="#30485d",linewidth=0.16) {#XTIM:3 (-16,40.65)};
// (-16.4,40.65) @TEXT("COMP_N",size=1.1,halign="end",valign="middle");
// &"COMP_P" @WIRE(mode="straight",linecolor="#30485d",linewidth=0.16) {#XTIM:4 (-16,37.35)};
// (-16.4,37.35) @TEXT("COMP_P",size=1.1,halign="end",valign="middle");
// &"PHI_U" @WIRE(mode="straight",linecolor="#30485d",linewidth=0.16) {#XTIM:6 (16,37.35)};
// (16.4,37.35) @TEXT("PHI_U",size=1.1,halign="start",valign="middle");
// &"SAMPLE" @WIRE(mode="straight",linecolor="#30485d",linewidth=0.16) {#XTIM:8 (-16,34.05)};
// (-16.4,34.05) @TEXT("SAMPLE",size=1.1,halign="end",valign="middle");
// &"VDD" @WIRE(mode="straight",linecolor="#30485d",linewidth=0.16) {#XTIM:9 (0,52.25)};
// (0,52.65) @TEXT("VDD",size=1.1,halign="middle",valign="bottom");
// &"VSS" @WIRE(mode="straight",linecolor="#30485d",linewidth=0.16) {#XTIM:10 (0,25.75)};
// (0,25.35) @TEXT("VSS",size=1.1,halign="middle",valign="top");
// &"PHI_U" @WIRE(mode="straight",linecolor="#30485d",linewidth=0.16) {#XSEQ:1 (-16,-15.35)};
// (-16.4,-15.35) @TEXT("PHI_U",size=1.1,halign="end",valign="middle");
// &"SAMPLE" @WIRE(mode="straight",linecolor="#30485d",linewidth=0.16) {#XSEQ:2 (-16,-18.65)};
// (-16.4,-18.65) @TEXT("SAMPLE",size=1.1,halign="end",valign="middle");
// {&"T0" &"T1" &"T2" &"T3" &"T4" &"T5" &"T6" &"T7"} @WIRE(mode="straight",linewidth=0.3) {#XSEQ:3 (16,-17)};
// (16.4,-17) @TEXT("T[7:0]",size=1.1,halign="start",valign="middle");
// &"VDD" @WIRE(mode="straight",linecolor="#30485d",linewidth=0.16) {#XSEQ:11 (0,-6)};
// (0,-5.6) @TEXT("VDD",size=1.1,halign="middle",valign="bottom");
// &"VSS" @WIRE(mode="straight",linecolor="#30485d",linewidth=0.16) {#XSEQ:12 (0,-28)};
// (0,-28.4) @TEXT("VSS",size=1.1,halign="middle",valign="top");
// &"CODE7" @WIRE(mode="straight",linecolor="#30485d",linewidth=0.16) {#XBIT7:1 (89,1.65)};
// (89.4,1.65) @TEXT("CODE7",size=1.1,halign="start",valign="middle");
// &"D7" @WIRE(mode="straight",linecolor="#30485d",linewidth=0.16) {#XBIT7:2 (89,-1.65)};
// (89.4,-1.65) @TEXT("D7",size=1.1,halign="start",valign="middle");
// &"SAMPLE" @WIRE(mode="straight",linecolor="#30485d",linewidth=0.16) {#XBIT7:5 (57,-1.65)};
// (56.6,-1.65) @TEXT("SAMPLE",size=1.1,halign="end",valign="middle");
// &"T7" @WIRE(mode="straight",linecolor="#30485d",linewidth=0.16) {#XBIT7:6 (57,-4.95)};
// (56.6,-4.95) @TEXT("T7",size=1.1,halign="end",valign="middle");
// &"VDD" @WIRE(mode="straight",linecolor="#30485d",linewidth=0.16) {#XBIT7:7 (73,13.25)};
// (73,13.65) @TEXT("VDD",size=1.1,halign="middle",valign="bottom");
// &"VSS" @WIRE(mode="straight",linecolor="#30485d",linewidth=0.16) {#XBIT7:8 (73,-13.25)};
// (73,-13.65) @TEXT("VSS",size=1.1,halign="middle",valign="top");
// &"CODE6" @WIRE(mode="straight",linecolor="#30485d",linewidth=0.16) {#XBIT6:1 (89,-33.35)};
// (89.4,-33.35) @TEXT("CODE6",size=1.1,halign="start",valign="middle");
// &"D6" @WIRE(mode="straight",linecolor="#30485d",linewidth=0.16) {#XBIT6:2 (89,-36.65)};
// (89.4,-36.65) @TEXT("D6",size=1.1,halign="start",valign="middle");
// &"SAMPLE" @WIRE(mode="straight",linecolor="#30485d",linewidth=0.16) {#XBIT6:5 (57,-36.65)};
// (56.6,-36.65) @TEXT("SAMPLE",size=1.1,halign="end",valign="middle");
// &"T6" @WIRE(mode="straight",linecolor="#30485d",linewidth=0.16) {#XBIT6:6 (57,-39.95)};
// (56.6,-39.95) @TEXT("T6",size=1.1,halign="end",valign="middle");
// &"VDD" @WIRE(mode="straight",linecolor="#30485d",linewidth=0.16) {#XBIT6:7 (73,-21.75)};
// (73,-21.35) @TEXT("VDD",size=1.1,halign="middle",valign="bottom");
// &"VSS" @WIRE(mode="straight",linecolor="#30485d",linewidth=0.16) {#XBIT6:8 (73,-48.25)};
// (73,-48.65) @TEXT("VSS",size=1.1,halign="middle",valign="top");
// &"CODE5" @WIRE(mode="straight",linecolor="#30485d",linewidth=0.16) {#XBIT5:1 (89,-68.35)};
// (89.4,-68.35) @TEXT("CODE5",size=1.1,halign="start",valign="middle");
// &"D5" @WIRE(mode="straight",linecolor="#30485d",linewidth=0.16) {#XBIT5:2 (89,-71.65)};
// (89.4,-71.65) @TEXT("D5",size=1.1,halign="start",valign="middle");
// &"SAMPLE" @WIRE(mode="straight",linecolor="#30485d",linewidth=0.16) {#XBIT5:5 (57,-71.65)};
// (56.6,-71.65) @TEXT("SAMPLE",size=1.1,halign="end",valign="middle");
// &"T5" @WIRE(mode="straight",linecolor="#30485d",linewidth=0.16) {#XBIT5:6 (57,-74.95)};
// (56.6,-74.95) @TEXT("T5",size=1.1,halign="end",valign="middle");
// &"VDD" @WIRE(mode="straight",linecolor="#30485d",linewidth=0.16) {#XBIT5:7 (73,-56.75)};
// (73,-56.35) @TEXT("VDD",size=1.1,halign="middle",valign="bottom");
// &"VSS" @WIRE(mode="straight",linecolor="#30485d",linewidth=0.16) {#XBIT5:8 (73,-83.25)};
// (73,-83.65) @TEXT("VSS",size=1.1,halign="middle",valign="top");
// &"CODE4" @WIRE(mode="straight",linecolor="#30485d",linewidth=0.16) {#XBIT4:1 (89,-103.35)};
// (89.4,-103.35) @TEXT("CODE4",size=1.1,halign="start",valign="middle");
// &"D4" @WIRE(mode="straight",linecolor="#30485d",linewidth=0.16) {#XBIT4:2 (89,-106.65)};
// (89.4,-106.65) @TEXT("D4",size=1.1,halign="start",valign="middle");
// &"SAMPLE" @WIRE(mode="straight",linecolor="#30485d",linewidth=0.16) {#XBIT4:5 (57,-106.65)};
// (56.6,-106.65) @TEXT("SAMPLE",size=1.1,halign="end",valign="middle");
// &"T4" @WIRE(mode="straight",linecolor="#30485d",linewidth=0.16) {#XBIT4:6 (57,-109.95)};
// (56.6,-109.95) @TEXT("T4",size=1.1,halign="end",valign="middle");
// &"VDD" @WIRE(mode="straight",linecolor="#30485d",linewidth=0.16) {#XBIT4:7 (73,-91.75)};
// (73,-91.35) @TEXT("VDD",size=1.1,halign="middle",valign="bottom");
// &"VSS" @WIRE(mode="straight",linecolor="#30485d",linewidth=0.16) {#XBIT4:8 (73,-118.25)};
// (73,-118.65) @TEXT("VSS",size=1.1,halign="middle",valign="top");
// &"CODE3" @WIRE(mode="straight",linecolor="#30485d",linewidth=0.16) {#XBIT3:1 (89,-138.35)};
// (89.4,-138.35) @TEXT("CODE3",size=1.1,halign="start",valign="middle");
// &"D3" @WIRE(mode="straight",linecolor="#30485d",linewidth=0.16) {#XBIT3:2 (89,-141.65)};
// (89.4,-141.65) @TEXT("D3",size=1.1,halign="start",valign="middle");
// &"SAMPLE" @WIRE(mode="straight",linecolor="#30485d",linewidth=0.16) {#XBIT3:5 (57,-141.65)};
// (56.6,-141.65) @TEXT("SAMPLE",size=1.1,halign="end",valign="middle");
// &"T3" @WIRE(mode="straight",linecolor="#30485d",linewidth=0.16) {#XBIT3:6 (57,-144.95)};
// (56.6,-144.95) @TEXT("T3",size=1.1,halign="end",valign="middle");
// &"VDD" @WIRE(mode="straight",linecolor="#30485d",linewidth=0.16) {#XBIT3:7 (73,-126.75)};
// (73,-126.35) @TEXT("VDD",size=1.1,halign="middle",valign="bottom");
// &"VSS" @WIRE(mode="straight",linecolor="#30485d",linewidth=0.16) {#XBIT3:8 (73,-153.25)};
// (73,-153.65) @TEXT("VSS",size=1.1,halign="middle",valign="top");
// &"CODE2" @WIRE(mode="straight",linecolor="#30485d",linewidth=0.16) {#XBIT2:1 (89,-173.35)};
// (89.4,-173.35) @TEXT("CODE2",size=1.1,halign="start",valign="middle");
// &"D2" @WIRE(mode="straight",linecolor="#30485d",linewidth=0.16) {#XBIT2:2 (89,-176.65)};
// (89.4,-176.65) @TEXT("D2",size=1.1,halign="start",valign="middle");
// &"SAMPLE" @WIRE(mode="straight",linecolor="#30485d",linewidth=0.16) {#XBIT2:5 (57,-176.65)};
// (56.6,-176.65) @TEXT("SAMPLE",size=1.1,halign="end",valign="middle");
// &"T2" @WIRE(mode="straight",linecolor="#30485d",linewidth=0.16) {#XBIT2:6 (57,-179.95)};
// (56.6,-179.95) @TEXT("T2",size=1.1,halign="end",valign="middle");
// &"VDD" @WIRE(mode="straight",linecolor="#30485d",linewidth=0.16) {#XBIT2:7 (73,-161.75)};
// (73,-161.35) @TEXT("VDD",size=1.1,halign="middle",valign="bottom");
// &"VSS" @WIRE(mode="straight",linecolor="#30485d",linewidth=0.16) {#XBIT2:8 (73,-188.25)};
// (73,-188.65) @TEXT("VSS",size=1.1,halign="middle",valign="top");
// &"CODE1" @WIRE(mode="straight",linecolor="#30485d",linewidth=0.16) {#XBIT1:1 (89,-208.35)};
// (89.4,-208.35) @TEXT("CODE1",size=1.1,halign="start",valign="middle");
// &"D1" @WIRE(mode="straight",linecolor="#30485d",linewidth=0.16) {#XBIT1:2 (89,-211.65)};
// (89.4,-211.65) @TEXT("D1",size=1.1,halign="start",valign="middle");
// &"SAMPLE" @WIRE(mode="straight",linecolor="#30485d",linewidth=0.16) {#XBIT1:5 (57,-211.65)};
// (56.6,-211.65) @TEXT("SAMPLE",size=1.1,halign="end",valign="middle");
// &"T1" @WIRE(mode="straight",linecolor="#30485d",linewidth=0.16) {#XBIT1:6 (57,-214.95)};
// (56.6,-214.95) @TEXT("T1",size=1.1,halign="end",valign="middle");
// &"VDD" @WIRE(mode="straight",linecolor="#30485d",linewidth=0.16) {#XBIT1:7 (73,-196.75)};
// (73,-196.35) @TEXT("VDD",size=1.1,halign="middle",valign="bottom");
// &"VSS" @WIRE(mode="straight",linecolor="#30485d",linewidth=0.16) {#XBIT1:8 (73,-223.25)};
// (73,-223.65) @TEXT("VSS",size=1.1,halign="middle",valign="top");
// &"CODE0" @WIRE(mode="straight",linecolor="#30485d",linewidth=0.16) {#XBIT0:1 (89,-243.35)};
// (89.4,-243.35) @TEXT("CODE0",size=1.1,halign="start",valign="middle");
// &"D0" @WIRE(mode="straight",linecolor="#30485d",linewidth=0.16) {#XBIT0:2 (89,-246.65)};
// (89.4,-246.65) @TEXT("D0",size=1.1,halign="start",valign="middle");
// &"SAMPLE" @WIRE(mode="straight",linecolor="#30485d",linewidth=0.16) {#XBIT0:5 (57,-246.65)};
// (56.6,-246.65) @TEXT("SAMPLE",size=1.1,halign="end",valign="middle");
// &"T0" @WIRE(mode="straight",linecolor="#30485d",linewidth=0.16) {#XBIT0:6 (57,-249.95)};
// (56.6,-249.95) @TEXT("T0",size=1.1,halign="end",valign="middle");
// &"VDD" @WIRE(mode="straight",linecolor="#30485d",linewidth=0.16) {#XBIT0:7 (73,-231.75)};
// (73,-231.35) @TEXT("VDD",size=1.1,halign="middle",valign="bottom");
// &"VSS" @WIRE(mode="straight",linecolor="#30485d",linewidth=0.16) {#XBIT0:8 (73,-258.25)};
// (73,-258.65) @TEXT("VSS",size=1.1,halign="middle",valign="top");
// &"VDD" @WIRE(mode="straight",linecolor="#30485d",linewidth=0.16) {#X018:3 (225,-95)};
// (225,-94.6) @TEXT("VDD",size=1.1,halign="middle",valign="bottom");
// &"VSS" @WIRE(mode="straight",linecolor="#30485d",linewidth=0.16) {#X018:4 (225,-115)};
// (225,-115.4) @TEXT("VSS",size=1.1,halign="middle",valign="top");
// &"VDD" @WIRE(mode="straight",linecolor="#30485d",linewidth=0.16) {#X017:3 (184,-165)};
// (184,-164.6) @TEXT("VDD",size=1.1,halign="middle",valign="bottom");
// &"VSS" @WIRE(mode="straight",linecolor="#30485d",linewidth=0.16) {#X017:4 (184,-185)};
// (184,-185.4) @TEXT("VSS",size=1.1,halign="middle",valign="top");
// &"VDD" @WIRE(mode="straight",linecolor="#30485d",linewidth=0.16) {#X016:3 (184,-25)};
// (184,-24.6) @TEXT("VDD",size=1.1,halign="middle",valign="bottom");
// &"VSS" @WIRE(mode="straight",linecolor="#30485d",linewidth=0.16) {#X016:4 (184,-45)};
// (184,-45.4) @TEXT("VSS",size=1.1,halign="middle",valign="top");
// &"T6" @WIRE(mode="straight",linecolor="#30485d",linewidth=0.16) {#X015:1 (132,-208.3)};
// (131.6,-208.3) @TEXT("T6",size=1.1,halign="end",valign="middle");
// &"T7" @WIRE(mode="straight",linecolor="#30485d",linewidth=0.16) {#X015:2 (132,-211.7)};
// (131.6,-211.7) @TEXT("T7",size=1.1,halign="end",valign="middle");
// &"VDD" @WIRE(mode="straight",linecolor="#30485d",linewidth=0.16) {#X015:3 (142,-200)};
// (142,-199.6) @TEXT("VDD",size=1.1,halign="middle",valign="bottom");
// &"VSS" @WIRE(mode="straight",linecolor="#30485d",linewidth=0.16) {#X015:4 (142,-220)};
// (142,-220.4) @TEXT("VSS",size=1.1,halign="middle",valign="top");
// &"T4" @WIRE(mode="straight",linecolor="#30485d",linewidth=0.16) {#X014:1 (132,-138.3)};
// (131.6,-138.3) @TEXT("T4",size=1.1,halign="end",valign="middle");
// &"T5" @WIRE(mode="straight",linecolor="#30485d",linewidth=0.16) {#X014:2 (132,-141.7)};
// (131.6,-141.7) @TEXT("T5",size=1.1,halign="end",valign="middle");
// &"VDD" @WIRE(mode="straight",linecolor="#30485d",linewidth=0.16) {#X014:3 (142,-130)};
// (142,-129.6) @TEXT("VDD",size=1.1,halign="middle",valign="bottom");
// &"VSS" @WIRE(mode="straight",linecolor="#30485d",linewidth=0.16) {#X014:4 (142,-150)};
// (142,-150.4) @TEXT("VSS",size=1.1,halign="middle",valign="top");
// &"T2" @WIRE(mode="straight",linecolor="#30485d",linewidth=0.16) {#X013:1 (132,-68.3)};
// (131.6,-68.3) @TEXT("T2",size=1.1,halign="end",valign="middle");
// &"T3" @WIRE(mode="straight",linecolor="#30485d",linewidth=0.16) {#X013:2 (132,-71.7)};
// (131.6,-71.7) @TEXT("T3",size=1.1,halign="end",valign="middle");
// &"VDD" @WIRE(mode="straight",linecolor="#30485d",linewidth=0.16) {#X013:3 (142,-60)};
// (142,-59.6) @TEXT("VDD",size=1.1,halign="middle",valign="bottom");
// &"VSS" @WIRE(mode="straight",linecolor="#30485d",linewidth=0.16) {#X013:4 (142,-80)};
// (142,-80.4) @TEXT("VSS",size=1.1,halign="middle",valign="top");
// &"T0" @WIRE(mode="straight",linecolor="#30485d",linewidth=0.16) {#X012:1 (132,1.7)};
// (131.6,1.7) @TEXT("T0",size=1.1,halign="end",valign="middle");
// &"T1" @WIRE(mode="straight",linecolor="#30485d",linewidth=0.16) {#X012:2 (132,-1.7)};
// (131.6,-1.7) @TEXT("T1",size=1.1,halign="end",valign="middle");
// &"VDD" @WIRE(mode="straight",linecolor="#30485d",linewidth=0.16) {#X012:3 (142,10)};
// (142,10.4) @TEXT("VDD",size=1.1,halign="middle",valign="bottom");
// &"VSS" @WIRE(mode="straight",linecolor="#30485d",linewidth=0.16) {#X012:4 (142,-10)};
// (142,-10.4) @TEXT("VSS",size=1.1,halign="middle",valign="top");
// }
// END SARADC RNL
ends sar8i_ctrl

subckt tb_cdac
// Isolated CDAC: precharge top plates, release, then single-bit steps and full-scale reversal.
VDPRE (d_pre 0) vsource type=pwl wave=[0 0.9 40n 0.9 40.1n 0]
VDCM (d_cm 0) vsource dc=0.45
XDPN (d_n d_cm d_pre VDD! 0) b_tb_switch
XDPP (d_p d_cm d_pre VDD! 0) b_tb_switch
VDgnn0 (d_gnn0 0) vsource type=pwl wave=[0 0.90000000000000002 5.9900000000000014e-08 0.90000000000000002 6.0000000000000008e-08 0 7.9900000000000007e-08 0 8.0000000000000002e-08 0.90000000000000002 9.9900000000000014e-08 0.90000000000000002 1.0000000000000001e-07 0.90000000000000002 1.1990000000000001e-07 0.90000000000000002 1.2000000000000002e-07 0.90000000000000002 1.399e-07 0.90000000000000002 1.4000000000000001e-07 0.90000000000000002 1.599e-07 0.90000000000000002 1.6e-07 0.90000000000000002 1.7990000000000002e-07 0.90000000000000002 1.8000000000000002e-07 0.90000000000000002 1.9990000000000001e-07 0.90000000000000002 2.0000000000000002e-07 0.90000000000000002 2.199e-07 0.90000000000000002 2.2000000000000001e-07 0 2.3990000000000002e-07 0 2.4000000000000003e-07 0.90000000000000002]
VDgnn1 (d_gnn1 0) vsource type=pwl wave=[0 0.90000000000000002 5.9900000000000014e-08 0.90000000000000002 6.0000000000000008e-08 0.90000000000000002 7.9900000000000007e-08 0.90000000000000002 8.0000000000000002e-08 0 9.9900000000000014e-08 0 1.0000000000000001e-07 0.90000000000000002 1.1990000000000001e-07 0.90000000000000002 1.2000000000000002e-07 0.90000000000000002 1.399e-07 0.90000000000000002 1.4000000000000001e-07 0.90000000000000002 1.599e-07 0.90000000000000002 1.6e-07 0.90000000000000002 1.7990000000000002e-07 0.90000000000000002 1.8000000000000002e-07 0.90000000000000002 1.9990000000000001e-07 0.90000000000000002 2.0000000000000002e-07 0.90000000000000002 2.199e-07 0.90000000000000002 2.2000000000000001e-07 0 2.3990000000000002e-07 0 2.4000000000000003e-07 0.90000000000000002]
VDgnn2 (d_gnn2 0) vsource type=pwl wave=[0 0.90000000000000002 5.9900000000000014e-08 0.90000000000000002 6.0000000000000008e-08 0.90000000000000002 7.9900000000000007e-08 0.90000000000000002 8.0000000000000002e-08 0.90000000000000002 9.9900000000000014e-08 0.90000000000000002 1.0000000000000001e-07 0 1.1990000000000001e-07 0 1.2000000000000002e-07 0.90000000000000002 1.399e-07 0.90000000000000002 1.4000000000000001e-07 0.90000000000000002 1.599e-07 0.90000000000000002 1.6e-07 0.90000000000000002 1.7990000000000002e-07 0.90000000000000002 1.8000000000000002e-07 0.90000000000000002 1.9990000000000001e-07 0.90000000000000002 2.0000000000000002e-07 0.90000000000000002 2.199e-07 0.90000000000000002 2.2000000000000001e-07 0 2.3990000000000002e-07 0 2.4000000000000003e-07 0.90000000000000002]
VDgnn3 (d_gnn3 0) vsource type=pwl wave=[0 0.90000000000000002 5.9900000000000014e-08 0.90000000000000002 6.0000000000000008e-08 0.90000000000000002 7.9900000000000007e-08 0.90000000000000002 8.0000000000000002e-08 0.90000000000000002 9.9900000000000014e-08 0.90000000000000002 1.0000000000000001e-07 0.90000000000000002 1.1990000000000001e-07 0.90000000000000002 1.2000000000000002e-07 0 1.399e-07 0 1.4000000000000001e-07 0.90000000000000002 1.599e-07 0.90000000000000002 1.6e-07 0.90000000000000002 1.7990000000000002e-07 0.90000000000000002 1.8000000000000002e-07 0.90000000000000002 1.9990000000000001e-07 0.90000000000000002 2.0000000000000002e-07 0.90000000000000002 2.199e-07 0.90000000000000002 2.2000000000000001e-07 0 2.3990000000000002e-07 0 2.4000000000000003e-07 0.90000000000000002]
VDgnn4 (d_gnn4 0) vsource type=pwl wave=[0 0.90000000000000002 5.9900000000000014e-08 0.90000000000000002 6.0000000000000008e-08 0.90000000000000002 7.9900000000000007e-08 0.90000000000000002 8.0000000000000002e-08 0.90000000000000002 9.9900000000000014e-08 0.90000000000000002 1.0000000000000001e-07 0.90000000000000002 1.1990000000000001e-07 0.90000000000000002 1.2000000000000002e-07 0.90000000000000002 1.399e-07 0.90000000000000002 1.4000000000000001e-07 0 1.599e-07 0 1.6e-07 0.90000000000000002 1.7990000000000002e-07 0.90000000000000002 1.8000000000000002e-07 0.90000000000000002 1.9990000000000001e-07 0.90000000000000002 2.0000000000000002e-07 0.90000000000000002 2.199e-07 0.90000000000000002 2.2000000000000001e-07 0 2.3990000000000002e-07 0 2.4000000000000003e-07 0.90000000000000002]
VDgnn5 (d_gnn5 0) vsource type=pwl wave=[0 0.90000000000000002 5.9900000000000014e-08 0.90000000000000002 6.0000000000000008e-08 0.90000000000000002 7.9900000000000007e-08 0.90000000000000002 8.0000000000000002e-08 0.90000000000000002 9.9900000000000014e-08 0.90000000000000002 1.0000000000000001e-07 0.90000000000000002 1.1990000000000001e-07 0.90000000000000002 1.2000000000000002e-07 0.90000000000000002 1.399e-07 0.90000000000000002 1.4000000000000001e-07 0.90000000000000002 1.599e-07 0.90000000000000002 1.6e-07 0 1.7990000000000002e-07 0 1.8000000000000002e-07 0.90000000000000002 1.9990000000000001e-07 0.90000000000000002 2.0000000000000002e-07 0.90000000000000002 2.199e-07 0.90000000000000002 2.2000000000000001e-07 0 2.3990000000000002e-07 0 2.4000000000000003e-07 0.90000000000000002]
VDgnn6 (d_gnn6 0) vsource type=pwl wave=[0 0.90000000000000002 5.9900000000000014e-08 0.90000000000000002 6.0000000000000008e-08 0.90000000000000002 7.9900000000000007e-08 0.90000000000000002 8.0000000000000002e-08 0.90000000000000002 9.9900000000000014e-08 0.90000000000000002 1.0000000000000001e-07 0.90000000000000002 1.1990000000000001e-07 0.90000000000000002 1.2000000000000002e-07 0.90000000000000002 1.399e-07 0.90000000000000002 1.4000000000000001e-07 0.90000000000000002 1.599e-07 0.90000000000000002 1.6e-07 0.90000000000000002 1.7990000000000002e-07 0.90000000000000002 1.8000000000000002e-07 0 1.9990000000000001e-07 0 2.0000000000000002e-07 0.90000000000000002 2.199e-07 0.90000000000000002 2.2000000000000001e-07 0 2.3990000000000002e-07 0 2.4000000000000003e-07 0.90000000000000002]
VDgnn7 (d_gnn7 0) vsource type=pwl wave=[0 0.90000000000000002 5.9900000000000014e-08 0.90000000000000002 6.0000000000000008e-08 0.90000000000000002 7.9900000000000007e-08 0.90000000000000002 8.0000000000000002e-08 0.90000000000000002 9.9900000000000014e-08 0.90000000000000002 1.0000000000000001e-07 0.90000000000000002 1.1990000000000001e-07 0.90000000000000002 1.2000000000000002e-07 0.90000000000000002 1.399e-07 0.90000000000000002 1.4000000000000001e-07 0.90000000000000002 1.599e-07 0.90000000000000002 1.6e-07 0.90000000000000002 1.7990000000000002e-07 0.90000000000000002 1.8000000000000002e-07 0.90000000000000002 1.9990000000000001e-07 0.90000000000000002 2.0000000000000002e-07 0 2.199e-07 0 2.2000000000000001e-07 0 2.3990000000000002e-07 0 2.4000000000000003e-07 0.90000000000000002]
VDgnp0 (d_gnp0 0) vsource type=pwl wave=[0 0.90000000000000002 5.9900000000000014e-08 0.90000000000000002 6.0000000000000008e-08 0 7.9900000000000007e-08 0 8.0000000000000002e-08 0.90000000000000002 9.9900000000000014e-08 0.90000000000000002 1.0000000000000001e-07 0.90000000000000002 1.1990000000000001e-07 0.90000000000000002 1.2000000000000002e-07 0.90000000000000002 1.399e-07 0.90000000000000002 1.4000000000000001e-07 0.90000000000000002 1.599e-07 0.90000000000000002 1.6e-07 0.90000000000000002 1.7990000000000002e-07 0.90000000000000002 1.8000000000000002e-07 0.90000000000000002 1.9990000000000001e-07 0.90000000000000002 2.0000000000000002e-07 0.90000000000000002 2.199e-07 0.90000000000000002 2.2000000000000001e-07 0 2.3990000000000002e-07 0 2.4000000000000003e-07 0.90000000000000002]
VDgnp1 (d_gnp1 0) vsource type=pwl wave=[0 0.90000000000000002 5.9900000000000014e-08 0.90000000000000002 6.0000000000000008e-08 0.90000000000000002 7.9900000000000007e-08 0.90000000000000002 8.0000000000000002e-08 0 9.9900000000000014e-08 0 1.0000000000000001e-07 0.90000000000000002 1.1990000000000001e-07 0.90000000000000002 1.2000000000000002e-07 0.90000000000000002 1.399e-07 0.90000000000000002 1.4000000000000001e-07 0.90000000000000002 1.599e-07 0.90000000000000002 1.6e-07 0.90000000000000002 1.7990000000000002e-07 0.90000000000000002 1.8000000000000002e-07 0.90000000000000002 1.9990000000000001e-07 0.90000000000000002 2.0000000000000002e-07 0.90000000000000002 2.199e-07 0.90000000000000002 2.2000000000000001e-07 0 2.3990000000000002e-07 0 2.4000000000000003e-07 0.90000000000000002]
VDgnp2 (d_gnp2 0) vsource type=pwl wave=[0 0.90000000000000002 5.9900000000000014e-08 0.90000000000000002 6.0000000000000008e-08 0.90000000000000002 7.9900000000000007e-08 0.90000000000000002 8.0000000000000002e-08 0.90000000000000002 9.9900000000000014e-08 0.90000000000000002 1.0000000000000001e-07 0 1.1990000000000001e-07 0 1.2000000000000002e-07 0.90000000000000002 1.399e-07 0.90000000000000002 1.4000000000000001e-07 0.90000000000000002 1.599e-07 0.90000000000000002 1.6e-07 0.90000000000000002 1.7990000000000002e-07 0.90000000000000002 1.8000000000000002e-07 0.90000000000000002 1.9990000000000001e-07 0.90000000000000002 2.0000000000000002e-07 0.90000000000000002 2.199e-07 0.90000000000000002 2.2000000000000001e-07 0 2.3990000000000002e-07 0 2.4000000000000003e-07 0.90000000000000002]
VDgnp3 (d_gnp3 0) vsource type=pwl wave=[0 0.90000000000000002 5.9900000000000014e-08 0.90000000000000002 6.0000000000000008e-08 0.90000000000000002 7.9900000000000007e-08 0.90000000000000002 8.0000000000000002e-08 0.90000000000000002 9.9900000000000014e-08 0.90000000000000002 1.0000000000000001e-07 0.90000000000000002 1.1990000000000001e-07 0.90000000000000002 1.2000000000000002e-07 0 1.399e-07 0 1.4000000000000001e-07 0.90000000000000002 1.599e-07 0.90000000000000002 1.6e-07 0.90000000000000002 1.7990000000000002e-07 0.90000000000000002 1.8000000000000002e-07 0.90000000000000002 1.9990000000000001e-07 0.90000000000000002 2.0000000000000002e-07 0.90000000000000002 2.199e-07 0.90000000000000002 2.2000000000000001e-07 0 2.3990000000000002e-07 0 2.4000000000000003e-07 0.90000000000000002]
VDgnp4 (d_gnp4 0) vsource type=pwl wave=[0 0.90000000000000002 5.9900000000000014e-08 0.90000000000000002 6.0000000000000008e-08 0.90000000000000002 7.9900000000000007e-08 0.90000000000000002 8.0000000000000002e-08 0.90000000000000002 9.9900000000000014e-08 0.90000000000000002 1.0000000000000001e-07 0.90000000000000002 1.1990000000000001e-07 0.90000000000000002 1.2000000000000002e-07 0.90000000000000002 1.399e-07 0.90000000000000002 1.4000000000000001e-07 0 1.599e-07 0 1.6e-07 0.90000000000000002 1.7990000000000002e-07 0.90000000000000002 1.8000000000000002e-07 0.90000000000000002 1.9990000000000001e-07 0.90000000000000002 2.0000000000000002e-07 0.90000000000000002 2.199e-07 0.90000000000000002 2.2000000000000001e-07 0 2.3990000000000002e-07 0 2.4000000000000003e-07 0.90000000000000002]
VDgnp5 (d_gnp5 0) vsource type=pwl wave=[0 0.90000000000000002 5.9900000000000014e-08 0.90000000000000002 6.0000000000000008e-08 0.90000000000000002 7.9900000000000007e-08 0.90000000000000002 8.0000000000000002e-08 0.90000000000000002 9.9900000000000014e-08 0.90000000000000002 1.0000000000000001e-07 0.90000000000000002 1.1990000000000001e-07 0.90000000000000002 1.2000000000000002e-07 0.90000000000000002 1.399e-07 0.90000000000000002 1.4000000000000001e-07 0.90000000000000002 1.599e-07 0.90000000000000002 1.6e-07 0 1.7990000000000002e-07 0 1.8000000000000002e-07 0.90000000000000002 1.9990000000000001e-07 0.90000000000000002 2.0000000000000002e-07 0.90000000000000002 2.199e-07 0.90000000000000002 2.2000000000000001e-07 0 2.3990000000000002e-07 0 2.4000000000000003e-07 0.90000000000000002]
VDgnp6 (d_gnp6 0) vsource type=pwl wave=[0 0.90000000000000002 5.9900000000000014e-08 0.90000000000000002 6.0000000000000008e-08 0.90000000000000002 7.9900000000000007e-08 0.90000000000000002 8.0000000000000002e-08 0.90000000000000002 9.9900000000000014e-08 0.90000000000000002 1.0000000000000001e-07 0.90000000000000002 1.1990000000000001e-07 0.90000000000000002 1.2000000000000002e-07 0.90000000000000002 1.399e-07 0.90000000000000002 1.4000000000000001e-07 0.90000000000000002 1.599e-07 0.90000000000000002 1.6e-07 0.90000000000000002 1.7990000000000002e-07 0.90000000000000002 1.8000000000000002e-07 0 1.9990000000000001e-07 0 2.0000000000000002e-07 0.90000000000000002 2.199e-07 0.90000000000000002 2.2000000000000001e-07 0 2.3990000000000002e-07 0 2.4000000000000003e-07 0.90000000000000002]
VDgnp7 (d_gnp7 0) vsource type=pwl wave=[0 0.90000000000000002 5.9900000000000014e-08 0.90000000000000002 6.0000000000000008e-08 0.90000000000000002 7.9900000000000007e-08 0.90000000000000002 8.0000000000000002e-08 0.90000000000000002 9.9900000000000014e-08 0.90000000000000002 1.0000000000000001e-07 0.90000000000000002 1.1990000000000001e-07 0.90000000000000002 1.2000000000000002e-07 0.90000000000000002 1.399e-07 0.90000000000000002 1.4000000000000001e-07 0.90000000000000002 1.599e-07 0.90000000000000002 1.6e-07 0.90000000000000002 1.7990000000000002e-07 0.90000000000000002 1.8000000000000002e-07 0.90000000000000002 1.9990000000000001e-07 0.90000000000000002 2.0000000000000002e-07 0 2.199e-07 0 2.2000000000000001e-07 0 2.3990000000000002e-07 0 2.4000000000000003e-07 0.90000000000000002]
VDgpn0 (d_gpn0 0) vsource type=pwl wave=[0 0 5.9900000000000014e-08 0 6.0000000000000008e-08 0.90000000000000002 7.9900000000000007e-08 0.90000000000000002 8.0000000000000002e-08 0 9.9900000000000014e-08 0 1.0000000000000001e-07 0 1.1990000000000001e-07 0 1.2000000000000002e-07 0 1.399e-07 0 1.4000000000000001e-07 0 1.599e-07 0 1.6e-07 0 1.7990000000000002e-07 0 1.8000000000000002e-07 0 1.9990000000000001e-07 0 2.0000000000000002e-07 0 2.199e-07 0 2.2000000000000001e-07 0.90000000000000002 2.3990000000000002e-07 0.90000000000000002 2.4000000000000003e-07 0]
VDgpn1 (d_gpn1 0) vsource type=pwl wave=[0 0 5.9900000000000014e-08 0 6.0000000000000008e-08 0 7.9900000000000007e-08 0 8.0000000000000002e-08 0.90000000000000002 9.9900000000000014e-08 0.90000000000000002 1.0000000000000001e-07 0 1.1990000000000001e-07 0 1.2000000000000002e-07 0 1.399e-07 0 1.4000000000000001e-07 0 1.599e-07 0 1.6e-07 0 1.7990000000000002e-07 0 1.8000000000000002e-07 0 1.9990000000000001e-07 0 2.0000000000000002e-07 0 2.199e-07 0 2.2000000000000001e-07 0.90000000000000002 2.3990000000000002e-07 0.90000000000000002 2.4000000000000003e-07 0]
VDgpn2 (d_gpn2 0) vsource type=pwl wave=[0 0 5.9900000000000014e-08 0 6.0000000000000008e-08 0 7.9900000000000007e-08 0 8.0000000000000002e-08 0 9.9900000000000014e-08 0 1.0000000000000001e-07 0.90000000000000002 1.1990000000000001e-07 0.90000000000000002 1.2000000000000002e-07 0 1.399e-07 0 1.4000000000000001e-07 0 1.599e-07 0 1.6e-07 0 1.7990000000000002e-07 0 1.8000000000000002e-07 0 1.9990000000000001e-07 0 2.0000000000000002e-07 0 2.199e-07 0 2.2000000000000001e-07 0.90000000000000002 2.3990000000000002e-07 0.90000000000000002 2.4000000000000003e-07 0]
VDgpn3 (d_gpn3 0) vsource type=pwl wave=[0 0 5.9900000000000014e-08 0 6.0000000000000008e-08 0 7.9900000000000007e-08 0 8.0000000000000002e-08 0 9.9900000000000014e-08 0 1.0000000000000001e-07 0 1.1990000000000001e-07 0 1.2000000000000002e-07 0.90000000000000002 1.399e-07 0.90000000000000002 1.4000000000000001e-07 0 1.599e-07 0 1.6e-07 0 1.7990000000000002e-07 0 1.8000000000000002e-07 0 1.9990000000000001e-07 0 2.0000000000000002e-07 0 2.199e-07 0 2.2000000000000001e-07 0.90000000000000002 2.3990000000000002e-07 0.90000000000000002 2.4000000000000003e-07 0]
VDgpn4 (d_gpn4 0) vsource type=pwl wave=[0 0 5.9900000000000014e-08 0 6.0000000000000008e-08 0 7.9900000000000007e-08 0 8.0000000000000002e-08 0 9.9900000000000014e-08 0 1.0000000000000001e-07 0 1.1990000000000001e-07 0 1.2000000000000002e-07 0 1.399e-07 0 1.4000000000000001e-07 0.90000000000000002 1.599e-07 0.90000000000000002 1.6e-07 0 1.7990000000000002e-07 0 1.8000000000000002e-07 0 1.9990000000000001e-07 0 2.0000000000000002e-07 0 2.199e-07 0 2.2000000000000001e-07 0.90000000000000002 2.3990000000000002e-07 0.90000000000000002 2.4000000000000003e-07 0]
VDgpn5 (d_gpn5 0) vsource type=pwl wave=[0 0 5.9900000000000014e-08 0 6.0000000000000008e-08 0 7.9900000000000007e-08 0 8.0000000000000002e-08 0 9.9900000000000014e-08 0 1.0000000000000001e-07 0 1.1990000000000001e-07 0 1.2000000000000002e-07 0 1.399e-07 0 1.4000000000000001e-07 0 1.599e-07 0 1.6e-07 0.90000000000000002 1.7990000000000002e-07 0.90000000000000002 1.8000000000000002e-07 0 1.9990000000000001e-07 0 2.0000000000000002e-07 0 2.199e-07 0 2.2000000000000001e-07 0.90000000000000002 2.3990000000000002e-07 0.90000000000000002 2.4000000000000003e-07 0]
VDgpn6 (d_gpn6 0) vsource type=pwl wave=[0 0 5.9900000000000014e-08 0 6.0000000000000008e-08 0 7.9900000000000007e-08 0 8.0000000000000002e-08 0 9.9900000000000014e-08 0 1.0000000000000001e-07 0 1.1990000000000001e-07 0 1.2000000000000002e-07 0 1.399e-07 0 1.4000000000000001e-07 0 1.599e-07 0 1.6e-07 0 1.7990000000000002e-07 0 1.8000000000000002e-07 0.90000000000000002 1.9990000000000001e-07 0.90000000000000002 2.0000000000000002e-07 0 2.199e-07 0 2.2000000000000001e-07 0.90000000000000002 2.3990000000000002e-07 0.90000000000000002 2.4000000000000003e-07 0]
VDgpn7 (d_gpn7 0) vsource type=pwl wave=[0 0 5.9900000000000014e-08 0 6.0000000000000008e-08 0 7.9900000000000007e-08 0 8.0000000000000002e-08 0 9.9900000000000014e-08 0 1.0000000000000001e-07 0 1.1990000000000001e-07 0 1.2000000000000002e-07 0 1.399e-07 0 1.4000000000000001e-07 0 1.599e-07 0 1.6e-07 0 1.7990000000000002e-07 0 1.8000000000000002e-07 0 1.9990000000000001e-07 0 2.0000000000000002e-07 0.90000000000000002 2.199e-07 0.90000000000000002 2.2000000000000001e-07 0.90000000000000002 2.3990000000000002e-07 0.90000000000000002 2.4000000000000003e-07 0]
VDgpp0 (d_gpp0 0) vsource type=pwl wave=[0 0 5.9900000000000014e-08 0 6.0000000000000008e-08 0.90000000000000002 7.9900000000000007e-08 0.90000000000000002 8.0000000000000002e-08 0 9.9900000000000014e-08 0 1.0000000000000001e-07 0 1.1990000000000001e-07 0 1.2000000000000002e-07 0 1.399e-07 0 1.4000000000000001e-07 0 1.599e-07 0 1.6e-07 0 1.7990000000000002e-07 0 1.8000000000000002e-07 0 1.9990000000000001e-07 0 2.0000000000000002e-07 0 2.199e-07 0 2.2000000000000001e-07 0.90000000000000002 2.3990000000000002e-07 0.90000000000000002 2.4000000000000003e-07 0]
VDgpp1 (d_gpp1 0) vsource type=pwl wave=[0 0 5.9900000000000014e-08 0 6.0000000000000008e-08 0 7.9900000000000007e-08 0 8.0000000000000002e-08 0.90000000000000002 9.9900000000000014e-08 0.90000000000000002 1.0000000000000001e-07 0 1.1990000000000001e-07 0 1.2000000000000002e-07 0 1.399e-07 0 1.4000000000000001e-07 0 1.599e-07 0 1.6e-07 0 1.7990000000000002e-07 0 1.8000000000000002e-07 0 1.9990000000000001e-07 0 2.0000000000000002e-07 0 2.199e-07 0 2.2000000000000001e-07 0.90000000000000002 2.3990000000000002e-07 0.90000000000000002 2.4000000000000003e-07 0]
VDgpp2 (d_gpp2 0) vsource type=pwl wave=[0 0 5.9900000000000014e-08 0 6.0000000000000008e-08 0 7.9900000000000007e-08 0 8.0000000000000002e-08 0 9.9900000000000014e-08 0 1.0000000000000001e-07 0.90000000000000002 1.1990000000000001e-07 0.90000000000000002 1.2000000000000002e-07 0 1.399e-07 0 1.4000000000000001e-07 0 1.599e-07 0 1.6e-07 0 1.7990000000000002e-07 0 1.8000000000000002e-07 0 1.9990000000000001e-07 0 2.0000000000000002e-07 0 2.199e-07 0 2.2000000000000001e-07 0.90000000000000002 2.3990000000000002e-07 0.90000000000000002 2.4000000000000003e-07 0]
VDgpp3 (d_gpp3 0) vsource type=pwl wave=[0 0 5.9900000000000014e-08 0 6.0000000000000008e-08 0 7.9900000000000007e-08 0 8.0000000000000002e-08 0 9.9900000000000014e-08 0 1.0000000000000001e-07 0 1.1990000000000001e-07 0 1.2000000000000002e-07 0.90000000000000002 1.399e-07 0.90000000000000002 1.4000000000000001e-07 0 1.599e-07 0 1.6e-07 0 1.7990000000000002e-07 0 1.8000000000000002e-07 0 1.9990000000000001e-07 0 2.0000000000000002e-07 0 2.199e-07 0 2.2000000000000001e-07 0.90000000000000002 2.3990000000000002e-07 0.90000000000000002 2.4000000000000003e-07 0]
VDgpp4 (d_gpp4 0) vsource type=pwl wave=[0 0 5.9900000000000014e-08 0 6.0000000000000008e-08 0 7.9900000000000007e-08 0 8.0000000000000002e-08 0 9.9900000000000014e-08 0 1.0000000000000001e-07 0 1.1990000000000001e-07 0 1.2000000000000002e-07 0 1.399e-07 0 1.4000000000000001e-07 0.90000000000000002 1.599e-07 0.90000000000000002 1.6e-07 0 1.7990000000000002e-07 0 1.8000000000000002e-07 0 1.9990000000000001e-07 0 2.0000000000000002e-07 0 2.199e-07 0 2.2000000000000001e-07 0.90000000000000002 2.3990000000000002e-07 0.90000000000000002 2.4000000000000003e-07 0]
VDgpp5 (d_gpp5 0) vsource type=pwl wave=[0 0 5.9900000000000014e-08 0 6.0000000000000008e-08 0 7.9900000000000007e-08 0 8.0000000000000002e-08 0 9.9900000000000014e-08 0 1.0000000000000001e-07 0 1.1990000000000001e-07 0 1.2000000000000002e-07 0 1.399e-07 0 1.4000000000000001e-07 0 1.599e-07 0 1.6e-07 0.90000000000000002 1.7990000000000002e-07 0.90000000000000002 1.8000000000000002e-07 0 1.9990000000000001e-07 0 2.0000000000000002e-07 0 2.199e-07 0 2.2000000000000001e-07 0.90000000000000002 2.3990000000000002e-07 0.90000000000000002 2.4000000000000003e-07 0]
VDgpp6 (d_gpp6 0) vsource type=pwl wave=[0 0 5.9900000000000014e-08 0 6.0000000000000008e-08 0 7.9900000000000007e-08 0 8.0000000000000002e-08 0 9.9900000000000014e-08 0 1.0000000000000001e-07 0 1.1990000000000001e-07 0 1.2000000000000002e-07 0 1.399e-07 0 1.4000000000000001e-07 0 1.599e-07 0 1.6e-07 0 1.7990000000000002e-07 0 1.8000000000000002e-07 0.90000000000000002 1.9990000000000001e-07 0.90000000000000002 2.0000000000000002e-07 0 2.199e-07 0 2.2000000000000001e-07 0.90000000000000002 2.3990000000000002e-07 0.90000000000000002 2.4000000000000003e-07 0]
VDgpp7 (d_gpp7 0) vsource type=pwl wave=[0 0 5.9900000000000014e-08 0 6.0000000000000008e-08 0 7.9900000000000007e-08 0 8.0000000000000002e-08 0 9.9900000000000014e-08 0 1.0000000000000001e-07 0 1.1990000000000001e-07 0 1.2000000000000002e-07 0 1.399e-07 0 1.4000000000000001e-07 0 1.599e-07 0 1.6e-07 0 1.7990000000000002e-07 0 1.8000000000000002e-07 0 1.9990000000000001e-07 0 2.0000000000000002e-07 0.90000000000000002 2.199e-07 0.90000000000000002 2.2000000000000001e-07 0.90000000000000002 2.3990000000000002e-07 0.90000000000000002 2.4000000000000003e-07 0]
XDAC (d_gnn0 d_gnn1 d_gnn2 d_gnn3 d_gnn4 d_gnn5 d_gnn6 d_gnn7 d_gnp0 d_gnp1 d_gnp2 d_gnp3 d_gnp4 d_gnp5 d_gnp6 d_gnp7 d_gpn0 d_gpn1 d_gpn2 d_gpn3 d_gpn4 d_gpn5 d_gpn6 d_gpn7 d_gpp0 d_gpp1 d_gpp2 d_gpp3 d_gpp4 d_gpp5 d_gpp6 d_gpp7 d_n d_p VDD! d_rn d_rp 0) sar8j_r1_cdac
VDRN (d_rns 0) vsource dc=0
VDRP (d_rps 0) vsource dc=0.9
RDRN (d_rns d_rn) resistor r=50
RDRP (d_rps d_rp) resistor r=50
CDRN (d_rn 0) capacitor c=4p
CDRP (d_rp 0) capacitor c=4p

// BEGIN SARADC RNL
// @RNL(author="saradc topology") {
// #VDPRE @SET-SYMBOL $VOLTAGE_SOURCE;
// #VDPRE @PLACE(-70,0) => @ORIENT("R0");
// #VDPRE @TEXT("VDPRE",key="name",size=1.3,halign="start") => @PLACE(-67,3);
// #VDPRE @TEXT("",key="value",size=0.9,halign="start") => @PLACE(-67,-4);
// #VDPRE @TEXT("",key="model");
// #VDCM @SET-SYMBOL $VOLTAGE_SOURCE;
// #VDCM @PLACE(-70,-33) => @ORIENT("R0");
// #VDCM @TEXT("VDCM",key="name",size=1.3,halign="start") => @PLACE(-67,-30);
// #VDCM @TEXT("",key="value",size=0.9,halign="start") => @PLACE(-67,-37);
// #VDCM @TEXT("",key="model");
// #VDgnn0 @SET-SYMBOL $VOLTAGE_SOURCE;
// #VDgnn0 @PLACE(-70,-66) => @ORIENT("R0");
// #VDgnn0 @TEXT("VDgnn0",key="name",size=1.3,halign="start") => @PLACE(-67,-63);
// #VDgnn0 @TEXT("",key="value",size=0.9,halign="start") => @PLACE(-67,-70);
// #VDgnn0 @TEXT("",key="model");
// #VDgnn1 @SET-SYMBOL $VOLTAGE_SOURCE;
// #VDgnn1 @PLACE(-70,-99) => @ORIENT("R0");
// #VDgnn1 @TEXT("VDgnn1",key="name",size=1.3,halign="start") => @PLACE(-67,-96);
// #VDgnn1 @TEXT("",key="value",size=0.9,halign="start") => @PLACE(-67,-103);
// #VDgnn1 @TEXT("",key="model");
// #VDgnn2 @SET-SYMBOL $VOLTAGE_SOURCE;
// #VDgnn2 @PLACE(-70,-132) => @ORIENT("R0");
// #VDgnn2 @TEXT("VDgnn2",key="name",size=1.3,halign="start") => @PLACE(-67,-129);
// #VDgnn2 @TEXT("",key="value",size=0.9,halign="start") => @PLACE(-67,-136);
// #VDgnn2 @TEXT("",key="model");
// #VDgnn3 @SET-SYMBOL $VOLTAGE_SOURCE;
// #VDgnn3 @PLACE(-70,-165) => @ORIENT("R0");
// #VDgnn3 @TEXT("VDgnn3",key="name",size=1.3,halign="start") => @PLACE(-67,-162);
// #VDgnn3 @TEXT("",key="value",size=0.9,halign="start") => @PLACE(-67,-169);
// #VDgnn3 @TEXT("",key="model");
// #VDgnn4 @SET-SYMBOL $VOLTAGE_SOURCE;
// #VDgnn4 @PLACE(-70,-198) => @ORIENT("R0");
// #VDgnn4 @TEXT("VDgnn4",key="name",size=1.3,halign="start") => @PLACE(-67,-195);
// #VDgnn4 @TEXT("",key="value",size=0.9,halign="start") => @PLACE(-67,-202);
// #VDgnn4 @TEXT("",key="model");
// #VDgnn5 @SET-SYMBOL $VOLTAGE_SOURCE;
// #VDgnn5 @PLACE(-70,-231) => @ORIENT("R0");
// #VDgnn5 @TEXT("VDgnn5",key="name",size=1.3,halign="start") => @PLACE(-67,-228);
// #VDgnn5 @TEXT("",key="value",size=0.9,halign="start") => @PLACE(-67,-235);
// #VDgnn5 @TEXT("",key="model");
// #VDgnn6 @SET-SYMBOL $VOLTAGE_SOURCE;
// #VDgnn6 @PLACE(-70,-264) => @ORIENT("R0");
// #VDgnn6 @TEXT("VDgnn6",key="name",size=1.3,halign="start") => @PLACE(-67,-261);
// #VDgnn6 @TEXT("",key="value",size=0.9,halign="start") => @PLACE(-67,-268);
// #VDgnn6 @TEXT("",key="model");
// #VDgnn7 @SET-SYMBOL $VOLTAGE_SOURCE;
// #VDgnn7 @PLACE(-70,-297) => @ORIENT("R0");
// #VDgnn7 @TEXT("VDgnn7",key="name",size=1.3,halign="start") => @PLACE(-67,-294);
// #VDgnn7 @TEXT("",key="value",size=0.9,halign="start") => @PLACE(-67,-301);
// #VDgnn7 @TEXT("",key="model");
// #VDgnp0 @SET-SYMBOL $VOLTAGE_SOURCE;
// #VDgnp0 @PLACE(-70,-330) => @ORIENT("R0");
// #VDgnp0 @TEXT("VDgnp0",key="name",size=1.3,halign="start") => @PLACE(-67,-327);
// #VDgnp0 @TEXT("",key="value",size=0.9,halign="start") => @PLACE(-67,-334);
// #VDgnp0 @TEXT("",key="model");
// #VDgnp1 @SET-SYMBOL $VOLTAGE_SOURCE;
// #VDgnp1 @PLACE(-70,-363) => @ORIENT("R0");
// #VDgnp1 @TEXT("VDgnp1",key="name",size=1.3,halign="start") => @PLACE(-67,-360);
// #VDgnp1 @TEXT("",key="value",size=0.9,halign="start") => @PLACE(-67,-367);
// #VDgnp1 @TEXT("",key="model");
// #VDgnp2 @SET-SYMBOL $VOLTAGE_SOURCE;
// #VDgnp2 @PLACE(-15,0) => @ORIENT("R0");
// #VDgnp2 @TEXT("VDgnp2",key="name",size=1.3,halign="start") => @PLACE(-12,3);
// #VDgnp2 @TEXT("",key="value",size=0.9,halign="start") => @PLACE(-12,-4);
// #VDgnp2 @TEXT("",key="model");
// #VDgnp3 @SET-SYMBOL $VOLTAGE_SOURCE;
// #VDgnp3 @PLACE(-15,-33) => @ORIENT("R0");
// #VDgnp3 @TEXT("VDgnp3",key="name",size=1.3,halign="start") => @PLACE(-12,-30);
// #VDgnp3 @TEXT("",key="value",size=0.9,halign="start") => @PLACE(-12,-37);
// #VDgnp3 @TEXT("",key="model");
// #VDgnp4 @SET-SYMBOL $VOLTAGE_SOURCE;
// #VDgnp4 @PLACE(-15,-66) => @ORIENT("R0");
// #VDgnp4 @TEXT("VDgnp4",key="name",size=1.3,halign="start") => @PLACE(-12,-63);
// #VDgnp4 @TEXT("",key="value",size=0.9,halign="start") => @PLACE(-12,-70);
// #VDgnp4 @TEXT("",key="model");
// #VDgnp5 @SET-SYMBOL $VOLTAGE_SOURCE;
// #VDgnp5 @PLACE(-15,-99) => @ORIENT("R0");
// #VDgnp5 @TEXT("VDgnp5",key="name",size=1.3,halign="start") => @PLACE(-12,-96);
// #VDgnp5 @TEXT("",key="value",size=0.9,halign="start") => @PLACE(-12,-103);
// #VDgnp5 @TEXT("",key="model");
// #VDgnp6 @SET-SYMBOL $VOLTAGE_SOURCE;
// #VDgnp6 @PLACE(-15,-132) => @ORIENT("R0");
// #VDgnp6 @TEXT("VDgnp6",key="name",size=1.3,halign="start") => @PLACE(-12,-129);
// #VDgnp6 @TEXT("",key="value",size=0.9,halign="start") => @PLACE(-12,-136);
// #VDgnp6 @TEXT("",key="model");
// #VDgnp7 @SET-SYMBOL $VOLTAGE_SOURCE;
// #VDgnp7 @PLACE(-15,-165) => @ORIENT("R0");
// #VDgnp7 @TEXT("VDgnp7",key="name",size=1.3,halign="start") => @PLACE(-12,-162);
// #VDgnp7 @TEXT("",key="value",size=0.9,halign="start") => @PLACE(-12,-169);
// #VDgnp7 @TEXT("",key="model");
// #VDgpn0 @SET-SYMBOL $VOLTAGE_SOURCE;
// #VDgpn0 @PLACE(-15,-198) => @ORIENT("R0");
// #VDgpn0 @TEXT("VDgpn0",key="name",size=1.3,halign="start") => @PLACE(-12,-195);
// #VDgpn0 @TEXT("",key="value",size=0.9,halign="start") => @PLACE(-12,-202);
// #VDgpn0 @TEXT("",key="model");
// #VDgpn1 @SET-SYMBOL $VOLTAGE_SOURCE;
// #VDgpn1 @PLACE(-15,-231) => @ORIENT("R0");
// #VDgpn1 @TEXT("VDgpn1",key="name",size=1.3,halign="start") => @PLACE(-12,-228);
// #VDgpn1 @TEXT("",key="value",size=0.9,halign="start") => @PLACE(-12,-235);
// #VDgpn1 @TEXT("",key="model");
// #VDgpn2 @SET-SYMBOL $VOLTAGE_SOURCE;
// #VDgpn2 @PLACE(-15,-264) => @ORIENT("R0");
// #VDgpn2 @TEXT("VDgpn2",key="name",size=1.3,halign="start") => @PLACE(-12,-261);
// #VDgpn2 @TEXT("",key="value",size=0.9,halign="start") => @PLACE(-12,-268);
// #VDgpn2 @TEXT("",key="model");
// #VDgpn3 @SET-SYMBOL $VOLTAGE_SOURCE;
// #VDgpn3 @PLACE(-15,-297) => @ORIENT("R0");
// #VDgpn3 @TEXT("VDgpn3",key="name",size=1.3,halign="start") => @PLACE(-12,-294);
// #VDgpn3 @TEXT("",key="value",size=0.9,halign="start") => @PLACE(-12,-301);
// #VDgpn3 @TEXT("",key="model");
// #VDgpn4 @SET-SYMBOL $VOLTAGE_SOURCE;
// #VDgpn4 @PLACE(-15,-330) => @ORIENT("R0");
// #VDgpn4 @TEXT("VDgpn4",key="name",size=1.3,halign="start") => @PLACE(-12,-327);
// #VDgpn4 @TEXT("",key="value",size=0.9,halign="start") => @PLACE(-12,-334);
// #VDgpn4 @TEXT("",key="model");
// #VDgpn5 @SET-SYMBOL $VOLTAGE_SOURCE;
// #VDgpn5 @PLACE(-15,-363) => @ORIENT("R0");
// #VDgpn5 @TEXT("VDgpn5",key="name",size=1.3,halign="start") => @PLACE(-12,-360);
// #VDgpn5 @TEXT("",key="value",size=0.9,halign="start") => @PLACE(-12,-367);
// #VDgpn5 @TEXT("",key="model");
// #VDgpn6 @SET-SYMBOL $VOLTAGE_SOURCE;
// #VDgpn6 @PLACE(40,0) => @ORIENT("R0");
// #VDgpn6 @TEXT("VDgpn6",key="name",size=1.3,halign="start") => @PLACE(43,3);
// #VDgpn6 @TEXT("",key="value",size=0.9,halign="start") => @PLACE(43,-4);
// #VDgpn6 @TEXT("",key="model");
// #VDgpn7 @SET-SYMBOL $VOLTAGE_SOURCE;
// #VDgpn7 @PLACE(40,-33) => @ORIENT("R0");
// #VDgpn7 @TEXT("VDgpn7",key="name",size=1.3,halign="start") => @PLACE(43,-30);
// #VDgpn7 @TEXT("",key="value",size=0.9,halign="start") => @PLACE(43,-37);
// #VDgpn7 @TEXT("",key="model");
// #VDgpp0 @SET-SYMBOL $VOLTAGE_SOURCE;
// #VDgpp0 @PLACE(40,-66) => @ORIENT("R0");
// #VDgpp0 @TEXT("VDgpp0",key="name",size=1.3,halign="start") => @PLACE(43,-63);
// #VDgpp0 @TEXT("",key="value",size=0.9,halign="start") => @PLACE(43,-70);
// #VDgpp0 @TEXT("",key="model");
// #VDgpp1 @SET-SYMBOL $VOLTAGE_SOURCE;
// #VDgpp1 @PLACE(40,-99) => @ORIENT("R0");
// #VDgpp1 @TEXT("VDgpp1",key="name",size=1.3,halign="start") => @PLACE(43,-96);
// #VDgpp1 @TEXT("",key="value",size=0.9,halign="start") => @PLACE(43,-103);
// #VDgpp1 @TEXT("",key="model");
// #VDgpp2 @SET-SYMBOL $VOLTAGE_SOURCE;
// #VDgpp2 @PLACE(40,-132) => @ORIENT("R0");
// #VDgpp2 @TEXT("VDgpp2",key="name",size=1.3,halign="start") => @PLACE(43,-129);
// #VDgpp2 @TEXT("",key="value",size=0.9,halign="start") => @PLACE(43,-136);
// #VDgpp2 @TEXT("",key="model");
// #VDgpp3 @SET-SYMBOL $VOLTAGE_SOURCE;
// #VDgpp3 @PLACE(40,-165) => @ORIENT("R0");
// #VDgpp3 @TEXT("VDgpp3",key="name",size=1.3,halign="start") => @PLACE(43,-162);
// #VDgpp3 @TEXT("",key="value",size=0.9,halign="start") => @PLACE(43,-169);
// #VDgpp3 @TEXT("",key="model");
// #VDgpp4 @SET-SYMBOL $VOLTAGE_SOURCE;
// #VDgpp4 @PLACE(40,-198) => @ORIENT("R0");
// #VDgpp4 @TEXT("VDgpp4",key="name",size=1.3,halign="start") => @PLACE(43,-195);
// #VDgpp4 @TEXT("",key="value",size=0.9,halign="start") => @PLACE(43,-202);
// #VDgpp4 @TEXT("",key="model");
// #VDgpp5 @SET-SYMBOL $VOLTAGE_SOURCE;
// #VDgpp5 @PLACE(40,-231) => @ORIENT("R0");
// #VDgpp5 @TEXT("VDgpp5",key="name",size=1.3,halign="start") => @PLACE(43,-228);
// #VDgpp5 @TEXT("",key="value",size=0.9,halign="start") => @PLACE(43,-235);
// #VDgpp5 @TEXT("",key="model");
// #VDgpp6 @SET-SYMBOL $VOLTAGE_SOURCE;
// #VDgpp6 @PLACE(40,-264) => @ORIENT("R0");
// #VDgpp6 @TEXT("VDgpp6",key="name",size=1.3,halign="start") => @PLACE(43,-261);
// #VDgpp6 @TEXT("",key="value",size=0.9,halign="start") => @PLACE(43,-268);
// #VDgpp6 @TEXT("",key="model");
// #VDgpp7 @SET-SYMBOL $VOLTAGE_SOURCE;
// #VDgpp7 @PLACE(40,-297) => @ORIENT("R0");
// #VDgpp7 @TEXT("VDgpp7",key="name",size=1.3,halign="start") => @PLACE(43,-294);
// #VDgpp7 @TEXT("",key="value",size=0.9,halign="start") => @PLACE(43,-301);
// #VDgpp7 @TEXT("",key="model");
// #VDRN @SET-SYMBOL $VOLTAGE_SOURCE;
// #VDRN @PLACE(40,-330) => @ORIENT("R0");
// #VDRN @TEXT("VDRN",key="name",size=1.3,halign="start") => @PLACE(43,-327);
// #VDRN @TEXT("",key="value",size=0.9,halign="start") => @PLACE(43,-334);
// #VDRN @TEXT("",key="model");
// #VDRP @SET-SYMBOL $VOLTAGE_SOURCE;
// #VDRP @PLACE(40,-363) => @ORIENT("R0");
// #VDRP @TEXT("VDRP",key="name",size=1.3,halign="start") => @PLACE(43,-360);
// #VDRP @TEXT("",key="value",size=0.9,halign="start") => @PLACE(43,-367);
// #VDRP @TEXT("",key="model");
// #XDPN @SET-SYMBOL $S_b_tb_switch;
// #XDPN @PLACE(0,0) => @ORIENT("R0");
// #XDPP @SET-SYMBOL $S_b_tb_switch;
// #XDPP @PLACE(0,-33) => @ORIENT("R0");
// #XDAC @SET-SYMBOL $S_sar8j_r1_cdac;
// #XDAC @PLACE(0,-66) => @ORIENT("R0");
// #RDRN @SET-SYMBOL $RESISTOR;
// #RDRN @PLACE(90,0) => @ORIENT("R0");
// #RDRN @TEXT("RDRN",key="name",size=1.3,halign="start") => @PLACE(93,3);
// #RDRN @TEXT("r=50",key="value",size=0.9,halign="start") => @PLACE(93,-4);
// #RDRN @TEXT("",key="model");
// #RDRP @SET-SYMBOL $RESISTOR;
// #RDRP @PLACE(90,-33) => @ORIENT("R0");
// #RDRP @TEXT("RDRP",key="name",size=1.3,halign="start") => @PLACE(93,-30);
// #RDRP @TEXT("r=50",key="value",size=0.9,halign="start") => @PLACE(93,-37);
// #RDRP @TEXT("",key="model");
// #CDRN @SET-SYMBOL $CAPACITOR;
// #CDRN @PLACE(90,-66) => @ORIENT("R0");
// #CDRN @TEXT("CDRN",key="name",size=1.3,halign="start") => @PLACE(93,-63);
// #CDRN @TEXT("c=4p",key="value",size=0.9,halign="start") => @PLACE(93,-70);
// #CDRN @TEXT("",key="model");
// #CDRP @SET-SYMBOL $CAPACITOR;
// #CDRP @PLACE(90,-99) => @ORIENT("R0");
// #CDRP @TEXT("CDRP",key="name",size=1.3,halign="start") => @PLACE(93,-96);
// #CDRP @TEXT("c=4p",key="value",size=0.9,halign="start") => @PLACE(93,-103);
// #CDRP @TEXT("",key="model");
// &"d_n" @WIRE(mode="straight",linecolor="#30485d",linewidth=0.16) {#XDPN:1 (0,3.3) (0,-64.35) #XDAC:33};
// &"d_p" @WIRE(mode="straight",linecolor="#30485d",linewidth=0.16) {#XDPP:1 (0,-29.7) (0,-67.65) #XDAC:34};
// (-89,30) @TEXT("tb_cdac / source-derived connections",size=1.4,halign="start",textcolor="#223d52");
// &"d_pre" @WIRE(mode="straight",linecolor="#30485d",linewidth=0.16) {#VDPRE:1 (-70,5)};
// (-70,5.4) @TEXT("d_pre",size=1.1,halign="middle",valign="bottom");
// &"0" @WIRE(mode="straight",linecolor="#30485d",linewidth=0.16) {#VDPRE:2 (-70,-5)};
// (-70,-5.4) @TEXT("0",size=1.1,halign="middle",valign="top");
// &"d_cm" @WIRE(mode="straight",linecolor="#30485d",linewidth=0.16) {#VDCM:1 (-70,-28)};
// (-70,-27.6) @TEXT("d_cm",size=1.1,halign="middle",valign="bottom");
// &"0" @WIRE(mode="straight",linecolor="#30485d",linewidth=0.16) {#VDCM:2 (-70,-38)};
// (-70,-38.4) @TEXT("0",size=1.1,halign="middle",valign="top");
// &"d_cm" @WIRE(mode="straight",linecolor="#30485d",linewidth=0.16) {#XDPN:2 (-16,0)};
// (-16.4,0) @TEXT("d_cm",size=1.1,halign="end",valign="middle");
// &"d_pre" @WIRE(mode="straight",linecolor="#30485d",linewidth=0.16) {#XDPN:3 (-16,-3.3)};
// (-16.4,-3.3) @TEXT("d_pre",size=1.1,halign="end",valign="middle");
// &"VDD!" @WIRE(mode="straight",linecolor="#30485d",linewidth=0.16) {#XDPN:4 (0,11.6)};
// (0,12) @TEXT("VDD!",size=1.1,halign="middle",valign="bottom");
// &"0" @WIRE(mode="straight",linecolor="#30485d",linewidth=0.16) {#XDPN:5 (0,-11.6)};
// (0,-12) @TEXT("0",size=1.1,halign="middle",valign="top");
// &"d_cm" @WIRE(mode="straight",linecolor="#30485d",linewidth=0.16) {#XDPP:2 (-16,-33)};
// (-16.4,-33) @TEXT("d_cm",size=1.1,halign="end",valign="middle");
// &"d_pre" @WIRE(mode="straight",linecolor="#30485d",linewidth=0.16) {#XDPP:3 (-16,-36.3)};
// (-16.4,-36.3) @TEXT("d_pre",size=1.1,halign="end",valign="middle");
// &"VDD!" @WIRE(mode="straight",linecolor="#30485d",linewidth=0.16) {#XDPP:4 (0,-21.4)};
// (0,-21) @TEXT("VDD!",size=1.1,halign="middle",valign="bottom");
// &"0" @WIRE(mode="straight",linecolor="#30485d",linewidth=0.16) {#XDPP:5 (0,-44.6)};
// (0,-45) @TEXT("0",size=1.1,halign="middle",valign="top");
// &"d_gnn0" @WIRE(mode="straight",linecolor="#30485d",linewidth=0.16) {#VDgnn0:1 (-70,-61)};
// (-70,-60.6) @TEXT("d_gnn0",size=1.1,halign="middle",valign="bottom");
// &"0" @WIRE(mode="straight",linecolor="#30485d",linewidth=0.16) {#VDgnn0:2 (-70,-71)};
// (-70,-71.4) @TEXT("0",size=1.1,halign="middle",valign="top");
// &"d_gnn1" @WIRE(mode="straight",linecolor="#30485d",linewidth=0.16) {#VDgnn1:1 (-70,-94)};
// (-70,-93.6) @TEXT("d_gnn1",size=1.1,halign="middle",valign="bottom");
// &"0" @WIRE(mode="straight",linecolor="#30485d",linewidth=0.16) {#VDgnn1:2 (-70,-104)};
// (-70,-104.4) @TEXT("0",size=1.1,halign="middle",valign="top");
// &"d_gnn2" @WIRE(mode="straight",linecolor="#30485d",linewidth=0.16) {#VDgnn2:1 (-70,-127)};
// (-70,-126.6) @TEXT("d_gnn2",size=1.1,halign="middle",valign="bottom");
// &"0" @WIRE(mode="straight",linecolor="#30485d",linewidth=0.16) {#VDgnn2:2 (-70,-137)};
// (-70,-137.4) @TEXT("0",size=1.1,halign="middle",valign="top");
// &"d_gnn3" @WIRE(mode="straight",linecolor="#30485d",linewidth=0.16) {#VDgnn3:1 (-70,-160)};
// (-70,-159.6) @TEXT("d_gnn3",size=1.1,halign="middle",valign="bottom");
// &"0" @WIRE(mode="straight",linecolor="#30485d",linewidth=0.16) {#VDgnn3:2 (-70,-170)};
// (-70,-170.4) @TEXT("0",size=1.1,halign="middle",valign="top");
// &"d_gnn4" @WIRE(mode="straight",linecolor="#30485d",linewidth=0.16) {#VDgnn4:1 (-70,-193)};
// (-70,-192.6) @TEXT("d_gnn4",size=1.1,halign="middle",valign="bottom");
// &"0" @WIRE(mode="straight",linecolor="#30485d",linewidth=0.16) {#VDgnn4:2 (-70,-203)};
// (-70,-203.4) @TEXT("0",size=1.1,halign="middle",valign="top");
// &"d_gnn5" @WIRE(mode="straight",linecolor="#30485d",linewidth=0.16) {#VDgnn5:1 (-70,-226)};
// (-70,-225.6) @TEXT("d_gnn5",size=1.1,halign="middle",valign="bottom");
// &"0" @WIRE(mode="straight",linecolor="#30485d",linewidth=0.16) {#VDgnn5:2 (-70,-236)};
// (-70,-236.4) @TEXT("0",size=1.1,halign="middle",valign="top");
// &"d_gnn6" @WIRE(mode="straight",linecolor="#30485d",linewidth=0.16) {#VDgnn6:1 (-70,-259)};
// (-70,-258.6) @TEXT("d_gnn6",size=1.1,halign="middle",valign="bottom");
// &"0" @WIRE(mode="straight",linecolor="#30485d",linewidth=0.16) {#VDgnn6:2 (-70,-269)};
// (-70,-269.4) @TEXT("0",size=1.1,halign="middle",valign="top");
// &"d_gnn7" @WIRE(mode="straight",linecolor="#30485d",linewidth=0.16) {#VDgnn7:1 (-70,-292)};
// (-70,-291.6) @TEXT("d_gnn7",size=1.1,halign="middle",valign="bottom");
// &"0" @WIRE(mode="straight",linecolor="#30485d",linewidth=0.16) {#VDgnn7:2 (-70,-302)};
// (-70,-302.4) @TEXT("0",size=1.1,halign="middle",valign="top");
// &"d_gnp0" @WIRE(mode="straight",linecolor="#30485d",linewidth=0.16) {#VDgnp0:1 (-70,-325)};
// (-70,-324.6) @TEXT("d_gnp0",size=1.1,halign="middle",valign="bottom");
// &"0" @WIRE(mode="straight",linecolor="#30485d",linewidth=0.16) {#VDgnp0:2 (-70,-335)};
// (-70,-335.4) @TEXT("0",size=1.1,halign="middle",valign="top");
// &"d_gnp1" @WIRE(mode="straight",linecolor="#30485d",linewidth=0.16) {#VDgnp1:1 (-70,-358)};
// (-70,-357.6) @TEXT("d_gnp1",size=1.1,halign="middle",valign="bottom");
// &"0" @WIRE(mode="straight",linecolor="#30485d",linewidth=0.16) {#VDgnp1:2 (-70,-368)};
// (-70,-368.4) @TEXT("0",size=1.1,halign="middle",valign="top");
// &"d_gnp2" @WIRE(mode="straight",linecolor="#30485d",linewidth=0.16) {#VDgnp2:1 (-15,5)};
// (-15,5.4) @TEXT("d_gnp2",size=1.1,halign="middle",valign="bottom");
// &"0" @WIRE(mode="straight",linecolor="#30485d",linewidth=0.16) {#VDgnp2:2 (-15,-5)};
// (-15,-5.4) @TEXT("0",size=1.1,halign="middle",valign="top");
// &"d_gnp3" @WIRE(mode="straight",linecolor="#30485d",linewidth=0.16) {#VDgnp3:1 (-15,-28)};
// (-15,-27.6) @TEXT("d_gnp3",size=1.1,halign="middle",valign="bottom");
// &"0" @WIRE(mode="straight",linecolor="#30485d",linewidth=0.16) {#VDgnp3:2 (-15,-38)};
// (-15,-38.4) @TEXT("0",size=1.1,halign="middle",valign="top");
// &"d_gnp4" @WIRE(mode="straight",linecolor="#30485d",linewidth=0.16) {#VDgnp4:1 (-15,-61)};
// (-15,-60.6) @TEXT("d_gnp4",size=1.1,halign="middle",valign="bottom");
// &"0" @WIRE(mode="straight",linecolor="#30485d",linewidth=0.16) {#VDgnp4:2 (-15,-71)};
// (-15,-71.4) @TEXT("0",size=1.1,halign="middle",valign="top");
// &"d_gnp5" @WIRE(mode="straight",linecolor="#30485d",linewidth=0.16) {#VDgnp5:1 (-15,-94)};
// (-15,-93.6) @TEXT("d_gnp5",size=1.1,halign="middle",valign="bottom");
// &"0" @WIRE(mode="straight",linecolor="#30485d",linewidth=0.16) {#VDgnp5:2 (-15,-104)};
// (-15,-104.4) @TEXT("0",size=1.1,halign="middle",valign="top");
// &"d_gnp6" @WIRE(mode="straight",linecolor="#30485d",linewidth=0.16) {#VDgnp6:1 (-15,-127)};
// (-15,-126.6) @TEXT("d_gnp6",size=1.1,halign="middle",valign="bottom");
// &"0" @WIRE(mode="straight",linecolor="#30485d",linewidth=0.16) {#VDgnp6:2 (-15,-137)};
// (-15,-137.4) @TEXT("0",size=1.1,halign="middle",valign="top");
// &"d_gnp7" @WIRE(mode="straight",linecolor="#30485d",linewidth=0.16) {#VDgnp7:1 (-15,-160)};
// (-15,-159.6) @TEXT("d_gnp7",size=1.1,halign="middle",valign="bottom");
// &"0" @WIRE(mode="straight",linecolor="#30485d",linewidth=0.16) {#VDgnp7:2 (-15,-170)};
// (-15,-170.4) @TEXT("0",size=1.1,halign="middle",valign="top");
// &"d_gpn0" @WIRE(mode="straight",linecolor="#30485d",linewidth=0.16) {#VDgpn0:1 (-15,-193)};
// (-15,-192.6) @TEXT("d_gpn0",size=1.1,halign="middle",valign="bottom");
// &"0" @WIRE(mode="straight",linecolor="#30485d",linewidth=0.16) {#VDgpn0:2 (-15,-203)};
// (-15,-203.4) @TEXT("0",size=1.1,halign="middle",valign="top");
// &"d_gpn1" @WIRE(mode="straight",linecolor="#30485d",linewidth=0.16) {#VDgpn1:1 (-15,-226)};
// (-15,-225.6) @TEXT("d_gpn1",size=1.1,halign="middle",valign="bottom");
// &"0" @WIRE(mode="straight",linecolor="#30485d",linewidth=0.16) {#VDgpn1:2 (-15,-236)};
// (-15,-236.4) @TEXT("0",size=1.1,halign="middle",valign="top");
// &"d_gpn2" @WIRE(mode="straight",linecolor="#30485d",linewidth=0.16) {#VDgpn2:1 (-15,-259)};
// (-15,-258.6) @TEXT("d_gpn2",size=1.1,halign="middle",valign="bottom");
// &"0" @WIRE(mode="straight",linecolor="#30485d",linewidth=0.16) {#VDgpn2:2 (-15,-269)};
// (-15,-269.4) @TEXT("0",size=1.1,halign="middle",valign="top");
// &"d_gpn3" @WIRE(mode="straight",linecolor="#30485d",linewidth=0.16) {#VDgpn3:1 (-15,-292)};
// (-15,-291.6) @TEXT("d_gpn3",size=1.1,halign="middle",valign="bottom");
// &"0" @WIRE(mode="straight",linecolor="#30485d",linewidth=0.16) {#VDgpn3:2 (-15,-302)};
// (-15,-302.4) @TEXT("0",size=1.1,halign="middle",valign="top");
// &"d_gpn4" @WIRE(mode="straight",linecolor="#30485d",linewidth=0.16) {#VDgpn4:1 (-15,-325)};
// (-15,-324.6) @TEXT("d_gpn4",size=1.1,halign="middle",valign="bottom");
// &"0" @WIRE(mode="straight",linecolor="#30485d",linewidth=0.16) {#VDgpn4:2 (-15,-335)};
// (-15,-335.4) @TEXT("0",size=1.1,halign="middle",valign="top");
// &"d_gpn5" @WIRE(mode="straight",linecolor="#30485d",linewidth=0.16) {#VDgpn5:1 (-15,-358)};
// (-15,-357.6) @TEXT("d_gpn5",size=1.1,halign="middle",valign="bottom");
// &"0" @WIRE(mode="straight",linecolor="#30485d",linewidth=0.16) {#VDgpn5:2 (-15,-368)};
// (-15,-368.4) @TEXT("0",size=1.1,halign="middle",valign="top");
// &"d_gpn6" @WIRE(mode="straight",linecolor="#30485d",linewidth=0.16) {#VDgpn6:1 (40,5)};
// (40,5.4) @TEXT("d_gpn6",size=1.1,halign="middle",valign="bottom");
// &"0" @WIRE(mode="straight",linecolor="#30485d",linewidth=0.16) {#VDgpn6:2 (40,-5)};
// (40,-5.4) @TEXT("0",size=1.1,halign="middle",valign="top");
// &"d_gpn7" @WIRE(mode="straight",linecolor="#30485d",linewidth=0.16) {#VDgpn7:1 (40,-28)};
// (40,-27.6) @TEXT("d_gpn7",size=1.1,halign="middle",valign="bottom");
// &"0" @WIRE(mode="straight",linecolor="#30485d",linewidth=0.16) {#VDgpn7:2 (40,-38)};
// (40,-38.4) @TEXT("0",size=1.1,halign="middle",valign="top");
// &"d_gpp0" @WIRE(mode="straight",linecolor="#30485d",linewidth=0.16) {#VDgpp0:1 (40,-61)};
// (40,-60.6) @TEXT("d_gpp0",size=1.1,halign="middle",valign="bottom");
// &"0" @WIRE(mode="straight",linecolor="#30485d",linewidth=0.16) {#VDgpp0:2 (40,-71)};
// (40,-71.4) @TEXT("0",size=1.1,halign="middle",valign="top");
// &"d_gpp1" @WIRE(mode="straight",linecolor="#30485d",linewidth=0.16) {#VDgpp1:1 (40,-94)};
// (40,-93.6) @TEXT("d_gpp1",size=1.1,halign="middle",valign="bottom");
// &"0" @WIRE(mode="straight",linecolor="#30485d",linewidth=0.16) {#VDgpp1:2 (40,-104)};
// (40,-104.4) @TEXT("0",size=1.1,halign="middle",valign="top");
// &"d_gpp2" @WIRE(mode="straight",linecolor="#30485d",linewidth=0.16) {#VDgpp2:1 (40,-127)};
// (40,-126.6) @TEXT("d_gpp2",size=1.1,halign="middle",valign="bottom");
// &"0" @WIRE(mode="straight",linecolor="#30485d",linewidth=0.16) {#VDgpp2:2 (40,-137)};
// (40,-137.4) @TEXT("0",size=1.1,halign="middle",valign="top");
// &"d_gpp3" @WIRE(mode="straight",linecolor="#30485d",linewidth=0.16) {#VDgpp3:1 (40,-160)};
// (40,-159.6) @TEXT("d_gpp3",size=1.1,halign="middle",valign="bottom");
// &"0" @WIRE(mode="straight",linecolor="#30485d",linewidth=0.16) {#VDgpp3:2 (40,-170)};
// (40,-170.4) @TEXT("0",size=1.1,halign="middle",valign="top");
// &"d_gpp4" @WIRE(mode="straight",linecolor="#30485d",linewidth=0.16) {#VDgpp4:1 (40,-193)};
// (40,-192.6) @TEXT("d_gpp4",size=1.1,halign="middle",valign="bottom");
// &"0" @WIRE(mode="straight",linecolor="#30485d",linewidth=0.16) {#VDgpp4:2 (40,-203)};
// (40,-203.4) @TEXT("0",size=1.1,halign="middle",valign="top");
// &"d_gpp5" @WIRE(mode="straight",linecolor="#30485d",linewidth=0.16) {#VDgpp5:1 (40,-226)};
// (40,-225.6) @TEXT("d_gpp5",size=1.1,halign="middle",valign="bottom");
// &"0" @WIRE(mode="straight",linecolor="#30485d",linewidth=0.16) {#VDgpp5:2 (40,-236)};
// (40,-236.4) @TEXT("0",size=1.1,halign="middle",valign="top");
// &"d_gpp6" @WIRE(mode="straight",linecolor="#30485d",linewidth=0.16) {#VDgpp6:1 (40,-259)};
// (40,-258.6) @TEXT("d_gpp6",size=1.1,halign="middle",valign="bottom");
// &"0" @WIRE(mode="straight",linecolor="#30485d",linewidth=0.16) {#VDgpp6:2 (40,-269)};
// (40,-269.4) @TEXT("0",size=1.1,halign="middle",valign="top");
// &"d_gpp7" @WIRE(mode="straight",linecolor="#30485d",linewidth=0.16) {#VDgpp7:1 (40,-292)};
// (40,-291.6) @TEXT("d_gpp7",size=1.1,halign="middle",valign="bottom");
// &"0" @WIRE(mode="straight",linecolor="#30485d",linewidth=0.16) {#VDgpp7:2 (40,-302)};
// (40,-302.4) @TEXT("0",size=1.1,halign="middle",valign="top");
// {&"d_gnn0" &"d_gnn1" &"d_gnn2" &"d_gnn3" &"d_gnn4" &"d_gnn5" &"d_gnn6" &"d_gnn7"} @WIRE(mode="straight",linewidth=0.3) {#XDAC:1 (-16,-57.75)};
// (-16.4,-57.75) @TEXT("d_gnn[7:0]",size=1.1,halign="end",valign="middle");
// {&"d_gnp0" &"d_gnp1" &"d_gnp2" &"d_gnp3" &"d_gnp4" &"d_gnp5" &"d_gnp6" &"d_gnp7"} @WIRE(mode="straight",linewidth=0.3) {#XDAC:9 (-16,-61.05)};
// (-16.4,-61.05) @TEXT("d_gnp[7:0]",size=1.1,halign="end",valign="middle");
// {&"d_gpn0" &"d_gpn1" &"d_gpn2" &"d_gpn3" &"d_gpn4" &"d_gpn5" &"d_gpn6" &"d_gpn7"} @WIRE(mode="straight",linewidth=0.3) {#XDAC:17 (-16,-64.35)};
// (-16.4,-64.35) @TEXT("d_gpn[7:0]",size=1.1,halign="end",valign="middle");
// {&"d_gpp0" &"d_gpp1" &"d_gpp2" &"d_gpp3" &"d_gpp4" &"d_gpp5" &"d_gpp6" &"d_gpp7"} @WIRE(mode="straight",linewidth=0.3) {#XDAC:25 (-16,-67.65)};
// (-16.4,-67.65) @TEXT("d_gpp[7:0]",size=1.1,halign="end",valign="middle");
// &"VDD!" @WIRE(mode="straight",linecolor="#30485d",linewidth=0.16) {#XDAC:35 (0,-49.45)};
// (0,-49.05) @TEXT("VDD!",size=1.1,halign="middle",valign="bottom");
// &"d_rn" @WIRE(mode="straight",linecolor="#30485d",linewidth=0.16) {#XDAC:36 (-16,-70.95)};
// (-16.4,-70.95) @TEXT("d_rn",size=1.1,halign="end",valign="middle");
// &"d_rp" @WIRE(mode="straight",linecolor="#30485d",linewidth=0.16) {#XDAC:37 (-16,-74.25)};
// (-16.4,-74.25) @TEXT("d_rp",size=1.1,halign="end",valign="middle");
// &"0" @WIRE(mode="straight",linecolor="#30485d",linewidth=0.16) {#XDAC:38 (0,-82.55)};
// (0,-82.95) @TEXT("0",size=1.1,halign="middle",valign="top");
// &"d_rns" @WIRE(mode="straight",linecolor="#30485d",linewidth=0.16) {#VDRN:1 (40,-325)};
// (40,-324.6) @TEXT("d_rns",size=1.1,halign="middle",valign="bottom");
// &"0" @WIRE(mode="straight",linecolor="#30485d",linewidth=0.16) {#VDRN:2 (40,-335)};
// (40,-335.4) @TEXT("0",size=1.1,halign="middle",valign="top");
// &"d_rps" @WIRE(mode="straight",linecolor="#30485d",linewidth=0.16) {#VDRP:1 (40,-358)};
// (40,-357.6) @TEXT("d_rps",size=1.1,halign="middle",valign="bottom");
// &"0" @WIRE(mode="straight",linecolor="#30485d",linewidth=0.16) {#VDRP:2 (40,-368)};
// (40,-368.4) @TEXT("0",size=1.1,halign="middle",valign="top");
// &"d_rns" @WIRE(mode="straight",linecolor="#30485d",linewidth=0.16) {#RDRN:1 (90,5)};
// (90,5.4) @TEXT("d_rns",size=1.1,halign="middle",valign="bottom");
// &"d_rn" @WIRE(mode="straight",linecolor="#30485d",linewidth=0.16) {#RDRN:2 (90,-5)};
// (90,-5.4) @TEXT("d_rn",size=1.1,halign="middle",valign="top");
// &"d_rps" @WIRE(mode="straight",linecolor="#30485d",linewidth=0.16) {#RDRP:1 (90,-28)};
// (90,-27.6) @TEXT("d_rps",size=1.1,halign="middle",valign="bottom");
// &"d_rp" @WIRE(mode="straight",linecolor="#30485d",linewidth=0.16) {#RDRP:2 (90,-38)};
// (90,-38.4) @TEXT("d_rp",size=1.1,halign="middle",valign="top");
// &"d_rn" @WIRE(mode="straight",linecolor="#30485d",linewidth=0.16) {#CDRN:1 (90,-61)};
// (90,-60.6) @TEXT("d_rn",size=1.1,halign="middle",valign="bottom");
// &"0" @WIRE(mode="straight",linecolor="#30485d",linewidth=0.16) {#CDRN:2 (90,-71)};
// (90,-71.4) @TEXT("0",size=1.1,halign="middle",valign="top");
// &"d_rp" @WIRE(mode="straight",linecolor="#30485d",linewidth=0.16) {#CDRP:1 (90,-94)};
// (90,-93.6) @TEXT("d_rp",size=1.1,halign="middle",valign="bottom");
// &"0" @WIRE(mode="straight",linecolor="#30485d",linewidth=0.16) {#CDRP:2 (90,-104)};
// (90,-104.4) @TEXT("0",size=1.1,halign="middle",valign="top");
// }
// END SARADC RNL
ends tb_cdac

subckt tb_comparator
// Comparator delay/reset at stated differential inputs; native MOM plus receiver gate loads.
VCCLOCK (c_clock 0) vsource type=pulse val0=0 val1=0.9 delay=5n rise=100p fall=100p width=4.9n period=10n
VCN (c_n 0) vsource dc=0.45
VCP (c_p 0) vsource type=pwl wave=[0 0.55000000000000004 9.900000000000001e-09 0.55000000000000004 1e-08 0.34999999999999998 1.99e-08 0.34999999999999998 2e-08 0.47999999999999998 2.9900000000000003e-08 0.47999999999999998 3.0000000000000004e-08 0.42000000000000004 3.99e-08 0.42000000000000004 4.0000000000000001e-08 0.45351562500000003 4.9899999999999997e-08 0.45351562500000003 4.9999999999999998e-08 0.44648437499999999 5.9900000000000014e-08 0.44648437499999999 6.0000000000000008e-08 0.45100000000000001 6.990000000000001e-08 0.45100000000000001 7.0000000000000005e-08 0.44900000000000001 7.9900000000000007e-08 0.44900000000000001 8.0000000000000002e-08 0.4501 8.9900000000000004e-08 0.4501 8.9999999999999999e-08 0.44990000000000002]
XCOMP (c_clock c_outn c_outp VDD! c_n c_p 0) sar_strongarm_t28
CCN (c_outn 0) cfmom_2t nr=8 lr=2.5u w=50n s=50n stm=1 spm=3 multi=2 mismatchflag=1
CCP (c_outp 0) cfmom_2t nr=8 lr=2.5u w=50n s=50n stm=1 spm=3 multi=2 mismatchflag=1
XCRN (c_outn VDD! 0 c_unusedn) sar8p_inv
XCRP (c_outp VDD! 0 c_unusedp) sar8p_inv
// Independent floating-input kickback fixture, same nominal CDAC-side MOM geometry.
VKINIT (k_init 0) vsource type=pwl wave=[0 0.9 10n 0.9 10.1n 0]
VKP (k_sp 0) vsource dc=0.4505
VKN (k_sn 0) vsource dc=0.4495
XKP (k_p k_sp k_init VDD! 0) b_tb_switch
XKN (k_n k_sn k_init VDD! 0) b_tb_switch
CKP (k_p 0) cfmom_2t nr=8 lr=2u w=50n s=50n stm=1 spm=3 multi=256 mismatchflag=1
CKN (k_n 0) cfmom_2t nr=8 lr=2u w=50n s=50n stm=1 spm=3 multi=256 mismatchflag=1
VKC (k_clock 0) vsource type=pulse val0=0 val1=0.9 delay=15n rise=100p fall=100p width=4.9n period=1000n
XKCOMP (k_clock k_outn k_outp VDD! k_n k_p 0) sar_strongarm_t28
CKON (k_outn 0) capacitor c=10f
CKOP (k_outp 0) capacitor c=10f

// BEGIN SARADC RNL
// @RNL(author="saradc topology") {
// #VCCLOCK @SET-SYMBOL $VOLTAGE_SOURCE;
// #VCCLOCK @PLACE(-70,0) => @ORIENT("R0");
// #VCCLOCK @TEXT("VCCLOCK",key="name",size=1.3,halign="start") => @PLACE(-67,3);
// #VCCLOCK @TEXT("",key="value",size=0.9,halign="start") => @PLACE(-67,-4);
// #VCCLOCK @TEXT("",key="model");
// #VCN @SET-SYMBOL $VOLTAGE_SOURCE;
// #VCN @PLACE(-70,-33) => @ORIENT("R0");
// #VCN @TEXT("VCN",key="name",size=1.3,halign="start") => @PLACE(-67,-30);
// #VCN @TEXT("",key="value",size=0.9,halign="start") => @PLACE(-67,-37);
// #VCN @TEXT("",key="model");
// #VCP @SET-SYMBOL $VOLTAGE_SOURCE;
// #VCP @PLACE(-70,-66) => @ORIENT("R0");
// #VCP @TEXT("VCP",key="name",size=1.3,halign="start") => @PLACE(-67,-63);
// #VCP @TEXT("",key="value",size=0.9,halign="start") => @PLACE(-67,-70);
// #VCP @TEXT("",key="model");
// #VKINIT @SET-SYMBOL $VOLTAGE_SOURCE;
// #VKINIT @PLACE(-70,-99) => @ORIENT("R0");
// #VKINIT @TEXT("VKINIT",key="name",size=1.3,halign="start") => @PLACE(-67,-96);
// #VKINIT @TEXT("",key="value",size=0.9,halign="start") => @PLACE(-67,-103);
// #VKINIT @TEXT("",key="model");
// #VKP @SET-SYMBOL $VOLTAGE_SOURCE;
// #VKP @PLACE(-70,-132) => @ORIENT("R0");
// #VKP @TEXT("VKP",key="name",size=1.3,halign="start") => @PLACE(-67,-129);
// #VKP @TEXT("",key="value",size=0.9,halign="start") => @PLACE(-67,-136);
// #VKP @TEXT("",key="model");
// #VKN @SET-SYMBOL $VOLTAGE_SOURCE;
// #VKN @PLACE(-70,-165) => @ORIENT("R0");
// #VKN @TEXT("VKN",key="name",size=1.3,halign="start") => @PLACE(-67,-162);
// #VKN @TEXT("",key="value",size=0.9,halign="start") => @PLACE(-67,-169);
// #VKN @TEXT("",key="model");
// #VKC @SET-SYMBOL $VOLTAGE_SOURCE;
// #VKC @PLACE(-70,-198) => @ORIENT("R0");
// #VKC @TEXT("VKC",key="name",size=1.3,halign="start") => @PLACE(-67,-195);
// #VKC @TEXT("",key="value",size=0.9,halign="start") => @PLACE(-67,-202);
// #VKC @TEXT("",key="model");
// #XCOMP @SET-SYMBOL $S_sar_strongarm_t28;
// #XCOMP @PLACE(0,0) => @ORIENT("R0");
// #XCRN @SET-SYMBOL $S_sar8p_inv;
// #XCRN @PLACE(0,-33) => @ORIENT("R0");
// #XCRP @SET-SYMBOL $S_sar8p_inv;
// #XCRP @PLACE(0,-66) => @ORIENT("R0");
// #XKP @SET-SYMBOL $S_b_tb_switch;
// #XKP @PLACE(0,-99) => @ORIENT("R0");
// #XKN @SET-SYMBOL $S_b_tb_switch;
// #XKN @PLACE(0,-132) => @ORIENT("R0");
// #XKCOMP @SET-SYMBOL $S_sar_strongarm_t28;
// #XKCOMP @PLACE(0,-165) => @ORIENT("R0");
// #CCN @SET-SYMBOL $CAPACITOR;
// #CCN @PLACE(90,0) => @ORIENT("R0");
// #CCN @TEXT("CCN",key="name",size=1.3,halign="start") => @PLACE(93,3);
// #CCN @TEXT("nr=8 lr=2.5u w=50n multi=2",key="value",size=0.9,halign="start") => @PLACE(93,-4);
// #CCN @TEXT("",key="model");
// #CCP @SET-SYMBOL $CAPACITOR;
// #CCP @PLACE(90,-33) => @ORIENT("R0");
// #CCP @TEXT("CCP",key="name",size=1.3,halign="start") => @PLACE(93,-30);
// #CCP @TEXT("nr=8 lr=2.5u w=50n multi=2",key="value",size=0.9,halign="start") => @PLACE(93,-37);
// #CCP @TEXT("",key="model");
// #CKP @SET-SYMBOL $CAPACITOR;
// #CKP @PLACE(90,-66) => @ORIENT("R0");
// #CKP @TEXT("CKP",key="name",size=1.3,halign="start") => @PLACE(93,-63);
// #CKP @TEXT("nr=8 lr=2u w=50n multi=256",key="value",size=0.9,halign="start") => @PLACE(93,-70);
// #CKP @TEXT("",key="model");
// #CKN @SET-SYMBOL $CAPACITOR;
// #CKN @PLACE(90,-99) => @ORIENT("R0");
// #CKN @TEXT("CKN",key="name",size=1.3,halign="start") => @PLACE(93,-96);
// #CKN @TEXT("nr=8 lr=2u w=50n multi=256",key="value",size=0.9,halign="start") => @PLACE(93,-103);
// #CKN @TEXT("",key="model");
// #CKON @SET-SYMBOL $CAPACITOR;
// #CKON @PLACE(90,-132) => @ORIENT("R0");
// #CKON @TEXT("CKON",key="name",size=1.3,halign="start") => @PLACE(93,-129);
// #CKON @TEXT("c=10f",key="value",size=0.9,halign="start") => @PLACE(93,-136);
// #CKON @TEXT("",key="model");
// #CKOP @SET-SYMBOL $CAPACITOR;
// #CKOP @PLACE(90,-165) => @ORIENT("R0");
// #CKOP @TEXT("CKOP",key="name",size=1.3,halign="start") => @PLACE(93,-162);
// #CKOP @TEXT("c=10f",key="value",size=0.9,halign="start") => @PLACE(93,-169);
// #CKOP @TEXT("",key="model");
// &"c_clock" @WIRE(mode="straight",linecolor="#30485d",linewidth=0.16) {#VCCLOCK:1 (-41.5,2) (-41.5,3.3) #XCOMP:1};
// &"c_n" @WIRE(mode="straight",linecolor="#30485d",linewidth=0.16) {#VCN:1 (-41.5,-31) (-41.5,0) #XCOMP:5};
// &"c_p" @WIRE(mode="straight",linecolor="#30485d",linewidth=0.16) {#VCP:1 (-41.5,-64) (-41.5,-3.3) #XCOMP:6};
// &"k_sp" @WIRE(mode="straight",linecolor="#30485d",linewidth=0.16) {#VKP:1 (-41.5,-130) (-41.5,-99) #XKP:2};
// &"k_sn" @WIRE(mode="straight",linecolor="#30485d",linewidth=0.16) {#VKN:1 (-41.5,-163) (-41.5,-132) #XKN:2};
// &"k_clock" @WIRE(mode="straight",linecolor="#30485d",linewidth=0.16) {#VKC:1 (-41.5,-196) (-41.5,-161.7) #XKCOMP:1};
// &"k_outn" @WIRE(mode="straight",linecolor="#30485d",linewidth=0.16) {#XKCOMP:2 (51.5,-163.35) (51.5,-130) #CKON:1};
// &"k_outp" @WIRE(mode="straight",linecolor="#30485d",linewidth=0.16) {#XKCOMP:3 (51.5,-166.65) (51.5,-163) #CKOP:1};
// (-89,30) @TEXT("tb_comparator / source-derived connections",size=1.4,halign="start",textcolor="#223d52");
// &"0" @WIRE(mode="straight",linecolor="#30485d",linewidth=0.16) {#VCCLOCK:2 (-70,-5)};
// (-70,-5.4) @TEXT("0",size=1.1,halign="middle",valign="top");
// &"0" @WIRE(mode="straight",linecolor="#30485d",linewidth=0.16) {#VCN:2 (-70,-38)};
// (-70,-38.4) @TEXT("0",size=1.1,halign="middle",valign="top");
// &"0" @WIRE(mode="straight",linecolor="#30485d",linewidth=0.16) {#VCP:2 (-70,-71)};
// (-70,-71.4) @TEXT("0",size=1.1,halign="middle",valign="top");
// &"c_outn" @WIRE(mode="straight",linecolor="#30485d",linewidth=0.16) {#XCOMP:2 (16,1.65)};
// (16.4,1.65) @TEXT("c_outn",size=1.1,halign="start",valign="middle");
// &"c_outp" @WIRE(mode="straight",linecolor="#30485d",linewidth=0.16) {#XCOMP:3 (16,-1.65)};
// (16.4,-1.65) @TEXT("c_outp",size=1.1,halign="start",valign="middle");
// &"VDD!" @WIRE(mode="straight",linecolor="#30485d",linewidth=0.16) {#XCOMP:4 (0,11.6)};
// (0,12) @TEXT("VDD!",size=1.1,halign="middle",valign="bottom");
// &"0" @WIRE(mode="straight",linecolor="#30485d",linewidth=0.16) {#XCOMP:7 (0,-11.6)};
// (0,-12) @TEXT("0",size=1.1,halign="middle",valign="top");
// &"c_outn" @WIRE(mode="straight",linecolor="#30485d",linewidth=0.16) {#CCN:1 (90,5)};
// (90,5.4) @TEXT("c_outn",size=1.1,halign="middle",valign="bottom");
// &"0" @WIRE(mode="straight",linecolor="#30485d",linewidth=0.16) {#CCN:2 (90,-5)};
// (90,-5.4) @TEXT("0",size=1.1,halign="middle",valign="top");
// &"c_outp" @WIRE(mode="straight",linecolor="#30485d",linewidth=0.16) {#CCP:1 (90,-28)};
// (90,-27.6) @TEXT("c_outp",size=1.1,halign="middle",valign="bottom");
// &"0" @WIRE(mode="straight",linecolor="#30485d",linewidth=0.16) {#CCP:2 (90,-38)};
// (90,-38.4) @TEXT("0",size=1.1,halign="middle",valign="top");
// &"c_outn" @WIRE(mode="straight",linecolor="#30485d",linewidth=0.16) {#XCRN:1 (-10,-33)};
// (-10.4,-33) @TEXT("c_outn",size=1.1,halign="end",valign="middle");
// &"VDD!" @WIRE(mode="straight",linecolor="#30485d",linewidth=0.16) {#XCRN:2 (0,-23)};
// (0,-22.6) @TEXT("VDD!",size=1.1,halign="middle",valign="bottom");
// &"0" @WIRE(mode="straight",linecolor="#30485d",linewidth=0.16) {#XCRN:3 (0,-43)};
// (0,-43.4) @TEXT("0",size=1.1,halign="middle",valign="top");
// &"c_unusedn" @WIRE(mode="straight",linecolor="#30485d",linewidth=0.16) {#XCRN:4 (10,-33)};
// (10.4,-33) @TEXT("c_unusedn",size=1.1,halign="start",valign="middle");
// &"c_outp" @WIRE(mode="straight",linecolor="#30485d",linewidth=0.16) {#XCRP:1 (-10,-66)};
// (-10.4,-66) @TEXT("c_outp",size=1.1,halign="end",valign="middle");
// &"VDD!" @WIRE(mode="straight",linecolor="#30485d",linewidth=0.16) {#XCRP:2 (0,-56)};
// (0,-55.6) @TEXT("VDD!",size=1.1,halign="middle",valign="bottom");
// &"0" @WIRE(mode="straight",linecolor="#30485d",linewidth=0.16) {#XCRP:3 (0,-76)};
// (0,-76.4) @TEXT("0",size=1.1,halign="middle",valign="top");
// &"c_unusedp" @WIRE(mode="straight",linecolor="#30485d",linewidth=0.16) {#XCRP:4 (10,-66)};
// (10.4,-66) @TEXT("c_unusedp",size=1.1,halign="start",valign="middle");
// &"k_init" @WIRE(mode="straight",linecolor="#30485d",linewidth=0.16) {#VKINIT:1 (-70,-94)};
// (-70,-93.6) @TEXT("k_init",size=1.1,halign="middle",valign="bottom");
// &"0" @WIRE(mode="straight",linecolor="#30485d",linewidth=0.16) {#VKINIT:2 (-70,-104)};
// (-70,-104.4) @TEXT("0",size=1.1,halign="middle",valign="top");
// &"0" @WIRE(mode="straight",linecolor="#30485d",linewidth=0.16) {#VKP:2 (-70,-137)};
// (-70,-137.4) @TEXT("0",size=1.1,halign="middle",valign="top");
// &"0" @WIRE(mode="straight",linecolor="#30485d",linewidth=0.16) {#VKN:2 (-70,-170)};
// (-70,-170.4) @TEXT("0",size=1.1,halign="middle",valign="top");
// &"k_p" @WIRE(mode="straight",linecolor="#30485d",linewidth=0.16) {#XKP:1 (-16,-95.7)};
// (-16.4,-95.7) @TEXT("k_p",size=1.1,halign="end",valign="middle");
// &"k_init" @WIRE(mode="straight",linecolor="#30485d",linewidth=0.16) {#XKP:3 (-16,-102.3)};
// (-16.4,-102.3) @TEXT("k_init",size=1.1,halign="end",valign="middle");
// &"VDD!" @WIRE(mode="straight",linecolor="#30485d",linewidth=0.16) {#XKP:4 (0,-87.4)};
// (0,-87) @TEXT("VDD!",size=1.1,halign="middle",valign="bottom");
// &"0" @WIRE(mode="straight",linecolor="#30485d",linewidth=0.16) {#XKP:5 (0,-110.6)};
// (0,-111) @TEXT("0",size=1.1,halign="middle",valign="top");
// &"k_n" @WIRE(mode="straight",linecolor="#30485d",linewidth=0.16) {#XKN:1 (-16,-128.7)};
// (-16.4,-128.7) @TEXT("k_n",size=1.1,halign="end",valign="middle");
// &"k_init" @WIRE(mode="straight",linecolor="#30485d",linewidth=0.16) {#XKN:3 (-16,-135.3)};
// (-16.4,-135.3) @TEXT("k_init",size=1.1,halign="end",valign="middle");
// &"VDD!" @WIRE(mode="straight",linecolor="#30485d",linewidth=0.16) {#XKN:4 (0,-120.4)};
// (0,-120) @TEXT("VDD!",size=1.1,halign="middle",valign="bottom");
// &"0" @WIRE(mode="straight",linecolor="#30485d",linewidth=0.16) {#XKN:5 (0,-143.6)};
// (0,-144) @TEXT("0",size=1.1,halign="middle",valign="top");
// &"k_p" @WIRE(mode="straight",linecolor="#30485d",linewidth=0.16) {#CKP:1 (90,-61)};
// (90,-60.6) @TEXT("k_p",size=1.1,halign="middle",valign="bottom");
// &"0" @WIRE(mode="straight",linecolor="#30485d",linewidth=0.16) {#CKP:2 (90,-71)};
// (90,-71.4) @TEXT("0",size=1.1,halign="middle",valign="top");
// &"k_n" @WIRE(mode="straight",linecolor="#30485d",linewidth=0.16) {#CKN:1 (90,-94)};
// (90,-93.6) @TEXT("k_n",size=1.1,halign="middle",valign="bottom");
// &"0" @WIRE(mode="straight",linecolor="#30485d",linewidth=0.16) {#CKN:2 (90,-104)};
// (90,-104.4) @TEXT("0",size=1.1,halign="middle",valign="top");
// &"0" @WIRE(mode="straight",linecolor="#30485d",linewidth=0.16) {#VKC:2 (-70,-203)};
// (-70,-203.4) @TEXT("0",size=1.1,halign="middle",valign="top");
// &"VDD!" @WIRE(mode="straight",linecolor="#30485d",linewidth=0.16) {#XKCOMP:4 (0,-153.4)};
// (0,-153) @TEXT("VDD!",size=1.1,halign="middle",valign="bottom");
// &"k_n" @WIRE(mode="straight",linecolor="#30485d",linewidth=0.16) {#XKCOMP:5 (-16,-165)};
// (-16.4,-165) @TEXT("k_n",size=1.1,halign="end",valign="middle");
// &"k_p" @WIRE(mode="straight",linecolor="#30485d",linewidth=0.16) {#XKCOMP:6 (-16,-168.3)};
// (-16.4,-168.3) @TEXT("k_p",size=1.1,halign="end",valign="middle");
// &"0" @WIRE(mode="straight",linecolor="#30485d",linewidth=0.16) {#XKCOMP:7 (0,-176.6)};
// (0,-177) @TEXT("0",size=1.1,halign="middle",valign="top");
// &"0" @WIRE(mode="straight",linecolor="#30485d",linewidth=0.16) {#CKON:2 (90,-137)};
// (90,-137.4) @TEXT("0",size=1.1,halign="middle",valign="top");
// &"0" @WIRE(mode="straight",linecolor="#30485d",linewidth=0.16) {#CKOP:2 (90,-170)};
// (90,-170.4) @TEXT("0",size=1.1,halign="middle",valign="top");
// }
// END SARADC RNL
ends tb_comparator

subckt tb_reference
// Reference storage, nonoverlap and gate-drive test with the ACTUAL CDAC as the load.
VRRESET (r_reset 0) vsource type=pwl wave=[0 0.9 20n 0.9 20.1n 0]
VRPHI (r_phi 0) vsource type=pulse val0=0 val1=0.9 delay=50n rise=100p fall=100p width=1.9n period=80n
VRB0 (r_bit0 0) vsource type=pwl wave=[0 0 4.4900000000000005e-08 0 4.5000000000000006e-08 0 1.2490000000000001e-07 0 1.2500000000000002e-07 0 2.0490000000000001e-07 0 2.0500000000000002e-07 0.90000000000000002 2.8490000000000002e-07 0.90000000000000002 2.8500000000000002e-07 0.90000000000000002 3.6489999999999999e-07 0.90000000000000002 3.65e-07 0 4.4490000000000002e-07 0 4.4500000000000003e-07 0]
VRB1 (r_bit1 0) vsource type=pwl wave=[0 0 4.4900000000000005e-08 0 4.5000000000000006e-08 0 1.2490000000000001e-07 0 1.2500000000000002e-07 0 2.0490000000000001e-07 0 2.0500000000000002e-07 0.90000000000000002 2.8490000000000002e-07 0.90000000000000002 2.8500000000000002e-07 0 3.6489999999999999e-07 0 3.65e-07 0.90000000000000002 4.4490000000000002e-07 0.90000000000000002 4.4500000000000003e-07 0]
VRB2 (r_bit2 0) vsource type=pwl wave=[0 0 4.4900000000000005e-08 0 4.5000000000000006e-08 0 1.2490000000000001e-07 0 1.2500000000000002e-07 0 2.0490000000000001e-07 0 2.0500000000000002e-07 0.90000000000000002 2.8490000000000002e-07 0.90000000000000002 2.8500000000000002e-07 0.90000000000000002 3.6489999999999999e-07 0.90000000000000002 3.65e-07 0 4.4490000000000002e-07 0 4.4500000000000003e-07 0]
VRB3 (r_bit3 0) vsource type=pwl wave=[0 0 4.4900000000000005e-08 0 4.5000000000000006e-08 0 1.2490000000000001e-07 0 1.2500000000000002e-07 0 2.0490000000000001e-07 0 2.0500000000000002e-07 0.90000000000000002 2.8490000000000002e-07 0.90000000000000002 2.8500000000000002e-07 0 3.6489999999999999e-07 0 3.65e-07 0.90000000000000002 4.4490000000000002e-07 0.90000000000000002 4.4500000000000003e-07 0]
VRB4 (r_bit4 0) vsource type=pwl wave=[0 0 4.4900000000000005e-08 0 4.5000000000000006e-08 0 1.2490000000000001e-07 0 1.2500000000000002e-07 0 2.0490000000000001e-07 0 2.0500000000000002e-07 0.90000000000000002 2.8490000000000002e-07 0.90000000000000002 2.8500000000000002e-07 0.90000000000000002 3.6489999999999999e-07 0.90000000000000002 3.65e-07 0 4.4490000000000002e-07 0 4.4500000000000003e-07 0]
VRB5 (r_bit5 0) vsource type=pwl wave=[0 0 4.4900000000000005e-08 0 4.5000000000000006e-08 0 1.2490000000000001e-07 0 1.2500000000000002e-07 0 2.0490000000000001e-07 0 2.0500000000000002e-07 0.90000000000000002 2.8490000000000002e-07 0.90000000000000002 2.8500000000000002e-07 0 3.6489999999999999e-07 0 3.65e-07 0.90000000000000002 4.4490000000000002e-07 0.90000000000000002 4.4500000000000003e-07 0]
VRB6 (r_bit6 0) vsource type=pwl wave=[0 0 4.4900000000000005e-08 0 4.5000000000000006e-08 0 1.2490000000000001e-07 0 1.2500000000000002e-07 0 2.0490000000000001e-07 0 2.0500000000000002e-07 0.90000000000000002 2.8490000000000002e-07 0.90000000000000002 2.8500000000000002e-07 0.90000000000000002 3.6489999999999999e-07 0.90000000000000002 3.65e-07 0 4.4490000000000002e-07 0 4.4500000000000003e-07 0]
VRB7 (r_bit7 0) vsource type=pwl wave=[0 0.90000000000000002 4.4900000000000005e-08 0.90000000000000002 4.5000000000000006e-08 0.90000000000000002 1.2490000000000001e-07 0.90000000000000002 1.2500000000000002e-07 0 2.0490000000000001e-07 0 2.0500000000000002e-07 0.90000000000000002 2.8490000000000002e-07 0.90000000000000002 2.8500000000000002e-07 0 3.6489999999999999e-07 0 3.65e-07 0.90000000000000002 4.4490000000000002e-07 0.90000000000000002 4.4500000000000003e-07 0.90000000000000002]
XREF (r_bit0 r_bit1 r_bit2 r_bit3 r_bit4 r_bit5 r_bit6 r_bit7 r_bit0 r_bit1 r_bit2 r_bit3 r_bit4 r_bit5 r_bit6 r_bit7 r_gnn0 r_gnn1 r_gnn2 r_gnn3 r_gnn4 r_gnn5 r_gnn6 r_gnn7 r_gnp0 r_gnp1 r_gnp2 r_gnp3 r_gnp4 r_gnp5 r_gnp6 r_gnp7 r_gpn0 r_gpn1 r_gpn2 r_gpn3 r_gpn4 r_gpn5 r_gpn6 r_gpn7 r_gpp0 r_gpp1 r_gpp2 r_gpp3 r_gpp4 r_gpp5 r_gpp6 r_gpp7 r_phi r_reset VDD! 0 r_done r_reset) sar8i_refword
XRLOAD (r_gnn0 r_gnn1 r_gnn2 r_gnn3 r_gnn4 r_gnn5 r_gnn6 r_gnn7 r_gnp0 r_gnp1 r_gnp2 r_gnp3 r_gnp4 r_gnp5 r_gnp6 r_gnp7 r_gpn0 r_gpn1 r_gpn2 r_gpn3 r_gpn4 r_gpn5 r_gpn6 r_gpn7 r_gpp0 r_gpp1 r_gpp2 r_gpp3 r_gpp4 r_gpp5 r_gpp6 r_gpp7 r_n r_p VDD! r_rn r_rp 0) sar8j_r1_cdac
VRRN (r_rns 0) vsource dc=0
VRRP (r_rps 0) vsource dc=0.9
RRRN (r_rns r_rn) resistor r=50
RRRP (r_rps r_rp) resistor r=50
CRRN (r_rn 0) capacitor c=4p
CRRP (r_rp 0) capacitor c=4p
RRNLEAK (r_n 0) resistor r=1e12
RRPLEAK (r_p 0) resistor r=1e12

// BEGIN SARADC RNL
// @RNL(author="saradc topology") {
// #VRRESET @SET-SYMBOL $VOLTAGE_SOURCE;
// #VRRESET @PLACE(-70,0) => @ORIENT("R0");
// #VRRESET @TEXT("VRRESET",key="name",size=1.3,halign="start") => @PLACE(-67,3);
// #VRRESET @TEXT("",key="value",size=0.9,halign="start") => @PLACE(-67,-4);
// #VRRESET @TEXT("",key="model");
// #VRPHI @SET-SYMBOL $VOLTAGE_SOURCE;
// #VRPHI @PLACE(-70,-33) => @ORIENT("R0");
// #VRPHI @TEXT("VRPHI",key="name",size=1.3,halign="start") => @PLACE(-67,-30);
// #VRPHI @TEXT("",key="value",size=0.9,halign="start") => @PLACE(-67,-37);
// #VRPHI @TEXT("",key="model");
// #VRB0 @SET-SYMBOL $VOLTAGE_SOURCE;
// #VRB0 @PLACE(-70,-66) => @ORIENT("R0");
// #VRB0 @TEXT("VRB0",key="name",size=1.3,halign="start") => @PLACE(-67,-63);
// #VRB0 @TEXT("",key="value",size=0.9,halign="start") => @PLACE(-67,-70);
// #VRB0 @TEXT("",key="model");
// #VRB1 @SET-SYMBOL $VOLTAGE_SOURCE;
// #VRB1 @PLACE(-70,-99) => @ORIENT("R0");
// #VRB1 @TEXT("VRB1",key="name",size=1.3,halign="start") => @PLACE(-67,-96);
// #VRB1 @TEXT("",key="value",size=0.9,halign="start") => @PLACE(-67,-103);
// #VRB1 @TEXT("",key="model");
// #VRB2 @SET-SYMBOL $VOLTAGE_SOURCE;
// #VRB2 @PLACE(-70,-132) => @ORIENT("R0");
// #VRB2 @TEXT("VRB2",key="name",size=1.3,halign="start") => @PLACE(-67,-129);
// #VRB2 @TEXT("",key="value",size=0.9,halign="start") => @PLACE(-67,-136);
// #VRB2 @TEXT("",key="model");
// #VRB3 @SET-SYMBOL $VOLTAGE_SOURCE;
// #VRB3 @PLACE(-70,-165) => @ORIENT("R0");
// #VRB3 @TEXT("VRB3",key="name",size=1.3,halign="start") => @PLACE(-67,-162);
// #VRB3 @TEXT("",key="value",size=0.9,halign="start") => @PLACE(-67,-169);
// #VRB3 @TEXT("",key="model");
// #VRB4 @SET-SYMBOL $VOLTAGE_SOURCE;
// #VRB4 @PLACE(-70,-198) => @ORIENT("R0");
// #VRB4 @TEXT("VRB4",key="name",size=1.3,halign="start") => @PLACE(-67,-195);
// #VRB4 @TEXT("",key="value",size=0.9,halign="start") => @PLACE(-67,-202);
// #VRB4 @TEXT("",key="model");
// #VRB5 @SET-SYMBOL $VOLTAGE_SOURCE;
// #VRB5 @PLACE(-70,-231) => @ORIENT("R0");
// #VRB5 @TEXT("VRB5",key="name",size=1.3,halign="start") => @PLACE(-67,-228);
// #VRB5 @TEXT("",key="value",size=0.9,halign="start") => @PLACE(-67,-235);
// #VRB5 @TEXT("",key="model");
// #VRB6 @SET-SYMBOL $VOLTAGE_SOURCE;
// #VRB6 @PLACE(-70,-264) => @ORIENT("R0");
// #VRB6 @TEXT("VRB6",key="name",size=1.3,halign="start") => @PLACE(-67,-261);
// #VRB6 @TEXT("",key="value",size=0.9,halign="start") => @PLACE(-67,-268);
// #VRB6 @TEXT("",key="model");
// #VRB7 @SET-SYMBOL $VOLTAGE_SOURCE;
// #VRB7 @PLACE(-70,-297) => @ORIENT("R0");
// #VRB7 @TEXT("VRB7",key="name",size=1.3,halign="start") => @PLACE(-67,-294);
// #VRB7 @TEXT("",key="value",size=0.9,halign="start") => @PLACE(-67,-301);
// #VRB7 @TEXT("",key="model");
// #VRRN @SET-SYMBOL $VOLTAGE_SOURCE;
// #VRRN @PLACE(-70,-330) => @ORIENT("R0");
// #VRRN @TEXT("VRRN",key="name",size=1.3,halign="start") => @PLACE(-67,-327);
// #VRRN @TEXT("",key="value",size=0.9,halign="start") => @PLACE(-67,-334);
// #VRRN @TEXT("",key="model");
// #VRRP @SET-SYMBOL $VOLTAGE_SOURCE;
// #VRRP @PLACE(-70,-363) => @ORIENT("R0");
// #VRRP @TEXT("VRRP",key="name",size=1.3,halign="start") => @PLACE(-67,-360);
// #VRRP @TEXT("",key="value",size=0.9,halign="start") => @PLACE(-67,-367);
// #VRRP @TEXT("",key="model");
// #XREF @SET-SYMBOL $S_sar8i_refword;
// #XREF @PLACE(0,0) => @ORIENT("R0");
// #XRLOAD @SET-SYMBOL $S_sar8j_r1_cdac;
// #XRLOAD @PLACE(0,-33) => @ORIENT("R0");
// #RRRN @SET-SYMBOL $RESISTOR;
// #RRRN @PLACE(90,0) => @ORIENT("R0");
// #RRRN @TEXT("RRRN",key="name",size=1.3,halign="start") => @PLACE(93,3);
// #RRRN @TEXT("r=50",key="value",size=0.9,halign="start") => @PLACE(93,-4);
// #RRRN @TEXT("",key="model");
// #RRRP @SET-SYMBOL $RESISTOR;
// #RRRP @PLACE(90,-33) => @ORIENT("R0");
// #RRRP @TEXT("RRRP",key="name",size=1.3,halign="start") => @PLACE(93,-30);
// #RRRP @TEXT("r=50",key="value",size=0.9,halign="start") => @PLACE(93,-37);
// #RRRP @TEXT("",key="model");
// #CRRN @SET-SYMBOL $CAPACITOR;
// #CRRN @PLACE(90,-66) => @ORIENT("R0");
// #CRRN @TEXT("CRRN",key="name",size=1.3,halign="start") => @PLACE(93,-63);
// #CRRN @TEXT("c=4p",key="value",size=0.9,halign="start") => @PLACE(93,-70);
// #CRRN @TEXT("",key="model");
// #CRRP @SET-SYMBOL $CAPACITOR;
// #CRRP @PLACE(90,-99) => @ORIENT("R0");
// #CRRP @TEXT("CRRP",key="name",size=1.3,halign="start") => @PLACE(93,-96);
// #CRRP @TEXT("c=4p",key="value",size=0.9,halign="start") => @PLACE(93,-103);
// #CRRP @TEXT("",key="model");
// #RRNLEAK @SET-SYMBOL $RESISTOR;
// #RRNLEAK @PLACE(90,-132) => @ORIENT("R0");
// #RRNLEAK @TEXT("RRNLEAK",key="name",size=1.3,halign="start") => @PLACE(93,-129);
// #RRNLEAK @TEXT("r=1e12",key="value",size=0.9,halign="start") => @PLACE(93,-136);
// #RRNLEAK @TEXT("",key="model");
// #RRPLEAK @SET-SYMBOL $RESISTOR;
// #RRPLEAK @PLACE(90,-165) => @ORIENT("R0");
// #RRPLEAK @TEXT("RRPLEAK",key="name",size=1.3,halign="start") => @PLACE(93,-162);
// #RRPLEAK @TEXT("r=1e12",key="value",size=0.9,halign="start") => @PLACE(93,-169);
// #RRPLEAK @TEXT("",key="model");
// &"r_phi" @WIRE(mode="straight",linecolor="#30485d",linewidth=0.16) {#VRPHI:1 (-41.5,-31) (-41.5,-1.65) #XREF:49};
// &"r_n" @WIRE(mode="straight",linecolor="#30485d",linewidth=0.16) {#XRLOAD:33 (51.5,-31.35) (51.5,-130) #RRNLEAK:1};
// (-89,30) @TEXT("tb_reference / source-derived connections",size=1.4,halign="start",textcolor="#223d52");
// &"r_reset" @WIRE(mode="straight",linecolor="#30485d",linewidth=0.16) {#VRRESET:1 (-70,5)};
// (-70,5.4) @TEXT("r_reset",size=1.1,halign="middle",valign="bottom");
// &"0" @WIRE(mode="straight",linecolor="#30485d",linewidth=0.16) {#VRRESET:2 (-70,-5)};
// (-70,-5.4) @TEXT("0",size=1.1,halign="middle",valign="top");
// &"0" @WIRE(mode="straight",linecolor="#30485d",linewidth=0.16) {#VRPHI:2 (-70,-38)};
// (-70,-38.4) @TEXT("0",size=1.1,halign="middle",valign="top");
// &"r_bit0" @WIRE(mode="straight",linecolor="#30485d",linewidth=0.16) {#VRB0:1 (-70,-61)};
// (-70,-60.6) @TEXT("r_bit0",size=1.1,halign="middle",valign="bottom");
// &"0" @WIRE(mode="straight",linecolor="#30485d",linewidth=0.16) {#VRB0:2 (-70,-71)};
// (-70,-71.4) @TEXT("0",size=1.1,halign="middle",valign="top");
// &"r_bit1" @WIRE(mode="straight",linecolor="#30485d",linewidth=0.16) {#VRB1:1 (-70,-94)};
// (-70,-93.6) @TEXT("r_bit1",size=1.1,halign="middle",valign="bottom");
// &"0" @WIRE(mode="straight",linecolor="#30485d",linewidth=0.16) {#VRB1:2 (-70,-104)};
// (-70,-104.4) @TEXT("0",size=1.1,halign="middle",valign="top");
// &"r_bit2" @WIRE(mode="straight",linecolor="#30485d",linewidth=0.16) {#VRB2:1 (-70,-127)};
// (-70,-126.6) @TEXT("r_bit2",size=1.1,halign="middle",valign="bottom");
// &"0" @WIRE(mode="straight",linecolor="#30485d",linewidth=0.16) {#VRB2:2 (-70,-137)};
// (-70,-137.4) @TEXT("0",size=1.1,halign="middle",valign="top");
// &"r_bit3" @WIRE(mode="straight",linecolor="#30485d",linewidth=0.16) {#VRB3:1 (-70,-160)};
// (-70,-159.6) @TEXT("r_bit3",size=1.1,halign="middle",valign="bottom");
// &"0" @WIRE(mode="straight",linecolor="#30485d",linewidth=0.16) {#VRB3:2 (-70,-170)};
// (-70,-170.4) @TEXT("0",size=1.1,halign="middle",valign="top");
// &"r_bit4" @WIRE(mode="straight",linecolor="#30485d",linewidth=0.16) {#VRB4:1 (-70,-193)};
// (-70,-192.6) @TEXT("r_bit4",size=1.1,halign="middle",valign="bottom");
// &"0" @WIRE(mode="straight",linecolor="#30485d",linewidth=0.16) {#VRB4:2 (-70,-203)};
// (-70,-203.4) @TEXT("0",size=1.1,halign="middle",valign="top");
// &"r_bit5" @WIRE(mode="straight",linecolor="#30485d",linewidth=0.16) {#VRB5:1 (-70,-226)};
// (-70,-225.6) @TEXT("r_bit5",size=1.1,halign="middle",valign="bottom");
// &"0" @WIRE(mode="straight",linecolor="#30485d",linewidth=0.16) {#VRB5:2 (-70,-236)};
// (-70,-236.4) @TEXT("0",size=1.1,halign="middle",valign="top");
// &"r_bit6" @WIRE(mode="straight",linecolor="#30485d",linewidth=0.16) {#VRB6:1 (-70,-259)};
// (-70,-258.6) @TEXT("r_bit6",size=1.1,halign="middle",valign="bottom");
// &"0" @WIRE(mode="straight",linecolor="#30485d",linewidth=0.16) {#VRB6:2 (-70,-269)};
// (-70,-269.4) @TEXT("0",size=1.1,halign="middle",valign="top");
// &"r_bit7" @WIRE(mode="straight",linecolor="#30485d",linewidth=0.16) {#VRB7:1 (-70,-292)};
// (-70,-291.6) @TEXT("r_bit7",size=1.1,halign="middle",valign="bottom");
// &"0" @WIRE(mode="straight",linecolor="#30485d",linewidth=0.16) {#VRB7:2 (-70,-302)};
// (-70,-302.4) @TEXT("0",size=1.1,halign="middle",valign="top");
// {&"r_bit0" &"r_bit1" &"r_bit2" &"r_bit3" &"r_bit4" &"r_bit5" &"r_bit6" &"r_bit7"} @WIRE(mode="straight",linewidth=0.3) {#XREF:1 (-16,4.95)};
// (-16.4,4.95) @TEXT("r_bit[7:0]",size=1.1,halign="end",valign="middle");
// {&"r_bit0" &"r_bit1" &"r_bit2" &"r_bit3" &"r_bit4" &"r_bit5" &"r_bit6" &"r_bit7"} @WIRE(mode="straight",linewidth=0.3) {#XREF:9 (-16,1.65)};
// (-16.4,1.65) @TEXT("r_bit[7:0]",size=1.1,halign="end",valign="middle");
// {&"r_gnn0" &"r_gnn1" &"r_gnn2" &"r_gnn3" &"r_gnn4" &"r_gnn5" &"r_gnn6" &"r_gnn7"} @WIRE(mode="straight",linewidth=0.3) {#XREF:17 (16,8.25)};
// (16.4,8.25) @TEXT("r_gnn[7:0]",size=1.1,halign="start",valign="middle");
// {&"r_gnp0" &"r_gnp1" &"r_gnp2" &"r_gnp3" &"r_gnp4" &"r_gnp5" &"r_gnp6" &"r_gnp7"} @WIRE(mode="straight",linewidth=0.3) {#XREF:25 (16,4.95)};
// (16.4,4.95) @TEXT("r_gnp[7:0]",size=1.1,halign="start",valign="middle");
// {&"r_gpn0" &"r_gpn1" &"r_gpn2" &"r_gpn3" &"r_gpn4" &"r_gpn5" &"r_gpn6" &"r_gpn7"} @WIRE(mode="straight",linewidth=0.3) {#XREF:33 (16,1.65)};
// (16.4,1.65) @TEXT("r_gpn[7:0]",size=1.1,halign="start",valign="middle");
// {&"r_gpp0" &"r_gpp1" &"r_gpp2" &"r_gpp3" &"r_gpp4" &"r_gpp5" &"r_gpp6" &"r_gpp7"} @WIRE(mode="straight",linewidth=0.3) {#XREF:41 (16,-1.65)};
// (16.4,-1.65) @TEXT("r_gpp[7:0]",size=1.1,halign="start",valign="middle");
// &"r_reset" @WIRE(mode="straight",linecolor="#30485d",linewidth=0.16) {#XREF:50 (-16,-4.95)};
// (-16.4,-4.95) @TEXT("r_reset",size=1.1,halign="end",valign="middle");
// &"VDD!" @WIRE(mode="straight",linecolor="#30485d",linewidth=0.16) {#XREF:51 (0,16.55)};
// (0,16.95) @TEXT("VDD!",size=1.1,halign="middle",valign="bottom");
// &"0" @WIRE(mode="straight",linecolor="#30485d",linewidth=0.16) {#XREF:52 (0,-16.55)};
// (0,-16.95) @TEXT("0",size=1.1,halign="middle",valign="top");
// &"r_done" @WIRE(mode="straight",linecolor="#30485d",linewidth=0.16) {#XREF:53 (16,-4.95)};
// (16.4,-4.95) @TEXT("r_done",size=1.1,halign="start",valign="middle");
// &"r_reset" @WIRE(mode="straight",linecolor="#30485d",linewidth=0.16) {#XREF:54 (16,-8.25)};
// (16.4,-8.25) @TEXT("r_reset",size=1.1,halign="start",valign="middle");
// {&"r_gnn0" &"r_gnn1" &"r_gnn2" &"r_gnn3" &"r_gnn4" &"r_gnn5" &"r_gnn6" &"r_gnn7"} @WIRE(mode="straight",linewidth=0.3) {#XRLOAD:1 (-16,-24.75)};
// (-16.4,-24.75) @TEXT("r_gnn[7:0]",size=1.1,halign="end",valign="middle");
// {&"r_gnp0" &"r_gnp1" &"r_gnp2" &"r_gnp3" &"r_gnp4" &"r_gnp5" &"r_gnp6" &"r_gnp7"} @WIRE(mode="straight",linewidth=0.3) {#XRLOAD:9 (-16,-28.05)};
// (-16.4,-28.05) @TEXT("r_gnp[7:0]",size=1.1,halign="end",valign="middle");
// {&"r_gpn0" &"r_gpn1" &"r_gpn2" &"r_gpn3" &"r_gpn4" &"r_gpn5" &"r_gpn6" &"r_gpn7"} @WIRE(mode="straight",linewidth=0.3) {#XRLOAD:17 (-16,-31.35)};
// (-16.4,-31.35) @TEXT("r_gpn[7:0]",size=1.1,halign="end",valign="middle");
// {&"r_gpp0" &"r_gpp1" &"r_gpp2" &"r_gpp3" &"r_gpp4" &"r_gpp5" &"r_gpp6" &"r_gpp7"} @WIRE(mode="straight",linewidth=0.3) {#XRLOAD:25 (-16,-34.65)};
// (-16.4,-34.65) @TEXT("r_gpp[7:0]",size=1.1,halign="end",valign="middle");
// &"r_p" @WIRE(mode="straight",linecolor="#30485d",linewidth=0.16) {#XRLOAD:34 (16,-34.65)};
// (16.4,-34.65) @TEXT("r_p",size=1.1,halign="start",valign="middle");
// &"VDD!" @WIRE(mode="straight",linecolor="#30485d",linewidth=0.16) {#XRLOAD:35 (0,-16.45)};
// (0,-16.05) @TEXT("VDD!",size=1.1,halign="middle",valign="bottom");
// &"r_rn" @WIRE(mode="straight",linecolor="#30485d",linewidth=0.16) {#XRLOAD:36 (-16,-37.95)};
// (-16.4,-37.95) @TEXT("r_rn",size=1.1,halign="end",valign="middle");
// &"r_rp" @WIRE(mode="straight",linecolor="#30485d",linewidth=0.16) {#XRLOAD:37 (-16,-41.25)};
// (-16.4,-41.25) @TEXT("r_rp",size=1.1,halign="end",valign="middle");
// &"0" @WIRE(mode="straight",linecolor="#30485d",linewidth=0.16) {#XRLOAD:38 (0,-49.55)};
// (0,-49.95) @TEXT("0",size=1.1,halign="middle",valign="top");
// &"r_rns" @WIRE(mode="straight",linecolor="#30485d",linewidth=0.16) {#VRRN:1 (-70,-325)};
// (-70,-324.6) @TEXT("r_rns",size=1.1,halign="middle",valign="bottom");
// &"0" @WIRE(mode="straight",linecolor="#30485d",linewidth=0.16) {#VRRN:2 (-70,-335)};
// (-70,-335.4) @TEXT("0",size=1.1,halign="middle",valign="top");
// &"r_rps" @WIRE(mode="straight",linecolor="#30485d",linewidth=0.16) {#VRRP:1 (-70,-358)};
// (-70,-357.6) @TEXT("r_rps",size=1.1,halign="middle",valign="bottom");
// &"0" @WIRE(mode="straight",linecolor="#30485d",linewidth=0.16) {#VRRP:2 (-70,-368)};
// (-70,-368.4) @TEXT("0",size=1.1,halign="middle",valign="top");
// &"r_rns" @WIRE(mode="straight",linecolor="#30485d",linewidth=0.16) {#RRRN:1 (90,5)};
// (90,5.4) @TEXT("r_rns",size=1.1,halign="middle",valign="bottom");
// &"r_rn" @WIRE(mode="straight",linecolor="#30485d",linewidth=0.16) {#RRRN:2 (90,-5)};
// (90,-5.4) @TEXT("r_rn",size=1.1,halign="middle",valign="top");
// &"r_rps" @WIRE(mode="straight",linecolor="#30485d",linewidth=0.16) {#RRRP:1 (90,-28)};
// (90,-27.6) @TEXT("r_rps",size=1.1,halign="middle",valign="bottom");
// &"r_rp" @WIRE(mode="straight",linecolor="#30485d",linewidth=0.16) {#RRRP:2 (90,-38)};
// (90,-38.4) @TEXT("r_rp",size=1.1,halign="middle",valign="top");
// &"r_rn" @WIRE(mode="straight",linecolor="#30485d",linewidth=0.16) {#CRRN:1 (90,-61)};
// (90,-60.6) @TEXT("r_rn",size=1.1,halign="middle",valign="bottom");
// &"0" @WIRE(mode="straight",linecolor="#30485d",linewidth=0.16) {#CRRN:2 (90,-71)};
// (90,-71.4) @TEXT("0",size=1.1,halign="middle",valign="top");
// &"r_rp" @WIRE(mode="straight",linecolor="#30485d",linewidth=0.16) {#CRRP:1 (90,-94)};
// (90,-93.6) @TEXT("r_rp",size=1.1,halign="middle",valign="bottom");
// &"0" @WIRE(mode="straight",linecolor="#30485d",linewidth=0.16) {#CRRP:2 (90,-104)};
// (90,-104.4) @TEXT("0",size=1.1,halign="middle",valign="top");
// &"0" @WIRE(mode="straight",linecolor="#30485d",linewidth=0.16) {#RRNLEAK:2 (90,-137)};
// (90,-137.4) @TEXT("0",size=1.1,halign="middle",valign="top");
// &"r_p" @WIRE(mode="straight",linecolor="#30485d",linewidth=0.16) {#RRPLEAK:1 (90,-160)};
// (90,-159.6) @TEXT("r_p",size=1.1,halign="middle",valign="bottom");
// &"0" @WIRE(mode="straight",linecolor="#30485d",linewidth=0.16) {#RRPLEAK:2 (90,-170)};
// (90,-170.4) @TEXT("0",size=1.1,halign="middle",valign="top");
// }
// END SARADC RNL
ends tb_reference

subckt tb_sampler
// Standalone sampler: normal initial 60 ns low / 40 ns high, 50 ohm source.
VBCLOCK (b_clock 0) vsource type=pulse val0=0 val1=0.9 delay=60n rise=100p fall=100p width=39.9n period=100n
VBIN (b_source 0) vsource type=pwl wave=[0 0.2 120n 0.2 120.1n 0.8]
RBIN (b_source b_in) resistor r=50
XBOOT (b_clock b_hold b_in) sar_bootstrap_flat_8b_p
CBLOAD (b_hold 0) cfmom_2t nr=8 lr=2u w=50n s=50n stm=1 spm=3 multi=256 mismatchflag=1

// BEGIN SARADC RNL
// @RNL(author="saradc topology") {
// #VBCLOCK @SET-SYMBOL $VOLTAGE_SOURCE;
// #VBCLOCK @PLACE(-70,0) => @ORIENT("R0");
// #VBCLOCK @TEXT("VBCLOCK",key="name",size=1.3,halign="start") => @PLACE(-67,3);
// #VBCLOCK @TEXT("",key="value",size=0.9,halign="start") => @PLACE(-67,-4);
// #VBCLOCK @TEXT("",key="model");
// #VBIN @SET-SYMBOL $VOLTAGE_SOURCE;
// #VBIN @PLACE(-70,-33) => @ORIENT("R0");
// #VBIN @TEXT("VBIN",key="name",size=1.3,halign="start") => @PLACE(-67,-30);
// #VBIN @TEXT("",key="value",size=0.9,halign="start") => @PLACE(-67,-37);
// #VBIN @TEXT("",key="model");
// #XBOOT @SET-SYMBOL $S_sar_bootstrap_flat_8b_p;
// #XBOOT @PLACE(0,0) => @ORIENT("R0");
// #RBIN @SET-SYMBOL $RESISTOR;
// #RBIN @PLACE(90,0) => @ORIENT("R0");
// #RBIN @TEXT("RBIN",key="name",size=1.3,halign="start") => @PLACE(93,3);
// #RBIN @TEXT("r=50",key="value",size=0.9,halign="start") => @PLACE(93,-4);
// #RBIN @TEXT("",key="model");
// #CBLOAD @SET-SYMBOL $CAPACITOR;
// #CBLOAD @PLACE(90,-33) => @ORIENT("R0");
// #CBLOAD @TEXT("CBLOAD",key="name",size=1.3,halign="start") => @PLACE(93,-30);
// #CBLOAD @TEXT("nr=8 lr=2u w=50n multi=256",key="value",size=0.9,halign="start") => @PLACE(93,-37);
// #CBLOAD @TEXT("",key="model");
// &"b_clock" @WIRE(mode="straight",linecolor="#30485d",linewidth=0.16) {#VBCLOCK:1 (-41.5,2) (-41.5,1.65) #XBOOT:1};
// &"b_in" @WIRE(mode="straight",linecolor="#30485d",linewidth=0.16) {#RBIN:2 (38.5,-2) (38.5,-1.65) #XBOOT:3};
// &"b_hold" @WIRE(mode="straight",linecolor="#30485d",linewidth=0.16) {#XBOOT:2 (51.5,0) (51.5,-31) #CBLOAD:1};
// (-89,30) @TEXT("tb_sampler / source-derived connections",size=1.4,halign="start",textcolor="#223d52");
// &"0" @WIRE(mode="straight",linecolor="#30485d",linewidth=0.16) {#VBCLOCK:2 (-70,-5)};
// (-70,-5.4) @TEXT("0",size=1.1,halign="middle",valign="top");
// &"b_source" @WIRE(mode="straight",linecolor="#30485d",linewidth=0.16) {#VBIN:1 (-70,-28)};
// (-70,-27.6) @TEXT("b_source",size=1.1,halign="middle",valign="bottom");
// &"0" @WIRE(mode="straight",linecolor="#30485d",linewidth=0.16) {#VBIN:2 (-70,-38)};
// (-70,-38.4) @TEXT("0",size=1.1,halign="middle",valign="top");
// &"b_source" @WIRE(mode="straight",linecolor="#30485d",linewidth=0.16) {#RBIN:1 (90,5)};
// (90,5.4) @TEXT("b_source",size=1.1,halign="middle",valign="bottom");
// &"0" @WIRE(mode="straight",linecolor="#30485d",linewidth=0.16) {#CBLOAD:2 (90,-38)};
// (90,-38.4) @TEXT("0",size=1.1,halign="middle",valign="top");
// }
// END SARADC RNL
ends tb_sampler

subckt tb_sar
// Native SAR and native delays; electrical VA sampler/CDAC/reference/comparator provide the environment.
VSCLOCK (s_clock 0) vsource type=pulse val0=0 val1=0.9 delay=60n rise=100p fall=100p width=39.9n period=100n
VSs_ps (s_ps 0) vsource type=pwl wave=[0 0.0017578125000000111 1.5980000000000001e-07 0.0017578125000000111 1.5990000000000002e-07 0.0439453125 2.5979999999999998e-07 0.0439453125 2.5989999999999999e-07 0.4482421875 3.5979999999999998e-07 0.4482421875 3.5989999999999999e-07 0.45175781250000002 4.5979999999999997e-07 0.45175781250000002 4.5989999999999998e-07 0.85605468750000002 5.5980000000000002e-07 0.85605468750000002 5.5990000000000003e-07 0.89824218750000007]
VSs_ns (s_ns 0) vsource type=pwl wave=[0 0.89824218749999996 1.5980000000000001e-07 0.89824218749999996 1.5990000000000002e-07 0.85605468750000002 2.5979999999999998e-07 0.85605468750000002 2.5989999999999999e-07 0.45175781250000002 3.5979999999999998e-07 0.45175781250000002 3.5989999999999999e-07 0.4482421875 4.5979999999999997e-07 0.4482421875 4.5989999999999998e-07 0.0439453125 5.5980000000000002e-07 0.0439453125 5.5990000000000003e-07 0.0017578124999999556]
XSAR (s_d0 s_d1 s_d2 s_d3 s_d4 s_d5 s_d6 s_d7 s_clock VDD! s_n s_p s_rn s_rp 0) tb_sar_top
RSIN (s_ns s_n) resistor r=50
RSIP (s_ps s_p) resistor r=50
VSRN (s_rns 0) vsource dc=0
VSRP (s_rps 0) vsource dc=0.9
RSRN (s_rns s_rn) resistor r=50
RSRP (s_rps s_rp) resistor r=50
CSRN (s_rn 0) capacitor c=4p
CSRP (s_rp 0) capacitor c=4p
XSPROBE (s_d0 s_d1 s_d2 s_d3 s_d4 s_d5 s_d6 s_d7 s_clock VDD! 0) b_behavior_observer model_id=901
CSL0 (s_d0 0) capacitor c=5f
CSL1 (s_d1 0) capacitor c=5f
CSL2 (s_d2 0) capacitor c=5f
CSL3 (s_d3 0) capacitor c=5f
CSL4 (s_d4 0) capacitor c=5f
CSL5 (s_d5 0) capacitor c=5f
CSL6 (s_d6 0) capacitor c=5f
CSL7 (s_d7 0) capacitor c=5f
// A second real SAR receives no comparator response. A new acquisition must
// clear it without a false write/update; this adds no watchdog to the design.
XSTALLED (f_d0 f_d1 f_d2 f_d3 f_d4 f_d5 f_d6 f_d7 s_clock VDD! f_n f_p f_rn f_rp 0) tb_sar_stalled_top
RFIN (s_ns f_n) resistor r=50
RFIP (s_ps f_p) resistor r=50
VFRN (f_rns 0) vsource dc=0
VFRP (f_rps 0) vsource dc=0.9
RFRN (f_rns f_rn) resistor r=50
RFRP (f_rps f_rp) resistor r=50
CFRN (f_rn 0) capacitor c=4p
CFRP (f_rp 0) capacitor c=4p
CFL0 (f_d0 0) capacitor c=5f
CFL1 (f_d1 0) capacitor c=5f
CFL2 (f_d2 0) capacitor c=5f
CFL3 (f_d3 0) capacitor c=5f
CFL4 (f_d4 0) capacitor c=5f
CFL5 (f_d5 0) capacitor c=5f
CFL6 (f_d6 0) capacitor c=5f
CFL7 (f_d7 0) capacitor c=5f

// BEGIN SARADC RNL
// @RNL(author="saradc topology") {
// #VSCLOCK @SET-SYMBOL $VOLTAGE_SOURCE;
// #VSCLOCK @PLACE(-70,0) => @ORIENT("R0");
// #VSCLOCK @TEXT("VSCLOCK",key="name",size=1.3,halign="start") => @PLACE(-67,3);
// #VSCLOCK @TEXT("",key="value",size=0.9,halign="start") => @PLACE(-67,-4);
// #VSCLOCK @TEXT("",key="model");
// #VSs_ps @SET-SYMBOL $VOLTAGE_SOURCE;
// #VSs_ps @PLACE(-70,-33) => @ORIENT("R0");
// #VSs_ps @TEXT("VSs_ps",key="name",size=1.3,halign="start") => @PLACE(-67,-30);
// #VSs_ps @TEXT("",key="value",size=0.9,halign="start") => @PLACE(-67,-37);
// #VSs_ps @TEXT("",key="model");
// #VSs_ns @SET-SYMBOL $VOLTAGE_SOURCE;
// #VSs_ns @PLACE(-70,-66) => @ORIENT("R0");
// #VSs_ns @TEXT("VSs_ns",key="name",size=1.3,halign="start") => @PLACE(-67,-63);
// #VSs_ns @TEXT("",key="value",size=0.9,halign="start") => @PLACE(-67,-70);
// #VSs_ns @TEXT("",key="model");
// #VSRN @SET-SYMBOL $VOLTAGE_SOURCE;
// #VSRN @PLACE(-70,-99) => @ORIENT("R0");
// #VSRN @TEXT("VSRN",key="name",size=1.3,halign="start") => @PLACE(-67,-96);
// #VSRN @TEXT("",key="value",size=0.9,halign="start") => @PLACE(-67,-103);
// #VSRN @TEXT("",key="model");
// #VSRP @SET-SYMBOL $VOLTAGE_SOURCE;
// #VSRP @PLACE(-70,-132) => @ORIENT("R0");
// #VSRP @TEXT("VSRP",key="name",size=1.3,halign="start") => @PLACE(-67,-129);
// #VSRP @TEXT("",key="value",size=0.9,halign="start") => @PLACE(-67,-136);
// #VSRP @TEXT("",key="model");
// #VFRN @SET-SYMBOL $VOLTAGE_SOURCE;
// #VFRN @PLACE(-70,-165) => @ORIENT("R0");
// #VFRN @TEXT("VFRN",key="name",size=1.3,halign="start") => @PLACE(-67,-162);
// #VFRN @TEXT("",key="value",size=0.9,halign="start") => @PLACE(-67,-169);
// #VFRN @TEXT("",key="model");
// #VFRP @SET-SYMBOL $VOLTAGE_SOURCE;
// #VFRP @PLACE(-70,-198) => @ORIENT("R0");
// #VFRP @TEXT("VFRP",key="name",size=1.3,halign="start") => @PLACE(-67,-195);
// #VFRP @TEXT("",key="value",size=0.9,halign="start") => @PLACE(-67,-202);
// #VFRP @TEXT("",key="model");
// #XSAR @SET-SYMBOL $S_tb_sar_top;
// #XSAR @PLACE(0,0) => @ORIENT("R0");
// #XSPROBE @SET-SYMBOL $S_b_behavior_observer;
// #XSPROBE @PLACE(0,-33) => @ORIENT("R0");
// #XSTALLED @SET-SYMBOL $S_tb_sar_stalled_top;
// #XSTALLED @PLACE(0,-66) => @ORIENT("R0");
// #RSIN @SET-SYMBOL $RESISTOR;
// #RSIN @PLACE(90,0) => @ORIENT("R0");
// #RSIN @TEXT("RSIN",key="name",size=1.3,halign="start") => @PLACE(93,3);
// #RSIN @TEXT("r=50",key="value",size=0.9,halign="start") => @PLACE(93,-4);
// #RSIN @TEXT("",key="model");
// #RSIP @SET-SYMBOL $RESISTOR;
// #RSIP @PLACE(90,-33) => @ORIENT("R0");
// #RSIP @TEXT("RSIP",key="name",size=1.3,halign="start") => @PLACE(93,-30);
// #RSIP @TEXT("r=50",key="value",size=0.9,halign="start") => @PLACE(93,-37);
// #RSIP @TEXT("",key="model");
// #RSRN @SET-SYMBOL $RESISTOR;
// #RSRN @PLACE(90,-66) => @ORIENT("R0");
// #RSRN @TEXT("RSRN",key="name",size=1.3,halign="start") => @PLACE(93,-63);
// #RSRN @TEXT("r=50",key="value",size=0.9,halign="start") => @PLACE(93,-70);
// #RSRN @TEXT("",key="model");
// #RSRP @SET-SYMBOL $RESISTOR;
// #RSRP @PLACE(90,-99) => @ORIENT("R0");
// #RSRP @TEXT("RSRP",key="name",size=1.3,halign="start") => @PLACE(93,-96);
// #RSRP @TEXT("r=50",key="value",size=0.9,halign="start") => @PLACE(93,-103);
// #RSRP @TEXT("",key="model");
// #CSRN @SET-SYMBOL $CAPACITOR;
// #CSRN @PLACE(90,-132) => @ORIENT("R0");
// #CSRN @TEXT("CSRN",key="name",size=1.3,halign="start") => @PLACE(93,-129);
// #CSRN @TEXT("c=4p",key="value",size=0.9,halign="start") => @PLACE(93,-136);
// #CSRN @TEXT("",key="model");
// #CSRP @SET-SYMBOL $CAPACITOR;
// #CSRP @PLACE(90,-165) => @ORIENT("R0");
// #CSRP @TEXT("CSRP",key="name",size=1.3,halign="start") => @PLACE(93,-162);
// #CSRP @TEXT("c=4p",key="value",size=0.9,halign="start") => @PLACE(93,-169);
// #CSRP @TEXT("",key="model");
// #CSL0 @SET-SYMBOL $CAPACITOR;
// #CSL0 @PLACE(90,-198) => @ORIENT("R0");
// #CSL0 @TEXT("CSL0",key="name",size=1.3,halign="start") => @PLACE(93,-195);
// #CSL0 @TEXT("c=5f",key="value",size=0.9,halign="start") => @PLACE(93,-202);
// #CSL0 @TEXT("",key="model");
// #CSL1 @SET-SYMBOL $CAPACITOR;
// #CSL1 @PLACE(90,-231) => @ORIENT("R0");
// #CSL1 @TEXT("CSL1",key="name",size=1.3,halign="start") => @PLACE(93,-228);
// #CSL1 @TEXT("c=5f",key="value",size=0.9,halign="start") => @PLACE(93,-235);
// #CSL1 @TEXT("",key="model");
// #CSL2 @SET-SYMBOL $CAPACITOR;
// #CSL2 @PLACE(90,-264) => @ORIENT("R0");
// #CSL2 @TEXT("CSL2",key="name",size=1.3,halign="start") => @PLACE(93,-261);
// #CSL2 @TEXT("c=5f",key="value",size=0.9,halign="start") => @PLACE(93,-268);
// #CSL2 @TEXT("",key="model");
// #CSL3 @SET-SYMBOL $CAPACITOR;
// #CSL3 @PLACE(90,-297) => @ORIENT("R0");
// #CSL3 @TEXT("CSL3",key="name",size=1.3,halign="start") => @PLACE(93,-294);
// #CSL3 @TEXT("c=5f",key="value",size=0.9,halign="start") => @PLACE(93,-301);
// #CSL3 @TEXT("",key="model");
// #CSL4 @SET-SYMBOL $CAPACITOR;
// #CSL4 @PLACE(90,-330) => @ORIENT("R0");
// #CSL4 @TEXT("CSL4",key="name",size=1.3,halign="start") => @PLACE(93,-327);
// #CSL4 @TEXT("c=5f",key="value",size=0.9,halign="start") => @PLACE(93,-334);
// #CSL4 @TEXT("",key="model");
// #CSL5 @SET-SYMBOL $CAPACITOR;
// #CSL5 @PLACE(90,-363) => @ORIENT("R0");
// #CSL5 @TEXT("CSL5",key="name",size=1.3,halign="start") => @PLACE(93,-360);
// #CSL5 @TEXT("c=5f",key="value",size=0.9,halign="start") => @PLACE(93,-367);
// #CSL5 @TEXT("",key="model");
// #CSL6 @SET-SYMBOL $CAPACITOR;
// #CSL6 @PLACE(145,0) => @ORIENT("R0");
// #CSL6 @TEXT("CSL6",key="name",size=1.3,halign="start") => @PLACE(148,3);
// #CSL6 @TEXT("c=5f",key="value",size=0.9,halign="start") => @PLACE(148,-4);
// #CSL6 @TEXT("",key="model");
// #CSL7 @SET-SYMBOL $CAPACITOR;
// #CSL7 @PLACE(145,-33) => @ORIENT("R0");
// #CSL7 @TEXT("CSL7",key="name",size=1.3,halign="start") => @PLACE(148,-30);
// #CSL7 @TEXT("c=5f",key="value",size=0.9,halign="start") => @PLACE(148,-37);
// #CSL7 @TEXT("",key="model");
// #RFIN @SET-SYMBOL $RESISTOR;
// #RFIN @PLACE(145,-66) => @ORIENT("R0");
// #RFIN @TEXT("RFIN",key="name",size=1.3,halign="start") => @PLACE(148,-63);
// #RFIN @TEXT("r=50",key="value",size=0.9,halign="start") => @PLACE(148,-70);
// #RFIN @TEXT("",key="model");
// #RFIP @SET-SYMBOL $RESISTOR;
// #RFIP @PLACE(145,-99) => @ORIENT("R0");
// #RFIP @TEXT("RFIP",key="name",size=1.3,halign="start") => @PLACE(148,-96);
// #RFIP @TEXT("r=50",key="value",size=0.9,halign="start") => @PLACE(148,-103);
// #RFIP @TEXT("",key="model");
// #RFRN @SET-SYMBOL $RESISTOR;
// #RFRN @PLACE(145,-132) => @ORIENT("R0");
// #RFRN @TEXT("RFRN",key="name",size=1.3,halign="start") => @PLACE(148,-129);
// #RFRN @TEXT("r=50",key="value",size=0.9,halign="start") => @PLACE(148,-136);
// #RFRN @TEXT("",key="model");
// #RFRP @SET-SYMBOL $RESISTOR;
// #RFRP @PLACE(145,-165) => @ORIENT("R0");
// #RFRP @TEXT("RFRP",key="name",size=1.3,halign="start") => @PLACE(148,-162);
// #RFRP @TEXT("r=50",key="value",size=0.9,halign="start") => @PLACE(148,-169);
// #RFRP @TEXT("",key="model");
// #CFRN @SET-SYMBOL $CAPACITOR;
// #CFRN @PLACE(145,-198) => @ORIENT("R0");
// #CFRN @TEXT("CFRN",key="name",size=1.3,halign="start") => @PLACE(148,-195);
// #CFRN @TEXT("c=4p",key="value",size=0.9,halign="start") => @PLACE(148,-202);
// #CFRN @TEXT("",key="model");
// #CFRP @SET-SYMBOL $CAPACITOR;
// #CFRP @PLACE(145,-231) => @ORIENT("R0");
// #CFRP @TEXT("CFRP",key="name",size=1.3,halign="start") => @PLACE(148,-228);
// #CFRP @TEXT("c=4p",key="value",size=0.9,halign="start") => @PLACE(148,-235);
// #CFRP @TEXT("",key="model");
// #CFL0 @SET-SYMBOL $CAPACITOR;
// #CFL0 @PLACE(145,-264) => @ORIENT("R0");
// #CFL0 @TEXT("CFL0",key="name",size=1.3,halign="start") => @PLACE(148,-261);
// #CFL0 @TEXT("c=5f",key="value",size=0.9,halign="start") => @PLACE(148,-268);
// #CFL0 @TEXT("",key="model");
// #CFL1 @SET-SYMBOL $CAPACITOR;
// #CFL1 @PLACE(145,-297) => @ORIENT("R0");
// #CFL1 @TEXT("CFL1",key="name",size=1.3,halign="start") => @PLACE(148,-294);
// #CFL1 @TEXT("c=5f",key="value",size=0.9,halign="start") => @PLACE(148,-301);
// #CFL1 @TEXT("",key="model");
// #CFL2 @SET-SYMBOL $CAPACITOR;
// #CFL2 @PLACE(145,-330) => @ORIENT("R0");
// #CFL2 @TEXT("CFL2",key="name",size=1.3,halign="start") => @PLACE(148,-327);
// #CFL2 @TEXT("c=5f",key="value",size=0.9,halign="start") => @PLACE(148,-334);
// #CFL2 @TEXT("",key="model");
// #CFL3 @SET-SYMBOL $CAPACITOR;
// #CFL3 @PLACE(145,-363) => @ORIENT("R0");
// #CFL3 @TEXT("CFL3",key="name",size=1.3,halign="start") => @PLACE(148,-360);
// #CFL3 @TEXT("c=5f",key="value",size=0.9,halign="start") => @PLACE(148,-367);
// #CFL3 @TEXT("",key="model");
// #CFL4 @SET-SYMBOL $CAPACITOR;
// #CFL4 @PLACE(200,0) => @ORIENT("R0");
// #CFL4 @TEXT("CFL4",key="name",size=1.3,halign="start") => @PLACE(203,3);
// #CFL4 @TEXT("c=5f",key="value",size=0.9,halign="start") => @PLACE(203,-4);
// #CFL4 @TEXT("",key="model");
// #CFL5 @SET-SYMBOL $CAPACITOR;
// #CFL5 @PLACE(200,-33) => @ORIENT("R0");
// #CFL5 @TEXT("CFL5",key="name",size=1.3,halign="start") => @PLACE(203,-30);
// #CFL5 @TEXT("c=5f",key="value",size=0.9,halign="start") => @PLACE(203,-37);
// #CFL5 @TEXT("",key="model");
// #CFL6 @SET-SYMBOL $CAPACITOR;
// #CFL6 @PLACE(200,-66) => @ORIENT("R0");
// #CFL6 @TEXT("CFL6",key="name",size=1.3,halign="start") => @PLACE(203,-63);
// #CFL6 @TEXT("c=5f",key="value",size=0.9,halign="start") => @PLACE(203,-70);
// #CFL6 @TEXT("",key="model");
// #CFL7 @SET-SYMBOL $CAPACITOR;
// #CFL7 @PLACE(200,-99) => @ORIENT("R0");
// #CFL7 @TEXT("CFL7",key="name",size=1.3,halign="start") => @PLACE(203,-96);
// #CFL7 @TEXT("c=5f",key="value",size=0.9,halign="start") => @PLACE(203,-103);
// #CFL7 @TEXT("",key="model");
// &"s_n" @WIRE(mode="straight",linecolor="#30485d",linewidth=0.16) {#XSAR:11 (38.5,3.3) (38.5,-2) #RSIN:2};
// &"s_p" @WIRE(mode="straight",linecolor="#30485d",linewidth=0.16) {#XSAR:12 (38.5,0) (38.5,-35) #RSIP:2};
// (-89,30) @TEXT("tb_sar / source-derived connections",size=1.4,halign="start",textcolor="#223d52");
// &"s_clock" @WIRE(mode="straight",linecolor="#30485d",linewidth=0.16) {#VSCLOCK:1 (-70,5)};
// (-70,5.4) @TEXT("s_clock",size=1.1,halign="middle",valign="bottom");
// &"0" @WIRE(mode="straight",linecolor="#30485d",linewidth=0.16) {#VSCLOCK:2 (-70,-5)};
// (-70,-5.4) @TEXT("0",size=1.1,halign="middle",valign="top");
// &"s_ps" @WIRE(mode="straight",linecolor="#30485d",linewidth=0.16) {#VSs_ps:1 (-70,-28)};
// (-70,-27.6) @TEXT("s_ps",size=1.1,halign="middle",valign="bottom");
// &"0" @WIRE(mode="straight",linecolor="#30485d",linewidth=0.16) {#VSs_ps:2 (-70,-38)};
// (-70,-38.4) @TEXT("0",size=1.1,halign="middle",valign="top");
// &"s_ns" @WIRE(mode="straight",linecolor="#30485d",linewidth=0.16) {#VSs_ns:1 (-70,-61)};
// (-70,-60.6) @TEXT("s_ns",size=1.1,halign="middle",valign="bottom");
// &"0" @WIRE(mode="straight",linecolor="#30485d",linewidth=0.16) {#VSs_ns:2 (-70,-71)};
// (-70,-71.4) @TEXT("0",size=1.1,halign="middle",valign="top");
// {&"s_d0" &"s_d1" &"s_d2" &"s_d3" &"s_d4" &"s_d5" &"s_d6" &"s_d7"} @WIRE(mode="straight",linewidth=0.3) {#XSAR:1 (16,0)};
// (16.4,0) @TEXT("s_d[7:0]",size=1.1,halign="start",valign="middle");
// &"s_clock" @WIRE(mode="straight",linecolor="#30485d",linewidth=0.16) {#XSAR:9 (-16,6.6)};
// (-16.4,6.6) @TEXT("s_clock",size=1.1,halign="end",valign="middle");
// &"VDD!" @WIRE(mode="straight",linecolor="#30485d",linewidth=0.16) {#XSAR:10 (0,14.9)};
// (0,15.3) @TEXT("VDD!",size=1.1,halign="middle",valign="bottom");
// &"s_rn" @WIRE(mode="straight",linecolor="#30485d",linewidth=0.16) {#XSAR:13 (-16,-3.3)};
// (-16.4,-3.3) @TEXT("s_rn",size=1.1,halign="end",valign="middle");
// &"s_rp" @WIRE(mode="straight",linecolor="#30485d",linewidth=0.16) {#XSAR:14 (-16,-6.6)};
// (-16.4,-6.6) @TEXT("s_rp",size=1.1,halign="end",valign="middle");
// &"0" @WIRE(mode="straight",linecolor="#30485d",linewidth=0.16) {#XSAR:15 (0,-14.9)};
// (0,-15.3) @TEXT("0",size=1.1,halign="middle",valign="top");
// &"s_ns" @WIRE(mode="straight",linecolor="#30485d",linewidth=0.16) {#RSIN:1 (90,5)};
// (90,5.4) @TEXT("s_ns",size=1.1,halign="middle",valign="bottom");
// &"s_ps" @WIRE(mode="straight",linecolor="#30485d",linewidth=0.16) {#RSIP:1 (90,-28)};
// (90,-27.6) @TEXT("s_ps",size=1.1,halign="middle",valign="bottom");
// &"s_rns" @WIRE(mode="straight",linecolor="#30485d",linewidth=0.16) {#VSRN:1 (-70,-94)};
// (-70,-93.6) @TEXT("s_rns",size=1.1,halign="middle",valign="bottom");
// &"0" @WIRE(mode="straight",linecolor="#30485d",linewidth=0.16) {#VSRN:2 (-70,-104)};
// (-70,-104.4) @TEXT("0",size=1.1,halign="middle",valign="top");
// &"s_rps" @WIRE(mode="straight",linecolor="#30485d",linewidth=0.16) {#VSRP:1 (-70,-127)};
// (-70,-126.6) @TEXT("s_rps",size=1.1,halign="middle",valign="bottom");
// &"0" @WIRE(mode="straight",linecolor="#30485d",linewidth=0.16) {#VSRP:2 (-70,-137)};
// (-70,-137.4) @TEXT("0",size=1.1,halign="middle",valign="top");
// &"s_rns" @WIRE(mode="straight",linecolor="#30485d",linewidth=0.16) {#RSRN:1 (90,-61)};
// (90,-60.6) @TEXT("s_rns",size=1.1,halign="middle",valign="bottom");
// &"s_rn" @WIRE(mode="straight",linecolor="#30485d",linewidth=0.16) {#RSRN:2 (90,-71)};
// (90,-71.4) @TEXT("s_rn",size=1.1,halign="middle",valign="top");
// &"s_rps" @WIRE(mode="straight",linecolor="#30485d",linewidth=0.16) {#RSRP:1 (90,-94)};
// (90,-93.6) @TEXT("s_rps",size=1.1,halign="middle",valign="bottom");
// &"s_rp" @WIRE(mode="straight",linecolor="#30485d",linewidth=0.16) {#RSRP:2 (90,-104)};
// (90,-104.4) @TEXT("s_rp",size=1.1,halign="middle",valign="top");
// &"s_rn" @WIRE(mode="straight",linecolor="#30485d",linewidth=0.16) {#CSRN:1 (90,-127)};
// (90,-126.6) @TEXT("s_rn",size=1.1,halign="middle",valign="bottom");
// &"0" @WIRE(mode="straight",linecolor="#30485d",linewidth=0.16) {#CSRN:2 (90,-137)};
// (90,-137.4) @TEXT("0",size=1.1,halign="middle",valign="top");
// &"s_rp" @WIRE(mode="straight",linecolor="#30485d",linewidth=0.16) {#CSRP:1 (90,-160)};
// (90,-159.6) @TEXT("s_rp",size=1.1,halign="middle",valign="bottom");
// &"0" @WIRE(mode="straight",linecolor="#30485d",linewidth=0.16) {#CSRP:2 (90,-170)};
// (90,-170.4) @TEXT("0",size=1.1,halign="middle",valign="top");
// {&"s_d0" &"s_d1" &"s_d2" &"s_d3" &"s_d4" &"s_d5" &"s_d6" &"s_d7"} @WIRE(mode="straight",linewidth=0.3) {#XSPROBE:1 (16,-33)};
// (16.4,-33) @TEXT("s_d[7:0]",size=1.1,halign="start",valign="middle");
// &"s_clock" @WIRE(mode="straight",linecolor="#30485d",linewidth=0.16) {#XSPROBE:9 (-16,-33)};
// (-16.4,-33) @TEXT("s_clock",size=1.1,halign="end",valign="middle");
// &"VDD!" @WIRE(mode="straight",linecolor="#30485d",linewidth=0.16) {#XSPROBE:10 (0,-22)};
// (0,-21.6) @TEXT("VDD!",size=1.1,halign="middle",valign="bottom");
// &"0" @WIRE(mode="straight",linecolor="#30485d",linewidth=0.16) {#XSPROBE:11 (0,-44)};
// (0,-44.4) @TEXT("0",size=1.1,halign="middle",valign="top");
// &"s_d0" @WIRE(mode="straight",linecolor="#30485d",linewidth=0.16) {#CSL0:1 (90,-193)};
// (90,-192.6) @TEXT("s_d0",size=1.1,halign="middle",valign="bottom");
// &"0" @WIRE(mode="straight",linecolor="#30485d",linewidth=0.16) {#CSL0:2 (90,-203)};
// (90,-203.4) @TEXT("0",size=1.1,halign="middle",valign="top");
// &"s_d1" @WIRE(mode="straight",linecolor="#30485d",linewidth=0.16) {#CSL1:1 (90,-226)};
// (90,-225.6) @TEXT("s_d1",size=1.1,halign="middle",valign="bottom");
// &"0" @WIRE(mode="straight",linecolor="#30485d",linewidth=0.16) {#CSL1:2 (90,-236)};
// (90,-236.4) @TEXT("0",size=1.1,halign="middle",valign="top");
// &"s_d2" @WIRE(mode="straight",linecolor="#30485d",linewidth=0.16) {#CSL2:1 (90,-259)};
// (90,-258.6) @TEXT("s_d2",size=1.1,halign="middle",valign="bottom");
// &"0" @WIRE(mode="straight",linecolor="#30485d",linewidth=0.16) {#CSL2:2 (90,-269)};
// (90,-269.4) @TEXT("0",size=1.1,halign="middle",valign="top");
// &"s_d3" @WIRE(mode="straight",linecolor="#30485d",linewidth=0.16) {#CSL3:1 (90,-292)};
// (90,-291.6) @TEXT("s_d3",size=1.1,halign="middle",valign="bottom");
// &"0" @WIRE(mode="straight",linecolor="#30485d",linewidth=0.16) {#CSL3:2 (90,-302)};
// (90,-302.4) @TEXT("0",size=1.1,halign="middle",valign="top");
// &"s_d4" @WIRE(mode="straight",linecolor="#30485d",linewidth=0.16) {#CSL4:1 (90,-325)};
// (90,-324.6) @TEXT("s_d4",size=1.1,halign="middle",valign="bottom");
// &"0" @WIRE(mode="straight",linecolor="#30485d",linewidth=0.16) {#CSL4:2 (90,-335)};
// (90,-335.4) @TEXT("0",size=1.1,halign="middle",valign="top");
// &"s_d5" @WIRE(mode="straight",linecolor="#30485d",linewidth=0.16) {#CSL5:1 (90,-358)};
// (90,-357.6) @TEXT("s_d5",size=1.1,halign="middle",valign="bottom");
// &"0" @WIRE(mode="straight",linecolor="#30485d",linewidth=0.16) {#CSL5:2 (90,-368)};
// (90,-368.4) @TEXT("0",size=1.1,halign="middle",valign="top");
// &"s_d6" @WIRE(mode="straight",linecolor="#30485d",linewidth=0.16) {#CSL6:1 (145,5)};
// (145,5.4) @TEXT("s_d6",size=1.1,halign="middle",valign="bottom");
// &"0" @WIRE(mode="straight",linecolor="#30485d",linewidth=0.16) {#CSL6:2 (145,-5)};
// (145,-5.4) @TEXT("0",size=1.1,halign="middle",valign="top");
// &"s_d7" @WIRE(mode="straight",linecolor="#30485d",linewidth=0.16) {#CSL7:1 (145,-28)};
// (145,-27.6) @TEXT("s_d7",size=1.1,halign="middle",valign="bottom");
// &"0" @WIRE(mode="straight",linecolor="#30485d",linewidth=0.16) {#CSL7:2 (145,-38)};
// (145,-38.4) @TEXT("0",size=1.1,halign="middle",valign="top");
// {&"f_d0" &"f_d1" &"f_d2" &"f_d3" &"f_d4" &"f_d5" &"f_d6" &"f_d7"} @WIRE(mode="straight",linewidth=0.3) {#XSTALLED:1 (16,-66)};
// (16.4,-66) @TEXT("f_d[7:0]",size=1.1,halign="start",valign="middle");
// &"s_clock" @WIRE(mode="straight",linecolor="#30485d",linewidth=0.16) {#XSTALLED:9 (-16,-59.4)};
// (-16.4,-59.4) @TEXT("s_clock",size=1.1,halign="end",valign="middle");
// &"VDD!" @WIRE(mode="straight",linecolor="#30485d",linewidth=0.16) {#XSTALLED:10 (0,-51.1)};
// (0,-50.7) @TEXT("VDD!",size=1.1,halign="middle",valign="bottom");
// &"f_n" @WIRE(mode="straight",linecolor="#30485d",linewidth=0.16) {#XSTALLED:11 (-16,-62.7)};
// (-16.4,-62.7) @TEXT("f_n",size=1.1,halign="end",valign="middle");
// &"f_p" @WIRE(mode="straight",linecolor="#30485d",linewidth=0.16) {#XSTALLED:12 (-16,-66)};
// (-16.4,-66) @TEXT("f_p",size=1.1,halign="end",valign="middle");
// &"f_rn" @WIRE(mode="straight",linecolor="#30485d",linewidth=0.16) {#XSTALLED:13 (-16,-69.3)};
// (-16.4,-69.3) @TEXT("f_rn",size=1.1,halign="end",valign="middle");
// &"f_rp" @WIRE(mode="straight",linecolor="#30485d",linewidth=0.16) {#XSTALLED:14 (-16,-72.6)};
// (-16.4,-72.6) @TEXT("f_rp",size=1.1,halign="end",valign="middle");
// &"0" @WIRE(mode="straight",linecolor="#30485d",linewidth=0.16) {#XSTALLED:15 (0,-80.9)};
// (0,-81.3) @TEXT("0",size=1.1,halign="middle",valign="top");
// &"s_ns" @WIRE(mode="straight",linecolor="#30485d",linewidth=0.16) {#RFIN:1 (145,-61)};
// (145,-60.6) @TEXT("s_ns",size=1.1,halign="middle",valign="bottom");
// &"f_n" @WIRE(mode="straight",linecolor="#30485d",linewidth=0.16) {#RFIN:2 (145,-71)};
// (145,-71.4) @TEXT("f_n",size=1.1,halign="middle",valign="top");
// &"s_ps" @WIRE(mode="straight",linecolor="#30485d",linewidth=0.16) {#RFIP:1 (145,-94)};
// (145,-93.6) @TEXT("s_ps",size=1.1,halign="middle",valign="bottom");
// &"f_p" @WIRE(mode="straight",linecolor="#30485d",linewidth=0.16) {#RFIP:2 (145,-104)};
// (145,-104.4) @TEXT("f_p",size=1.1,halign="middle",valign="top");
// &"f_rns" @WIRE(mode="straight",linecolor="#30485d",linewidth=0.16) {#VFRN:1 (-70,-160)};
// (-70,-159.6) @TEXT("f_rns",size=1.1,halign="middle",valign="bottom");
// &"0" @WIRE(mode="straight",linecolor="#30485d",linewidth=0.16) {#VFRN:2 (-70,-170)};
// (-70,-170.4) @TEXT("0",size=1.1,halign="middle",valign="top");
// &"f_rps" @WIRE(mode="straight",linecolor="#30485d",linewidth=0.16) {#VFRP:1 (-70,-193)};
// (-70,-192.6) @TEXT("f_rps",size=1.1,halign="middle",valign="bottom");
// &"0" @WIRE(mode="straight",linecolor="#30485d",linewidth=0.16) {#VFRP:2 (-70,-203)};
// (-70,-203.4) @TEXT("0",size=1.1,halign="middle",valign="top");
// &"f_rns" @WIRE(mode="straight",linecolor="#30485d",linewidth=0.16) {#RFRN:1 (145,-127)};
// (145,-126.6) @TEXT("f_rns",size=1.1,halign="middle",valign="bottom");
// &"f_rn" @WIRE(mode="straight",linecolor="#30485d",linewidth=0.16) {#RFRN:2 (145,-137)};
// (145,-137.4) @TEXT("f_rn",size=1.1,halign="middle",valign="top");
// &"f_rps" @WIRE(mode="straight",linecolor="#30485d",linewidth=0.16) {#RFRP:1 (145,-160)};
// (145,-159.6) @TEXT("f_rps",size=1.1,halign="middle",valign="bottom");
// &"f_rp" @WIRE(mode="straight",linecolor="#30485d",linewidth=0.16) {#RFRP:2 (145,-170)};
// (145,-170.4) @TEXT("f_rp",size=1.1,halign="middle",valign="top");
// &"f_rn" @WIRE(mode="straight",linecolor="#30485d",linewidth=0.16) {#CFRN:1 (145,-193)};
// (145,-192.6) @TEXT("f_rn",size=1.1,halign="middle",valign="bottom");
// &"0" @WIRE(mode="straight",linecolor="#30485d",linewidth=0.16) {#CFRN:2 (145,-203)};
// (145,-203.4) @TEXT("0",size=1.1,halign="middle",valign="top");
// &"f_rp" @WIRE(mode="straight",linecolor="#30485d",linewidth=0.16) {#CFRP:1 (145,-226)};
// (145,-225.6) @TEXT("f_rp",size=1.1,halign="middle",valign="bottom");
// &"0" @WIRE(mode="straight",linecolor="#30485d",linewidth=0.16) {#CFRP:2 (145,-236)};
// (145,-236.4) @TEXT("0",size=1.1,halign="middle",valign="top");
// &"f_d0" @WIRE(mode="straight",linecolor="#30485d",linewidth=0.16) {#CFL0:1 (145,-259)};
// (145,-258.6) @TEXT("f_d0",size=1.1,halign="middle",valign="bottom");
// &"0" @WIRE(mode="straight",linecolor="#30485d",linewidth=0.16) {#CFL0:2 (145,-269)};
// (145,-269.4) @TEXT("0",size=1.1,halign="middle",valign="top");
// &"f_d1" @WIRE(mode="straight",linecolor="#30485d",linewidth=0.16) {#CFL1:1 (145,-292)};
// (145,-291.6) @TEXT("f_d1",size=1.1,halign="middle",valign="bottom");
// &"0" @WIRE(mode="straight",linecolor="#30485d",linewidth=0.16) {#CFL1:2 (145,-302)};
// (145,-302.4) @TEXT("0",size=1.1,halign="middle",valign="top");
// &"f_d2" @WIRE(mode="straight",linecolor="#30485d",linewidth=0.16) {#CFL2:1 (145,-325)};
// (145,-324.6) @TEXT("f_d2",size=1.1,halign="middle",valign="bottom");
// &"0" @WIRE(mode="straight",linecolor="#30485d",linewidth=0.16) {#CFL2:2 (145,-335)};
// (145,-335.4) @TEXT("0",size=1.1,halign="middle",valign="top");
// &"f_d3" @WIRE(mode="straight",linecolor="#30485d",linewidth=0.16) {#CFL3:1 (145,-358)};
// (145,-357.6) @TEXT("f_d3",size=1.1,halign="middle",valign="bottom");
// &"0" @WIRE(mode="straight",linecolor="#30485d",linewidth=0.16) {#CFL3:2 (145,-368)};
// (145,-368.4) @TEXT("0",size=1.1,halign="middle",valign="top");
// &"f_d4" @WIRE(mode="straight",linecolor="#30485d",linewidth=0.16) {#CFL4:1 (200,5)};
// (200,5.4) @TEXT("f_d4",size=1.1,halign="middle",valign="bottom");
// &"0" @WIRE(mode="straight",linecolor="#30485d",linewidth=0.16) {#CFL4:2 (200,-5)};
// (200,-5.4) @TEXT("0",size=1.1,halign="middle",valign="top");
// &"f_d5" @WIRE(mode="straight",linecolor="#30485d",linewidth=0.16) {#CFL5:1 (200,-28)};
// (200,-27.6) @TEXT("f_d5",size=1.1,halign="middle",valign="bottom");
// &"0" @WIRE(mode="straight",linecolor="#30485d",linewidth=0.16) {#CFL5:2 (200,-38)};
// (200,-38.4) @TEXT("0",size=1.1,halign="middle",valign="top");
// &"f_d6" @WIRE(mode="straight",linecolor="#30485d",linewidth=0.16) {#CFL6:1 (200,-61)};
// (200,-60.6) @TEXT("f_d6",size=1.1,halign="middle",valign="bottom");
// &"0" @WIRE(mode="straight",linecolor="#30485d",linewidth=0.16) {#CFL6:2 (200,-71)};
// (200,-71.4) @TEXT("0",size=1.1,halign="middle",valign="top");
// &"f_d7" @WIRE(mode="straight",linecolor="#30485d",linewidth=0.16) {#CFL7:1 (200,-94)};
// (200,-93.6) @TEXT("f_d7",size=1.1,halign="middle",valign="bottom");
// &"0" @WIRE(mode="straight",linecolor="#30485d",linewidth=0.16) {#CFL7:2 (200,-104)};
// (200,-104.4) @TEXT("0",size=1.1,halign="middle",valign="top");
// }
// END SARADC RNL
ends tb_sar

subckt tb_timing
// Every exported delay/edge helper, loaded by a native standard-cell input.
VTCLOCK (t_clock 0) vsource type=pulse val0=0 val1=0.9 delay=60n rise=100p fall=100p width=39.9n period=100n
XT0 (t_clock VDD! 0 t_out0) sar8p_delay_valid
XTL0 (t_out0 VDD! 0 t_unused0) sar8p_inv
XT1 (t_clock VDD! 0 t_out1) sar8p_delay_write
XTL1 (t_out1 VDD! 0 t_unused1) sar8p_inv
XT2 (t_clock VDD! 0 t_out2) sar8p_delay_quiet
XTL2 (t_out2 VDD! 0 t_unused2) sar8p_inv
XT3 (t_clock VDD! 0 t_out3) sar8p_delay_capture
XTL3 (t_out3 VDD! 0 t_unused3) sar8p_inv
XT4 (t_clock VDD! 0 t_out4) sar8p_delay_bbm
XTL4 (t_out4 VDD! 0 t_unused4) sar8p_inv
XT5 (t_clock VDD! 0 t_out5) sar8r_delay
XTL5 (t_out5 VDD! 0 t_unused5) sar8p_inv
XT6 (t_clock VDD! 0 t_out6) sar8s_step
XTL6 (t_out6 VDD! 0 t_unused6) sar8p_inv
XT7 (t_clock VDD! 0 t_out7) sar8i_guard
XTL7 (t_out7 VDD! 0 t_unused7) sar8p_inv
XT8 (t_clock VDD! 0 t_out8) sar8r_edge
XTL8 (t_out8 VDD! 0 t_unused8) sar8p_inv
XT9 (t_clock VDD! 0 t_out9) sar8p_clkbuf
XTL9 (t_out9 VDD! 0 t_unused9) sar8p_inv

// BEGIN SARADC RNL
// @RNL(author="saradc topology") {
// #VTCLOCK @SET-SYMBOL $VOLTAGE_SOURCE;
// #VTCLOCK @PLACE(-70,0) => @ORIENT("R0");
// #VTCLOCK @TEXT("VTCLOCK",key="name",size=1.3,halign="start") => @PLACE(-67,3);
// #VTCLOCK @TEXT("",key="value",size=0.9,halign="start") => @PLACE(-67,-4);
// #VTCLOCK @TEXT("",key="model");
// #XT0 @SET-SYMBOL $S_sar8p_delay_valid;
// #XT0 @PLACE(0,0) => @ORIENT("R0");
// #XTL0 @SET-SYMBOL $S_sar8p_inv;
// #XTL0 @PLACE(0,-33) => @ORIENT("R0");
// #XT1 @SET-SYMBOL $S_sar8p_delay_write;
// #XT1 @PLACE(0,-66) => @ORIENT("R0");
// #XTL1 @SET-SYMBOL $S_sar8p_inv;
// #XTL1 @PLACE(0,-99) => @ORIENT("R0");
// #XT2 @SET-SYMBOL $S_sar8p_delay_quiet;
// #XT2 @PLACE(0,-132) => @ORIENT("R0");
// #XTL2 @SET-SYMBOL $S_sar8p_inv;
// #XTL2 @PLACE(0,-165) => @ORIENT("R0");
// #XT3 @SET-SYMBOL $S_sar8p_delay_capture;
// #XT3 @PLACE(0,-198) => @ORIENT("R0");
// #XTL3 @SET-SYMBOL $S_sar8p_inv;
// #XTL3 @PLACE(0,-231) => @ORIENT("R0");
// #XT4 @SET-SYMBOL $S_sar8p_delay_bbm;
// #XT4 @PLACE(0,-264) => @ORIENT("R0");
// #XTL4 @SET-SYMBOL $S_sar8p_inv;
// #XTL4 @PLACE(0,-297) => @ORIENT("R0");
// #XT5 @SET-SYMBOL $S_sar8r_delay;
// #XT5 @PLACE(0,-330) => @ORIENT("R0");
// #XTL5 @SET-SYMBOL $S_sar8p_inv;
// #XTL5 @PLACE(0,-363) => @ORIENT("R0");
// #XT6 @SET-SYMBOL $S_sar8s_step;
// #XT6 @PLACE(55,0) => @ORIENT("R0");
// #XTL6 @SET-SYMBOL $S_sar8p_inv;
// #XTL6 @PLACE(55,-33) => @ORIENT("R0");
// #XT7 @SET-SYMBOL $S_sar8i_guard;
// #XT7 @PLACE(55,-66) => @ORIENT("R0");
// #XTL7 @SET-SYMBOL $S_sar8p_inv;
// #XTL7 @PLACE(55,-99) => @ORIENT("R0");
// #XT8 @SET-SYMBOL $S_sar8r_edge;
// #XT8 @PLACE(55,-132) => @ORIENT("R0");
// #XTL8 @SET-SYMBOL $S_sar8p_inv;
// #XTL8 @PLACE(55,-165) => @ORIENT("R0");
// #XT9 @SET-SYMBOL $S_sar8p_clkbuf;
// #XT9 @PLACE(55,-198) => @ORIENT("R0");
// #XTL9 @SET-SYMBOL $S_sar8p_inv;
// #XTL9 @PLACE(55,-231) => @ORIENT("R0");
// &"t_out0" @WIRE(mode="straight",linecolor="#30485d",linewidth=0.16) {#XT0:4 (3,0) (3,-33) #XTL0:1};
// &"t_out1" @WIRE(mode="straight",linecolor="#30485d",linewidth=0.16) {#XT1:4 (3,-66) (3,-99) #XTL1:1};
// &"t_out2" @WIRE(mode="straight",linecolor="#30485d",linewidth=0.16) {#XT2:4 (3,-132) (3,-165) #XTL2:1};
// &"t_out3" @WIRE(mode="straight",linecolor="#30485d",linewidth=0.16) {#XT3:4 (3,-198) (3,-231) #XTL3:1};
// &"t_out4" @WIRE(mode="straight",linecolor="#30485d",linewidth=0.16) {#XT4:4 (3,-264) (3,-297) #XTL4:1};
// &"t_out5" @WIRE(mode="straight",linecolor="#30485d",linewidth=0.16) {#XT5:4 (3,-330) (3,-363) #XTL5:1};
// &"t_out6" @WIRE(mode="straight",linecolor="#30485d",linewidth=0.16) {#XT6:4 (58,0) (58,-33) #XTL6:1};
// &"t_out7" @WIRE(mode="straight",linecolor="#30485d",linewidth=0.16) {#XT7:4 (58,-66) (58,-99) #XTL7:1};
// &"t_out8" @WIRE(mode="straight",linecolor="#30485d",linewidth=0.16) {#XT8:4 (58,-132) (58,-165) #XTL8:1};
// &"t_out9" @WIRE(mode="straight",linecolor="#30485d",linewidth=0.16) {#XT9:4 (55,-198) (55,-231) #XTL9:1};
// (-89,30) @TEXT("tb_timing / source-derived connections",size=1.4,halign="start",textcolor="#223d52");
// &"t_clock" @WIRE(mode="straight",linecolor="#30485d",linewidth=0.16) {#VTCLOCK:1 (-70,5)};
// (-70,5.4) @TEXT("t_clock",size=1.1,halign="middle",valign="bottom");
// &"0" @WIRE(mode="straight",linecolor="#30485d",linewidth=0.16) {#VTCLOCK:2 (-70,-5)};
// (-70,-5.4) @TEXT("0",size=1.1,halign="middle",valign="top");
// &"t_clock" @WIRE(mode="straight",linecolor="#30485d",linewidth=0.16) {#XT0:1 (-16,0)};
// (-16.4,0) @TEXT("t_clock",size=1.1,halign="end",valign="middle");
// &"VDD!" @WIRE(mode="straight",linecolor="#30485d",linewidth=0.16) {#XT0:2 (0,11)};
// (0,11.4) @TEXT("VDD!",size=1.1,halign="middle",valign="bottom");
// &"0" @WIRE(mode="straight",linecolor="#30485d",linewidth=0.16) {#XT0:3 (0,-11)};
// (0,-11.4) @TEXT("0",size=1.1,halign="middle",valign="top");
// &"VDD!" @WIRE(mode="straight",linecolor="#30485d",linewidth=0.16) {#XTL0:2 (0,-23)};
// (0,-22.6) @TEXT("VDD!",size=1.1,halign="middle",valign="bottom");
// &"0" @WIRE(mode="straight",linecolor="#30485d",linewidth=0.16) {#XTL0:3 (0,-43)};
// (0,-43.4) @TEXT("0",size=1.1,halign="middle",valign="top");
// &"t_unused0" @WIRE(mode="straight",linecolor="#30485d",linewidth=0.16) {#XTL0:4 (10,-33)};
// (10.4,-33) @TEXT("t_unused0",size=1.1,halign="start",valign="middle");
// &"t_clock" @WIRE(mode="straight",linecolor="#30485d",linewidth=0.16) {#XT1:1 (-16,-66)};
// (-16.4,-66) @TEXT("t_clock",size=1.1,halign="end",valign="middle");
// &"VDD!" @WIRE(mode="straight",linecolor="#30485d",linewidth=0.16) {#XT1:2 (0,-55)};
// (0,-54.6) @TEXT("VDD!",size=1.1,halign="middle",valign="bottom");
// &"0" @WIRE(mode="straight",linecolor="#30485d",linewidth=0.16) {#XT1:3 (0,-77)};
// (0,-77.4) @TEXT("0",size=1.1,halign="middle",valign="top");
// &"VDD!" @WIRE(mode="straight",linecolor="#30485d",linewidth=0.16) {#XTL1:2 (0,-89)};
// (0,-88.6) @TEXT("VDD!",size=1.1,halign="middle",valign="bottom");
// &"0" @WIRE(mode="straight",linecolor="#30485d",linewidth=0.16) {#XTL1:3 (0,-109)};
// (0,-109.4) @TEXT("0",size=1.1,halign="middle",valign="top");
// &"t_unused1" @WIRE(mode="straight",linecolor="#30485d",linewidth=0.16) {#XTL1:4 (10,-99)};
// (10.4,-99) @TEXT("t_unused1",size=1.1,halign="start",valign="middle");
// &"t_clock" @WIRE(mode="straight",linecolor="#30485d",linewidth=0.16) {#XT2:1 (-16,-132)};
// (-16.4,-132) @TEXT("t_clock",size=1.1,halign="end",valign="middle");
// &"VDD!" @WIRE(mode="straight",linecolor="#30485d",linewidth=0.16) {#XT2:2 (0,-121)};
// (0,-120.6) @TEXT("VDD!",size=1.1,halign="middle",valign="bottom");
// &"0" @WIRE(mode="straight",linecolor="#30485d",linewidth=0.16) {#XT2:3 (0,-143)};
// (0,-143.4) @TEXT("0",size=1.1,halign="middle",valign="top");
// &"VDD!" @WIRE(mode="straight",linecolor="#30485d",linewidth=0.16) {#XTL2:2 (0,-155)};
// (0,-154.6) @TEXT("VDD!",size=1.1,halign="middle",valign="bottom");
// &"0" @WIRE(mode="straight",linecolor="#30485d",linewidth=0.16) {#XTL2:3 (0,-175)};
// (0,-175.4) @TEXT("0",size=1.1,halign="middle",valign="top");
// &"t_unused2" @WIRE(mode="straight",linecolor="#30485d",linewidth=0.16) {#XTL2:4 (10,-165)};
// (10.4,-165) @TEXT("t_unused2",size=1.1,halign="start",valign="middle");
// &"t_clock" @WIRE(mode="straight",linecolor="#30485d",linewidth=0.16) {#XT3:1 (-16,-198)};
// (-16.4,-198) @TEXT("t_clock",size=1.1,halign="end",valign="middle");
// &"VDD!" @WIRE(mode="straight",linecolor="#30485d",linewidth=0.16) {#XT3:2 (0,-187)};
// (0,-186.6) @TEXT("VDD!",size=1.1,halign="middle",valign="bottom");
// &"0" @WIRE(mode="straight",linecolor="#30485d",linewidth=0.16) {#XT3:3 (0,-209)};
// (0,-209.4) @TEXT("0",size=1.1,halign="middle",valign="top");
// &"VDD!" @WIRE(mode="straight",linecolor="#30485d",linewidth=0.16) {#XTL3:2 (0,-221)};
// (0,-220.6) @TEXT("VDD!",size=1.1,halign="middle",valign="bottom");
// &"0" @WIRE(mode="straight",linecolor="#30485d",linewidth=0.16) {#XTL3:3 (0,-241)};
// (0,-241.4) @TEXT("0",size=1.1,halign="middle",valign="top");
// &"t_unused3" @WIRE(mode="straight",linecolor="#30485d",linewidth=0.16) {#XTL3:4 (10,-231)};
// (10.4,-231) @TEXT("t_unused3",size=1.1,halign="start",valign="middle");
// &"t_clock" @WIRE(mode="straight",linecolor="#30485d",linewidth=0.16) {#XT4:1 (-16,-264)};
// (-16.4,-264) @TEXT("t_clock",size=1.1,halign="end",valign="middle");
// &"VDD!" @WIRE(mode="straight",linecolor="#30485d",linewidth=0.16) {#XT4:2 (0,-253)};
// (0,-252.6) @TEXT("VDD!",size=1.1,halign="middle",valign="bottom");
// &"0" @WIRE(mode="straight",linecolor="#30485d",linewidth=0.16) {#XT4:3 (0,-275)};
// (0,-275.4) @TEXT("0",size=1.1,halign="middle",valign="top");
// &"VDD!" @WIRE(mode="straight",linecolor="#30485d",linewidth=0.16) {#XTL4:2 (0,-287)};
// (0,-286.6) @TEXT("VDD!",size=1.1,halign="middle",valign="bottom");
// &"0" @WIRE(mode="straight",linecolor="#30485d",linewidth=0.16) {#XTL4:3 (0,-307)};
// (0,-307.4) @TEXT("0",size=1.1,halign="middle",valign="top");
// &"t_unused4" @WIRE(mode="straight",linecolor="#30485d",linewidth=0.16) {#XTL4:4 (10,-297)};
// (10.4,-297) @TEXT("t_unused4",size=1.1,halign="start",valign="middle");
// &"t_clock" @WIRE(mode="straight",linecolor="#30485d",linewidth=0.16) {#XT5:1 (-16,-330)};
// (-16.4,-330) @TEXT("t_clock",size=1.1,halign="end",valign="middle");
// &"VDD!" @WIRE(mode="straight",linecolor="#30485d",linewidth=0.16) {#XT5:2 (0,-319)};
// (0,-318.6) @TEXT("VDD!",size=1.1,halign="middle",valign="bottom");
// &"0" @WIRE(mode="straight",linecolor="#30485d",linewidth=0.16) {#XT5:3 (0,-341)};
// (0,-341.4) @TEXT("0",size=1.1,halign="middle",valign="top");
// &"VDD!" @WIRE(mode="straight",linecolor="#30485d",linewidth=0.16) {#XTL5:2 (0,-353)};
// (0,-352.6) @TEXT("VDD!",size=1.1,halign="middle",valign="bottom");
// &"0" @WIRE(mode="straight",linecolor="#30485d",linewidth=0.16) {#XTL5:3 (0,-373)};
// (0,-373.4) @TEXT("0",size=1.1,halign="middle",valign="top");
// &"t_unused5" @WIRE(mode="straight",linecolor="#30485d",linewidth=0.16) {#XTL5:4 (10,-363)};
// (10.4,-363) @TEXT("t_unused5",size=1.1,halign="start",valign="middle");
// &"t_clock" @WIRE(mode="straight",linecolor="#30485d",linewidth=0.16) {#XT6:1 (39,0)};
// (38.6,0) @TEXT("t_clock",size=1.1,halign="end",valign="middle");
// &"VDD!" @WIRE(mode="straight",linecolor="#30485d",linewidth=0.16) {#XT6:2 (55,11)};
// (55,11.4) @TEXT("VDD!",size=1.1,halign="middle",valign="bottom");
// &"0" @WIRE(mode="straight",linecolor="#30485d",linewidth=0.16) {#XT6:3 (55,-11)};
// (55,-11.4) @TEXT("0",size=1.1,halign="middle",valign="top");
// &"VDD!" @WIRE(mode="straight",linecolor="#30485d",linewidth=0.16) {#XTL6:2 (55,-23)};
// (55,-22.6) @TEXT("VDD!",size=1.1,halign="middle",valign="bottom");
// &"0" @WIRE(mode="straight",linecolor="#30485d",linewidth=0.16) {#XTL6:3 (55,-43)};
// (55,-43.4) @TEXT("0",size=1.1,halign="middle",valign="top");
// &"t_unused6" @WIRE(mode="straight",linecolor="#30485d",linewidth=0.16) {#XTL6:4 (65,-33)};
// (65.4,-33) @TEXT("t_unused6",size=1.1,halign="start",valign="middle");
// &"t_clock" @WIRE(mode="straight",linecolor="#30485d",linewidth=0.16) {#XT7:1 (39,-66)};
// (38.6,-66) @TEXT("t_clock",size=1.1,halign="end",valign="middle");
// &"VDD!" @WIRE(mode="straight",linecolor="#30485d",linewidth=0.16) {#XT7:2 (55,-55)};
// (55,-54.6) @TEXT("VDD!",size=1.1,halign="middle",valign="bottom");
// &"0" @WIRE(mode="straight",linecolor="#30485d",linewidth=0.16) {#XT7:3 (55,-77)};
// (55,-77.4) @TEXT("0",size=1.1,halign="middle",valign="top");
// &"VDD!" @WIRE(mode="straight",linecolor="#30485d",linewidth=0.16) {#XTL7:2 (55,-89)};
// (55,-88.6) @TEXT("VDD!",size=1.1,halign="middle",valign="bottom");
// &"0" @WIRE(mode="straight",linecolor="#30485d",linewidth=0.16) {#XTL7:3 (55,-109)};
// (55,-109.4) @TEXT("0",size=1.1,halign="middle",valign="top");
// &"t_unused7" @WIRE(mode="straight",linecolor="#30485d",linewidth=0.16) {#XTL7:4 (65,-99)};
// (65.4,-99) @TEXT("t_unused7",size=1.1,halign="start",valign="middle");
// &"t_clock" @WIRE(mode="straight",linecolor="#30485d",linewidth=0.16) {#XT8:1 (39,-132)};
// (38.6,-132) @TEXT("t_clock",size=1.1,halign="end",valign="middle");
// &"VDD!" @WIRE(mode="straight",linecolor="#30485d",linewidth=0.16) {#XT8:2 (55,-121)};
// (55,-120.6) @TEXT("VDD!",size=1.1,halign="middle",valign="bottom");
// &"0" @WIRE(mode="straight",linecolor="#30485d",linewidth=0.16) {#XT8:3 (55,-143)};
// (55,-143.4) @TEXT("0",size=1.1,halign="middle",valign="top");
// &"VDD!" @WIRE(mode="straight",linecolor="#30485d",linewidth=0.16) {#XTL8:2 (55,-155)};
// (55,-154.6) @TEXT("VDD!",size=1.1,halign="middle",valign="bottom");
// &"0" @WIRE(mode="straight",linecolor="#30485d",linewidth=0.16) {#XTL8:3 (55,-175)};
// (55,-175.4) @TEXT("0",size=1.1,halign="middle",valign="top");
// &"t_unused8" @WIRE(mode="straight",linecolor="#30485d",linewidth=0.16) {#XTL8:4 (65,-165)};
// (65.4,-165) @TEXT("t_unused8",size=1.1,halign="start",valign="middle");
// &"t_clock" @WIRE(mode="straight",linecolor="#30485d",linewidth=0.16) {#XT9:1 (45,-198)};
// (44.6,-198) @TEXT("t_clock",size=1.1,halign="end",valign="middle");
// &"VDD!" @WIRE(mode="straight",linecolor="#30485d",linewidth=0.16) {#XT9:2 (55,-188)};
// (55,-187.6) @TEXT("VDD!",size=1.1,halign="middle",valign="bottom");
// &"0" @WIRE(mode="straight",linecolor="#30485d",linewidth=0.16) {#XT9:3 (55,-208)};
// (55,-208.4) @TEXT("0",size=1.1,halign="middle",valign="top");
// &"VDD!" @WIRE(mode="straight",linecolor="#30485d",linewidth=0.16) {#XTL9:2 (55,-221)};
// (55,-220.6) @TEXT("VDD!",size=1.1,halign="middle",valign="bottom");
// &"0" @WIRE(mode="straight",linecolor="#30485d",linewidth=0.16) {#XTL9:3 (55,-241)};
// (55,-241.4) @TEXT("0",size=1.1,halign="middle",valign="top");
// &"t_unused9" @WIRE(mode="straight",linecolor="#30485d",linewidth=0.16) {#XTL9:4 (65,-231)};
// (65.4,-231) @TEXT("t_unused9",size=1.1,halign="start",valign="middle");
// }
// END SARADC RNL
ends tb_timing

subckt tb_sar_top D0 D1 D2 D3 D4 D5 D6 D7 SAMPLE VDD! VINN VINP  VREFN VREFP 0
    XSEQ (SAMPLE_MATCH VDD! 0 SEQ_SAMPLE) sar8r_edge
    XIDLE (ACTIVE SAMPLE_INT VDD! 0 PRESET SAMPLE_MATCH) b_idle
    XSAMPLE (SAMPLE VDD! 0 SAMPLE_INT) sar8p_clkbuf
    XBOOTN (SEQ_SAMPLE TOPN VINN) b_sampler_bridge
    XBOOTP (SEQ_SAMPLE TOPP VINP) b_sampler_bridge
    XCDAC (GNN0 GNN1 GNN2 GNN3 GNN4 GNN5 GNN6 GNN7 GNP0 GNP1 GNP2 GNP3  GNP4 GNP5 GNP6 GNP7 GPN0 GPN1 GPN2 GPN3 GPN4 GPN5 GPN6 GPN7 GPP0  GPP1 GPP2 GPP3 GPP4 GPP5 GPP6 GPP7 TOPN TOPP VDD! VREFN VREFP 0)  b_cdac
    XCTRL (CMP_CLK CODE0 CODE1 CODE2 CODE3 CODE4 CODE5 CODE6 CODE7 COMP_N  COMP_P D0 D1 D2 D3 D4 D5 D6 D7 PHI_U SAMPLE_INT VDD! 0 ACTIVE)  sar8i_ctrl
    XREF (CODE0 CODE1 CODE2 CODE3 CODE4 CODE5 CODE6 CODE7 D0 D1 D2 D3 D4  D5 D6 D7 GNN0 GNN1 GNN2 GNN3 GNN4 GNN5 GNN6 GNN7 GNP0 GNP1 GNP2  GNP3 GNP4 GNP5 GNP6 GNP7 GPN0 GPN1 GPN2 GPN3 GPN4 GPN5 GPN6 GPN7  GPP0 GPP1 GPP2 GPP3 GPP4 GPP5 GPP6 GPP7 PHI_U SAMPLE_INT VDD! 0 RST_DONE PRESET)  b_reference
    XCOMP (CMP_CLK COMP_N COMP_P VDD! TOPN TOPP 0) b_comparator
    CL_COMP_N (COMP_N 0) cfmom_2t nr=8 lr=2.5u w=50n s=50n stm=1 spm=3  multi=2 mismatchflag=1
    CL_COMP_P (COMP_P 0) cfmom_2t nr=8 lr=2.5u w=50n s=50n stm=1 spm=3  multi=2 mismatchflag=1
    CL_CMP_CLK (CMP_CLK 0) cfmom_2t nr=8 lr=2.5u w=50n s=50n stm=1 spm=3  multi=2 mismatchflag=1
// BEGIN SARADC RNL
// @RNL(author="saradc topology") {
// (-24,105) @TEXT("SAR8 / current transistor hierarchy",size=2,halign="start",textcolor="#223d52");
// (-24,97) @TEXT("VIN pair -> Bootstrap -> MOM CDAC -> StrongARM -> asynchronous SAR",size=1.15,halign="start",textcolor="#223d52");
// #XSAMPLE @SET-SYMBOL $S_sar8p_clkbuf;
// #XSAMPLE @PLACE(0,67) => @ORIENT("R0");
// #XIDLE @SET-SYMBOL $S_sar8i_idle;
// #XIDLE @PLACE(65,67) => @ORIENT("R0");
// #XSEQ @SET-SYMBOL $S_sar8r_edge;
// #XSEQ @PLACE(130,67) => @ORIENT("R0");
// #XBOOTN @SET-SYMBOL $S_sar_bootstrap_flat_8b_p;
// #XBOOTN @PLACE(0,12) => @ORIENT("R0");
// #XBOOTP @SET-SYMBOL $S_sar_bootstrap_flat_8b_p;
// #XBOOTP @PLACE(0,-25) => @ORIENT("R0");
// #XCDAC @SET-SYMBOL $S_sar8j_r1_cdac;
// #XCDAC @PLACE(72,-7) => @ORIENT("R0");
// #XCOMP @SET-SYMBOL $S_sar_strongarm_t28;
// #XCOMP @PLACE(137,-7) => @ORIENT("R0");
// #XCTRL @SET-SYMBOL $S_sar8i_ctrl;
// #XCTRL @PLACE(204,-7) => @ORIENT("R0");
// #XREF @SET-SYMBOL $S_sar8i_refword;
// #XREF @PLACE(72,-91) => @ORIENT("R0");
// #CL_COMP_N @SET-SYMBOL $CAPACITOR;
// #CL_COMP_N @PLACE(168,-45) => @ORIENT("R0");
// #CL_COMP_N @TEXT("CL_COMP_N",key="name",size=1.3,halign="start") => @PLACE(171,-42);
// #CL_COMP_N @TEXT("nr=8 lr=2.5u w=50n multi=2",key="value",size=0.9,halign="start") => @PLACE(171,-49);
// #CL_COMP_N @TEXT("",key="model");
// #CL_COMP_P @SET-SYMBOL $CAPACITOR;
// #CL_COMP_P @PLACE(184,-45) => @ORIENT("R0");
// #CL_COMP_P @TEXT("CL_COMP_P",key="name",size=1.3,halign="start") => @PLACE(187,-42);
// #CL_COMP_P @TEXT("nr=8 lr=2.5u w=50n multi=2",key="value",size=0.9,halign="start") => @PLACE(187,-49);
// #CL_COMP_P @TEXT("",key="model");
// #CL_CMP_CLK @SET-SYMBOL $CAPACITOR;
// #CL_CMP_CLK @PLACE(222,-45) => @ORIENT("R0");
// #CL_CMP_CLK @TEXT("CL_CMP_CLK",key="name",size=1.3,halign="start") => @PLACE(225,-42);
// #CL_CMP_CLK @TEXT("nr=8 lr=2.5u w=50n multi=2",key="value",size=0.9,halign="start") => @PLACE(225,-49);
// #CL_CMP_CLK @TEXT("",key="model");
// (-12,81) @TEXT("Sample buffer",size=2.4,halign="start",textcolor="#223d52");
// (53,82) @TEXT("Idle / preset",size=2.4,halign="start",textcolor="#223d52");
// (118,82) @TEXT("Sample edge",size=2.4,halign="start",textcolor="#223d52");
// (-12,27) @TEXT("Bootstrap -",size=2.4,halign="start",textcolor="#223d52");
// (-12,-10) @TEXT("Bootstrap +",size=2.4,halign="start",textcolor="#223d52");
// (60,13.55) @TEXT("MOM CDAC",size=2.4,halign="start",textcolor="#223d52");
// (125,8.6) @TEXT("StrongARM",size=2.4,halign="start",textcolor="#223d52");
// (192,11.9) @TEXT("Async SAR",size=2.4,halign="start",textcolor="#223d52");
// (60,-70.45) @TEXT("Reference word",size=2.4,halign="start",textcolor="#223d52");
// &"SAMPLE_INT" @WIRE(mode="straight",linecolor="#30485d",linewidth=0.16) {#XSAMPLE:4 (29.5,67) (29.5,65.35) #XIDLE:2};
// &"SAMPLE_MATCH" @WIRE(mode="straight",linecolor="#30485d",linewidth=0.16) {#XIDLE:6 (97.5,65.35) (97.5,67) #XSEQ:1};
// &"SEQ_SAMPLE" @WIRE(mode="straight",linecolor="#94601a",linewidth=0.16) {(-25,-23.35) (-25,13.65) (-25,67)};
// &"SEQ_SAMPLE" @WIRE(mode="straight",linecolor="#94601a",linewidth=0.16) {#XSEQ:4 (-25,67)};
// $JUNCTION @ATTACH (-25,67);
// &"SEQ_SAMPLE" @WIRE(mode="straight",linecolor="#94601a",linewidth=0.16) {#XBOOTN:1 (-25,13.65)};
// $JUNCTION @ATTACH (-25,13.65);
// &"SEQ_SAMPLE" @WIRE(mode="straight",linecolor="#94601a",linewidth=0.16) {#XBOOTP:1 (-25,-23.35)};
// $JUNCTION @ATTACH (-25,-23.35);
// &"TOPN" @WIRE(mode="straight",linecolor="#30485d",linewidth=0.16) {#XBOOTN:2 (32,12) (32,24) (98,24) (98,-5.35) #XCDAC:33};
// &"TOPP" @WIRE(mode="straight",linecolor="#30485d",linewidth=0.16) {#XBOOTP:2 (36,-25) (36,-31) (101,-31) (101,-8.65) #XCDAC:34};
// &"TOPN" @WIRE(mode="straight",linecolor="#30485d",linewidth=0.16) {#XCDAC:33 (104.5,-5.35) (104.5,-7) #XCOMP:5};
// &"TOPP" @WIRE(mode="straight",linecolor="#30485d",linewidth=0.16) {#XCDAC:34 (104.5,-8.65) (104.5,-10.3) #XCOMP:6};
// &"COMP_N" @WIRE(mode="straight",linecolor="#30485d",linewidth=0.16) {(168,-43) (168,-5.35) (168,-3.7)};
// &"COMP_N" @WIRE(mode="straight",linecolor="#30485d",linewidth=0.16) {#XCOMP:2 (168,-5.35)};
// $JUNCTION @ATTACH (168,-5.35);
// &"COMP_N" @WIRE(mode="straight",linecolor="#30485d",linewidth=0.16) {#XCTRL:10 (168,-3.7)};
// $JUNCTION @ATTACH (168,-3.7);
// &"COMP_N" @WIRE(mode="straight",linecolor="#30485d",linewidth=0.16) {#CL_COMP_N:1 (168,-43)};
// $JUNCTION @ATTACH (168,-43);
// &"COMP_P" @WIRE(mode="straight",linecolor="#30485d",linewidth=0.16) {(184,-43) (184,-8.65) (184,-7)};
// &"COMP_P" @WIRE(mode="straight",linecolor="#30485d",linewidth=0.16) {#XCOMP:3 (184,-8.65)};
// $JUNCTION @ATTACH (184,-8.65);
// &"COMP_P" @WIRE(mode="straight",linecolor="#30485d",linewidth=0.16) {#XCTRL:11 (184,-7)};
// $JUNCTION @ATTACH (184,-7);
// &"COMP_P" @WIRE(mode="straight",linecolor="#30485d",linewidth=0.16) {#CL_COMP_P:1 (184,-43)};
// $JUNCTION @ATTACH (184,-43);
// &"CMP_CLK" @WIRE(mode="straight",linecolor="#94601a",linewidth=0.16) {(124,34) (217,34) (222,34)};
// &"CMP_CLK" @WIRE(mode="straight",linecolor="#94601a",linewidth=0.16) {#XCTRL:1 (217,34)};
// $JUNCTION @ATTACH (217,34);
// &"CMP_CLK" @WIRE(mode="straight",linecolor="#94601a",linewidth=0.16) {#XCOMP:1 (124,34)};
// $JUNCTION @ATTACH (124,34);
// &"CMP_CLK" @WIRE(mode="straight",linecolor="#94601a",linewidth=0.16) {#CL_CMP_CLK:1 (222,34)};
// $JUNCTION @ATTACH (222,34);
// {&"GNN0" &"GNN1" &"GNN2" &"GNN3" &"GNN4" &"GNN5" &"GNN6" &"GNN7"} @WIRE(mode="straight",linewidth=0.3) {#XREF:17 (111,-82.75) (111,-60) (41,-60) (41,1.25) #XCDAC:1};
// {&"GNP0" &"GNP1" &"GNP2" &"GNP3" &"GNP4" &"GNP5" &"GNP6" &"GNP7"} @WIRE(mode="straight",linewidth=0.3) {#XREF:25 (115,-86.05) (115,-64) (37,-64) (37,-2.05) #XCDAC:9};
// {&"GPN0" &"GPN1" &"GPN2" &"GPN3" &"GPN4" &"GPN5" &"GPN6" &"GPN7"} @WIRE(mode="straight",linewidth=0.3) {#XREF:33 (119,-89.35) (119,-68) (33,-68) (33,-5.35) #XCDAC:17};
// {&"GPP0" &"GPP1" &"GPP2" &"GPP3" &"GPP4" &"GPP5" &"GPP6" &"GPP7"} @WIRE(mode="straight",linewidth=0.3) {#XREF:41 (123,-92.65) (123,-72) (29,-72) (29,-8.65) #XCDAC:25};
// {&"CODE0" &"CODE1" &"CODE2" &"CODE3" &"CODE4" &"CODE5" &"CODE6" &"CODE7"} @WIRE(mode="straight",linewidth=0.3) {#XCTRL:2 (244,-3.7) (244,-132) (43,-132) (43,-86.05) #XREF:1};
// {&"D0" &"D1" &"D2" &"D3" &"D4" &"D5" &"D6" &"D7"} @WIRE(mode="straight",linewidth=0.3) {#XCTRL:12 (248,-7) (248,-136) (39,-136) (39,-89.35) #XREF:9};
// (155,-128) @TEXT("CODE[7:0] / D[7:0] feedback",size=0.95,halign="start",textcolor="#223d52");
// (-24,-145) @TEXT("All three physical comparator/clock MOM loads are shown. VDD! / 0 are global rails.",size=0.95,halign="start",textcolor="#223d52");
// &"VDD!" @WIRE(mode="straight",linecolor="#30485d",linewidth=0.16) {#XSEQ:2 (130,78)};
// (130,78.4) @TEXT("VDD!",size=1.1,halign="middle",valign="bottom");
// &"0" @WIRE(mode="straight",linecolor="#30485d",linewidth=0.16) {#XSEQ:3 (130,56)};
// (130,55.6) @TEXT("0",size=1.1,halign="middle",valign="top");
// &"ACTIVE" @WIRE(mode="straight",linecolor="#30485d",linewidth=0.16) {#XIDLE:1 (49,68.65)};
// (48.6,68.65) @TEXT("ACTIVE",size=1.1,halign="end",valign="middle");
// &"VDD!" @WIRE(mode="straight",linecolor="#30485d",linewidth=0.16) {#XIDLE:3 (65,78)};
// (65,78.4) @TEXT("VDD!",size=1.1,halign="middle",valign="bottom");
// &"0" @WIRE(mode="straight",linecolor="#30485d",linewidth=0.16) {#XIDLE:4 (65,56)};
// (65,55.6) @TEXT("0",size=1.1,halign="middle",valign="top");
// &"PRESET" @WIRE(mode="straight",linecolor="#30485d",linewidth=0.16) {#XIDLE:5 (81,68.65)};
// (81.4,68.65) @TEXT("PRESET",size=1.1,halign="start",valign="middle");
// &"SAMPLE" @WIRE(mode="straight",linecolor="#30485d",linewidth=0.16) {#XSAMPLE:1 (-10,67)};
// (-10.4,67) @TEXT("SAMPLE",size=1.1,halign="end",valign="middle");
// &"VDD!" @WIRE(mode="straight",linecolor="#30485d",linewidth=0.16) {#XSAMPLE:2 (0,77)};
// (0,77.4) @TEXT("VDD!",size=1.1,halign="middle",valign="bottom");
// &"0" @WIRE(mode="straight",linecolor="#30485d",linewidth=0.16) {#XSAMPLE:3 (0,57)};
// (0,56.6) @TEXT("0",size=1.1,halign="middle",valign="top");
// &"VINN" @WIRE(mode="straight",linecolor="#30485d",linewidth=0.16) {#XBOOTN:3 (-16,10.35)};
// (-16.4,10.35) @TEXT("VINN",size=1.1,halign="end",valign="middle");
// &"VINP" @WIRE(mode="straight",linecolor="#30485d",linewidth=0.16) {#XBOOTP:3 (-16,-26.65)};
// (-16.4,-26.65) @TEXT("VINP",size=1.1,halign="end",valign="middle");
// &"VDD!" @WIRE(mode="straight",linecolor="#30485d",linewidth=0.16) {#XCDAC:35 (72,9.55)};
// (72,9.95) @TEXT("VDD!",size=1.1,halign="middle",valign="bottom");
// &"VREFN" @WIRE(mode="straight",linecolor="#30485d",linewidth=0.16) {#XCDAC:36 (56,-11.95)};
// (55.6,-11.95) @TEXT("VREFN",size=1.1,halign="end",valign="middle");
// &"VREFP" @WIRE(mode="straight",linecolor="#30485d",linewidth=0.16) {#XCDAC:37 (56,-15.25)};
// (55.6,-15.25) @TEXT("VREFP",size=1.1,halign="end",valign="middle");
// &"0" @WIRE(mode="straight",linecolor="#30485d",linewidth=0.16) {#XCDAC:38 (72,-23.55)};
// (72,-23.95) @TEXT("0",size=1.1,halign="middle",valign="top");
// &"PHI_U" @WIRE(mode="straight",linecolor="#30485d",linewidth=0.16) {#XCTRL:20 (220,-10.3)};
// (220.4,-10.3) @TEXT("PHI_U",size=1.1,halign="start",valign="middle");
// &"SAMPLE_INT" @WIRE(mode="straight",linecolor="#30485d",linewidth=0.16) {#XCTRL:21 (188,-10.3)};
// (187.6,-10.3) @TEXT("SAMPLE_INT",size=1.1,halign="end",valign="middle");
// &"VDD!" @WIRE(mode="straight",linecolor="#30485d",linewidth=0.16) {#XCTRL:22 (204,7.9)};
// (204,8.3) @TEXT("VDD!",size=1.1,halign="middle",valign="bottom");
// &"0" @WIRE(mode="straight",linecolor="#30485d",linewidth=0.16) {#XCTRL:23 (204,-21.9)};
// (204,-22.3) @TEXT("0",size=1.1,halign="middle",valign="top");
// &"ACTIVE" @WIRE(mode="straight",linecolor="#30485d",linewidth=0.16) {#XCTRL:24 (220,-13.6)};
// (220.4,-13.6) @TEXT("ACTIVE",size=1.1,halign="start",valign="middle");
// &"PHI_U" @WIRE(mode="straight",linecolor="#30485d",linewidth=0.16) {#XREF:49 (56,-92.65)};
// (55.6,-92.65) @TEXT("PHI_U",size=1.1,halign="end",valign="middle");
// &"SAMPLE_INT" @WIRE(mode="straight",linecolor="#30485d",linewidth=0.16) {#XREF:50 (56,-95.95)};
// (55.6,-95.95) @TEXT("SAMPLE_INT",size=1.1,halign="end",valign="middle");
// &"VDD!" @WIRE(mode="straight",linecolor="#30485d",linewidth=0.16) {#XREF:51 (72,-74.45)};
// (72,-74.05) @TEXT("VDD!",size=1.1,halign="middle",valign="bottom");
// &"0" @WIRE(mode="straight",linecolor="#30485d",linewidth=0.16) {#XREF:52 (72,-107.55)};
// (72,-107.95) @TEXT("0",size=1.1,halign="middle",valign="top");
// &"RST_DONE" @WIRE(mode="straight",linecolor="#30485d",linewidth=0.16) {#XREF:53 (88,-95.95)};
// (88.4,-95.95) @TEXT("RST_DONE",size=1.1,halign="start",valign="middle");
// &"PRESET" @WIRE(mode="straight",linecolor="#30485d",linewidth=0.16) {#XREF:54 (88,-99.25)};
// (88.4,-99.25) @TEXT("PRESET",size=1.1,halign="start",valign="middle");
// &"VDD!" @WIRE(mode="straight",linecolor="#30485d",linewidth=0.16) {#XCOMP:4 (137,4.6)};
// (137,5) @TEXT("VDD!",size=1.1,halign="middle",valign="bottom");
// &"0" @WIRE(mode="straight",linecolor="#30485d",linewidth=0.16) {#XCOMP:7 (137,-18.6)};
// (137,-19) @TEXT("0",size=1.1,halign="middle",valign="top");
// &"0" @WIRE(mode="straight",linecolor="#30485d",linewidth=0.16) {#CL_COMP_N:2 (168,-50)};
// (168,-50.4) @TEXT("0",size=1.1,halign="middle",valign="top");
// &"0" @WIRE(mode="straight",linecolor="#30485d",linewidth=0.16) {#CL_COMP_P:2 (184,-50)};
// (184,-50.4) @TEXT("0",size=1.1,halign="middle",valign="top");
// &"0" @WIRE(mode="straight",linecolor="#30485d",linewidth=0.16) {#CL_CMP_CLK:2 (222,-50)};
// (222,-50.4) @TEXT("0",size=1.1,halign="middle",valign="top");
// }
// END SARADC RNL
ends tb_sar_top

subckt tb_sar_stalled_top D0 D1 D2 D3 D4 D5 D6 D7 SAMPLE VDD! VINN VINP  VREFN VREFP 0
    XSEQ (SAMPLE_MATCH VDD! 0 SEQ_SAMPLE) sar8r_edge
    XIDLE (ACTIVE SAMPLE_INT VDD! 0 PRESET SAMPLE_MATCH) b_idle
    XSAMPLE (SAMPLE VDD! 0 SAMPLE_INT) sar8p_clkbuf
    XBOOTN (SEQ_SAMPLE TOPN VINN) b_sampler_bridge
    XBOOTP (SEQ_SAMPLE TOPP VINP) b_sampler_bridge
    XCDAC (GNN0 GNN1 GNN2 GNN3 GNN4 GNN5 GNN6 GNN7 GNP0 GNP1 GNP2 GNP3  GNP4 GNP5 GNP6 GNP7 GPN0 GPN1 GPN2 GPN3 GPN4 GPN5 GPN6 GPN7 GPP0  GPP1 GPP2 GPP3 GPP4 GPP5 GPP6 GPP7 TOPN TOPP VDD! VREFN VREFP 0)  b_cdac
    XCTRL (CMP_CLK CODE0 CODE1 CODE2 CODE3 CODE4 CODE5 CODE6 CODE7 COMP_N  COMP_P D0 D1 D2 D3 D4 D5 D6 D7 PHI_U SAMPLE_INT VDD! 0 ACTIVE)  sar8i_ctrl
    XREF (CODE0 CODE1 CODE2 CODE3 CODE4 CODE5 CODE6 CODE7 D0 D1 D2 D3 D4  D5 D6 D7 GNN0 GNN1 GNN2 GNN3 GNN4 GNN5 GNN6 GNN7 GNP0 GNP1 GNP2  GNP3 GNP4 GNP5 GNP6 GNP7 GPN0 GPN1 GPN2 GPN3 GPN4 GPN5 GPN6 GPN7  GPP0 GPP1 GPP2 GPP3 GPP4 GPP5 GPP6 GPP7 PHI_U SAMPLE_INT VDD! 0 RST_DONE PRESET)  b_reference
    XCOMP (CMP_CLK COMP_N COMP_P VDD! TOPN TOPP 0) b_comparator force_stuck=1
    CL_COMP_N (COMP_N 0) cfmom_2t nr=8 lr=2.5u w=50n s=50n stm=1 spm=3  multi=2 mismatchflag=1
    CL_COMP_P (COMP_P 0) cfmom_2t nr=8 lr=2.5u w=50n s=50n stm=1 spm=3  multi=2 mismatchflag=1
    CL_CMP_CLK (CMP_CLK 0) cfmom_2t nr=8 lr=2.5u w=50n s=50n stm=1 spm=3  multi=2 mismatchflag=1
// BEGIN SARADC RNL
// @RNL(author="saradc topology") {
// (-24,105) @TEXT("SAR8 / current transistor hierarchy",size=2,halign="start",textcolor="#223d52");
// (-24,97) @TEXT("VIN pair -> Bootstrap -> MOM CDAC -> StrongARM -> asynchronous SAR",size=1.15,halign="start",textcolor="#223d52");
// #XSAMPLE @SET-SYMBOL $S_sar8p_clkbuf;
// #XSAMPLE @PLACE(0,67) => @ORIENT("R0");
// #XIDLE @SET-SYMBOL $S_sar8i_idle;
// #XIDLE @PLACE(65,67) => @ORIENT("R0");
// #XSEQ @SET-SYMBOL $S_sar8r_edge;
// #XSEQ @PLACE(130,67) => @ORIENT("R0");
// #XBOOTN @SET-SYMBOL $S_sar_bootstrap_flat_8b_p;
// #XBOOTN @PLACE(0,12) => @ORIENT("R0");
// #XBOOTP @SET-SYMBOL $S_sar_bootstrap_flat_8b_p;
// #XBOOTP @PLACE(0,-25) => @ORIENT("R0");
// #XCDAC @SET-SYMBOL $S_sar8j_r1_cdac;
// #XCDAC @PLACE(72,-7) => @ORIENT("R0");
// #XCOMP @SET-SYMBOL $S_sar_strongarm_t28;
// #XCOMP @PLACE(137,-7) => @ORIENT("R0");
// #XCTRL @SET-SYMBOL $S_sar8i_ctrl;
// #XCTRL @PLACE(204,-7) => @ORIENT("R0");
// #XREF @SET-SYMBOL $S_sar8i_refword;
// #XREF @PLACE(72,-91) => @ORIENT("R0");
// #CL_COMP_N @SET-SYMBOL $CAPACITOR;
// #CL_COMP_N @PLACE(168,-45) => @ORIENT("R0");
// #CL_COMP_N @TEXT("CL_COMP_N",key="name",size=1.3,halign="start") => @PLACE(171,-42);
// #CL_COMP_N @TEXT("nr=8 lr=2.5u w=50n multi=2",key="value",size=0.9,halign="start") => @PLACE(171,-49);
// #CL_COMP_N @TEXT("",key="model");
// #CL_COMP_P @SET-SYMBOL $CAPACITOR;
// #CL_COMP_P @PLACE(184,-45) => @ORIENT("R0");
// #CL_COMP_P @TEXT("CL_COMP_P",key="name",size=1.3,halign="start") => @PLACE(187,-42);
// #CL_COMP_P @TEXT("nr=8 lr=2.5u w=50n multi=2",key="value",size=0.9,halign="start") => @PLACE(187,-49);
// #CL_COMP_P @TEXT("",key="model");
// #CL_CMP_CLK @SET-SYMBOL $CAPACITOR;
// #CL_CMP_CLK @PLACE(222,-45) => @ORIENT("R0");
// #CL_CMP_CLK @TEXT("CL_CMP_CLK",key="name",size=1.3,halign="start") => @PLACE(225,-42);
// #CL_CMP_CLK @TEXT("nr=8 lr=2.5u w=50n multi=2",key="value",size=0.9,halign="start") => @PLACE(225,-49);
// #CL_CMP_CLK @TEXT("",key="model");
// (-12,81) @TEXT("Sample buffer",size=2.4,halign="start",textcolor="#223d52");
// (53,82) @TEXT("Idle / preset",size=2.4,halign="start",textcolor="#223d52");
// (118,82) @TEXT("Sample edge",size=2.4,halign="start",textcolor="#223d52");
// (-12,27) @TEXT("Bootstrap -",size=2.4,halign="start",textcolor="#223d52");
// (-12,-10) @TEXT("Bootstrap +",size=2.4,halign="start",textcolor="#223d52");
// (60,13.55) @TEXT("MOM CDAC",size=2.4,halign="start",textcolor="#223d52");
// (125,8.6) @TEXT("StrongARM",size=2.4,halign="start",textcolor="#223d52");
// (192,11.9) @TEXT("Async SAR",size=2.4,halign="start",textcolor="#223d52");
// (60,-70.45) @TEXT("Reference word",size=2.4,halign="start",textcolor="#223d52");
// &"SAMPLE_INT" @WIRE(mode="straight",linecolor="#30485d",linewidth=0.16) {#XSAMPLE:4 (29.5,67) (29.5,65.35) #XIDLE:2};
// &"SAMPLE_MATCH" @WIRE(mode="straight",linecolor="#30485d",linewidth=0.16) {#XIDLE:6 (97.5,65.35) (97.5,67) #XSEQ:1};
// &"SEQ_SAMPLE" @WIRE(mode="straight",linecolor="#94601a",linewidth=0.16) {(-25,-23.35) (-25,13.65) (-25,67)};
// &"SEQ_SAMPLE" @WIRE(mode="straight",linecolor="#94601a",linewidth=0.16) {#XSEQ:4 (-25,67)};
// $JUNCTION @ATTACH (-25,67);
// &"SEQ_SAMPLE" @WIRE(mode="straight",linecolor="#94601a",linewidth=0.16) {#XBOOTN:1 (-25,13.65)};
// $JUNCTION @ATTACH (-25,13.65);
// &"SEQ_SAMPLE" @WIRE(mode="straight",linecolor="#94601a",linewidth=0.16) {#XBOOTP:1 (-25,-23.35)};
// $JUNCTION @ATTACH (-25,-23.35);
// &"TOPN" @WIRE(mode="straight",linecolor="#30485d",linewidth=0.16) {#XBOOTN:2 (32,12) (32,24) (98,24) (98,-5.35) #XCDAC:33};
// &"TOPP" @WIRE(mode="straight",linecolor="#30485d",linewidth=0.16) {#XBOOTP:2 (36,-25) (36,-31) (101,-31) (101,-8.65) #XCDAC:34};
// &"TOPN" @WIRE(mode="straight",linecolor="#30485d",linewidth=0.16) {#XCDAC:33 (104.5,-5.35) (104.5,-7) #XCOMP:5};
// &"TOPP" @WIRE(mode="straight",linecolor="#30485d",linewidth=0.16) {#XCDAC:34 (104.5,-8.65) (104.5,-10.3) #XCOMP:6};
// &"COMP_N" @WIRE(mode="straight",linecolor="#30485d",linewidth=0.16) {(168,-43) (168,-5.35) (168,-3.7)};
// &"COMP_N" @WIRE(mode="straight",linecolor="#30485d",linewidth=0.16) {#XCOMP:2 (168,-5.35)};
// $JUNCTION @ATTACH (168,-5.35);
// &"COMP_N" @WIRE(mode="straight",linecolor="#30485d",linewidth=0.16) {#XCTRL:10 (168,-3.7)};
// $JUNCTION @ATTACH (168,-3.7);
// &"COMP_N" @WIRE(mode="straight",linecolor="#30485d",linewidth=0.16) {#CL_COMP_N:1 (168,-43)};
// $JUNCTION @ATTACH (168,-43);
// &"COMP_P" @WIRE(mode="straight",linecolor="#30485d",linewidth=0.16) {(184,-43) (184,-8.65) (184,-7)};
// &"COMP_P" @WIRE(mode="straight",linecolor="#30485d",linewidth=0.16) {#XCOMP:3 (184,-8.65)};
// $JUNCTION @ATTACH (184,-8.65);
// &"COMP_P" @WIRE(mode="straight",linecolor="#30485d",linewidth=0.16) {#XCTRL:11 (184,-7)};
// $JUNCTION @ATTACH (184,-7);
// &"COMP_P" @WIRE(mode="straight",linecolor="#30485d",linewidth=0.16) {#CL_COMP_P:1 (184,-43)};
// $JUNCTION @ATTACH (184,-43);
// &"CMP_CLK" @WIRE(mode="straight",linecolor="#94601a",linewidth=0.16) {(124,34) (217,34) (222,34)};
// &"CMP_CLK" @WIRE(mode="straight",linecolor="#94601a",linewidth=0.16) {#XCTRL:1 (217,34)};
// $JUNCTION @ATTACH (217,34);
// &"CMP_CLK" @WIRE(mode="straight",linecolor="#94601a",linewidth=0.16) {#XCOMP:1 (124,34)};
// $JUNCTION @ATTACH (124,34);
// &"CMP_CLK" @WIRE(mode="straight",linecolor="#94601a",linewidth=0.16) {#CL_CMP_CLK:1 (222,34)};
// $JUNCTION @ATTACH (222,34);
// {&"GNN0" &"GNN1" &"GNN2" &"GNN3" &"GNN4" &"GNN5" &"GNN6" &"GNN7"} @WIRE(mode="straight",linewidth=0.3) {#XREF:17 (111,-82.75) (111,-60) (41,-60) (41,1.25) #XCDAC:1};
// {&"GNP0" &"GNP1" &"GNP2" &"GNP3" &"GNP4" &"GNP5" &"GNP6" &"GNP7"} @WIRE(mode="straight",linewidth=0.3) {#XREF:25 (115,-86.05) (115,-64) (37,-64) (37,-2.05) #XCDAC:9};
// {&"GPN0" &"GPN1" &"GPN2" &"GPN3" &"GPN4" &"GPN5" &"GPN6" &"GPN7"} @WIRE(mode="straight",linewidth=0.3) {#XREF:33 (119,-89.35) (119,-68) (33,-68) (33,-5.35) #XCDAC:17};
// {&"GPP0" &"GPP1" &"GPP2" &"GPP3" &"GPP4" &"GPP5" &"GPP6" &"GPP7"} @WIRE(mode="straight",linewidth=0.3) {#XREF:41 (123,-92.65) (123,-72) (29,-72) (29,-8.65) #XCDAC:25};
// {&"CODE0" &"CODE1" &"CODE2" &"CODE3" &"CODE4" &"CODE5" &"CODE6" &"CODE7"} @WIRE(mode="straight",linewidth=0.3) {#XCTRL:2 (244,-3.7) (244,-132) (43,-132) (43,-86.05) #XREF:1};
// {&"D0" &"D1" &"D2" &"D3" &"D4" &"D5" &"D6" &"D7"} @WIRE(mode="straight",linewidth=0.3) {#XCTRL:12 (248,-7) (248,-136) (39,-136) (39,-89.35) #XREF:9};
// (155,-128) @TEXT("CODE[7:0] / D[7:0] feedback",size=0.95,halign="start",textcolor="#223d52");
// (-24,-145) @TEXT("All three physical comparator/clock MOM loads are shown. VDD! / 0 are global rails.",size=0.95,halign="start",textcolor="#223d52");
// &"VDD!" @WIRE(mode="straight",linecolor="#30485d",linewidth=0.16) {#XSEQ:2 (130,78)};
// (130,78.4) @TEXT("VDD!",size=1.1,halign="middle",valign="bottom");
// &"0" @WIRE(mode="straight",linecolor="#30485d",linewidth=0.16) {#XSEQ:3 (130,56)};
// (130,55.6) @TEXT("0",size=1.1,halign="middle",valign="top");
// &"ACTIVE" @WIRE(mode="straight",linecolor="#30485d",linewidth=0.16) {#XIDLE:1 (49,68.65)};
// (48.6,68.65) @TEXT("ACTIVE",size=1.1,halign="end",valign="middle");
// &"VDD!" @WIRE(mode="straight",linecolor="#30485d",linewidth=0.16) {#XIDLE:3 (65,78)};
// (65,78.4) @TEXT("VDD!",size=1.1,halign="middle",valign="bottom");
// &"0" @WIRE(mode="straight",linecolor="#30485d",linewidth=0.16) {#XIDLE:4 (65,56)};
// (65,55.6) @TEXT("0",size=1.1,halign="middle",valign="top");
// &"PRESET" @WIRE(mode="straight",linecolor="#30485d",linewidth=0.16) {#XIDLE:5 (81,68.65)};
// (81.4,68.65) @TEXT("PRESET",size=1.1,halign="start",valign="middle");
// &"SAMPLE" @WIRE(mode="straight",linecolor="#30485d",linewidth=0.16) {#XSAMPLE:1 (-10,67)};
// (-10.4,67) @TEXT("SAMPLE",size=1.1,halign="end",valign="middle");
// &"VDD!" @WIRE(mode="straight",linecolor="#30485d",linewidth=0.16) {#XSAMPLE:2 (0,77)};
// (0,77.4) @TEXT("VDD!",size=1.1,halign="middle",valign="bottom");
// &"0" @WIRE(mode="straight",linecolor="#30485d",linewidth=0.16) {#XSAMPLE:3 (0,57)};
// (0,56.6) @TEXT("0",size=1.1,halign="middle",valign="top");
// &"VINN" @WIRE(mode="straight",linecolor="#30485d",linewidth=0.16) {#XBOOTN:3 (-16,10.35)};
// (-16.4,10.35) @TEXT("VINN",size=1.1,halign="end",valign="middle");
// &"VINP" @WIRE(mode="straight",linecolor="#30485d",linewidth=0.16) {#XBOOTP:3 (-16,-26.65)};
// (-16.4,-26.65) @TEXT("VINP",size=1.1,halign="end",valign="middle");
// &"VDD!" @WIRE(mode="straight",linecolor="#30485d",linewidth=0.16) {#XCDAC:35 (72,9.55)};
// (72,9.95) @TEXT("VDD!",size=1.1,halign="middle",valign="bottom");
// &"VREFN" @WIRE(mode="straight",linecolor="#30485d",linewidth=0.16) {#XCDAC:36 (56,-11.95)};
// (55.6,-11.95) @TEXT("VREFN",size=1.1,halign="end",valign="middle");
// &"VREFP" @WIRE(mode="straight",linecolor="#30485d",linewidth=0.16) {#XCDAC:37 (56,-15.25)};
// (55.6,-15.25) @TEXT("VREFP",size=1.1,halign="end",valign="middle");
// &"0" @WIRE(mode="straight",linecolor="#30485d",linewidth=0.16) {#XCDAC:38 (72,-23.55)};
// (72,-23.95) @TEXT("0",size=1.1,halign="middle",valign="top");
// &"PHI_U" @WIRE(mode="straight",linecolor="#30485d",linewidth=0.16) {#XCTRL:20 (220,-10.3)};
// (220.4,-10.3) @TEXT("PHI_U",size=1.1,halign="start",valign="middle");
// &"SAMPLE_INT" @WIRE(mode="straight",linecolor="#30485d",linewidth=0.16) {#XCTRL:21 (188,-10.3)};
// (187.6,-10.3) @TEXT("SAMPLE_INT",size=1.1,halign="end",valign="middle");
// &"VDD!" @WIRE(mode="straight",linecolor="#30485d",linewidth=0.16) {#XCTRL:22 (204,7.9)};
// (204,8.3) @TEXT("VDD!",size=1.1,halign="middle",valign="bottom");
// &"0" @WIRE(mode="straight",linecolor="#30485d",linewidth=0.16) {#XCTRL:23 (204,-21.9)};
// (204,-22.3) @TEXT("0",size=1.1,halign="middle",valign="top");
// &"ACTIVE" @WIRE(mode="straight",linecolor="#30485d",linewidth=0.16) {#XCTRL:24 (220,-13.6)};
// (220.4,-13.6) @TEXT("ACTIVE",size=1.1,halign="start",valign="middle");
// &"PHI_U" @WIRE(mode="straight",linecolor="#30485d",linewidth=0.16) {#XREF:49 (56,-92.65)};
// (55.6,-92.65) @TEXT("PHI_U",size=1.1,halign="end",valign="middle");
// &"SAMPLE_INT" @WIRE(mode="straight",linecolor="#30485d",linewidth=0.16) {#XREF:50 (56,-95.95)};
// (55.6,-95.95) @TEXT("SAMPLE_INT",size=1.1,halign="end",valign="middle");
// &"VDD!" @WIRE(mode="straight",linecolor="#30485d",linewidth=0.16) {#XREF:51 (72,-74.45)};
// (72,-74.05) @TEXT("VDD!",size=1.1,halign="middle",valign="bottom");
// &"0" @WIRE(mode="straight",linecolor="#30485d",linewidth=0.16) {#XREF:52 (72,-107.55)};
// (72,-107.95) @TEXT("0",size=1.1,halign="middle",valign="top");
// &"RST_DONE" @WIRE(mode="straight",linecolor="#30485d",linewidth=0.16) {#XREF:53 (88,-95.95)};
// (88.4,-95.95) @TEXT("RST_DONE",size=1.1,halign="start",valign="middle");
// &"PRESET" @WIRE(mode="straight",linecolor="#30485d",linewidth=0.16) {#XREF:54 (88,-99.25)};
// (88.4,-99.25) @TEXT("PRESET",size=1.1,halign="start",valign="middle");
// &"VDD!" @WIRE(mode="straight",linecolor="#30485d",linewidth=0.16) {#XCOMP:4 (137,4.6)};
// (137,5) @TEXT("VDD!",size=1.1,halign="middle",valign="bottom");
// &"0" @WIRE(mode="straight",linecolor="#30485d",linewidth=0.16) {#XCOMP:7 (137,-18.6)};
// (137,-19) @TEXT("0",size=1.1,halign="middle",valign="top");
// &"0" @WIRE(mode="straight",linecolor="#30485d",linewidth=0.16) {#CL_COMP_N:2 (168,-50)};
// (168,-50.4) @TEXT("0",size=1.1,halign="middle",valign="top");
// &"0" @WIRE(mode="straight",linecolor="#30485d",linewidth=0.16) {#CL_COMP_P:2 (184,-50)};
// (184,-50.4) @TEXT("0",size=1.1,halign="middle",valign="top");
// &"0" @WIRE(mode="straight",linecolor="#30485d",linewidth=0.16) {#CL_CMP_CLK:2 (222,-50)};
// (222,-50.4) @TEXT("0",size=1.1,halign="middle",valign="top");
// }
// END SARADC RNL
ends tb_sar_stalled_top

subckt INVD1BWP12T30P140 A Y VDD VSS
// BEGIN SARADC RNL
// @RNL(author="saradc topology") {
// (-89,30) @TEXT("INVD1BWP12T30P140 / source-derived connections",size=1.4,halign="start",textcolor="#223d52");
// (-20,5) @TEXT("Interface view only - no transistor body is distributed here.",size=1.2,halign="start",textcolor="#223d52");
// (-20,-2) @TEXT("Ports: A, Y, VDD, VSS",size=0.9,halign="start",textcolor="#223d52");
// }
// END SARADC RNL
ends INVD1BWP12T30P140

subckt INVD2BWP12T30P140 I ZN VDD VSS
// BEGIN SARADC RNL
// @RNL(author="saradc topology") {
// (-89,30) @TEXT("INVD2BWP12T30P140 / source-derived connections",size=1.4,halign="start",textcolor="#223d52");
// (-20,5) @TEXT("Interface view only - no transistor body is distributed here.",size=1.2,halign="start",textcolor="#223d52");
// (-20,-2) @TEXT("Ports: I, ZN, VDD, VSS",size=0.9,halign="start",textcolor="#223d52");
// }
// END SARADC RNL
ends INVD2BWP12T30P140

subckt OR2D1BWP12T30P140 A1 A2 Z VDD VSS
// BEGIN SARADC RNL
// @RNL(author="saradc topology") {
// (-89,30) @TEXT("OR2D1BWP12T30P140 / source-derived connections",size=1.4,halign="start",textcolor="#223d52");
// (-20,5) @TEXT("Interface view only - no transistor body is distributed here.",size=1.2,halign="start",textcolor="#223d52");
// (-20,-2) @TEXT("Ports: A1, A2, Z, VDD, VSS",size=0.9,halign="start",textcolor="#223d52");
// }
// END SARADC RNL
ends OR2D1BWP12T30P140

subckt ND2D1BWP12T30P140 A B Y VDD VSS
// BEGIN SARADC RNL
// @RNL(author="saradc topology") {
// (-89,30) @TEXT("ND2D1BWP12T30P140 / source-derived connections",size=1.4,halign="start",textcolor="#223d52");
// (-20,5) @TEXT("Interface view only - no transistor body is distributed here.",size=1.2,halign="start",textcolor="#223d52");
// (-20,-2) @TEXT("Ports: A, B, Y, VDD, VSS",size=0.9,halign="start",textcolor="#223d52");
// }
// END SARADC RNL
ends ND2D1BWP12T30P140

subckt DFCNQD1BWP12T30P140 D CK RN Q VDD VSS
// BEGIN SARADC RNL
// @RNL(author="saradc topology") {
// (-89,30) @TEXT("DFCNQD1BWP12T30P140 / source-derived connections",size=1.4,halign="start",textcolor="#223d52");
// (-20,5) @TEXT("Interface view only - no transistor body is distributed here.",size=1.2,halign="start",textcolor="#223d52");
// (-20,-2) @TEXT("Ports: D, CK, RN, Q, VDD, VSS",size=0.9,halign="start",textcolor="#223d52");
// }
// END SARADC RNL
ends DFCNQD1BWP12T30P140

subckt iprobe p n
// BEGIN SARADC RNL
// @RNL(author="saradc topology") {
// (-89,30) @TEXT("iprobe / source-derived connections",size=1.4,halign="start",textcolor="#223d52");
// (-20,5) @TEXT("Interface view only - no transistor body is distributed here.",size=1.2,halign="start",textcolor="#223d52");
// (-20,-2) @TEXT("Ports: p, n",size=0.9,halign="start",textcolor="#223d52");
// }
// END SARADC RNL
ends iprobe

subckt DEL025D1BWP12T30P140 I Z VDD VSS
// BEGIN SARADC RNL
// @RNL(author="saradc topology") {
// (-89,30) @TEXT("DEL025D1BWP12T30P140 / source-derived connections",size=1.4,halign="start",textcolor="#223d52");
// (-20,5) @TEXT("Interface view only - no transistor body is distributed here.",size=1.2,halign="start",textcolor="#223d52");
// (-20,-2) @TEXT("Ports: I, Z, VDD, VSS",size=0.9,halign="start",textcolor="#223d52");
// }
// END SARADC RNL
ends DEL025D1BWP12T30P140

subckt DEL050D1BWP12T30P140 I Z VDD VSS
// BEGIN SARADC RNL
// @RNL(author="saradc topology") {
// (-89,30) @TEXT("DEL050D1BWP12T30P140 / source-derived connections",size=1.4,halign="start",textcolor="#223d52");
// (-20,5) @TEXT("Interface view only - no transistor body is distributed here.",size=1.2,halign="start",textcolor="#223d52");
// (-20,-2) @TEXT("Ports: I, Z, VDD, VSS",size=0.9,halign="start",textcolor="#223d52");
// }
// END SARADC RNL
ends DEL050D1BWP12T30P140

subckt DEL075D1BWP12T30P140 I Z VDD VSS
// BEGIN SARADC RNL
// @RNL(author="saradc topology") {
// (-89,30) @TEXT("DEL075D1BWP12T30P140 / source-derived connections",size=1.4,halign="start",textcolor="#223d52");
// (-20,5) @TEXT("Interface view only - no transistor body is distributed here.",size=1.2,halign="start",textcolor="#223d52");
// (-20,-2) @TEXT("Ports: I, Z, VDD, VSS",size=0.9,halign="start",textcolor="#223d52");
// }
// END SARADC RNL
ends DEL075D1BWP12T30P140

subckt DEL100D1BWP12T30P140 I Z VDD VSS
// BEGIN SARADC RNL
// @RNL(author="saradc topology") {
// (-89,30) @TEXT("DEL100D1BWP12T30P140 / source-derived connections",size=1.4,halign="start",textcolor="#223d52");
// (-20,5) @TEXT("Interface view only - no transistor body is distributed here.",size=1.2,halign="start",textcolor="#223d52");
// (-20,-2) @TEXT("Ports: I, Z, VDD, VSS",size=0.9,halign="start",textcolor="#223d52");
// }
// END SARADC RNL
ends DEL100D1BWP12T30P140

subckt DEL150D1BWP12T30P140 I Z VDD VSS
// BEGIN SARADC RNL
// @RNL(author="saradc topology") {
// (-89,30) @TEXT("DEL150D1BWP12T30P140 / source-derived connections",size=1.4,halign="start",textcolor="#223d52");
// (-20,5) @TEXT("Interface view only - no transistor body is distributed here.",size=1.2,halign="start",textcolor="#223d52");
// (-20,-2) @TEXT("Ports: I, Z, VDD, VSS",size=0.9,halign="start",textcolor="#223d52");
// }
// END SARADC RNL
ends DEL150D1BWP12T30P140

subckt DEL200D1BWP12T30P140 I Z VDD VSS
// BEGIN SARADC RNL
// @RNL(author="saradc topology") {
// (-89,30) @TEXT("DEL200D1BWP12T30P140 / source-derived connections",size=1.4,halign="start",textcolor="#223d52");
// (-20,5) @TEXT("Interface view only - no transistor body is distributed here.",size=1.2,halign="start",textcolor="#223d52");
// (-20,-2) @TEXT("Ports: I, Z, VDD, VSS",size=0.9,halign="start",textcolor="#223d52");
// }
// END SARADC RNL
ends DEL200D1BWP12T30P140

subckt DEL250D1BWP12T30P140 I Z VDD VSS
// BEGIN SARADC RNL
// @RNL(author="saradc topology") {
// (-89,30) @TEXT("DEL250D1BWP12T30P140 / source-derived connections",size=1.4,halign="start",textcolor="#223d52");
// (-20,5) @TEXT("Interface view only - no transistor body is distributed here.",size=1.2,halign="start",textcolor="#223d52");
// (-20,-2) @TEXT("Ports: I, Z, VDD, VSS",size=0.9,halign="start",textcolor="#223d52");
// }
// END SARADC RNL
ends DEL250D1BWP12T30P140

subckt b_cdac GNN0 GNN1 GNN2 GNN3 GNN4 GNN5 GNN6 GNN7 GNP0 GNP1 GNP2 GNP3 GNP4 GNP5 GNP6 GNP7 GPN0 GPN1 GPN2 GPN3 GPN4 GPN5 GPN6 GPN7 GPP0 GPP1 GPP2 GPP3 GPP4 GPP5 GPP6 GPP7 TOPN TOPP VDD VREFN VREFP VSS
// BEGIN SARADC RNL
// @RNL(author="saradc topology") {
// (-89,30) @TEXT("b_cdac / source-derived connections",size=1.4,halign="start",textcolor="#223d52");
// (-20,5) @TEXT("Interface view only - no transistor body is distributed here.",size=1.2,halign="start",textcolor="#223d52");
// (-20,-2) @TEXT("Ports: GNN0, GNN1, GNN2, GNN3, GNN4, GNN5, GNN6, GNN7, GNP0, GNP1, GNP2, GNP3, GNP4, GNP5, GNP6, GNP7, GPN0, GPN1, GPN2, GPN3, GPN4, GPN5, GPN6, GPN7, GPP0, GPP1, GPP2, GPP3, GPP4, GPP5, GPP6, GPP7, TOPN, TOPP, VDD, VREFN, VREFP, VSS",size=0.9,halign="start",textcolor="#223d52");
// }
// END SARADC RNL
ends b_cdac

subckt b_cdac_bit GNN GNP GPN GPP TOPN TOPP VREFN VREFP VDD VSS
// BEGIN SARADC RNL
// @RNL(author="saradc topology") {
// (-89,30) @TEXT("b_cdac_bit / source-derived connections",size=1.4,halign="start",textcolor="#223d52");
// (-20,5) @TEXT("Interface view only - no transistor body is distributed here.",size=1.2,halign="start",textcolor="#223d52");
// (-20,-2) @TEXT("Ports: GNN, GNP, GPN, GPP, TOPN, TOPP, VREFN, VREFP, VDD, VSS",size=0.9,halign="start",textcolor="#223d52");
// }
// END SARADC RNL
ends b_cdac_bit

subckt b_comparator CLK OUTN OUTP VDD VINN VINP VSS
// BEGIN SARADC RNL
// @RNL(author="saradc topology") {
// (-89,30) @TEXT("b_comparator / source-derived connections",size=1.4,halign="start",textcolor="#223d52");
// (-20,5) @TEXT("Interface view only - no transistor body is distributed here.",size=1.2,halign="start",textcolor="#223d52");
// (-20,-2) @TEXT("Ports: CLK, OUTN, OUTP, VDD, VINN, VINP, VSS",size=0.9,halign="start",textcolor="#223d52");
// }
// END SARADC RNL
ends b_comparator

subckt b_reference CODE0 CODE1 CODE2 CODE3 CODE4 CODE5 CODE6 CODE7 D0 D1 D2 D3 D4 D5 D6 D7 GNN0 GNN1 GNN2 GNN3 GNN4 GNN5 GNN6 GNN7 GNP0 GNP1 GNP2 GNP3 GNP4 GNP5 GNP6 GNP7 GPN0 GPN1 GPN2 GPN3 GPN4 GPN5 GPN6 GPN7 GPP0 GPP1 GPP2 GPP3 GPP4 GPP5 GPP6 GPP7 PHI_U SAMPLE VDD VSS RST_DONE PRESET
// BEGIN SARADC RNL
// @RNL(author="saradc topology") {
// (-89,30) @TEXT("b_reference / source-derived connections",size=1.4,halign="start",textcolor="#223d52");
// (-20,5) @TEXT("Interface view only - no transistor body is distributed here.",size=1.2,halign="start",textcolor="#223d52");
// (-20,-2) @TEXT("Ports: CODE0, CODE1, CODE2, CODE3, CODE4, CODE5, CODE6, CODE7, D0, D1, D2, D3, D4, D5, D6, D7, GNN0, GNN1, GNN2, GNN3, GNN4, GNN5, GNN6, GNN7, GNP0, GNP1, GNP2, GNP3, GNP4, GNP5, GNP6, GNP7, GPN0, GPN1, GPN2, GPN3, GPN4, GPN5, GPN6, GPN7, GPP0, GPP1, GPP2, GPP3, GPP4, GPP5, GPP6, GPP7, PHI_U, SAMPLE, VDD, VSS, RST_DONE, PRESET",size=0.9,halign="start",textcolor="#223d52");
// }
// END SARADC RNL
ends b_reference

subckt b_edge A VDD VSS Y
// BEGIN SARADC RNL
// @RNL(author="saradc topology") {
// (-89,30) @TEXT("b_edge / source-derived connections",size=1.4,halign="start",textcolor="#223d52");
// (-20,5) @TEXT("Interface view only - no transistor body is distributed here.",size=1.2,halign="start",textcolor="#223d52");
// (-20,-2) @TEXT("Ports: A, VDD, VSS, Y",size=0.9,halign="start",textcolor="#223d52");
// }
// END SARADC RNL
ends b_edge

subckt b_idle ACTIVE SAMPLE VDD VSS PRESET SAMPLE_MATCH
// BEGIN SARADC RNL
// @RNL(author="saradc topology") {
// (-89,30) @TEXT("b_idle / source-derived connections",size=1.4,halign="start",textcolor="#223d52");
// (-20,5) @TEXT("Interface view only - no transistor body is distributed here.",size=1.2,halign="start",textcolor="#223d52");
// (-20,-2) @TEXT("Ports: ACTIVE, SAMPLE, VDD, VSS, PRESET, SAMPLE_MATCH",size=0.9,halign="start",textcolor="#223d52");
// }
// END SARADC RNL
ends b_idle

subckt b_sampler CLKS VOUT VIN VDD VSS
// BEGIN SARADC RNL
// @RNL(author="saradc topology") {
// (-89,30) @TEXT("b_sampler / source-derived connections",size=1.4,halign="start",textcolor="#223d52");
// (-20,5) @TEXT("Interface view only - no transistor body is distributed here.",size=1.2,halign="start",textcolor="#223d52");
// (-20,-2) @TEXT("Ports: CLKS, VOUT, VIN, VDD, VSS",size=0.9,halign="start",textcolor="#223d52");
// }
// END SARADC RNL
ends b_sampler

subckt b_sar CMP_CLK CODE0 CODE1 CODE2 CODE3 CODE4 CODE5 CODE6 CODE7 COMP_N COMP_P D0 D1 D2 D3 D4 D5 D6 D7 PHI_U SAMPLE VDD VSS ACTIVE
// BEGIN SARADC RNL
// @RNL(author="saradc topology") {
// (-89,30) @TEXT("b_sar / source-derived connections",size=1.4,halign="start",textcolor="#223d52");
// (-20,5) @TEXT("Interface view only - no transistor body is distributed here.",size=1.2,halign="start",textcolor="#223d52");
// (-20,-2) @TEXT("Ports: CMP_CLK, CODE0, CODE1, CODE2, CODE3, CODE4, CODE5, CODE6, CODE7, COMP_N, COMP_P, D0, D1, D2, D3, D4, D5, D6, D7, PHI_U, SAMPLE, VDD, VSS, ACTIVE",size=0.9,halign="start",textcolor="#223d52");
// }
// END SARADC RNL
ends b_sar

subckt sar_adc_b D0 D1 D2 D3 D4 D5 D6 D7 SAMPLE VDD VINN VINP VREFN VREFP VSS
// BEGIN SARADC RNL
// @RNL(author="saradc topology") {
// (-89,30) @TEXT("sar_adc_b / source-derived connections",size=1.4,halign="start",textcolor="#223d52");
// (-20,5) @TEXT("Interface view only - no transistor body is distributed here.",size=1.2,halign="start",textcolor="#223d52");
// (-20,-2) @TEXT("Ports: D0, D1, D2, D3, D4, D5, D6, D7, SAMPLE, VDD, VINN, VINP, VREFN, VREFP, VSS",size=0.9,halign="start",textcolor="#223d52");
// }
// END SARADC RNL
ends sar_adc_b

subckt b_delay A VDD VSS Y
// BEGIN SARADC RNL
// @RNL(author="saradc topology") {
// (-89,30) @TEXT("b_delay / source-derived connections",size=1.4,halign="start",textcolor="#223d52");
// (-20,5) @TEXT("Interface view only - no transistor body is distributed here.",size=1.2,halign="start",textcolor="#223d52");
// (-20,-2) @TEXT("Ports: A, VDD, VSS, Y",size=0.9,halign="start",textcolor="#223d52");
// }
// END SARADC RNL
ends b_delay

subckt b_behavior_observer D0 D1 D2 D3 D4 D5 D6 D7 SAMPLE VDD VSS
// BEGIN SARADC RNL
// @RNL(author="saradc topology") {
// (-89,30) @TEXT("b_behavior_observer / source-derived connections",size=1.4,halign="start",textcolor="#223d52");
// (-20,5) @TEXT("Interface view only - no transistor body is distributed here.",size=1.2,halign="start",textcolor="#223d52");
// (-20,-2) @TEXT("Ports: D0, D1, D2, D3, D4, D5, D6, D7, SAMPLE, VDD, VSS",size=0.9,halign="start",textcolor="#223d52");
// }
// END SARADC RNL
ends b_behavior_observer

subckt b_tb_switch A B EN VDD VSS
// BEGIN SARADC RNL
// @RNL(author="saradc topology") {
// (-89,30) @TEXT("b_tb_switch / source-derived connections",size=1.4,halign="start",textcolor="#223d52");
// (-20,5) @TEXT("Interface view only - no transistor body is distributed here.",size=1.2,halign="start",textcolor="#223d52");
// (-20,-2) @TEXT("Ports: A, B, EN, VDD, VSS",size=0.9,halign="start",textcolor="#223d52");
// }
// END SARADC RNL
ends b_tb_switch

subckt b_sampler_bridge CLKS VOUT Vin
// BEGIN SARADC RNL
// @RNL(author="saradc topology") {
// (-89,30) @TEXT("b_sampler_bridge / source-derived connections",size=1.4,halign="start",textcolor="#223d52");
// (-20,5) @TEXT("Interface view only - no transistor body is distributed here.",size=1.2,halign="start",textcolor="#223d52");
// (-20,-2) @TEXT("Ports: CLKS, VOUT, Vin",size=0.9,halign="start",textcolor="#223d52");
// }
// END SARADC RNL
ends b_sampler_bridge

subckt b_sar8p_delay_valid A VDD VSS Y
// BEGIN SARADC RNL
// @RNL(author="saradc topology") {
// (-89,30) @TEXT("b_sar8p_delay_valid / source-derived connections",size=1.4,halign="start",textcolor="#223d52");
// (-20,5) @TEXT("Interface view only - no transistor body is distributed here.",size=1.2,halign="start",textcolor="#223d52");
// (-20,-2) @TEXT("Ports: A, VDD, VSS, Y",size=0.9,halign="start",textcolor="#223d52");
// }
// END SARADC RNL
ends b_sar8p_delay_valid

subckt b_sar8p_delay_write A VDD VSS Y
// BEGIN SARADC RNL
// @RNL(author="saradc topology") {
// (-89,30) @TEXT("b_sar8p_delay_write / source-derived connections",size=1.4,halign="start",textcolor="#223d52");
// (-20,5) @TEXT("Interface view only - no transistor body is distributed here.",size=1.2,halign="start",textcolor="#223d52");
// (-20,-2) @TEXT("Ports: A, VDD, VSS, Y",size=0.9,halign="start",textcolor="#223d52");
// }
// END SARADC RNL
ends b_sar8p_delay_write

subckt b_sar8p_delay_quiet A VDD VSS Y
// BEGIN SARADC RNL
// @RNL(author="saradc topology") {
// (-89,30) @TEXT("b_sar8p_delay_quiet / source-derived connections",size=1.4,halign="start",textcolor="#223d52");
// (-20,5) @TEXT("Interface view only - no transistor body is distributed here.",size=1.2,halign="start",textcolor="#223d52");
// (-20,-2) @TEXT("Ports: A, VDD, VSS, Y",size=0.9,halign="start",textcolor="#223d52");
// }
// END SARADC RNL
ends b_sar8p_delay_quiet

subckt b_sar8p_delay_capture A VDD VSS Y
// BEGIN SARADC RNL
// @RNL(author="saradc topology") {
// (-89,30) @TEXT("b_sar8p_delay_capture / source-derived connections",size=1.4,halign="start",textcolor="#223d52");
// (-20,5) @TEXT("Interface view only - no transistor body is distributed here.",size=1.2,halign="start",textcolor="#223d52");
// (-20,-2) @TEXT("Ports: A, VDD, VSS, Y",size=0.9,halign="start",textcolor="#223d52");
// }
// END SARADC RNL
ends b_sar8p_delay_capture

subckt b_sar8p_delay_bbm A VDD VSS Y
// BEGIN SARADC RNL
// @RNL(author="saradc topology") {
// (-89,30) @TEXT("b_sar8p_delay_bbm / source-derived connections",size=1.4,halign="start",textcolor="#223d52");
// (-20,5) @TEXT("Interface view only - no transistor body is distributed here.",size=1.2,halign="start",textcolor="#223d52");
// (-20,-2) @TEXT("Ports: A, VDD, VSS, Y",size=0.9,halign="start",textcolor="#223d52");
// }
// END SARADC RNL
ends b_sar8p_delay_bbm

subckt b_sar8r_delay A VDD VSS Y
// BEGIN SARADC RNL
// @RNL(author="saradc topology") {
// (-89,30) @TEXT("b_sar8r_delay / source-derived connections",size=1.4,halign="start",textcolor="#223d52");
// (-20,5) @TEXT("Interface view only - no transistor body is distributed here.",size=1.2,halign="start",textcolor="#223d52");
// (-20,-2) @TEXT("Ports: A, VDD, VSS, Y",size=0.9,halign="start",textcolor="#223d52");
// }
// END SARADC RNL
ends b_sar8r_delay

subckt b_sar8s_step A VDD VSS Y
// BEGIN SARADC RNL
// @RNL(author="saradc topology") {
// (-89,30) @TEXT("b_sar8s_step / source-derived connections",size=1.4,halign="start",textcolor="#223d52");
// (-20,5) @TEXT("Interface view only - no transistor body is distributed here.",size=1.2,halign="start",textcolor="#223d52");
// (-20,-2) @TEXT("Ports: A, VDD, VSS, Y",size=0.9,halign="start",textcolor="#223d52");
// }
// END SARADC RNL
ends b_sar8s_step

subckt b_sar8i_guard A VDD VSS Y
// BEGIN SARADC RNL
// @RNL(author="saradc topology") {
// (-89,30) @TEXT("b_sar8i_guard / source-derived connections",size=1.4,halign="start",textcolor="#223d52");
// (-20,5) @TEXT("Interface view only - no transistor body is distributed here.",size=1.2,halign="start",textcolor="#223d52");
// (-20,-2) @TEXT("Ports: A, VDD, VSS, Y",size=0.9,halign="start",textcolor="#223d52");
// }
// END SARADC RNL
ends b_sar8i_guard

subckt b_sar8r_edge A VDD VSS Y
// BEGIN SARADC RNL
// @RNL(author="saradc topology") {
// (-89,30) @TEXT("b_sar8r_edge / source-derived connections",size=1.4,halign="start",textcolor="#223d52");
// (-20,5) @TEXT("Interface view only - no transistor body is distributed here.",size=1.2,halign="start",textcolor="#223d52");
// (-20,-2) @TEXT("Ports: A, VDD, VSS, Y",size=0.9,halign="start",textcolor="#223d52");
// }
// END SARADC RNL
ends b_sar8r_edge

subckt b_sar8p_clkbuf A VDD VSS Y
// BEGIN SARADC RNL
// @RNL(author="saradc topology") {
// (-89,30) @TEXT("b_sar8p_clkbuf / source-derived connections",size=1.4,halign="start",textcolor="#223d52");
// (-20,5) @TEXT("Interface view only - no transistor body is distributed here.",size=1.2,halign="start",textcolor="#223d52");
// (-20,-2) @TEXT("Ports: A, VDD, VSS, Y",size=0.9,halign="start",textcolor="#223d52");
// }
// END SARADC RNL
ends b_sar8p_clkbuf
