// Generated from frozen B by scripts/sar8_entry.py build.
// BEGIN SARADC RNL
// @RNL(type="header") { @VERSION("0.3");
// @USE-PACKAGE(name="sar8",version="0.1",path="../../rnl/sar8.rnl");
// @USE-PACKAGE(name="rnl-std-fill") {}; }
// END SARADC RNL
// Electrical subcircuit statements are preserved verbatim.

subckt sar_strongarm_t28 CLK OUTN OUTP VDD VINN VINP VSS
    MNLATN (OUTN OUTP Y VSS) nch_mac l=30n w=500n multi=1 nf=1 sd=100n \
        ad=3.75e-14 as=3.75e-14 pd=1.15u ps=1.15u nrd=0.662935 \
        nrs=0.662935 sa=75.0n sb=75.0n sa1=75.0n sa2=75.0n sa3=75.0n \
        sa4=75.0n sb1=75.0n sb2=75.0n sb3=75.0n spa=100n spa1=100n \
        spa2=100n spa3=100n sap=91.9776n sapb=114.444n spba=115.715n \
        spba1=117.043n dfm_flag=0 spmt=1.11111e+15 spomt=0 \
        spomt1=1.11111e+60 spmb=1.11111e+15 spomb=0 spomb1=1.11111e+60
    MNLATP (OUTP OUTN X VSS) nch_mac l=30n w=500n multi=1 nf=1 sd=100n \
        ad=3.75e-14 as=3.75e-14 pd=1.15u ps=1.15u nrd=0.662935 \
        nrs=0.662935 sa=75.0n sb=75.0n sa1=75.0n sa2=75.0n sa3=75.0n \
        sa4=75.0n sb1=75.0n sb2=75.0n sb3=75.0n spa=100n spa1=100n \
        spa2=100n spa3=100n sap=91.9776n sapb=114.444n spba=115.715n \
        spba1=117.043n dfm_flag=0 spmt=1.11111e+15 spomt=0 \
        spomt1=1.11111e+60 spmb=1.11111e+15 spomb=0 spomb1=1.11111e+60
    MNINN (X VINN TAIL VSS) nch_mac l=30n w=1u multi=1 nf=1 sd=100n \
        ad=7.5e-14 as=7.5e-14 pd=2.15u ps=2.15u nrd=0.289519 nrs=0.289519 \
        sa=75.0n sb=75.0n sa1=75.0n sa2=75.0n sa3=75.0n sa4=75.0n \
        sb1=75.0n sb2=75.0n sb3=75.0n spa=100n spa1=100n spa2=100n \
        spa3=100n sap=91.9776n sapb=114.444n spba=115.715n spba1=117.043n \
        dfm_flag=0 spmt=1.11111e+15 spomt=0 spomt1=1.11111e+60 \
        spmb=1.11111e+15 spomb=0 spomb1=1.11111e+60
    MNINP (Y VINP TAIL VSS) nch_mac l=30n w=1u multi=1 nf=1 sd=100n \
        ad=7.5e-14 as=7.5e-14 pd=2.15u ps=2.15u nrd=0.289519 nrs=0.289519 \
        sa=75.0n sb=75.0n sa1=75.0n sa2=75.0n sa3=75.0n sa4=75.0n \
        sb1=75.0n sb2=75.0n sb3=75.0n spa=100n spa1=100n spa2=100n \
        spa3=100n sap=91.9776n sapb=114.444n spba=115.715n spba1=117.043n \
        dfm_flag=0 spmt=1.11111e+15 spomt=0 spomt1=1.11111e+60 \
        spmb=1.11111e+15 spomb=0 spomb1=1.11111e+60
    MNTAIL (TAIL CLK VSS VSS) nch_mac l=30n w=1u multi=1 nf=1 sd=100n \
        ad=7.5e-14 as=7.5e-14 pd=2.15u ps=2.15u nrd=0.289519 nrs=0.289519 \
        sa=75.0n sb=75.0n sa1=75.0n sa2=75.0n sa3=75.0n sa4=75.0n \
        sb1=75.0n sb2=75.0n sb3=75.0n spa=100n spa1=100n spa2=100n \
        spa3=100n sap=91.9776n sapb=114.444n spba=115.715n spba1=117.043n \
        dfm_flag=0 spmt=1.11111e+15 spomt=0 spomt1=1.11111e+60 \
        spmb=1.11111e+15 spomb=0 spomb1=1.11111e+60
    MPRSTN (OUTN CLK VDD VDD) pch_mac l=30n w=500n multi=1 nf=1 sd=100n \
        ad=3.75e-14 as=3.75e-14 pd=1.15u ps=1.15u nrd=0.383209 \
        nrs=0.383209 sa=75.0n sb=75.0n sa1=75.0n sa2=75.0n sa3=75.0n \
        sa4=75.0n sb1=75.0n sb2=75.0n sb3=75.0n spa=100n spa1=100n \
        spa2=100n spa3=100n sap=91.9776n sapb=114.444n spba=115.715n \
        spba1=117.043n dfm_flag=0 spmt=1.11111e+15 spomt=0 \
        spomt1=1.11111e+60 spmb=1.11111e+15 spomb=0 spomb1=1.11111e+60
    MPRSTP (OUTP CLK VDD VDD) pch_mac l=30n w=500n multi=1 nf=1 sd=100n \
        ad=3.75e-14 as=3.75e-14 pd=1.15u ps=1.15u nrd=0.383209 \
        nrs=0.383209 sa=75.0n sb=75.0n sa1=75.0n sa2=75.0n sa3=75.0n \
        sa4=75.0n sb1=75.0n sb2=75.0n sb3=75.0n spa=100n spa1=100n \
        spa2=100n spa3=100n sap=91.9776n sapb=114.444n spba=115.715n \
        spba1=117.043n dfm_flag=0 spmt=1.11111e+15 spomt=0 \
        spomt1=1.11111e+60 spmb=1.11111e+15 spomb=0 spomb1=1.11111e+60
    MPRSTY (Y CLK VDD VDD) pch_mac l=30n w=500n multi=1 nf=1 sd=100n \
        ad=3.75e-14 as=3.75e-14 pd=1.15u ps=1.15u nrd=0.383209 \
        nrs=0.383209 sa=75.0n sb=75.0n sa1=75.0n sa2=75.0n sa3=75.0n \
        sa4=75.0n sb1=75.0n sb2=75.0n sb3=75.0n spa=100n spa1=100n \
        spa2=100n spa3=100n sap=91.9776n sapb=114.444n spba=115.715n \
        spba1=117.043n dfm_flag=0 spmt=1.11111e+15 spomt=0 \
        spomt1=1.11111e+60 spmb=1.11111e+15 spomb=0 spomb1=1.11111e+60
    MPRSTX (X CLK VDD VDD) pch_mac l=30n w=500n multi=1 nf=1 sd=100n \
        ad=3.75e-14 as=3.75e-14 pd=1.15u ps=1.15u nrd=0.383209 \
        nrs=0.383209 sa=75.0n sb=75.0n sa1=75.0n sa2=75.0n sa3=75.0n \
        sa4=75.0n sb1=75.0n sb2=75.0n sb3=75.0n spa=100n spa1=100n \
        spa2=100n spa3=100n sap=91.9776n sapb=114.444n spba=115.715n \
        spba1=117.043n dfm_flag=0 spmt=1.11111e+15 spomt=0 \
        spomt1=1.11111e+60 spmb=1.11111e+15 spomb=0 spomb1=1.11111e+60
    MPLATN (OUTN OUTP VDD VDD) pch_mac l=30n w=500n multi=1 nf=1 sd=100n \
        ad=3.75e-14 as=3.75e-14 pd=1.15u ps=1.15u nrd=0.383209 \
        nrs=0.383209 sa=75.0n sb=75.0n sa1=75.0n sa2=75.0n sa3=75.0n \
        sa4=75.0n sb1=75.0n sb2=75.0n sb3=75.0n spa=100n spa1=100n \
        spa2=100n spa3=100n sap=91.9776n sapb=114.444n spba=115.715n \
        spba1=117.043n dfm_flag=0 spmt=1.11111e+15 spomt=0 \
        spomt1=1.11111e+60 spmb=1.11111e+15 spomb=0 spomb1=1.11111e+60
    MPLATP (OUTP OUTN VDD VDD) pch_mac l=30n w=500n multi=1 nf=1 sd=100n \
        ad=3.75e-14 as=3.75e-14 pd=1.15u ps=1.15u nrd=0.383209 \
        nrs=0.383209 sa=75.0n sb=75.0n sa1=75.0n sa2=75.0n sa3=75.0n \
        sa4=75.0n sb1=75.0n sb2=75.0n sb3=75.0n spa=100n spa1=100n \
        spa2=100n spa3=100n sap=91.9776n sapb=114.444n spba=115.715n \
        spba1=117.043n dfm_flag=0 spmt=1.11111e+15 spomt=0 \
        spomt1=1.11111e+60 spmb=1.11111e+15 spomb=0 spomb1=1.11111e+60
// BEGIN SARADC RNL
// @RNL(author="saradc topology") {
// (-47,72) @TEXT("StrongARM / 11 MOS / symmetric latch and input pair",size=1.5,halign="start",textcolor="#223d52");
// #MPLATN @SET-SYMBOL $PMOS_4TERM;
// #MPLATN @PLACE(-20,42) => @ORIENT("MY");
// #MPLATN @TEXT("MPLATN",key="name",size=1.3,halign="start") => @PLACE(-17,45);
// #MPLATN @TEXT("l=30n w=500n multi=1",key="value",size=0.9,halign="start") => @PLACE(-17,38);
// #MPLATN @TEXT("",key="model");
// #MPLATP @SET-SYMBOL $PMOS_4TERM;
// #MPLATP @PLACE(20,42) => @ORIENT("R0");
// #MPLATP @TEXT("MPLATP",key="name",size=1.3,halign="start") => @PLACE(23,45);
// #MPLATP @TEXT("l=30n w=500n multi=1",key="value",size=0.9,halign="start") => @PLACE(23,38);
// #MPLATP @TEXT("",key="model");
// #MNLATN @SET-SYMBOL $NMOS_4TERM;
// #MNLATN @PLACE(-20,20) => @ORIENT("MY");
// #MNLATN @TEXT("MNLATN",key="name",size=1.3,halign="start") => @PLACE(-17,23);
// #MNLATN @TEXT("l=30n w=500n multi=1",key="value",size=0.9,halign="start") => @PLACE(-17,16);
// #MNLATN @TEXT("",key="model");
// #MNLATP @SET-SYMBOL $NMOS_4TERM;
// #MNLATP @PLACE(20,20) => @ORIENT("R0");
// #MNLATP @TEXT("MNLATP",key="name",size=1.3,halign="start") => @PLACE(23,23);
// #MNLATP @TEXT("l=30n w=500n multi=1",key="value",size=0.9,halign="start") => @PLACE(23,16);
// #MNLATP @TEXT("",key="model");
// #MNINP @SET-SYMBOL $NMOS_4TERM;
// #MNINP @PLACE(-20,-5) => @ORIENT("R0");
// #MNINP @TEXT("MNINP",key="name",size=1.3,halign="start") => @PLACE(-17,-2);
// #MNINP @TEXT("l=30n w=1u multi=1",key="value",size=0.9,halign="start") => @PLACE(-17,-9);
// #MNINP @TEXT("",key="model");
// #MNINN @SET-SYMBOL $NMOS_4TERM;
// #MNINN @PLACE(20,-5) => @ORIENT("MY");
// #MNINN @TEXT("MNINN",key="name",size=1.3,halign="start") => @PLACE(23,-2);
// #MNINN @TEXT("l=30n w=1u multi=1",key="value",size=0.9,halign="start") => @PLACE(23,-9);
// #MNINN @TEXT("",key="model");
// #MNTAIL @SET-SYMBOL $NMOS_4TERM;
// #MNTAIL @PLACE(0,-30) => @ORIENT("R0");
// #MNTAIL @TEXT("MNTAIL",key="name",size=1.3,halign="start") => @PLACE(3,-27);
// #MNTAIL @TEXT("l=30n w=1u multi=1",key="value",size=0.9,halign="start") => @PLACE(3,-34);
// #MNTAIL @TEXT("",key="model");
// #MPRSTN @SET-SYMBOL $PMOS_4TERM;
// #MPRSTN @PLACE(-42,42) => @ORIENT("R0");
// #MPRSTN @TEXT("MPRSTN",key="name",size=1.3,halign="start") => @PLACE(-39,45);
// #MPRSTN @TEXT("l=30n w=500n multi=1",key="value",size=0.9,halign="start") => @PLACE(-39,38);
// #MPRSTN @TEXT("",key="model");
// #MPRSTP @SET-SYMBOL $PMOS_4TERM;
// #MPRSTP @PLACE(42,42) => @ORIENT("MY");
// #MPRSTP @TEXT("MPRSTP",key="name",size=1.3,halign="start") => @PLACE(45,45);
// #MPRSTP @TEXT("l=30n w=500n multi=1",key="value",size=0.9,halign="start") => @PLACE(45,38);
// #MPRSTP @TEXT("",key="model");
// #MPRSTY @SET-SYMBOL $PMOS_4TERM;
// #MPRSTY @PLACE(-42,10) => @ORIENT("R0");
// #MPRSTY @TEXT("MPRSTY",key="name",size=1.3,halign="start") => @PLACE(-39,13);
// #MPRSTY @TEXT("l=30n w=500n multi=1",key="value",size=0.9,halign="start") => @PLACE(-39,6);
// #MPRSTY @TEXT("",key="model");
// #MPRSTX @SET-SYMBOL $PMOS_4TERM;
// #MPRSTX @PLACE(42,10) => @ORIENT("MY");
// #MPRSTX @TEXT("MPRSTX",key="name",size=1.3,halign="start") => @PLACE(45,13);
// #MPRSTX @TEXT("l=30n w=500n multi=1",key="value",size=0.9,halign="start") => @PLACE(45,6);
// #MPRSTX @TEXT("",key="model");
// &"VDD" @WIRE(mode="straight",linecolor="#647584",linewidth=0.16) {(-42,61) (-20,61) (20,61) (42,61)};
// &"VDD" @WIRE(mode="straight",linecolor="#647584",linewidth=0.16) {#MPLATN:3 (-20,61)};
// $JUNCTION @ATTACH (-20,61);
// &"VDD" @WIRE(mode="straight",linecolor="#647584",linewidth=0.16) {#MPLATP:3 (20,61)};
// $JUNCTION @ATTACH (20,61);
// &"VDD" @WIRE(mode="straight",linecolor="#647584",linewidth=0.16) {#MPRSTN:3 (-42,61)};
// $JUNCTION @ATTACH (-42,61);
// &"VDD" @WIRE(mode="straight",linecolor="#647584",linewidth=0.16) {#MPRSTP:3 (42,61)};
// $JUNCTION @ATTACH (42,61);
// &"VDD" @WIRE(mode="straight",linecolor="#647584",linewidth=0.16) {#MPRSTY:3 (-42,61)};
// $JUNCTION @ATTACH (-42,61);
// &"VDD" @WIRE(mode="straight",linecolor="#647584",linewidth=0.16) {#MPRSTX:3 (42,61)};
// $JUNCTION @ATTACH (42,61);
// &"OUTN" @WIRE(mode="straight",linecolor="#226e85",linewidth=0.16) {(-42,31) (-20,31)};
// &"OUTN" @WIRE(mode="straight",linecolor="#226e85",linewidth=0.16) {#MPLATN:1 (-20,31)};
// $JUNCTION @ATTACH (-20,31);
// &"OUTN" @WIRE(mode="straight",linecolor="#226e85",linewidth=0.16) {#MNLATN:1 (-20,31)};
// $JUNCTION @ATTACH (-20,31);
// &"OUTN" @WIRE(mode="straight",linecolor="#226e85",linewidth=0.16) {#MPRSTN:1 (-42,31)};
// $JUNCTION @ATTACH (-42,31);
// &"OUTP" @WIRE(mode="straight",linecolor="#226e85",linewidth=0.16) {(20,33) (42,33)};
// &"OUTP" @WIRE(mode="straight",linecolor="#226e85",linewidth=0.16) {#MPLATP:1 (20,33)};
// $JUNCTION @ATTACH (20,33);
// &"OUTP" @WIRE(mode="straight",linecolor="#226e85",linewidth=0.16) {#MNLATP:1 (20,33)};
// $JUNCTION @ATTACH (20,33);
// &"OUTP" @WIRE(mode="straight",linecolor="#226e85",linewidth=0.16) {#MPRSTP:1 (42,33)};
// $JUNCTION @ATTACH (42,33);
// &"OUTN" @WIRE(mode="straight",linecolor="#226e85",linewidth=0.16) {#MPLATN:1 (-20,36) (8,36) (8,42) #MPLATP:2};
// &"OUTN" @WIRE(mode="straight",linecolor="#226e85",linewidth=0.16) {(8,36) (8,20) #MNLATP:2};
// $JUNCTION @ATTACH (8,36);
// &"OUTP" @WIRE(mode="straight",linecolor="#226e85",linewidth=0.16) {#MPLATP:1 (20,28) (-8,28) (-8,42) #MPLATN:2};
// &"OUTP" @WIRE(mode="straight",linecolor="#226e85",linewidth=0.16) {(-8,28) (-8,20) #MNLATN:2};
// $JUNCTION @ATTACH (-8,28);
// &"Y" @WIRE(mode="straight",linecolor="#226e85",linewidth=0.16) {(-42,4) (-20,4)};
// &"Y" @WIRE(mode="straight",linecolor="#226e85",linewidth=0.16) {#MNLATN:3 (-20,4)};
// $JUNCTION @ATTACH (-20,4);
// &"Y" @WIRE(mode="straight",linecolor="#226e85",linewidth=0.16) {#MNINP:1 (-20,4)};
// $JUNCTION @ATTACH (-20,4);
// &"Y" @WIRE(mode="straight",linecolor="#226e85",linewidth=0.16) {#MPRSTY:1 (-42,4)};
// $JUNCTION @ATTACH (-42,4);
// &"X" @WIRE(mode="straight",linecolor="#226e85",linewidth=0.16) {(20,4) (42,4)};
// &"X" @WIRE(mode="straight",linecolor="#226e85",linewidth=0.16) {#MNLATP:3 (20,4)};
// $JUNCTION @ATTACH (20,4);
// &"X" @WIRE(mode="straight",linecolor="#226e85",linewidth=0.16) {#MNINN:1 (20,4)};
// $JUNCTION @ATTACH (20,4);
// &"X" @WIRE(mode="straight",linecolor="#226e85",linewidth=0.16) {#MPRSTX:1 (42,4)};
// $JUNCTION @ATTACH (42,4);
// &"TAIL" @WIRE(mode="straight",linecolor="#226e85",linewidth=0.16) {(-20,-18) (0,-18) (20,-18)};
// &"TAIL" @WIRE(mode="straight",linecolor="#226e85",linewidth=0.16) {#MNINP:3 (-20,-18)};
// $JUNCTION @ATTACH (-20,-18);
// &"TAIL" @WIRE(mode="straight",linecolor="#226e85",linewidth=0.16) {#MNINN:3 (20,-18)};
// $JUNCTION @ATTACH (20,-18);
// &"TAIL" @WIRE(mode="straight",linecolor="#226e85",linewidth=0.16) {#MNTAIL:1 (0,-18)};
// $JUNCTION @ATTACH (0,-18);
// (-46,-48) @TEXT("VINP -> Y -> OUTN; VINN -> X -> OUTP. CLK resets PMOS and enables tail NMOS.",size=0.95,halign="start",textcolor="#223d52");
// &"VSS" @WIRE(mode="straight",linecolor="#30485d",linewidth=0.16) {#MNLATN:4 (-24,20)};
// (-24.4,20) @TEXT("VSS",size=1.1,halign="end",valign="middle");
// &"VSS" @WIRE(mode="straight",linecolor="#30485d",linewidth=0.16) {#MNLATP:4 (24,20)};
// (24.4,20) @TEXT("VSS",size=1.1,halign="start",valign="middle");
// &"VINN" @WIRE(mode="straight",linecolor="#30485d",linewidth=0.16) {#MNINN:2 (26,-5)};
// (26.4,-5) @TEXT("VINN",size=1.1,halign="start",valign="middle");
// &"VSS" @WIRE(mode="straight",linecolor="#30485d",linewidth=0.16) {#MNINN:4 (16,-5)};
// (15.6,-5) @TEXT("VSS",size=1.1,halign="end",valign="middle");
// &"VINP" @WIRE(mode="straight",linecolor="#30485d",linewidth=0.16) {#MNINP:2 (-26,-5)};
// (-26.4,-5) @TEXT("VINP",size=1.1,halign="end",valign="middle");
// &"VSS" @WIRE(mode="straight",linecolor="#30485d",linewidth=0.16) {#MNINP:4 (-16,-5)};
// (-15.6,-5) @TEXT("VSS",size=1.1,halign="start",valign="middle");
// &"CLK" @WIRE(mode="straight",linecolor="#30485d",linewidth=0.16) {#MNTAIL:2 (-6,-30)};
// (-6.4,-30) @TEXT("CLK",size=1.1,halign="end",valign="middle");
// &"VSS" @WIRE(mode="straight",linecolor="#30485d",linewidth=0.16) {#MNTAIL:3 (0,-35)};
// (0,-35.4) @TEXT("VSS",size=1.1,halign="middle",valign="top");
// &"VSS" @WIRE(mode="straight",linecolor="#30485d",linewidth=0.16) {#MNTAIL:4 (4,-30)};
// (4.4,-30) @TEXT("VSS",size=1.1,halign="start",valign="middle");
// &"CLK" @WIRE(mode="straight",linecolor="#30485d",linewidth=0.16) {#MPRSTN:2 (-48,42)};
// (-48.4,42) @TEXT("CLK",size=1.1,halign="end",valign="middle");
// &"VDD" @WIRE(mode="straight",linecolor="#30485d",linewidth=0.16) {#MPRSTN:4 (-38,42)};
// (-37.6,42) @TEXT("VDD",size=1.1,halign="start",valign="middle");
// &"CLK" @WIRE(mode="straight",linecolor="#30485d",linewidth=0.16) {#MPRSTP:2 (48,42)};
// (48.4,42) @TEXT("CLK",size=1.1,halign="start",valign="middle");
// &"VDD" @WIRE(mode="straight",linecolor="#30485d",linewidth=0.16) {#MPRSTP:4 (38,42)};
// (37.6,42) @TEXT("VDD",size=1.1,halign="end",valign="middle");
// &"CLK" @WIRE(mode="straight",linecolor="#30485d",linewidth=0.16) {#MPRSTY:2 (-48,10)};
// (-48.4,10) @TEXT("CLK",size=1.1,halign="end",valign="middle");
// &"VDD" @WIRE(mode="straight",linecolor="#30485d",linewidth=0.16) {#MPRSTY:4 (-38,10)};
// (-37.6,10) @TEXT("VDD",size=1.1,halign="start",valign="middle");
// &"CLK" @WIRE(mode="straight",linecolor="#30485d",linewidth=0.16) {#MPRSTX:2 (48,10)};
// (48.4,10) @TEXT("CLK",size=1.1,halign="start",valign="middle");
// &"VDD" @WIRE(mode="straight",linecolor="#30485d",linewidth=0.16) {#MPRSTX:4 (38,10)};
// (37.6,10) @TEXT("VDD",size=1.1,halign="end",valign="middle");
// &"VDD" @WIRE(mode="straight",linecolor="#30485d",linewidth=0.16) {#MPLATN:4 (-24,42)};
// (-24.4,42) @TEXT("VDD",size=1.1,halign="end",valign="middle");
// &"VDD" @WIRE(mode="straight",linecolor="#30485d",linewidth=0.16) {#MPLATP:4 (24,42)};
// (24.4,42) @TEXT("VDD",size=1.1,halign="start",valign="middle");
// }
// END SARADC RNL
ends sar_strongarm_t28
