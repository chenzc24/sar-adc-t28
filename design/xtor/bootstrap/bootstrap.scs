// Generated from frozen B; main switch widened to four 1 um devices on 2026-11-21.
// BEGIN SARADC RNL
// @RNL(type="header") { @VERSION("0.3");
// @USE-PACKAGE(name="sar8",version="0.1",path="../../rnl/sar8.rnl");
// @USE-PACKAGE(name="rnl-std-fill") {}; }
// END SARADC RNL
// Electrical subcircuit statements are preserved verbatim.

subckt sar_bootstrap_flat_8b_p CLKS VOUT Vin
    Mmain (VOUT G Vin 0) nch_18_mac l=150.0n w=1u multi=1 nf=1 sd=180.0n \
        ad=1.55e-13 as=1.55e-13 pd=2.31u ps=2.31u nrd=0 nrs=0 sa=155.00n \
        sb=155.00n sa1=155.00n sa2=155.00n sa3=155.00n sa4=155.00n \
        sb1=155.00n sb2=155.00n sb3=155.00n spa=180.0n spa1=180.0n \
        spa2=180.0n spa3=180.0n sap=172.362n sapb=242.67n spba=233.666n \
        spba1=239.844n spmt=1.11111e+15 spomt=0 spomt1=1.11111e+60 \
        spmb=1.11111e+15 spomb=0 spomb1=1.11111e+60
    Mmain_U1 (VOUT G Vin 0) nch_18_mac l=150.0n w=1u multi=1 nf=1 sd=180.0n \
        ad=1.55e-13 as=1.55e-13 pd=2.31u ps=2.31u nrd=0 nrs=0 sa=155.00n \
        sb=155.00n sa1=155.00n sa2=155.00n sa3=155.00n sa4=155.00n \
        sb1=155.00n sb2=155.00n sb3=155.00n spa=180.0n spa1=180.0n \
        spa2=180.0n spa3=180.0n sap=172.362n sapb=242.67n spba=233.666n \
        spba1=239.844n spmt=1.11111e+15 spomt=0 spomt1=1.11111e+60 \
        spmb=1.11111e+15 spomb=0 spomb1=1.11111e+60
    Mmain_U2 (VOUT G Vin 0) nch_18_mac l=150.0n w=1u multi=1 nf=1 sd=180.0n \
        ad=1.55e-13 as=1.55e-13 pd=2.31u ps=2.31u nrd=0 nrs=0 sa=155.00n \
        sb=155.00n sa1=155.00n sa2=155.00n sa3=155.00n sa4=155.00n \
        sb1=155.00n sb2=155.00n sb3=155.00n spa=180.0n spa1=180.0n \
        spa2=180.0n spa3=180.0n sap=172.362n sapb=242.67n spba=233.666n \
        spba1=239.844n spmt=1.11111e+15 spomt=0 spomt1=1.11111e+60 \
        spmb=1.11111e+15 spomb=0 spomb1=1.11111e+60
    Mmain_U3 (VOUT G Vin 0) nch_18_mac l=150.0n w=1u multi=1 nf=1 sd=180.0n \
        ad=1.55e-13 as=1.55e-13 pd=2.31u ps=2.31u nrd=0 nrs=0 sa=155.00n \
        sb=155.00n sa1=155.00n sa2=155.00n sa3=155.00n sa4=155.00n \
        sb1=155.00n sb2=155.00n sb3=155.00n spa=180.0n spa1=180.0n \
        spa2=180.0n spa3=180.0n sap=172.362n sapb=242.67n spba=233.666n \
        spba1=239.844n spmt=1.11111e+15 spomt=0 spomt1=1.11111e+60 \
        spmb=1.11111e+15 spomb=0 spomb1=1.11111e+60
    M4C (CTRL CLKS BBOT 0) nch_18_mac l=150.0n w=1u multi=1 nf=1 sd=180.0n \
        ad=1.55e-13 as=1.55e-13 pd=2.31u ps=2.31u nrd=0 nrs=0 sa=155.00n \
        sb=155.00n sa1=155.00n sa2=155.00n sa3=155.00n sa4=155.00n \
        sb1=155.00n sb2=155.00n sb3=155.00n spa=180.0n spa1=180.0n \
        spa2=180.0n spa3=180.0n sap=172.362n sapb=242.67n spba=233.666n \
        spba1=239.844n spmt=1.11111e+15 spomt=0 spomt1=1.11111e+60 \
        spmb=1.11111e+15 spomb=0 spomb1=1.11111e+60
    Msin (BBOT G Vin 0) nch_18_mac l=150.0n w=1u multi=1 nf=1 sd=180.0n \
        ad=1.55e-13 as=1.55e-13 pd=2.31u ps=2.31u nrd=0 nrs=0 sa=155.00n \
        sb=155.00n sa1=155.00n sa2=155.00n sa3=155.00n sa4=155.00n \
        sb1=155.00n sb2=155.00n sb3=155.00n spa=180.0n spa1=180.0n \
        spa2=180.0n spa3=180.0n sap=172.362n sapb=242.67n spba=233.666n \
        spba1=239.844n spmt=1.11111e+15 spomt=0 spomt1=1.11111e+60 \
        spmb=1.11111e+15 spomb=0 spomb1=1.11111e+60
    Maux (G VDD! GRESET 0) nch_18_mac l=150.0n w=1u multi=1 nf=1 sd=180.0n \
        ad=1.55e-13 as=1.55e-13 pd=2.31u ps=2.31u nrd=0 nrs=0 sa=155.00n \
        sb=155.00n sa1=155.00n sa2=155.00n sa3=155.00n sa4=155.00n \
        sb1=155.00n sb2=155.00n sb3=155.00n spa=180.0n spa1=180.0n \
        spa2=180.0n spa3=180.0n sap=172.362n sapb=242.67n spba=233.666n \
        spba1=239.844n spmt=1.11111e+15 spomt=0 spomt1=1.11111e+60 \
        spmb=1.11111e+15 spomb=0 spomb1=1.11111e+60
    MRSTG (GRESET CLKSB 0 0) nch_18_mac l=150.0n w=1u multi=1 nf=1 \
        sd=180.0n ad=1.55e-13 as=1.55e-13 pd=2.31u ps=2.31u nrd=0 nrs=0 \
        sa=155.00n sb=155.00n sa1=155.00n sa2=155.00n sa3=155.00n \
        sa4=155.00n sb1=155.00n sb2=155.00n sb3=155.00n spa=180.0n \
        spa1=180.0n spa2=180.0n spa3=180.0n sap=172.362n sapb=242.67n \
        spba=233.666n spba1=239.844n spmt=1.11111e+15 spomt=0 \
        spomt1=1.11111e+60 spmb=1.11111e+15 spomb=0 spomb1=1.11111e+60
    M4A (CTRL G BBOT 0) nch_18_mac l=150.0n w=1u multi=1 nf=1 sd=180.0n \
        ad=1.55e-13 as=1.55e-13 pd=2.31u ps=2.31u nrd=0 nrs=0 sa=155.00n \
        sb=155.00n sa1=155.00n sa2=155.00n sa3=155.00n sa4=155.00n \
        sb1=155.00n sb2=155.00n sb3=155.00n spa=180.0n spa1=180.0n \
        spa2=180.0n spa3=180.0n sap=172.362n sapb=242.67n spba=233.666n \
        spba1=239.844n spmt=1.11111e+15 spomt=0 spomt1=1.11111e+60 \
        spmb=1.11111e+15 spomb=0 spomb1=1.11111e+60
    M8 (BBOT CLKSB 0 0) nch_18_mac l=150.0n w=1u multi=1 nf=1 sd=180.0n \
        ad=1.55e-13 as=1.55e-13 pd=2.31u ps=2.31u nrd=0 nrs=0 sa=155.00n \
        sb=155.00n sa1=155.00n sa2=155.00n sa3=155.00n sa4=155.00n \
        sb1=155.00n sb2=155.00n sb3=155.00n spa=180.0n spa1=180.0n \
        spa2=180.0n spa3=180.0n sap=172.362n sapb=242.67n spba=233.666n \
        spba1=239.844n spmt=1.11111e+15 spomt=0 spomt1=1.11111e+60 \
        spmb=1.11111e+15 spomb=0 spomb1=1.11111e+60
    MNCLK (CLKSB CLKS 0 0) nch_18_mac l=150.0n w=1u multi=1 nf=1 sd=180.0n \
        ad=1.55e-13 as=1.55e-13 pd=2.31u ps=2.31u nrd=0 nrs=0 sa=155.00n \
        sb=155.00n sa1=155.00n sa2=155.00n sa3=155.00n sa4=155.00n \
        sb1=155.00n sb2=155.00n sb3=155.00n spa=180.0n spa1=180.0n \
        spa2=180.0n spa3=180.0n sap=172.362n sapb=242.67n spba=233.666n \
        spba1=239.844n spmt=1.11111e+15 spomt=0 spomt1=1.11111e+60 \
        spmb=1.11111e+15 spomb=0 spomb1=1.11111e+60
    M2 (BTOP G VDD! BTOP) pch_18_mac l=150.0n w=1u multi=1 nf=1 sd=180.0n \
        ad=1.55e-13 as=1.55e-13 pd=2.31u ps=2.31u nrd=0 nrs=0 sa=155.00n \
        sb=155.00n sa1=155.00n sa2=155.00n sa3=155.00n sa4=155.00n \
        sb1=155.00n sb2=155.00n sb3=155.00n spa=180.0n spa1=180.0n \
        spa2=180.0n spa3=180.0n sap=172.362n sapb=242.67n spba=233.666n \
        spba1=239.844n spmt=1.11111e+15 spomt=0 spomt1=1.11111e+60 \
        spmb=1.11111e+15 spomb=0 spomb1=1.11111e+60
    M4 (G CTRL BTOP BTOP) pch_18_mac l=150.0n w=1u multi=1 nf=1 sd=180.0n \
        ad=1.55e-13 as=1.55e-13 pd=2.31u ps=2.31u nrd=0 nrs=0 sa=155.00n \
        sb=155.00n sa1=155.00n sa2=155.00n sa3=155.00n sa4=155.00n \
        sb1=155.00n sb2=155.00n sb3=155.00n spa=180.0n spa1=180.0n \
        spa2=180.0n spa3=180.0n sap=172.362n sapb=242.67n spba=233.666n \
        spba1=239.844n spmt=1.11111e+15 spomt=0 spomt1=1.11111e+60 \
        spmb=1.11111e+15 spomb=0 spomb1=1.11111e+60
    M4B (CTRL CLKS VDD! VDD!) pch_18_mac l=150.0n w=1u multi=1 nf=1 \
        sd=180.0n ad=1.55e-13 as=1.55e-13 pd=2.31u ps=2.31u nrd=0 nrs=0 \
        sa=155.00n sb=155.00n sa1=155.00n sa2=155.00n sa3=155.00n \
        sa4=155.00n sb1=155.00n sb2=155.00n sb3=155.00n spa=180.0n \
        spa1=180.0n spa2=180.0n spa3=180.0n sap=172.362n sapb=242.67n \
        spba=233.666n spba1=239.844n spmt=1.11111e+15 spomt=0 \
        spomt1=1.11111e+60 spmb=1.11111e+15 spomb=0 spomb1=1.11111e+60
    MPCLK (CLKSB CLKS VDD! VDD!) pch_18_mac l=150.0n w=1u multi=1 nf=1 \
        sd=180.0n ad=1.55e-13 as=1.55e-13 pd=2.31u ps=2.31u nrd=0 nrs=0 \
        sa=155.00n sb=155.00n sa1=155.00n sa2=155.00n sa3=155.00n \
        sa4=155.00n sb1=155.00n sb2=155.00n sb3=155.00n spa=180.0n \
        spa1=180.0n spa2=180.0n spa3=180.0n sap=172.362n sapb=242.67n \
        spba=233.666n spba1=239.844n spmt=1.11111e+15 spomt=0 \
        spomt1=1.11111e+60 spmb=1.11111e+15 spomb=0 spomb1=1.11111e+60
    Cboot (BTOP BBOT) cfmom_2t nr=8 lr=2.5u w=50n s=50n stm=1 spm=3 \
        multi=200 mismatchflag=1
// BEGIN SARADC RNL
// @RNL(author="saradc topology") {
// (-13,70) @TEXT("Bootstrap / four parallel sampling switches / MOM bootstrap capacitor",size=1.5,halign="start",textcolor="#223d52");
// #MPCLK @SET-SYMBOL $PMOS_4TERM;
// #MPCLK @PLACE(0,35) => @ORIENT("R0");
// #MPCLK @TEXT("MPCLK",key="name",size=1.3,halign="start") => @PLACE(3,38);
// #MPCLK @TEXT("l=150.0n w=1u multi=1",key="value",size=0.9,halign="start") => @PLACE(3,31);
// #MPCLK @TEXT("",key="model");
// #MNCLK @SET-SYMBOL $NMOS_4TERM;
// #MNCLK @PLACE(0,5) => @ORIENT("R0");
// #MNCLK @TEXT("MNCLK",key="name",size=1.3,halign="start") => @PLACE(3,8);
// #MNCLK @TEXT("l=150.0n w=1u multi=1",key="value",size=0.9,halign="start") => @PLACE(3,1);
// #MNCLK @TEXT("",key="model");
// #M4B @SET-SYMBOL $PMOS_4TERM;
// #M4B @PLACE(38,35) => @ORIENT("R0");
// #M4B @TEXT("M4B",key="name",size=1.3,halign="start") => @PLACE(41,38);
// #M4B @TEXT("l=150.0n w=1u multi=1",key="value",size=0.9,halign="start") => @PLACE(41,31);
// #M4B @TEXT("",key="model");
// #M4C @SET-SYMBOL $NMOS_4TERM;
// #M4C @PLACE(38,5) => @ORIENT("R0");
// #M4C @TEXT("M4C",key="name",size=1.3,halign="start") => @PLACE(41,8);
// #M4C @TEXT("l=150.0n w=1u multi=1",key="value",size=0.9,halign="start") => @PLACE(41,1);
// #M4C @TEXT("",key="model");
// #M4A @SET-SYMBOL $NMOS_4TERM;
// #M4A @PLACE(56,5) => @ORIENT("R0");
// #M4A @TEXT("M4A",key="name",size=1.3,halign="start") => @PLACE(59,8);
// #M4A @TEXT("l=150.0n w=1u multi=1",key="value",size=0.9,halign="start") => @PLACE(59,1);
// #M4A @TEXT("",key="model");
// #Cboot @SET-SYMBOL $CAPACITOR;
// #Cboot @PLACE(80,21) => @ORIENT("R0");
// #Cboot @TEXT("Cboot",key="name",size=1.3,halign="start") => @PLACE(83,24);
// #Cboot @TEXT("nr=8 lr=2.5u w=50n multi=200",key="value",size=0.9,halign="start") => @PLACE(83,17);
// #Cboot @TEXT("",key="model");
// #M2 @SET-SYMBOL $PMOS_4TERM;
// #M2 @PLACE(80,48) => @ORIENT("R0");
// #M2 @TEXT("M2",key="name",size=1.3,halign="start") => @PLACE(83,51);
// #M2 @TEXT("l=150.0n w=1u multi=1",key="value",size=0.9,halign="start") => @PLACE(83,44);
// #M2 @TEXT("",key="model");
// #M8 @SET-SYMBOL $NMOS_4TERM;
// #M8 @PLACE(80,-9) => @ORIENT("R0");
// #M8 @TEXT("M8",key="name",size=1.3,halign="start") => @PLACE(83,-6);
// #M8 @TEXT("l=150.0n w=1u multi=1",key="value",size=0.9,halign="start") => @PLACE(83,-13);
// #M8 @TEXT("",key="model");
// #Msin @SET-SYMBOL $NMOS_4TERM;
// #Msin @PLACE(101,-9) => @ORIENT("R0");
// #Msin @TEXT("Msin",key="name",size=1.3,halign="start") => @PLACE(104,-6);
// #Msin @TEXT("l=150.0n w=1u multi=1",key="value",size=0.9,halign="start") => @PLACE(104,-13);
// #Msin @TEXT("",key="model");
// #M4 @SET-SYMBOL $PMOS_4TERM;
// #M4 @PLACE(116,43) => @ORIENT("R0");
// #M4 @TEXT("M4",key="name",size=1.3,halign="start") => @PLACE(119,46);
// #M4 @TEXT("l=150.0n w=1u multi=1",key="value",size=0.9,halign="start") => @PLACE(119,39);
// #M4 @TEXT("",key="model");
// #Maux @SET-SYMBOL $NMOS_4TERM;
// #Maux @PLACE(116,4) => @ORIENT("R0");
// #Maux @TEXT("Maux",key="name",size=1.3,halign="start") => @PLACE(119,7);
// #Maux @TEXT("l=150.0n w=1u multi=1",key="value",size=0.9,halign="start") => @PLACE(119,0);
// #Maux @TEXT("",key="model");
// #MRSTG @SET-SYMBOL $NMOS_4TERM;
// #MRSTG @PLACE(116,-22) => @ORIENT("R0");
// #MRSTG @TEXT("MRSTG",key="name",size=1.3,halign="start") => @PLACE(119,-19);
// #MRSTG @TEXT("l=150.0n w=1u multi=1",key="value",size=0.9,halign="start") => @PLACE(119,-26);
// #MRSTG @TEXT("",key="model");
// #Mmain_U3 @SET-SYMBOL $NMOS_4TERM;
// #Mmain_U3 @PLACE(158,42) => @ORIENT("R270");
// #Mmain_U3 @TEXT("Mmain_U3",key="name",size=1.3,halign="start") => @PLACE(161,45);
// #Mmain_U3 @TEXT("l=150.0n w=1u multi=1",key="value",size=0.9,halign="start") => @PLACE(161,38);
// #Mmain_U3 @TEXT("",key="model");
// #Mmain @SET-SYMBOL $NMOS_4TERM;
// #Mmain @PLACE(158,17) => @ORIENT("R270");
// #Mmain @TEXT("Mmain",key="name",size=1.3,halign="start") => @PLACE(161,20);
// #Mmain @TEXT("l=150.0n w=1u multi=1",key="value",size=0.9,halign="start") => @PLACE(161,13);
// #Mmain @TEXT("",key="model");
// #Mmain_U1 @SET-SYMBOL $NMOS_4TERM;
// #Mmain_U1 @PLACE(158,-8) => @ORIENT("R270");
// #Mmain_U1 @TEXT("Mmain_U1",key="name",size=1.3,halign="start") => @PLACE(161,-5);
// #Mmain_U1 @TEXT("l=150.0n w=1u multi=1",key="value",size=0.9,halign="start") => @PLACE(161,-12);
// #Mmain_U1 @TEXT("",key="model");
// #Mmain_U2 @SET-SYMBOL $NMOS_4TERM;
// #Mmain_U2 @PLACE(158,-33) => @ORIENT("R270");
// #Mmain_U2 @TEXT("Mmain_U2",key="name",size=1.3,halign="start") => @PLACE(161,-30);
// #Mmain_U2 @TEXT("l=150.0n w=1u multi=1",key="value",size=0.9,halign="start") => @PLACE(161,-37);
// #Mmain_U2 @TEXT("",key="model");
// &"CLKSB" @WIRE(mode="straight",linecolor="#30485d",linewidth=0.16) {#MPCLK:1 (0,20)};
// $JUNCTION @ATTACH (0,20);
// &"CLKSB" @WIRE(mode="straight",linecolor="#30485d",linewidth=0.16) {#MNCLK:1 (0,20)};
// $JUNCTION @ATTACH (0,20);
// &"CTRL" @WIRE(mode="straight",linecolor="#30485d",linewidth=0.16) {(56,60) (113,60)};
// &"CTRL" @WIRE(mode="straight",linecolor="#30485d",linewidth=0.16) {#M4A:1 (56,60)};
// $JUNCTION @ATTACH (56,60);
// &"CTRL" @WIRE(mode="straight",linecolor="#30485d",linewidth=0.16) {#M4:2 (113,60)};
// $JUNCTION @ATTACH (113,60);
// &"CTRL" @WIRE(mode="straight",linecolor="#30485d",linewidth=0.16) {(28,60) (31,60) (56,60)};
// &"CTRL" @WIRE(mode="straight",linecolor="#30485d",linewidth=0.16) {#M4B:1 (38,29) (31,29) (31,60)};
// $JUNCTION @ATTACH (31,60);
// &"CTRL" @WIRE(mode="straight",linecolor="#30485d",linewidth=0.16) {#M4C:1 (38,12) (28,12) (28,60)};
// $JUNCTION @ATTACH (28,60);
// &"BTOP" @WIRE(mode="straight",linecolor="#226e85",linewidth=0.16) {#Cboot:1 (80,31)};
// $JUNCTION @ATTACH (80,31);
// &"BTOP" @WIRE(mode="straight",linecolor="#226e85",linewidth=0.16) {#M2:1 (80,31)};
// $JUNCTION @ATTACH (80,31);
// &"BTOP" @WIRE(mode="straight",linecolor="#226e85",linewidth=0.16) {#M4:3 (116,48) (124,48) (124,31) (80,31)};
// &"BBOT" @WIRE(mode="straight",linecolor="#226e85",linewidth=0.16) {(38,-2) (56,-2) (80,-2) (101,-2)};
// &"BBOT" @WIRE(mode="straight",linecolor="#226e85",linewidth=0.16) {#Cboot:2 (80,-2)};
// $JUNCTION @ATTACH (80,-2);
// &"BBOT" @WIRE(mode="straight",linecolor="#226e85",linewidth=0.16) {#M4C:3 (38,-2)};
// $JUNCTION @ATTACH (38,-2);
// &"BBOT" @WIRE(mode="straight",linecolor="#226e85",linewidth=0.16) {#M4A:3 (56,-2)};
// $JUNCTION @ATTACH (56,-2);
// &"BBOT" @WIRE(mode="straight",linecolor="#226e85",linewidth=0.16) {#M8:1 (80,-2)};
// $JUNCTION @ATTACH (80,-2);
// &"BBOT" @WIRE(mode="straight",linecolor="#226e85",linewidth=0.16) {#Msin:1 (101,-2)};
// $JUNCTION @ATTACH (101,-2);
// &"G" @WIRE(mode="straight",linecolor="#226e85",linewidth=0.16) {(138,-30) (138,-5) (138,6) (138,20) (138,41) (138,45)};
// &"G" @WIRE(mode="straight",linecolor="#226e85",linewidth=0.16) {#M4:1 (138,41)};
// $JUNCTION @ATTACH (138,41);
// &"G" @WIRE(mode="straight",linecolor="#226e85",linewidth=0.16) {#Maux:1 (138,6)};
// $JUNCTION @ATTACH (138,6);
// &"G" @WIRE(mode="straight",linecolor="#226e85",linewidth=0.16) {#Mmain:2 (138,20)};
// $JUNCTION @ATTACH (138,20);
// &"G" @WIRE(mode="straight",linecolor="#226e85",linewidth=0.16) {#Mmain_U1:2 (138,-5)};
// $JUNCTION @ATTACH (138,-5);
// &"G" @WIRE(mode="straight",linecolor="#226e85",linewidth=0.16) {#Mmain_U2:2 (138,-30)};
// $JUNCTION @ATTACH (138,-30);
// &"G" @WIRE(mode="straight",linecolor="#226e85",linewidth=0.16) {#Mmain_U3:2 (138,45)};
// $JUNCTION @ATTACH (138,45);
// &"GRESET" @WIRE(mode="straight",linecolor="#30485d",linewidth=0.16) {#Maux:3 (116,2) (116,-20) #MRSTG:1};
// &"Vin" @WIRE(mode="straight",linecolor="#226e85",linewidth=0.16) {(146,-33) (146,-11) (146,-8) (146,17) (146,42)};
// &"Vin" @WIRE(mode="straight",linecolor="#226e85",linewidth=0.16) {#Msin:3 (146,-11)};
// $JUNCTION @ATTACH (146,-11);
// &"Vin" @WIRE(mode="straight",linecolor="#226e85",linewidth=0.16) {#Mmain:3 (146,17)};
// $JUNCTION @ATTACH (146,17);
// &"Vin" @WIRE(mode="straight",linecolor="#226e85",linewidth=0.16) {#Mmain_U1:3 (146,-8)};
// $JUNCTION @ATTACH (146,-8);
// &"Vin" @WIRE(mode="straight",linecolor="#226e85",linewidth=0.16) {#Mmain_U2:3 (146,-33)};
// $JUNCTION @ATTACH (146,-33);
// &"Vin" @WIRE(mode="straight",linecolor="#226e85",linewidth=0.16) {#Mmain_U3:3 (146,42)};
// $JUNCTION @ATTACH (146,42);
// &"VOUT" @WIRE(mode="straight",linecolor="#226e85",linewidth=0.16) {(177,-33) (177,-8) (177,17) (177,42)};
// &"VOUT" @WIRE(mode="straight",linecolor="#226e85",linewidth=0.16) {#Mmain:1 (177,17)};
// $JUNCTION @ATTACH (177,17);
// &"VOUT" @WIRE(mode="straight",linecolor="#226e85",linewidth=0.16) {#Mmain_U1:1 (177,-8)};
// $JUNCTION @ATTACH (177,-8);
// &"VOUT" @WIRE(mode="straight",linecolor="#226e85",linewidth=0.16) {#Mmain_U2:1 (177,-33)};
// $JUNCTION @ATTACH (177,-33);
// &"VOUT" @WIRE(mode="straight",linecolor="#226e85",linewidth=0.16) {#Mmain_U3:1 (177,42)};
// $JUNCTION @ATTACH (177,42);
// (-13,-44) @TEXT("Clock inverter",size=1.1,halign="start",textcolor="#223d52");
// (33,-44) @TEXT("Precharge / boosted G and BTOP",size=1.1,halign="start",textcolor="#223d52");
// (144,-44) @TEXT("Vin -> VOUT",size=1.1,halign="start",textcolor="#223d52");
// (-13,-51) @TEXT("Bulk connections remain explicit: M2/M4 use BTOP; sampling MOS uses 0. No ideal replacement.",size=0.9,halign="start",textcolor="#223d52");
// &"0" @WIRE(mode="straight",linecolor="#30485d",linewidth=0.16) {#Mmain:4 (158,13)};
// (158,12.6) @TEXT("0",size=1.1,halign="middle",valign="top");
// &"0" @WIRE(mode="straight",linecolor="#30485d",linewidth=0.16) {#Mmain_U1:4 (158,-12)};
// (158,-12.4) @TEXT("0",size=1.1,halign="middle",valign="top");
// &"0" @WIRE(mode="straight",linecolor="#30485d",linewidth=0.16) {#Mmain_U2:4 (158,-37)};
// (158,-37.4) @TEXT("0",size=1.1,halign="middle",valign="top");
// &"0" @WIRE(mode="straight",linecolor="#30485d",linewidth=0.16) {#Mmain_U3:4 (158,38)};
// (158,37.6) @TEXT("0",size=1.1,halign="middle",valign="top");
// &"CLKS" @WIRE(mode="straight",linecolor="#30485d",linewidth=0.16) {#M4C:2 (32,5)};
// (31.6,5) @TEXT("CLKS",size=1.1,halign="end",valign="middle");
// &"0" @WIRE(mode="straight",linecolor="#30485d",linewidth=0.16) {#M4C:4 (42,5)};
// (42.4,5) @TEXT("0",size=1.1,halign="start",valign="middle");
// &"G" @WIRE(mode="straight",linecolor="#30485d",linewidth=0.16) {#Msin:2 (95,-9)};
// (94.6,-9) @TEXT("G",size=1.1,halign="end",valign="middle");
// &"0" @WIRE(mode="straight",linecolor="#30485d",linewidth=0.16) {#Msin:4 (105,-9)};
// (105.4,-9) @TEXT("0",size=1.1,halign="start",valign="middle");
// &"VDD!" @WIRE(mode="straight",linecolor="#30485d",linewidth=0.16) {#Maux:2 (110,4)};
// (109.6,4) @TEXT("VDD!",size=1.1,halign="end",valign="middle");
// &"0" @WIRE(mode="straight",linecolor="#30485d",linewidth=0.16) {#Maux:4 (120,4)};
// (120.4,4) @TEXT("0",size=1.1,halign="start",valign="middle");
// &"CLKSB" @WIRE(mode="straight",linecolor="#30485d",linewidth=0.16) {#MRSTG:2 (110,-22)};
// (109.6,-22) @TEXT("CLKSB",size=1.1,halign="end",valign="middle");
// &"0" @WIRE(mode="straight",linecolor="#30485d",linewidth=0.16) {#MRSTG:3 (116,-27)};
// (116,-27.4) @TEXT("0",size=1.1,halign="middle",valign="top");
// &"0" @WIRE(mode="straight",linecolor="#30485d",linewidth=0.16) {#MRSTG:4 (120,-22)};
// (120.4,-22) @TEXT("0",size=1.1,halign="start",valign="middle");
// &"G" @WIRE(mode="straight",linecolor="#30485d",linewidth=0.16) {#M4A:2 (50,5)};
// (49.6,5) @TEXT("G",size=1.1,halign="end",valign="middle");
// &"0" @WIRE(mode="straight",linecolor="#30485d",linewidth=0.16) {#M4A:4 (60,5)};
// (60.4,5) @TEXT("0",size=1.1,halign="start",valign="middle");
// &"CLKSB" @WIRE(mode="straight",linecolor="#30485d",linewidth=0.16) {#M8:2 (74,-9)};
// (73.6,-9) @TEXT("CLKSB",size=1.1,halign="end",valign="middle");
// &"0" @WIRE(mode="straight",linecolor="#30485d",linewidth=0.16) {#M8:3 (80,-14)};
// (80,-14.4) @TEXT("0",size=1.1,halign="middle",valign="top");
// &"0" @WIRE(mode="straight",linecolor="#30485d",linewidth=0.16) {#M8:4 (84,-9)};
// (84.4,-9) @TEXT("0",size=1.1,halign="start",valign="middle");
// &"CLKS" @WIRE(mode="straight",linecolor="#30485d",linewidth=0.16) {#MNCLK:2 (-6,5)};
// (-6.4,5) @TEXT("CLKS",size=1.1,halign="end",valign="middle");
// &"0" @WIRE(mode="straight",linecolor="#30485d",linewidth=0.16) {#MNCLK:3 (0,0)};
// (0,-0.4) @TEXT("0",size=1.1,halign="middle",valign="top");
// &"0" @WIRE(mode="straight",linecolor="#30485d",linewidth=0.16) {#MNCLK:4 (4,5)};
// (4.4,5) @TEXT("0",size=1.1,halign="start",valign="middle");
// &"G" @WIRE(mode="straight",linecolor="#30485d",linewidth=0.16) {#M2:2 (74,48)};
// (73.6,48) @TEXT("G",size=1.1,halign="end",valign="middle");
// &"VDD!" @WIRE(mode="straight",linecolor="#30485d",linewidth=0.16) {#M2:3 (80,53)};
// (80,53.4) @TEXT("VDD!",size=1.1,halign="middle",valign="bottom");
// &"BTOP" @WIRE(mode="straight",linecolor="#30485d",linewidth=0.16) {#M2:4 (84,48)};
// (84.4,48) @TEXT("BTOP",size=1.1,halign="start",valign="middle");
// &"BTOP" @WIRE(mode="straight",linecolor="#30485d",linewidth=0.16) {#M4:4 (120,43)};
// (120.4,43) @TEXT("BTOP",size=1.1,halign="start",valign="middle");
// &"CLKS" @WIRE(mode="straight",linecolor="#30485d",linewidth=0.16) {#M4B:2 (32,35)};
// (31.6,35) @TEXT("CLKS",size=1.1,halign="end",valign="middle");
// &"VDD!" @WIRE(mode="straight",linecolor="#30485d",linewidth=0.16) {#M4B:3 (38,40)};
// (38,40.4) @TEXT("VDD!",size=1.1,halign="middle",valign="bottom");
// &"VDD!" @WIRE(mode="straight",linecolor="#30485d",linewidth=0.16) {#M4B:4 (42,35)};
// (42.4,35) @TEXT("VDD!",size=1.1,halign="start",valign="middle");
// &"CLKS" @WIRE(mode="straight",linecolor="#30485d",linewidth=0.16) {#MPCLK:2 (-6,35)};
// (-6.4,35) @TEXT("CLKS",size=1.1,halign="end",valign="middle");
// &"VDD!" @WIRE(mode="straight",linecolor="#30485d",linewidth=0.16) {#MPCLK:3 (0,40)};
// (0,40.4) @TEXT("VDD!",size=1.1,halign="middle",valign="bottom");
// &"VDD!" @WIRE(mode="straight",linecolor="#30485d",linewidth=0.16) {#MPCLK:4 (4,35)};
// (4.4,35) @TEXT("VDD!",size=1.1,halign="start",valign="middle");
// }
// END SARADC RNL
ends sar_bootstrap_flat_8b_p
