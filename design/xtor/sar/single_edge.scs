// Single-edge SAR. All logic and delay devices are native standard cells.
// BEGIN SARADC RNL
// @RNL(type="header") { @VERSION("0.3");
// @USE-PACKAGE(name="sar8",version="0.1",path="../../rnl/sar8.rnl");
// @USE-PACKAGE(name="rnl-std-fill") {}; }
// END SARADC RNL
subckt sar8_next_word CODE0 CODE1 CODE2 CODE3 CODE4 CODE5 CODE6 CODE7 DATA DONE D0 D1 D2 D3 D4 D5 D6 D7 NEXT0 NEXT1 NEXT2 NEXT3 NEXT4 NEXT5 NEXT6 NEXT7 TRIAL6 TRIAL5 TRIAL4 TRIAL3 TRIAL2 VDD VSS
// Prefix ORs identify the current trial and are evaluated before DATA arrives.
X01 (CODE0 CODE1 ANY01 VDD VSS) OR2D1BWP12T30P140
X23 (CODE2 CODE3 ANY23 VDD VSS) OR2D1BWP12T30P140
X45 (CODE4 CODE5 ANY45 VDD VSS) OR2D1BWP12T30P140
X02 (ANY01 CODE2 ANY02 VDD VSS) OR2D1BWP12T30P140
X03 (ANY01 ANY23 ANY03 VDD VSS) OR2D1BWP12T30P140
X04 (ANY03 CODE4 LOW_BITS VDD VSS) OR2D1BWP12T30P140
X05 (ANY03 ANY45 ANY05 VDD VSS) OR2D1BWP12T30P140
X06 (ANY05 CODE6 ANY06 VDD VSS) OR2D1BWP12T30P140
XREAD0 (CODE0 DONE D0 VDD VSS) AN2D1BWP12T30P140
XEMPTY1 (CODE0 EMPTY1 VDD VSS) INVD1BWP12T30P140
XTRIAL1 (EMPTY1 CODE1 TRIAL1 VDD VSS) AN2D1BWP12T30P140
XVISIBLE1 (CODE0 DONE VISIBLE1 VDD VSS) OR2D1BWP12T30P140
XREAD1 (CODE1 VISIBLE1 D1 VDD VSS) AN2D1BWP12T30P140
XEMPTY2 (ANY01 EMPTY2 VDD VSS) INVD1BWP12T30P140
XTRIAL2 (EMPTY2 CODE2 TRIAL2 VDD VSS) AN2D1BWP12T30P140
XVISIBLE2 (ANY01 DONE VISIBLE2 VDD VSS) OR2D1BWP12T30P140
XREAD2 (CODE2 VISIBLE2 D2 VDD VSS) AN2D1BWP12T30P140
XEMPTY3 (ANY02 EMPTY3 VDD VSS) INVD1BWP12T30P140
XTRIAL3 (EMPTY3 CODE3 TRIAL3 VDD VSS) AN2D1BWP12T30P140
XVISIBLE3 (ANY02 DONE VISIBLE3 VDD VSS) OR2D1BWP12T30P140
XREAD3 (CODE3 VISIBLE3 D3 VDD VSS) AN2D1BWP12T30P140
XEMPTY4 (ANY03 EMPTY4 VDD VSS) INVD1BWP12T30P140
XTRIAL4 (EMPTY4 CODE4 TRIAL4 VDD VSS) AN2D1BWP12T30P140
XVISIBLE4 (ANY03 DONE VISIBLE4 VDD VSS) OR2D1BWP12T30P140
XREAD4 (CODE4 VISIBLE4 D4 VDD VSS) AN2D1BWP12T30P140
XEMPTY5 (LOW_BITS EMPTY5 VDD VSS) INVD1BWP12T30P140
XTRIAL5 (EMPTY5 CODE5 TRIAL5 VDD VSS) AN2D1BWP12T30P140
XVISIBLE5 (LOW_BITS DONE VISIBLE5 VDD VSS) OR2D1BWP12T30P140
XREAD5 (CODE5 VISIBLE5 D5 VDD VSS) AN2D1BWP12T30P140
XEMPTY6 (ANY05 EMPTY6 VDD VSS) INVD1BWP12T30P140
XTRIAL6 (EMPTY6 CODE6 TRIAL6 VDD VSS) AN2D1BWP12T30P140
XVISIBLE6 (ANY05 DONE VISIBLE6 VDD VSS) OR2D1BWP12T30P140
XREAD6 (CODE6 VISIBLE6 D6 VDD VSS) AN2D1BWP12T30P140
XEMPTY7 (ANY06 EMPTY7 VDD VSS) INVD1BWP12T30P140
XTRIAL7 (EMPTY7 CODE7 TRIAL7 VDD VSS) AN2D1BWP12T30P140
XVISIBLE7 (ANY06 DONE VISIBLE7 VDD VSS) OR2D1BWP12T30P140
XREAD7 (CODE7 VISIBLE7 D7 VDD VSS) AN2D1BWP12T30P140
XBASE0 (D0 TRIAL1 BASE0 VDD VSS) OR2D1BWP12T30P140
XKEEP0 (CODE0 DATA KEEP0 VDD VSS) AN2D1BWP12T30P140
XNEXT0 (BASE0 KEEP0 NEXT0 VDD VSS) OR2D1BWP12T30P140
XBASE1 (D1 TRIAL2 BASE1 VDD VSS) OR2D1BWP12T30P140
XKEEP1 (TRIAL1 DATA KEEP1 VDD VSS) AN2D1BWP12T30P140
XNEXT1 (BASE1 KEEP1 NEXT1 VDD VSS) OR2D1BWP12T30P140
XBASE2 (D2 TRIAL3 BASE2 VDD VSS) OR2D1BWP12T30P140
XKEEP2 (TRIAL2 DATA KEEP2 VDD VSS) AN2D1BWP12T30P140
XNEXT2 (BASE2 KEEP2 NEXT2 VDD VSS) OR2D1BWP12T30P140
XBASE3 (D3 TRIAL4 BASE3 VDD VSS) OR2D1BWP12T30P140
XKEEP3 (TRIAL3 DATA KEEP3 VDD VSS) AN2D1BWP12T30P140
XNEXT3 (BASE3 KEEP3 NEXT3 VDD VSS) OR2D1BWP12T30P140
XBASE4 (D4 TRIAL5 BASE4 VDD VSS) OR2D1BWP12T30P140
XKEEP4 (TRIAL4 DATA KEEP4 VDD VSS) AN2D1BWP12T30P140
XNEXT4 (BASE4 KEEP4 NEXT4 VDD VSS) OR2D1BWP12T30P140
XBASE5 (D5 TRIAL6 BASE5 VDD VSS) OR2D1BWP12T30P140
XKEEP5 (TRIAL5 DATA KEEP5 VDD VSS) AN2D1BWP12T30P140
XNEXT5 (BASE5 KEEP5 NEXT5 VDD VSS) OR2D1BWP12T30P140
XBASE6 (D6 TRIAL7 BASE6 VDD VSS) OR2D1BWP12T30P140
XKEEP6 (TRIAL6 DATA KEEP6 VDD VSS) AN2D1BWP12T30P140
XNEXT6 (BASE6 KEEP6 NEXT6 VDD VSS) OR2D1BWP12T30P140
XKEEP7 (TRIAL7 DATA KEEP7 VDD VSS) AN2D1BWP12T30P140
XNEXT7 (D7 KEEP7 NEXT7 VDD VSS) OR2D1BWP12T30P140
// BEGIN SARADC RNL
// @RNL(author="saradc topology") {
// (-18,45) @TEXT("Next trial word",size=2,halign="start",textcolor="#223d52");
// #X01 @SET-SYMBOL $S_OR2D1BWP12T30P140;
// #X01 @PLACE(0,22) => @ORIENT("R0");
// #X23 @SET-SYMBOL $S_OR2D1BWP12T30P140;
// #X23 @PLACE(34,22) => @ORIENT("R0");
// #X45 @SET-SYMBOL $S_OR2D1BWP12T30P140;
// #X45 @PLACE(68,22) => @ORIENT("R0");
// #X02 @SET-SYMBOL $S_OR2D1BWP12T30P140;
// #X02 @PLACE(102,22) => @ORIENT("R0");
// #X03 @SET-SYMBOL $S_OR2D1BWP12T30P140;
// #X03 @PLACE(136,22) => @ORIENT("R0");
// #X04 @SET-SYMBOL $S_OR2D1BWP12T30P140;
// #X04 @PLACE(170,22) => @ORIENT("R0");
// #X05 @SET-SYMBOL $S_OR2D1BWP12T30P140;
// #X05 @PLACE(204,22) => @ORIENT("R0");
// #X06 @SET-SYMBOL $S_OR2D1BWP12T30P140;
// #X06 @PLACE(238,22) => @ORIENT("R0");
// (-24,-5) @TEXT("Bit 0",size=1.2,halign="start",textcolor="#223d52");
// #XREAD0 @SET-SYMBOL $S_AN2D1BWP12T30P140;
// #XREAD0 @PLACE(105,-12) => @ORIENT("R0");
// #XBASE0 @SET-SYMBOL $S_OR2D1BWP12T30P140;
// #XBASE0 @PLACE(140,-12) => @ORIENT("R0");
// #XKEEP0 @SET-SYMBOL $S_AN2D1BWP12T30P140;
// #XKEEP0 @PLACE(175,-12) => @ORIENT("R0");
// #XNEXT0 @SET-SYMBOL $S_OR2D1BWP12T30P140;
// #XNEXT0 @PLACE(210,-12) => @ORIENT("R0");
// (-24,-37) @TEXT("Bit 1",size=1.2,halign="start",textcolor="#223d52");
// #XEMPTY1 @SET-SYMBOL $S_INVD1BWP12T30P140;
// #XEMPTY1 @PLACE(0,-44) => @ORIENT("R0");
// #XTRIAL1 @SET-SYMBOL $S_AN2D1BWP12T30P140;
// #XTRIAL1 @PLACE(35,-44) => @ORIENT("R0");
// #XVISIBLE1 @SET-SYMBOL $S_OR2D1BWP12T30P140;
// #XVISIBLE1 @PLACE(70,-44) => @ORIENT("R0");
// #XREAD1 @SET-SYMBOL $S_AN2D1BWP12T30P140;
// #XREAD1 @PLACE(105,-44) => @ORIENT("R0");
// #XBASE1 @SET-SYMBOL $S_OR2D1BWP12T30P140;
// #XBASE1 @PLACE(140,-44) => @ORIENT("R0");
// #XKEEP1 @SET-SYMBOL $S_AN2D1BWP12T30P140;
// #XKEEP1 @PLACE(175,-44) => @ORIENT("R0");
// #XNEXT1 @SET-SYMBOL $S_OR2D1BWP12T30P140;
// #XNEXT1 @PLACE(210,-44) => @ORIENT("R0");
// (-24,-69) @TEXT("Bit 2",size=1.2,halign="start",textcolor="#223d52");
// #XEMPTY2 @SET-SYMBOL $S_INVD1BWP12T30P140;
// #XEMPTY2 @PLACE(0,-76) => @ORIENT("R0");
// #XTRIAL2 @SET-SYMBOL $S_AN2D1BWP12T30P140;
// #XTRIAL2 @PLACE(35,-76) => @ORIENT("R0");
// #XVISIBLE2 @SET-SYMBOL $S_OR2D1BWP12T30P140;
// #XVISIBLE2 @PLACE(70,-76) => @ORIENT("R0");
// #XREAD2 @SET-SYMBOL $S_AN2D1BWP12T30P140;
// #XREAD2 @PLACE(105,-76) => @ORIENT("R0");
// #XBASE2 @SET-SYMBOL $S_OR2D1BWP12T30P140;
// #XBASE2 @PLACE(140,-76) => @ORIENT("R0");
// #XKEEP2 @SET-SYMBOL $S_AN2D1BWP12T30P140;
// #XKEEP2 @PLACE(175,-76) => @ORIENT("R0");
// #XNEXT2 @SET-SYMBOL $S_OR2D1BWP12T30P140;
// #XNEXT2 @PLACE(210,-76) => @ORIENT("R0");
// (-24,-101) @TEXT("Bit 3",size=1.2,halign="start",textcolor="#223d52");
// #XEMPTY3 @SET-SYMBOL $S_INVD1BWP12T30P140;
// #XEMPTY3 @PLACE(0,-108) => @ORIENT("R0");
// #XTRIAL3 @SET-SYMBOL $S_AN2D1BWP12T30P140;
// #XTRIAL3 @PLACE(35,-108) => @ORIENT("R0");
// #XVISIBLE3 @SET-SYMBOL $S_OR2D1BWP12T30P140;
// #XVISIBLE3 @PLACE(70,-108) => @ORIENT("R0");
// #XREAD3 @SET-SYMBOL $S_AN2D1BWP12T30P140;
// #XREAD3 @PLACE(105,-108) => @ORIENT("R0");
// #XBASE3 @SET-SYMBOL $S_OR2D1BWP12T30P140;
// #XBASE3 @PLACE(140,-108) => @ORIENT("R0");
// #XKEEP3 @SET-SYMBOL $S_AN2D1BWP12T30P140;
// #XKEEP3 @PLACE(175,-108) => @ORIENT("R0");
// #XNEXT3 @SET-SYMBOL $S_OR2D1BWP12T30P140;
// #XNEXT3 @PLACE(210,-108) => @ORIENT("R0");
// (-24,-133) @TEXT("Bit 4",size=1.2,halign="start",textcolor="#223d52");
// #XEMPTY4 @SET-SYMBOL $S_INVD1BWP12T30P140;
// #XEMPTY4 @PLACE(0,-140) => @ORIENT("R0");
// #XTRIAL4 @SET-SYMBOL $S_AN2D1BWP12T30P140;
// #XTRIAL4 @PLACE(35,-140) => @ORIENT("R0");
// #XVISIBLE4 @SET-SYMBOL $S_OR2D1BWP12T30P140;
// #XVISIBLE4 @PLACE(70,-140) => @ORIENT("R0");
// #XREAD4 @SET-SYMBOL $S_AN2D1BWP12T30P140;
// #XREAD4 @PLACE(105,-140) => @ORIENT("R0");
// #XBASE4 @SET-SYMBOL $S_OR2D1BWP12T30P140;
// #XBASE4 @PLACE(140,-140) => @ORIENT("R0");
// #XKEEP4 @SET-SYMBOL $S_AN2D1BWP12T30P140;
// #XKEEP4 @PLACE(175,-140) => @ORIENT("R0");
// #XNEXT4 @SET-SYMBOL $S_OR2D1BWP12T30P140;
// #XNEXT4 @PLACE(210,-140) => @ORIENT("R0");
// (-24,-165) @TEXT("Bit 5",size=1.2,halign="start",textcolor="#223d52");
// #XEMPTY5 @SET-SYMBOL $S_INVD1BWP12T30P140;
// #XEMPTY5 @PLACE(0,-172) => @ORIENT("R0");
// #XTRIAL5 @SET-SYMBOL $S_AN2D1BWP12T30P140;
// #XTRIAL5 @PLACE(35,-172) => @ORIENT("R0");
// #XVISIBLE5 @SET-SYMBOL $S_OR2D1BWP12T30P140;
// #XVISIBLE5 @PLACE(70,-172) => @ORIENT("R0");
// #XREAD5 @SET-SYMBOL $S_AN2D1BWP12T30P140;
// #XREAD5 @PLACE(105,-172) => @ORIENT("R0");
// #XBASE5 @SET-SYMBOL $S_OR2D1BWP12T30P140;
// #XBASE5 @PLACE(140,-172) => @ORIENT("R0");
// #XKEEP5 @SET-SYMBOL $S_AN2D1BWP12T30P140;
// #XKEEP5 @PLACE(175,-172) => @ORIENT("R0");
// #XNEXT5 @SET-SYMBOL $S_OR2D1BWP12T30P140;
// #XNEXT5 @PLACE(210,-172) => @ORIENT("R0");
// (-24,-197) @TEXT("Bit 6",size=1.2,halign="start",textcolor="#223d52");
// #XEMPTY6 @SET-SYMBOL $S_INVD1BWP12T30P140;
// #XEMPTY6 @PLACE(0,-204) => @ORIENT("R0");
// #XTRIAL6 @SET-SYMBOL $S_AN2D1BWP12T30P140;
// #XTRIAL6 @PLACE(35,-204) => @ORIENT("R0");
// #XVISIBLE6 @SET-SYMBOL $S_OR2D1BWP12T30P140;
// #XVISIBLE6 @PLACE(70,-204) => @ORIENT("R0");
// #XREAD6 @SET-SYMBOL $S_AN2D1BWP12T30P140;
// #XREAD6 @PLACE(105,-204) => @ORIENT("R0");
// #XBASE6 @SET-SYMBOL $S_OR2D1BWP12T30P140;
// #XBASE6 @PLACE(140,-204) => @ORIENT("R0");
// #XKEEP6 @SET-SYMBOL $S_AN2D1BWP12T30P140;
// #XKEEP6 @PLACE(175,-204) => @ORIENT("R0");
// #XNEXT6 @SET-SYMBOL $S_OR2D1BWP12T30P140;
// #XNEXT6 @PLACE(210,-204) => @ORIENT("R0");
// (-24,-229) @TEXT("Bit 7",size=1.2,halign="start",textcolor="#223d52");
// #XEMPTY7 @SET-SYMBOL $S_INVD1BWP12T30P140;
// #XEMPTY7 @PLACE(0,-236) => @ORIENT("R0");
// #XTRIAL7 @SET-SYMBOL $S_AN2D1BWP12T30P140;
// #XTRIAL7 @PLACE(35,-236) => @ORIENT("R0");
// #XVISIBLE7 @SET-SYMBOL $S_OR2D1BWP12T30P140;
// #XVISIBLE7 @PLACE(70,-236) => @ORIENT("R0");
// #XREAD7 @SET-SYMBOL $S_AN2D1BWP12T30P140;
// #XREAD7 @PLACE(105,-236) => @ORIENT("R0");
// #XKEEP7 @SET-SYMBOL $S_AN2D1BWP12T30P140;
// #XKEEP7 @PLACE(175,-236) => @ORIENT("R0");
// #XNEXT7 @SET-SYMBOL $S_OR2D1BWP12T30P140;
// #XNEXT7 @PLACE(210,-236) => @ORIENT("R0");
// &"D0" @WIRE(mode="straight",linecolor="#30485d",linewidth=0.16) {#XREAD0:3 (122.5,-12) (122.5,-10.35) #XBASE0:1};
// &"EMPTY1" @WIRE(mode="straight",linecolor="#30485d",linewidth=0.16) {#XEMPTY1:2 (14.5,-44) (14.5,-42.35) #XTRIAL1:1};
// &"VISIBLE1" @WIRE(mode="straight",linecolor="#30485d",linewidth=0.16) {#XVISIBLE1:3 (87.5,-44) (87.5,-45.65) #XREAD1:2};
// &"D1" @WIRE(mode="straight",linecolor="#30485d",linewidth=0.16) {#XREAD1:3 (122.5,-44) (122.5,-42.35) #XBASE1:1};
// &"EMPTY2" @WIRE(mode="straight",linecolor="#30485d",linewidth=0.16) {#XEMPTY2:2 (14.5,-76) (14.5,-74.35) #XTRIAL2:1};
// &"VISIBLE2" @WIRE(mode="straight",linecolor="#30485d",linewidth=0.16) {#XVISIBLE2:3 (87.5,-76) (87.5,-77.65) #XREAD2:2};
// &"D2" @WIRE(mode="straight",linecolor="#30485d",linewidth=0.16) {#XREAD2:3 (122.5,-76) (122.5,-74.35) #XBASE2:1};
// &"EMPTY3" @WIRE(mode="straight",linecolor="#30485d",linewidth=0.16) {#XEMPTY3:2 (14.5,-108) (14.5,-106.35) #XTRIAL3:1};
// &"VISIBLE3" @WIRE(mode="straight",linecolor="#30485d",linewidth=0.16) {#XVISIBLE3:3 (87.5,-108) (87.5,-109.65) #XREAD3:2};
// &"D3" @WIRE(mode="straight",linecolor="#30485d",linewidth=0.16) {#XREAD3:3 (122.5,-108) (122.5,-106.35) #XBASE3:1};
// &"EMPTY4" @WIRE(mode="straight",linecolor="#30485d",linewidth=0.16) {#XEMPTY4:2 (14.5,-140) (14.5,-138.35) #XTRIAL4:1};
// &"VISIBLE4" @WIRE(mode="straight",linecolor="#30485d",linewidth=0.16) {#XVISIBLE4:3 (87.5,-140) (87.5,-141.65) #XREAD4:2};
// &"D4" @WIRE(mode="straight",linecolor="#30485d",linewidth=0.16) {#XREAD4:3 (122.5,-140) (122.5,-138.35) #XBASE4:1};
// &"EMPTY5" @WIRE(mode="straight",linecolor="#30485d",linewidth=0.16) {#XEMPTY5:2 (14.5,-172) (14.5,-170.35) #XTRIAL5:1};
// &"VISIBLE5" @WIRE(mode="straight",linecolor="#30485d",linewidth=0.16) {#XVISIBLE5:3 (87.5,-172) (87.5,-173.65) #XREAD5:2};
// &"D5" @WIRE(mode="straight",linecolor="#30485d",linewidth=0.16) {#XREAD5:3 (122.5,-172) (122.5,-170.35) #XBASE5:1};
// &"EMPTY6" @WIRE(mode="straight",linecolor="#30485d",linewidth=0.16) {#XEMPTY6:2 (14.5,-204) (14.5,-202.35) #XTRIAL6:1};
// &"VISIBLE6" @WIRE(mode="straight",linecolor="#30485d",linewidth=0.16) {#XVISIBLE6:3 (87.5,-204) (87.5,-205.65) #XREAD6:2};
// &"D6" @WIRE(mode="straight",linecolor="#30485d",linewidth=0.16) {#XREAD6:3 (122.5,-204) (122.5,-202.35) #XBASE6:1};
// &"EMPTY7" @WIRE(mode="straight",linecolor="#30485d",linewidth=0.16) {#XEMPTY7:2 (14.5,-236) (14.5,-234.35) #XTRIAL7:1};
// &"VISIBLE7" @WIRE(mode="straight",linecolor="#30485d",linewidth=0.16) {#XVISIBLE7:3 (87.5,-236) (87.5,-237.65) #XREAD7:2};
// &"KEEP0" @WIRE(mode="straight",linecolor="#30485d",linewidth=0.16) {#XKEEP0:3 (192.5,-12) (192.5,-13.65) #XNEXT0:2};
// &"KEEP1" @WIRE(mode="straight",linecolor="#30485d",linewidth=0.16) {#XKEEP1:3 (192.5,-44) (192.5,-45.65) #XNEXT1:2};
// &"KEEP2" @WIRE(mode="straight",linecolor="#30485d",linewidth=0.16) {#XKEEP2:3 (192.5,-76) (192.5,-77.65) #XNEXT2:2};
// &"KEEP3" @WIRE(mode="straight",linecolor="#30485d",linewidth=0.16) {#XKEEP3:3 (192.5,-108) (192.5,-109.65) #XNEXT3:2};
// &"KEEP4" @WIRE(mode="straight",linecolor="#30485d",linewidth=0.16) {#XKEEP4:3 (192.5,-140) (192.5,-141.65) #XNEXT4:2};
// &"KEEP5" @WIRE(mode="straight",linecolor="#30485d",linewidth=0.16) {#XKEEP5:3 (192.5,-172) (192.5,-173.65) #XNEXT5:2};
// &"KEEP6" @WIRE(mode="straight",linecolor="#30485d",linewidth=0.16) {#XKEEP6:3 (192.5,-204) (192.5,-205.65) #XNEXT6:2};
// &"KEEP7" @WIRE(mode="straight",linecolor="#30485d",linewidth=0.16) {#XKEEP7:3 (192.5,-236) (192.5,-237.65) #XNEXT7:2};
// &"CODE0" @WIRE(mode="straight",linecolor="#30485d",linewidth=0.16) {#X01:1 (-16,23.65)};
// (-16.4,23.65) @TEXT("CODE0",size=1.1,halign="end",valign="middle");
// &"CODE1" @WIRE(mode="straight",linecolor="#30485d",linewidth=0.16) {#X01:2 (-16,20.35)};
// (-16.4,20.35) @TEXT("CODE1",size=1.1,halign="end",valign="middle");
// &"ANY01" @WIRE(mode="straight",linecolor="#30485d",linewidth=0.16) {#X01:3 (16,22)};
// (16.4,22) @TEXT("ANY01",size=1.1,halign="start",valign="middle");
// &"VDD" @WIRE(mode="straight",linecolor="#30485d",linewidth=0.16) {#X01:4 (0,33)};
// (0,33.4) @TEXT("VDD",size=1.1,halign="middle",valign="bottom");
// &"VSS" @WIRE(mode="straight",linecolor="#30485d",linewidth=0.16) {#X01:5 (0,11)};
// (0,10.6) @TEXT("VSS",size=1.1,halign="middle",valign="top");
// &"CODE2" @WIRE(mode="straight",linecolor="#30485d",linewidth=0.16) {#X23:1 (18,23.65)};
// (17.6,23.65) @TEXT("CODE2",size=1.1,halign="end",valign="middle");
// &"CODE3" @WIRE(mode="straight",linecolor="#30485d",linewidth=0.16) {#X23:2 (18,20.35)};
// (17.6,20.35) @TEXT("CODE3",size=1.1,halign="end",valign="middle");
// &"ANY23" @WIRE(mode="straight",linecolor="#30485d",linewidth=0.16) {#X23:3 (50,22)};
// (50.4,22) @TEXT("ANY23",size=1.1,halign="start",valign="middle");
// &"VDD" @WIRE(mode="straight",linecolor="#30485d",linewidth=0.16) {#X23:4 (34,33)};
// (34,33.4) @TEXT("VDD",size=1.1,halign="middle",valign="bottom");
// &"VSS" @WIRE(mode="straight",linecolor="#30485d",linewidth=0.16) {#X23:5 (34,11)};
// (34,10.6) @TEXT("VSS",size=1.1,halign="middle",valign="top");
// &"CODE4" @WIRE(mode="straight",linecolor="#30485d",linewidth=0.16) {#X45:1 (52,23.65)};
// (51.6,23.65) @TEXT("CODE4",size=1.1,halign="end",valign="middle");
// &"CODE5" @WIRE(mode="straight",linecolor="#30485d",linewidth=0.16) {#X45:2 (52,20.35)};
// (51.6,20.35) @TEXT("CODE5",size=1.1,halign="end",valign="middle");
// &"ANY45" @WIRE(mode="straight",linecolor="#30485d",linewidth=0.16) {#X45:3 (84,22)};
// (84.4,22) @TEXT("ANY45",size=1.1,halign="start",valign="middle");
// &"VDD" @WIRE(mode="straight",linecolor="#30485d",linewidth=0.16) {#X45:4 (68,33)};
// (68,33.4) @TEXT("VDD",size=1.1,halign="middle",valign="bottom");
// &"VSS" @WIRE(mode="straight",linecolor="#30485d",linewidth=0.16) {#X45:5 (68,11)};
// (68,10.6) @TEXT("VSS",size=1.1,halign="middle",valign="top");
// &"ANY01" @WIRE(mode="straight",linecolor="#30485d",linewidth=0.16) {#X02:1 (86,23.65)};
// (85.6,23.65) @TEXT("ANY01",size=1.1,halign="end",valign="middle");
// &"CODE2" @WIRE(mode="straight",linecolor="#30485d",linewidth=0.16) {#X02:2 (86,20.35)};
// (85.6,20.35) @TEXT("CODE2",size=1.1,halign="end",valign="middle");
// &"ANY02" @WIRE(mode="straight",linecolor="#30485d",linewidth=0.16) {#X02:3 (118,22)};
// (118.4,22) @TEXT("ANY02",size=1.1,halign="start",valign="middle");
// &"VDD" @WIRE(mode="straight",linecolor="#30485d",linewidth=0.16) {#X02:4 (102,33)};
// (102,33.4) @TEXT("VDD",size=1.1,halign="middle",valign="bottom");
// &"VSS" @WIRE(mode="straight",linecolor="#30485d",linewidth=0.16) {#X02:5 (102,11)};
// (102,10.6) @TEXT("VSS",size=1.1,halign="middle",valign="top");
// &"ANY01" @WIRE(mode="straight",linecolor="#30485d",linewidth=0.16) {#X03:1 (120,23.65)};
// (119.6,23.65) @TEXT("ANY01",size=1.1,halign="end",valign="middle");
// &"ANY23" @WIRE(mode="straight",linecolor="#30485d",linewidth=0.16) {#X03:2 (120,20.35)};
// (119.6,20.35) @TEXT("ANY23",size=1.1,halign="end",valign="middle");
// &"ANY03" @WIRE(mode="straight",linecolor="#30485d",linewidth=0.16) {#X03:3 (152,22)};
// (152.4,22) @TEXT("ANY03",size=1.1,halign="start",valign="middle");
// &"VDD" @WIRE(mode="straight",linecolor="#30485d",linewidth=0.16) {#X03:4 (136,33)};
// (136,33.4) @TEXT("VDD",size=1.1,halign="middle",valign="bottom");
// &"VSS" @WIRE(mode="straight",linecolor="#30485d",linewidth=0.16) {#X03:5 (136,11)};
// (136,10.6) @TEXT("VSS",size=1.1,halign="middle",valign="top");
// &"ANY03" @WIRE(mode="straight",linecolor="#30485d",linewidth=0.16) {#X04:1 (154,23.65)};
// (153.6,23.65) @TEXT("ANY03",size=1.1,halign="end",valign="middle");
// &"CODE4" @WIRE(mode="straight",linecolor="#30485d",linewidth=0.16) {#X04:2 (154,20.35)};
// (153.6,20.35) @TEXT("CODE4",size=1.1,halign="end",valign="middle");
// &"LOW_BITS" @WIRE(mode="straight",linecolor="#30485d",linewidth=0.16) {#X04:3 (186,22)};
// (186.4,22) @TEXT("LOW_BITS",size=1.1,halign="start",valign="middle");
// &"VDD" @WIRE(mode="straight",linecolor="#30485d",linewidth=0.16) {#X04:4 (170,33)};
// (170,33.4) @TEXT("VDD",size=1.1,halign="middle",valign="bottom");
// &"VSS" @WIRE(mode="straight",linecolor="#30485d",linewidth=0.16) {#X04:5 (170,11)};
// (170,10.6) @TEXT("VSS",size=1.1,halign="middle",valign="top");
// &"ANY03" @WIRE(mode="straight",linecolor="#30485d",linewidth=0.16) {#X05:1 (188,23.65)};
// (187.6,23.65) @TEXT("ANY03",size=1.1,halign="end",valign="middle");
// &"ANY45" @WIRE(mode="straight",linecolor="#30485d",linewidth=0.16) {#X05:2 (188,20.35)};
// (187.6,20.35) @TEXT("ANY45",size=1.1,halign="end",valign="middle");
// &"ANY05" @WIRE(mode="straight",linecolor="#30485d",linewidth=0.16) {#X05:3 (220,22)};
// (220.4,22) @TEXT("ANY05",size=1.1,halign="start",valign="middle");
// &"VDD" @WIRE(mode="straight",linecolor="#30485d",linewidth=0.16) {#X05:4 (204,33)};
// (204,33.4) @TEXT("VDD",size=1.1,halign="middle",valign="bottom");
// &"VSS" @WIRE(mode="straight",linecolor="#30485d",linewidth=0.16) {#X05:5 (204,11)};
// (204,10.6) @TEXT("VSS",size=1.1,halign="middle",valign="top");
// &"ANY05" @WIRE(mode="straight",linecolor="#30485d",linewidth=0.16) {#X06:1 (222,23.65)};
// (221.6,23.65) @TEXT("ANY05",size=1.1,halign="end",valign="middle");
// &"CODE6" @WIRE(mode="straight",linecolor="#30485d",linewidth=0.16) {#X06:2 (222,20.35)};
// (221.6,20.35) @TEXT("CODE6",size=1.1,halign="end",valign="middle");
// &"ANY06" @WIRE(mode="straight",linecolor="#30485d",linewidth=0.16) {#X06:3 (254,22)};
// (254.4,22) @TEXT("ANY06",size=1.1,halign="start",valign="middle");
// &"VDD" @WIRE(mode="straight",linecolor="#30485d",linewidth=0.16) {#X06:4 (238,33)};
// (238,33.4) @TEXT("VDD",size=1.1,halign="middle",valign="bottom");
// &"VSS" @WIRE(mode="straight",linecolor="#30485d",linewidth=0.16) {#X06:5 (238,11)};
// (238,10.6) @TEXT("VSS",size=1.1,halign="middle",valign="top");
// &"CODE0" @WIRE(mode="straight",linecolor="#30485d",linewidth=0.16) {#XREAD0:1 (89,-10.35)};
// (88.6,-10.35) @TEXT("CODE0",size=1.1,halign="end",valign="middle");
// &"DONE" @WIRE(mode="straight",linecolor="#30485d",linewidth=0.16) {#XREAD0:2 (89,-13.65)};
// (88.6,-13.65) @TEXT("DONE",size=1.1,halign="end",valign="middle");
// &"VDD" @WIRE(mode="straight",linecolor="#30485d",linewidth=0.16) {#XREAD0:4 (105,-1)};
// (105,-0.6) @TEXT("VDD",size=1.1,halign="middle",valign="bottom");
// &"VSS" @WIRE(mode="straight",linecolor="#30485d",linewidth=0.16) {#XREAD0:5 (105,-23)};
// (105,-23.4) @TEXT("VSS",size=1.1,halign="middle",valign="top");
// &"CODE0" @WIRE(mode="straight",linecolor="#30485d",linewidth=0.16) {#XEMPTY1:1 (-10,-44)};
// (-10.4,-44) @TEXT("CODE0",size=1.1,halign="end",valign="middle");
// &"VDD" @WIRE(mode="straight",linecolor="#30485d",linewidth=0.16) {#XEMPTY1:3 (0,-34)};
// (0,-33.6) @TEXT("VDD",size=1.1,halign="middle",valign="bottom");
// &"VSS" @WIRE(mode="straight",linecolor="#30485d",linewidth=0.16) {#XEMPTY1:4 (0,-54)};
// (0,-54.4) @TEXT("VSS",size=1.1,halign="middle",valign="top");
// &"CODE1" @WIRE(mode="straight",linecolor="#30485d",linewidth=0.16) {#XTRIAL1:2 (19,-45.65)};
// (18.6,-45.65) @TEXT("CODE1",size=1.1,halign="end",valign="middle");
// &"TRIAL1" @WIRE(mode="straight",linecolor="#30485d",linewidth=0.16) {#XTRIAL1:3 (51,-44)};
// (51.4,-44) @TEXT("TRIAL1",size=1.1,halign="start",valign="middle");
// &"VDD" @WIRE(mode="straight",linecolor="#30485d",linewidth=0.16) {#XTRIAL1:4 (35,-33)};
// (35,-32.6) @TEXT("VDD",size=1.1,halign="middle",valign="bottom");
// &"VSS" @WIRE(mode="straight",linecolor="#30485d",linewidth=0.16) {#XTRIAL1:5 (35,-55)};
// (35,-55.4) @TEXT("VSS",size=1.1,halign="middle",valign="top");
// &"CODE0" @WIRE(mode="straight",linecolor="#30485d",linewidth=0.16) {#XVISIBLE1:1 (54,-42.35)};
// (53.6,-42.35) @TEXT("CODE0",size=1.1,halign="end",valign="middle");
// &"DONE" @WIRE(mode="straight",linecolor="#30485d",linewidth=0.16) {#XVISIBLE1:2 (54,-45.65)};
// (53.6,-45.65) @TEXT("DONE",size=1.1,halign="end",valign="middle");
// &"VDD" @WIRE(mode="straight",linecolor="#30485d",linewidth=0.16) {#XVISIBLE1:4 (70,-33)};
// (70,-32.6) @TEXT("VDD",size=1.1,halign="middle",valign="bottom");
// &"VSS" @WIRE(mode="straight",linecolor="#30485d",linewidth=0.16) {#XVISIBLE1:5 (70,-55)};
// (70,-55.4) @TEXT("VSS",size=1.1,halign="middle",valign="top");
// &"CODE1" @WIRE(mode="straight",linecolor="#30485d",linewidth=0.16) {#XREAD1:1 (89,-42.35)};
// (88.6,-42.35) @TEXT("CODE1",size=1.1,halign="end",valign="middle");
// &"VDD" @WIRE(mode="straight",linecolor="#30485d",linewidth=0.16) {#XREAD1:4 (105,-33)};
// (105,-32.6) @TEXT("VDD",size=1.1,halign="middle",valign="bottom");
// &"VSS" @WIRE(mode="straight",linecolor="#30485d",linewidth=0.16) {#XREAD1:5 (105,-55)};
// (105,-55.4) @TEXT("VSS",size=1.1,halign="middle",valign="top");
// &"ANY01" @WIRE(mode="straight",linecolor="#30485d",linewidth=0.16) {#XEMPTY2:1 (-10,-76)};
// (-10.4,-76) @TEXT("ANY01",size=1.1,halign="end",valign="middle");
// &"VDD" @WIRE(mode="straight",linecolor="#30485d",linewidth=0.16) {#XEMPTY2:3 (0,-66)};
// (0,-65.6) @TEXT("VDD",size=1.1,halign="middle",valign="bottom");
// &"VSS" @WIRE(mode="straight",linecolor="#30485d",linewidth=0.16) {#XEMPTY2:4 (0,-86)};
// (0,-86.4) @TEXT("VSS",size=1.1,halign="middle",valign="top");
// &"CODE2" @WIRE(mode="straight",linecolor="#30485d",linewidth=0.16) {#XTRIAL2:2 (19,-77.65)};
// (18.6,-77.65) @TEXT("CODE2",size=1.1,halign="end",valign="middle");
// &"TRIAL2" @WIRE(mode="straight",linecolor="#30485d",linewidth=0.16) {#XTRIAL2:3 (51,-76)};
// (51.4,-76) @TEXT("TRIAL2",size=1.1,halign="start",valign="middle");
// &"VDD" @WIRE(mode="straight",linecolor="#30485d",linewidth=0.16) {#XTRIAL2:4 (35,-65)};
// (35,-64.6) @TEXT("VDD",size=1.1,halign="middle",valign="bottom");
// &"VSS" @WIRE(mode="straight",linecolor="#30485d",linewidth=0.16) {#XTRIAL2:5 (35,-87)};
// (35,-87.4) @TEXT("VSS",size=1.1,halign="middle",valign="top");
// &"ANY01" @WIRE(mode="straight",linecolor="#30485d",linewidth=0.16) {#XVISIBLE2:1 (54,-74.35)};
// (53.6,-74.35) @TEXT("ANY01",size=1.1,halign="end",valign="middle");
// &"DONE" @WIRE(mode="straight",linecolor="#30485d",linewidth=0.16) {#XVISIBLE2:2 (54,-77.65)};
// (53.6,-77.65) @TEXT("DONE",size=1.1,halign="end",valign="middle");
// &"VDD" @WIRE(mode="straight",linecolor="#30485d",linewidth=0.16) {#XVISIBLE2:4 (70,-65)};
// (70,-64.6) @TEXT("VDD",size=1.1,halign="middle",valign="bottom");
// &"VSS" @WIRE(mode="straight",linecolor="#30485d",linewidth=0.16) {#XVISIBLE2:5 (70,-87)};
// (70,-87.4) @TEXT("VSS",size=1.1,halign="middle",valign="top");
// &"CODE2" @WIRE(mode="straight",linecolor="#30485d",linewidth=0.16) {#XREAD2:1 (89,-74.35)};
// (88.6,-74.35) @TEXT("CODE2",size=1.1,halign="end",valign="middle");
// &"VDD" @WIRE(mode="straight",linecolor="#30485d",linewidth=0.16) {#XREAD2:4 (105,-65)};
// (105,-64.6) @TEXT("VDD",size=1.1,halign="middle",valign="bottom");
// &"VSS" @WIRE(mode="straight",linecolor="#30485d",linewidth=0.16) {#XREAD2:5 (105,-87)};
// (105,-87.4) @TEXT("VSS",size=1.1,halign="middle",valign="top");
// &"ANY02" @WIRE(mode="straight",linecolor="#30485d",linewidth=0.16) {#XEMPTY3:1 (-10,-108)};
// (-10.4,-108) @TEXT("ANY02",size=1.1,halign="end",valign="middle");
// &"VDD" @WIRE(mode="straight",linecolor="#30485d",linewidth=0.16) {#XEMPTY3:3 (0,-98)};
// (0,-97.6) @TEXT("VDD",size=1.1,halign="middle",valign="bottom");
// &"VSS" @WIRE(mode="straight",linecolor="#30485d",linewidth=0.16) {#XEMPTY3:4 (0,-118)};
// (0,-118.4) @TEXT("VSS",size=1.1,halign="middle",valign="top");
// &"CODE3" @WIRE(mode="straight",linecolor="#30485d",linewidth=0.16) {#XTRIAL3:2 (19,-109.65)};
// (18.6,-109.65) @TEXT("CODE3",size=1.1,halign="end",valign="middle");
// &"TRIAL3" @WIRE(mode="straight",linecolor="#30485d",linewidth=0.16) {#XTRIAL3:3 (51,-108)};
// (51.4,-108) @TEXT("TRIAL3",size=1.1,halign="start",valign="middle");
// &"VDD" @WIRE(mode="straight",linecolor="#30485d",linewidth=0.16) {#XTRIAL3:4 (35,-97)};
// (35,-96.6) @TEXT("VDD",size=1.1,halign="middle",valign="bottom");
// &"VSS" @WIRE(mode="straight",linecolor="#30485d",linewidth=0.16) {#XTRIAL3:5 (35,-119)};
// (35,-119.4) @TEXT("VSS",size=1.1,halign="middle",valign="top");
// &"ANY02" @WIRE(mode="straight",linecolor="#30485d",linewidth=0.16) {#XVISIBLE3:1 (54,-106.35)};
// (53.6,-106.35) @TEXT("ANY02",size=1.1,halign="end",valign="middle");
// &"DONE" @WIRE(mode="straight",linecolor="#30485d",linewidth=0.16) {#XVISIBLE3:2 (54,-109.65)};
// (53.6,-109.65) @TEXT("DONE",size=1.1,halign="end",valign="middle");
// &"VDD" @WIRE(mode="straight",linecolor="#30485d",linewidth=0.16) {#XVISIBLE3:4 (70,-97)};
// (70,-96.6) @TEXT("VDD",size=1.1,halign="middle",valign="bottom");
// &"VSS" @WIRE(mode="straight",linecolor="#30485d",linewidth=0.16) {#XVISIBLE3:5 (70,-119)};
// (70,-119.4) @TEXT("VSS",size=1.1,halign="middle",valign="top");
// &"CODE3" @WIRE(mode="straight",linecolor="#30485d",linewidth=0.16) {#XREAD3:1 (89,-106.35)};
// (88.6,-106.35) @TEXT("CODE3",size=1.1,halign="end",valign="middle");
// &"VDD" @WIRE(mode="straight",linecolor="#30485d",linewidth=0.16) {#XREAD3:4 (105,-97)};
// (105,-96.6) @TEXT("VDD",size=1.1,halign="middle",valign="bottom");
// &"VSS" @WIRE(mode="straight",linecolor="#30485d",linewidth=0.16) {#XREAD3:5 (105,-119)};
// (105,-119.4) @TEXT("VSS",size=1.1,halign="middle",valign="top");
// &"ANY03" @WIRE(mode="straight",linecolor="#30485d",linewidth=0.16) {#XEMPTY4:1 (-10,-140)};
// (-10.4,-140) @TEXT("ANY03",size=1.1,halign="end",valign="middle");
// &"VDD" @WIRE(mode="straight",linecolor="#30485d",linewidth=0.16) {#XEMPTY4:3 (0,-130)};
// (0,-129.6) @TEXT("VDD",size=1.1,halign="middle",valign="bottom");
// &"VSS" @WIRE(mode="straight",linecolor="#30485d",linewidth=0.16) {#XEMPTY4:4 (0,-150)};
// (0,-150.4) @TEXT("VSS",size=1.1,halign="middle",valign="top");
// &"CODE4" @WIRE(mode="straight",linecolor="#30485d",linewidth=0.16) {#XTRIAL4:2 (19,-141.65)};
// (18.6,-141.65) @TEXT("CODE4",size=1.1,halign="end",valign="middle");
// &"TRIAL4" @WIRE(mode="straight",linecolor="#30485d",linewidth=0.16) {#XTRIAL4:3 (51,-140)};
// (51.4,-140) @TEXT("TRIAL4",size=1.1,halign="start",valign="middle");
// &"VDD" @WIRE(mode="straight",linecolor="#30485d",linewidth=0.16) {#XTRIAL4:4 (35,-129)};
// (35,-128.6) @TEXT("VDD",size=1.1,halign="middle",valign="bottom");
// &"VSS" @WIRE(mode="straight",linecolor="#30485d",linewidth=0.16) {#XTRIAL4:5 (35,-151)};
// (35,-151.4) @TEXT("VSS",size=1.1,halign="middle",valign="top");
// &"ANY03" @WIRE(mode="straight",linecolor="#30485d",linewidth=0.16) {#XVISIBLE4:1 (54,-138.35)};
// (53.6,-138.35) @TEXT("ANY03",size=1.1,halign="end",valign="middle");
// &"DONE" @WIRE(mode="straight",linecolor="#30485d",linewidth=0.16) {#XVISIBLE4:2 (54,-141.65)};
// (53.6,-141.65) @TEXT("DONE",size=1.1,halign="end",valign="middle");
// &"VDD" @WIRE(mode="straight",linecolor="#30485d",linewidth=0.16) {#XVISIBLE4:4 (70,-129)};
// (70,-128.6) @TEXT("VDD",size=1.1,halign="middle",valign="bottom");
// &"VSS" @WIRE(mode="straight",linecolor="#30485d",linewidth=0.16) {#XVISIBLE4:5 (70,-151)};
// (70,-151.4) @TEXT("VSS",size=1.1,halign="middle",valign="top");
// &"CODE4" @WIRE(mode="straight",linecolor="#30485d",linewidth=0.16) {#XREAD4:1 (89,-138.35)};
// (88.6,-138.35) @TEXT("CODE4",size=1.1,halign="end",valign="middle");
// &"VDD" @WIRE(mode="straight",linecolor="#30485d",linewidth=0.16) {#XREAD4:4 (105,-129)};
// (105,-128.6) @TEXT("VDD",size=1.1,halign="middle",valign="bottom");
// &"VSS" @WIRE(mode="straight",linecolor="#30485d",linewidth=0.16) {#XREAD4:5 (105,-151)};
// (105,-151.4) @TEXT("VSS",size=1.1,halign="middle",valign="top");
// &"LOW_BITS" @WIRE(mode="straight",linecolor="#30485d",linewidth=0.16) {#XEMPTY5:1 (-10,-172)};
// (-10.4,-172) @TEXT("LOW_BITS",size=1.1,halign="end",valign="middle");
// &"VDD" @WIRE(mode="straight",linecolor="#30485d",linewidth=0.16) {#XEMPTY5:3 (0,-162)};
// (0,-161.6) @TEXT("VDD",size=1.1,halign="middle",valign="bottom");
// &"VSS" @WIRE(mode="straight",linecolor="#30485d",linewidth=0.16) {#XEMPTY5:4 (0,-182)};
// (0,-182.4) @TEXT("VSS",size=1.1,halign="middle",valign="top");
// &"CODE5" @WIRE(mode="straight",linecolor="#30485d",linewidth=0.16) {#XTRIAL5:2 (19,-173.65)};
// (18.6,-173.65) @TEXT("CODE5",size=1.1,halign="end",valign="middle");
// &"TRIAL5" @WIRE(mode="straight",linecolor="#30485d",linewidth=0.16) {#XTRIAL5:3 (51,-172)};
// (51.4,-172) @TEXT("TRIAL5",size=1.1,halign="start",valign="middle");
// &"VDD" @WIRE(mode="straight",linecolor="#30485d",linewidth=0.16) {#XTRIAL5:4 (35,-161)};
// (35,-160.6) @TEXT("VDD",size=1.1,halign="middle",valign="bottom");
// &"VSS" @WIRE(mode="straight",linecolor="#30485d",linewidth=0.16) {#XTRIAL5:5 (35,-183)};
// (35,-183.4) @TEXT("VSS",size=1.1,halign="middle",valign="top");
// &"LOW_BITS" @WIRE(mode="straight",linecolor="#30485d",linewidth=0.16) {#XVISIBLE5:1 (54,-170.35)};
// (53.6,-170.35) @TEXT("LOW_BITS",size=1.1,halign="end",valign="middle");
// &"DONE" @WIRE(mode="straight",linecolor="#30485d",linewidth=0.16) {#XVISIBLE5:2 (54,-173.65)};
// (53.6,-173.65) @TEXT("DONE",size=1.1,halign="end",valign="middle");
// &"VDD" @WIRE(mode="straight",linecolor="#30485d",linewidth=0.16) {#XVISIBLE5:4 (70,-161)};
// (70,-160.6) @TEXT("VDD",size=1.1,halign="middle",valign="bottom");
// &"VSS" @WIRE(mode="straight",linecolor="#30485d",linewidth=0.16) {#XVISIBLE5:5 (70,-183)};
// (70,-183.4) @TEXT("VSS",size=1.1,halign="middle",valign="top");
// &"CODE5" @WIRE(mode="straight",linecolor="#30485d",linewidth=0.16) {#XREAD5:1 (89,-170.35)};
// (88.6,-170.35) @TEXT("CODE5",size=1.1,halign="end",valign="middle");
// &"VDD" @WIRE(mode="straight",linecolor="#30485d",linewidth=0.16) {#XREAD5:4 (105,-161)};
// (105,-160.6) @TEXT("VDD",size=1.1,halign="middle",valign="bottom");
// &"VSS" @WIRE(mode="straight",linecolor="#30485d",linewidth=0.16) {#XREAD5:5 (105,-183)};
// (105,-183.4) @TEXT("VSS",size=1.1,halign="middle",valign="top");
// &"ANY05" @WIRE(mode="straight",linecolor="#30485d",linewidth=0.16) {#XEMPTY6:1 (-10,-204)};
// (-10.4,-204) @TEXT("ANY05",size=1.1,halign="end",valign="middle");
// &"VDD" @WIRE(mode="straight",linecolor="#30485d",linewidth=0.16) {#XEMPTY6:3 (0,-194)};
// (0,-193.6) @TEXT("VDD",size=1.1,halign="middle",valign="bottom");
// &"VSS" @WIRE(mode="straight",linecolor="#30485d",linewidth=0.16) {#XEMPTY6:4 (0,-214)};
// (0,-214.4) @TEXT("VSS",size=1.1,halign="middle",valign="top");
// &"CODE6" @WIRE(mode="straight",linecolor="#30485d",linewidth=0.16) {#XTRIAL6:2 (19,-205.65)};
// (18.6,-205.65) @TEXT("CODE6",size=1.1,halign="end",valign="middle");
// &"TRIAL6" @WIRE(mode="straight",linecolor="#30485d",linewidth=0.16) {#XTRIAL6:3 (51,-204)};
// (51.4,-204) @TEXT("TRIAL6",size=1.1,halign="start",valign="middle");
// &"VDD" @WIRE(mode="straight",linecolor="#30485d",linewidth=0.16) {#XTRIAL6:4 (35,-193)};
// (35,-192.6) @TEXT("VDD",size=1.1,halign="middle",valign="bottom");
// &"VSS" @WIRE(mode="straight",linecolor="#30485d",linewidth=0.16) {#XTRIAL6:5 (35,-215)};
// (35,-215.4) @TEXT("VSS",size=1.1,halign="middle",valign="top");
// &"ANY05" @WIRE(mode="straight",linecolor="#30485d",linewidth=0.16) {#XVISIBLE6:1 (54,-202.35)};
// (53.6,-202.35) @TEXT("ANY05",size=1.1,halign="end",valign="middle");
// &"DONE" @WIRE(mode="straight",linecolor="#30485d",linewidth=0.16) {#XVISIBLE6:2 (54,-205.65)};
// (53.6,-205.65) @TEXT("DONE",size=1.1,halign="end",valign="middle");
// &"VDD" @WIRE(mode="straight",linecolor="#30485d",linewidth=0.16) {#XVISIBLE6:4 (70,-193)};
// (70,-192.6) @TEXT("VDD",size=1.1,halign="middle",valign="bottom");
// &"VSS" @WIRE(mode="straight",linecolor="#30485d",linewidth=0.16) {#XVISIBLE6:5 (70,-215)};
// (70,-215.4) @TEXT("VSS",size=1.1,halign="middle",valign="top");
// &"CODE6" @WIRE(mode="straight",linecolor="#30485d",linewidth=0.16) {#XREAD6:1 (89,-202.35)};
// (88.6,-202.35) @TEXT("CODE6",size=1.1,halign="end",valign="middle");
// &"VDD" @WIRE(mode="straight",linecolor="#30485d",linewidth=0.16) {#XREAD6:4 (105,-193)};
// (105,-192.6) @TEXT("VDD",size=1.1,halign="middle",valign="bottom");
// &"VSS" @WIRE(mode="straight",linecolor="#30485d",linewidth=0.16) {#XREAD6:5 (105,-215)};
// (105,-215.4) @TEXT("VSS",size=1.1,halign="middle",valign="top");
// &"ANY06" @WIRE(mode="straight",linecolor="#30485d",linewidth=0.16) {#XEMPTY7:1 (-10,-236)};
// (-10.4,-236) @TEXT("ANY06",size=1.1,halign="end",valign="middle");
// &"VDD" @WIRE(mode="straight",linecolor="#30485d",linewidth=0.16) {#XEMPTY7:3 (0,-226)};
// (0,-225.6) @TEXT("VDD",size=1.1,halign="middle",valign="bottom");
// &"VSS" @WIRE(mode="straight",linecolor="#30485d",linewidth=0.16) {#XEMPTY7:4 (0,-246)};
// (0,-246.4) @TEXT("VSS",size=1.1,halign="middle",valign="top");
// &"CODE7" @WIRE(mode="straight",linecolor="#30485d",linewidth=0.16) {#XTRIAL7:2 (19,-237.65)};
// (18.6,-237.65) @TEXT("CODE7",size=1.1,halign="end",valign="middle");
// &"TRIAL7" @WIRE(mode="straight",linecolor="#30485d",linewidth=0.16) {#XTRIAL7:3 (51,-236)};
// (51.4,-236) @TEXT("TRIAL7",size=1.1,halign="start",valign="middle");
// &"VDD" @WIRE(mode="straight",linecolor="#30485d",linewidth=0.16) {#XTRIAL7:4 (35,-225)};
// (35,-224.6) @TEXT("VDD",size=1.1,halign="middle",valign="bottom");
// &"VSS" @WIRE(mode="straight",linecolor="#30485d",linewidth=0.16) {#XTRIAL7:5 (35,-247)};
// (35,-247.4) @TEXT("VSS",size=1.1,halign="middle",valign="top");
// &"ANY06" @WIRE(mode="straight",linecolor="#30485d",linewidth=0.16) {#XVISIBLE7:1 (54,-234.35)};
// (53.6,-234.35) @TEXT("ANY06",size=1.1,halign="end",valign="middle");
// &"DONE" @WIRE(mode="straight",linecolor="#30485d",linewidth=0.16) {#XVISIBLE7:2 (54,-237.65)};
// (53.6,-237.65) @TEXT("DONE",size=1.1,halign="end",valign="middle");
// &"VDD" @WIRE(mode="straight",linecolor="#30485d",linewidth=0.16) {#XVISIBLE7:4 (70,-225)};
// (70,-224.6) @TEXT("VDD",size=1.1,halign="middle",valign="bottom");
// &"VSS" @WIRE(mode="straight",linecolor="#30485d",linewidth=0.16) {#XVISIBLE7:5 (70,-247)};
// (70,-247.4) @TEXT("VSS",size=1.1,halign="middle",valign="top");
// &"CODE7" @WIRE(mode="straight",linecolor="#30485d",linewidth=0.16) {#XREAD7:1 (89,-234.35)};
// (88.6,-234.35) @TEXT("CODE7",size=1.1,halign="end",valign="middle");
// &"D7" @WIRE(mode="straight",linecolor="#30485d",linewidth=0.16) {#XREAD7:3 (121,-236)};
// (121.4,-236) @TEXT("D7",size=1.1,halign="start",valign="middle");
// &"VDD" @WIRE(mode="straight",linecolor="#30485d",linewidth=0.16) {#XREAD7:4 (105,-225)};
// (105,-224.6) @TEXT("VDD",size=1.1,halign="middle",valign="bottom");
// &"VSS" @WIRE(mode="straight",linecolor="#30485d",linewidth=0.16) {#XREAD7:5 (105,-247)};
// (105,-247.4) @TEXT("VSS",size=1.1,halign="middle",valign="top");
// &"TRIAL1" @WIRE(mode="straight",linecolor="#30485d",linewidth=0.16) {#XBASE0:2 (124,-13.65)};
// (123.6,-13.65) @TEXT("TRIAL1",size=1.1,halign="end",valign="middle");
// &"BASE0" @WIRE(mode="straight",linecolor="#30485d",linewidth=0.16) {#XBASE0:3 (156,-12)};
// (156.4,-12) @TEXT("BASE0",size=1.1,halign="start",valign="middle");
// &"VDD" @WIRE(mode="straight",linecolor="#30485d",linewidth=0.16) {#XBASE0:4 (140,-1)};
// (140,-0.6) @TEXT("VDD",size=1.1,halign="middle",valign="bottom");
// &"VSS" @WIRE(mode="straight",linecolor="#30485d",linewidth=0.16) {#XBASE0:5 (140,-23)};
// (140,-23.4) @TEXT("VSS",size=1.1,halign="middle",valign="top");
// &"CODE0" @WIRE(mode="straight",linecolor="#30485d",linewidth=0.16) {#XKEEP0:1 (159,-10.35)};
// (158.6,-10.35) @TEXT("CODE0",size=1.1,halign="end",valign="middle");
// &"DATA" @WIRE(mode="straight",linecolor="#30485d",linewidth=0.16) {#XKEEP0:2 (159,-13.65)};
// (158.6,-13.65) @TEXT("DATA",size=1.1,halign="end",valign="middle");
// &"VDD" @WIRE(mode="straight",linecolor="#30485d",linewidth=0.16) {#XKEEP0:4 (175,-1)};
// (175,-0.6) @TEXT("VDD",size=1.1,halign="middle",valign="bottom");
// &"VSS" @WIRE(mode="straight",linecolor="#30485d",linewidth=0.16) {#XKEEP0:5 (175,-23)};
// (175,-23.4) @TEXT("VSS",size=1.1,halign="middle",valign="top");
// &"BASE0" @WIRE(mode="straight",linecolor="#30485d",linewidth=0.16) {#XNEXT0:1 (194,-10.35)};
// (193.6,-10.35) @TEXT("BASE0",size=1.1,halign="end",valign="middle");
// &"NEXT0" @WIRE(mode="straight",linecolor="#30485d",linewidth=0.16) {#XNEXT0:3 (226,-12)};
// (226.4,-12) @TEXT("NEXT0",size=1.1,halign="start",valign="middle");
// &"VDD" @WIRE(mode="straight",linecolor="#30485d",linewidth=0.16) {#XNEXT0:4 (210,-1)};
// (210,-0.6) @TEXT("VDD",size=1.1,halign="middle",valign="bottom");
// &"VSS" @WIRE(mode="straight",linecolor="#30485d",linewidth=0.16) {#XNEXT0:5 (210,-23)};
// (210,-23.4) @TEXT("VSS",size=1.1,halign="middle",valign="top");
// &"TRIAL2" @WIRE(mode="straight",linecolor="#30485d",linewidth=0.16) {#XBASE1:2 (124,-45.65)};
// (123.6,-45.65) @TEXT("TRIAL2",size=1.1,halign="end",valign="middle");
// &"BASE1" @WIRE(mode="straight",linecolor="#30485d",linewidth=0.16) {#XBASE1:3 (156,-44)};
// (156.4,-44) @TEXT("BASE1",size=1.1,halign="start",valign="middle");
// &"VDD" @WIRE(mode="straight",linecolor="#30485d",linewidth=0.16) {#XBASE1:4 (140,-33)};
// (140,-32.6) @TEXT("VDD",size=1.1,halign="middle",valign="bottom");
// &"VSS" @WIRE(mode="straight",linecolor="#30485d",linewidth=0.16) {#XBASE1:5 (140,-55)};
// (140,-55.4) @TEXT("VSS",size=1.1,halign="middle",valign="top");
// &"TRIAL1" @WIRE(mode="straight",linecolor="#30485d",linewidth=0.16) {#XKEEP1:1 (159,-42.35)};
// (158.6,-42.35) @TEXT("TRIAL1",size=1.1,halign="end",valign="middle");
// &"DATA" @WIRE(mode="straight",linecolor="#30485d",linewidth=0.16) {#XKEEP1:2 (159,-45.65)};
// (158.6,-45.65) @TEXT("DATA",size=1.1,halign="end",valign="middle");
// &"VDD" @WIRE(mode="straight",linecolor="#30485d",linewidth=0.16) {#XKEEP1:4 (175,-33)};
// (175,-32.6) @TEXT("VDD",size=1.1,halign="middle",valign="bottom");
// &"VSS" @WIRE(mode="straight",linecolor="#30485d",linewidth=0.16) {#XKEEP1:5 (175,-55)};
// (175,-55.4) @TEXT("VSS",size=1.1,halign="middle",valign="top");
// &"BASE1" @WIRE(mode="straight",linecolor="#30485d",linewidth=0.16) {#XNEXT1:1 (194,-42.35)};
// (193.6,-42.35) @TEXT("BASE1",size=1.1,halign="end",valign="middle");
// &"NEXT1" @WIRE(mode="straight",linecolor="#30485d",linewidth=0.16) {#XNEXT1:3 (226,-44)};
// (226.4,-44) @TEXT("NEXT1",size=1.1,halign="start",valign="middle");
// &"VDD" @WIRE(mode="straight",linecolor="#30485d",linewidth=0.16) {#XNEXT1:4 (210,-33)};
// (210,-32.6) @TEXT("VDD",size=1.1,halign="middle",valign="bottom");
// &"VSS" @WIRE(mode="straight",linecolor="#30485d",linewidth=0.16) {#XNEXT1:5 (210,-55)};
// (210,-55.4) @TEXT("VSS",size=1.1,halign="middle",valign="top");
// &"TRIAL3" @WIRE(mode="straight",linecolor="#30485d",linewidth=0.16) {#XBASE2:2 (124,-77.65)};
// (123.6,-77.65) @TEXT("TRIAL3",size=1.1,halign="end",valign="middle");
// &"BASE2" @WIRE(mode="straight",linecolor="#30485d",linewidth=0.16) {#XBASE2:3 (156,-76)};
// (156.4,-76) @TEXT("BASE2",size=1.1,halign="start",valign="middle");
// &"VDD" @WIRE(mode="straight",linecolor="#30485d",linewidth=0.16) {#XBASE2:4 (140,-65)};
// (140,-64.6) @TEXT("VDD",size=1.1,halign="middle",valign="bottom");
// &"VSS" @WIRE(mode="straight",linecolor="#30485d",linewidth=0.16) {#XBASE2:5 (140,-87)};
// (140,-87.4) @TEXT("VSS",size=1.1,halign="middle",valign="top");
// &"TRIAL2" @WIRE(mode="straight",linecolor="#30485d",linewidth=0.16) {#XKEEP2:1 (159,-74.35)};
// (158.6,-74.35) @TEXT("TRIAL2",size=1.1,halign="end",valign="middle");
// &"DATA" @WIRE(mode="straight",linecolor="#30485d",linewidth=0.16) {#XKEEP2:2 (159,-77.65)};
// (158.6,-77.65) @TEXT("DATA",size=1.1,halign="end",valign="middle");
// &"VDD" @WIRE(mode="straight",linecolor="#30485d",linewidth=0.16) {#XKEEP2:4 (175,-65)};
// (175,-64.6) @TEXT("VDD",size=1.1,halign="middle",valign="bottom");
// &"VSS" @WIRE(mode="straight",linecolor="#30485d",linewidth=0.16) {#XKEEP2:5 (175,-87)};
// (175,-87.4) @TEXT("VSS",size=1.1,halign="middle",valign="top");
// &"BASE2" @WIRE(mode="straight",linecolor="#30485d",linewidth=0.16) {#XNEXT2:1 (194,-74.35)};
// (193.6,-74.35) @TEXT("BASE2",size=1.1,halign="end",valign="middle");
// &"NEXT2" @WIRE(mode="straight",linecolor="#30485d",linewidth=0.16) {#XNEXT2:3 (226,-76)};
// (226.4,-76) @TEXT("NEXT2",size=1.1,halign="start",valign="middle");
// &"VDD" @WIRE(mode="straight",linecolor="#30485d",linewidth=0.16) {#XNEXT2:4 (210,-65)};
// (210,-64.6) @TEXT("VDD",size=1.1,halign="middle",valign="bottom");
// &"VSS" @WIRE(mode="straight",linecolor="#30485d",linewidth=0.16) {#XNEXT2:5 (210,-87)};
// (210,-87.4) @TEXT("VSS",size=1.1,halign="middle",valign="top");
// &"TRIAL4" @WIRE(mode="straight",linecolor="#30485d",linewidth=0.16) {#XBASE3:2 (124,-109.65)};
// (123.6,-109.65) @TEXT("TRIAL4",size=1.1,halign="end",valign="middle");
// &"BASE3" @WIRE(mode="straight",linecolor="#30485d",linewidth=0.16) {#XBASE3:3 (156,-108)};
// (156.4,-108) @TEXT("BASE3",size=1.1,halign="start",valign="middle");
// &"VDD" @WIRE(mode="straight",linecolor="#30485d",linewidth=0.16) {#XBASE3:4 (140,-97)};
// (140,-96.6) @TEXT("VDD",size=1.1,halign="middle",valign="bottom");
// &"VSS" @WIRE(mode="straight",linecolor="#30485d",linewidth=0.16) {#XBASE3:5 (140,-119)};
// (140,-119.4) @TEXT("VSS",size=1.1,halign="middle",valign="top");
// &"TRIAL3" @WIRE(mode="straight",linecolor="#30485d",linewidth=0.16) {#XKEEP3:1 (159,-106.35)};
// (158.6,-106.35) @TEXT("TRIAL3",size=1.1,halign="end",valign="middle");
// &"DATA" @WIRE(mode="straight",linecolor="#30485d",linewidth=0.16) {#XKEEP3:2 (159,-109.65)};
// (158.6,-109.65) @TEXT("DATA",size=1.1,halign="end",valign="middle");
// &"VDD" @WIRE(mode="straight",linecolor="#30485d",linewidth=0.16) {#XKEEP3:4 (175,-97)};
// (175,-96.6) @TEXT("VDD",size=1.1,halign="middle",valign="bottom");
// &"VSS" @WIRE(mode="straight",linecolor="#30485d",linewidth=0.16) {#XKEEP3:5 (175,-119)};
// (175,-119.4) @TEXT("VSS",size=1.1,halign="middle",valign="top");
// &"BASE3" @WIRE(mode="straight",linecolor="#30485d",linewidth=0.16) {#XNEXT3:1 (194,-106.35)};
// (193.6,-106.35) @TEXT("BASE3",size=1.1,halign="end",valign="middle");
// &"NEXT3" @WIRE(mode="straight",linecolor="#30485d",linewidth=0.16) {#XNEXT3:3 (226,-108)};
// (226.4,-108) @TEXT("NEXT3",size=1.1,halign="start",valign="middle");
// &"VDD" @WIRE(mode="straight",linecolor="#30485d",linewidth=0.16) {#XNEXT3:4 (210,-97)};
// (210,-96.6) @TEXT("VDD",size=1.1,halign="middle",valign="bottom");
// &"VSS" @WIRE(mode="straight",linecolor="#30485d",linewidth=0.16) {#XNEXT3:5 (210,-119)};
// (210,-119.4) @TEXT("VSS",size=1.1,halign="middle",valign="top");
// &"TRIAL5" @WIRE(mode="straight",linecolor="#30485d",linewidth=0.16) {#XBASE4:2 (124,-141.65)};
// (123.6,-141.65) @TEXT("TRIAL5",size=1.1,halign="end",valign="middle");
// &"BASE4" @WIRE(mode="straight",linecolor="#30485d",linewidth=0.16) {#XBASE4:3 (156,-140)};
// (156.4,-140) @TEXT("BASE4",size=1.1,halign="start",valign="middle");
// &"VDD" @WIRE(mode="straight",linecolor="#30485d",linewidth=0.16) {#XBASE4:4 (140,-129)};
// (140,-128.6) @TEXT("VDD",size=1.1,halign="middle",valign="bottom");
// &"VSS" @WIRE(mode="straight",linecolor="#30485d",linewidth=0.16) {#XBASE4:5 (140,-151)};
// (140,-151.4) @TEXT("VSS",size=1.1,halign="middle",valign="top");
// &"TRIAL4" @WIRE(mode="straight",linecolor="#30485d",linewidth=0.16) {#XKEEP4:1 (159,-138.35)};
// (158.6,-138.35) @TEXT("TRIAL4",size=1.1,halign="end",valign="middle");
// &"DATA" @WIRE(mode="straight",linecolor="#30485d",linewidth=0.16) {#XKEEP4:2 (159,-141.65)};
// (158.6,-141.65) @TEXT("DATA",size=1.1,halign="end",valign="middle");
// &"VDD" @WIRE(mode="straight",linecolor="#30485d",linewidth=0.16) {#XKEEP4:4 (175,-129)};
// (175,-128.6) @TEXT("VDD",size=1.1,halign="middle",valign="bottom");
// &"VSS" @WIRE(mode="straight",linecolor="#30485d",linewidth=0.16) {#XKEEP4:5 (175,-151)};
// (175,-151.4) @TEXT("VSS",size=1.1,halign="middle",valign="top");
// &"BASE4" @WIRE(mode="straight",linecolor="#30485d",linewidth=0.16) {#XNEXT4:1 (194,-138.35)};
// (193.6,-138.35) @TEXT("BASE4",size=1.1,halign="end",valign="middle");
// &"NEXT4" @WIRE(mode="straight",linecolor="#30485d",linewidth=0.16) {#XNEXT4:3 (226,-140)};
// (226.4,-140) @TEXT("NEXT4",size=1.1,halign="start",valign="middle");
// &"VDD" @WIRE(mode="straight",linecolor="#30485d",linewidth=0.16) {#XNEXT4:4 (210,-129)};
// (210,-128.6) @TEXT("VDD",size=1.1,halign="middle",valign="bottom");
// &"VSS" @WIRE(mode="straight",linecolor="#30485d",linewidth=0.16) {#XNEXT4:5 (210,-151)};
// (210,-151.4) @TEXT("VSS",size=1.1,halign="middle",valign="top");
// &"TRIAL6" @WIRE(mode="straight",linecolor="#30485d",linewidth=0.16) {#XBASE5:2 (124,-173.65)};
// (123.6,-173.65) @TEXT("TRIAL6",size=1.1,halign="end",valign="middle");
// &"BASE5" @WIRE(mode="straight",linecolor="#30485d",linewidth=0.16) {#XBASE5:3 (156,-172)};
// (156.4,-172) @TEXT("BASE5",size=1.1,halign="start",valign="middle");
// &"VDD" @WIRE(mode="straight",linecolor="#30485d",linewidth=0.16) {#XBASE5:4 (140,-161)};
// (140,-160.6) @TEXT("VDD",size=1.1,halign="middle",valign="bottom");
// &"VSS" @WIRE(mode="straight",linecolor="#30485d",linewidth=0.16) {#XBASE5:5 (140,-183)};
// (140,-183.4) @TEXT("VSS",size=1.1,halign="middle",valign="top");
// &"TRIAL5" @WIRE(mode="straight",linecolor="#30485d",linewidth=0.16) {#XKEEP5:1 (159,-170.35)};
// (158.6,-170.35) @TEXT("TRIAL5",size=1.1,halign="end",valign="middle");
// &"DATA" @WIRE(mode="straight",linecolor="#30485d",linewidth=0.16) {#XKEEP5:2 (159,-173.65)};
// (158.6,-173.65) @TEXT("DATA",size=1.1,halign="end",valign="middle");
// &"VDD" @WIRE(mode="straight",linecolor="#30485d",linewidth=0.16) {#XKEEP5:4 (175,-161)};
// (175,-160.6) @TEXT("VDD",size=1.1,halign="middle",valign="bottom");
// &"VSS" @WIRE(mode="straight",linecolor="#30485d",linewidth=0.16) {#XKEEP5:5 (175,-183)};
// (175,-183.4) @TEXT("VSS",size=1.1,halign="middle",valign="top");
// &"BASE5" @WIRE(mode="straight",linecolor="#30485d",linewidth=0.16) {#XNEXT5:1 (194,-170.35)};
// (193.6,-170.35) @TEXT("BASE5",size=1.1,halign="end",valign="middle");
// &"NEXT5" @WIRE(mode="straight",linecolor="#30485d",linewidth=0.16) {#XNEXT5:3 (226,-172)};
// (226.4,-172) @TEXT("NEXT5",size=1.1,halign="start",valign="middle");
// &"VDD" @WIRE(mode="straight",linecolor="#30485d",linewidth=0.16) {#XNEXT5:4 (210,-161)};
// (210,-160.6) @TEXT("VDD",size=1.1,halign="middle",valign="bottom");
// &"VSS" @WIRE(mode="straight",linecolor="#30485d",linewidth=0.16) {#XNEXT5:5 (210,-183)};
// (210,-183.4) @TEXT("VSS",size=1.1,halign="middle",valign="top");
// &"TRIAL7" @WIRE(mode="straight",linecolor="#30485d",linewidth=0.16) {#XBASE6:2 (124,-205.65)};
// (123.6,-205.65) @TEXT("TRIAL7",size=1.1,halign="end",valign="middle");
// &"BASE6" @WIRE(mode="straight",linecolor="#30485d",linewidth=0.16) {#XBASE6:3 (156,-204)};
// (156.4,-204) @TEXT("BASE6",size=1.1,halign="start",valign="middle");
// &"VDD" @WIRE(mode="straight",linecolor="#30485d",linewidth=0.16) {#XBASE6:4 (140,-193)};
// (140,-192.6) @TEXT("VDD",size=1.1,halign="middle",valign="bottom");
// &"VSS" @WIRE(mode="straight",linecolor="#30485d",linewidth=0.16) {#XBASE6:5 (140,-215)};
// (140,-215.4) @TEXT("VSS",size=1.1,halign="middle",valign="top");
// &"TRIAL6" @WIRE(mode="straight",linecolor="#30485d",linewidth=0.16) {#XKEEP6:1 (159,-202.35)};
// (158.6,-202.35) @TEXT("TRIAL6",size=1.1,halign="end",valign="middle");
// &"DATA" @WIRE(mode="straight",linecolor="#30485d",linewidth=0.16) {#XKEEP6:2 (159,-205.65)};
// (158.6,-205.65) @TEXT("DATA",size=1.1,halign="end",valign="middle");
// &"VDD" @WIRE(mode="straight",linecolor="#30485d",linewidth=0.16) {#XKEEP6:4 (175,-193)};
// (175,-192.6) @TEXT("VDD",size=1.1,halign="middle",valign="bottom");
// &"VSS" @WIRE(mode="straight",linecolor="#30485d",linewidth=0.16) {#XKEEP6:5 (175,-215)};
// (175,-215.4) @TEXT("VSS",size=1.1,halign="middle",valign="top");
// &"BASE6" @WIRE(mode="straight",linecolor="#30485d",linewidth=0.16) {#XNEXT6:1 (194,-202.35)};
// (193.6,-202.35) @TEXT("BASE6",size=1.1,halign="end",valign="middle");
// &"NEXT6" @WIRE(mode="straight",linecolor="#30485d",linewidth=0.16) {#XNEXT6:3 (226,-204)};
// (226.4,-204) @TEXT("NEXT6",size=1.1,halign="start",valign="middle");
// &"VDD" @WIRE(mode="straight",linecolor="#30485d",linewidth=0.16) {#XNEXT6:4 (210,-193)};
// (210,-192.6) @TEXT("VDD",size=1.1,halign="middle",valign="bottom");
// &"VSS" @WIRE(mode="straight",linecolor="#30485d",linewidth=0.16) {#XNEXT6:5 (210,-215)};
// (210,-215.4) @TEXT("VSS",size=1.1,halign="middle",valign="top");
// &"TRIAL7" @WIRE(mode="straight",linecolor="#30485d",linewidth=0.16) {#XKEEP7:1 (159,-234.35)};
// (158.6,-234.35) @TEXT("TRIAL7",size=1.1,halign="end",valign="middle");
// &"DATA" @WIRE(mode="straight",linecolor="#30485d",linewidth=0.16) {#XKEEP7:2 (159,-237.65)};
// (158.6,-237.65) @TEXT("DATA",size=1.1,halign="end",valign="middle");
// &"VDD" @WIRE(mode="straight",linecolor="#30485d",linewidth=0.16) {#XKEEP7:4 (175,-225)};
// (175,-224.6) @TEXT("VDD",size=1.1,halign="middle",valign="bottom");
// &"VSS" @WIRE(mode="straight",linecolor="#30485d",linewidth=0.16) {#XKEEP7:5 (175,-247)};
// (175,-247.4) @TEXT("VSS",size=1.1,halign="middle",valign="top");
// &"D7" @WIRE(mode="straight",linecolor="#30485d",linewidth=0.16) {#XNEXT7:1 (194,-234.35)};
// (193.6,-234.35) @TEXT("D7",size=1.1,halign="end",valign="middle");
// &"NEXT7" @WIRE(mode="straight",linecolor="#30485d",linewidth=0.16) {#XNEXT7:3 (226,-236)};
// (226.4,-236) @TEXT("NEXT7",size=1.1,halign="start",valign="middle");
// &"VDD" @WIRE(mode="straight",linecolor="#30485d",linewidth=0.16) {#XNEXT7:4 (210,-225)};
// (210,-224.6) @TEXT("VDD",size=1.1,halign="middle",valign="bottom");
// &"VSS" @WIRE(mode="straight",linecolor="#30485d",linewidth=0.16) {#XNEXT7:5 (210,-247)};
// (210,-247.4) @TEXT("VSS",size=1.1,halign="middle",valign="top");
// }
// END SARADC RNL
ends sar8_next_word

subckt sar8_se_window PHASE_REQUEST SEL9 SEL7 SEL6 SEL5 SEL4 VDD VSS DELIVERED
// A transition propagates once per decision. Both polarities traverse real DEL cells.
// Taps by compared bit: 6:T11 5:T9 4:T7 3:T6 2:T5 1,0:T4. Each SELn rises once per
// conversion, on the commit before its first use, and only shortens the window.
XDEL1 (PHASE_REQUEST T1 VDD VSS) DEL250D1BWP12T30P140
XDEL2 (T1 T2 VDD VSS) DEL250D1BWP12T30P140
XDEL3 (T2 T3 VDD VSS) DEL250D1BWP12T30P140
XDEL4 (T3 T4 VDD VSS) DEL250D1BWP12T30P140
XDEL5 (T4 T5 VDD VSS) DEL250D1BWP12T30P140
XDEL6 (T5 T6 VDD VSS) DEL250D1BWP12T30P140
XDEL7 (T6 T7 VDD VSS) DEL250D1BWP12T30P140
XDEL8 (T7 T8 VDD VSS) DEL250D1BWP12T30P140
XDEL9 (T8 T9 VDD VSS) DEL250D1BWP12T30P140
XDEL10 (T9 T10 VDD VSS) DEL250D1BWP12T30P140
XDEL11 (T10 T11 VDD VSS) DEL250D1BWP12T30P140
XTAP9 (T11 T9 SEL9 W9 VDD VSS) MUX2D1BWP12T30P140
XTAP7 (W9 T7 SEL7 W7 VDD VSS) MUX2D1BWP12T30P140
XTAP6 (W7 T6 SEL6 W6 VDD VSS) MUX2D1BWP12T30P140
XTAP5 (W6 T5 SEL5 W5 VDD VSS) MUX2D1BWP12T30P140
XTAP4 (W5 T4 SEL4 DELIVERED VDD VSS) MUX2D1BWP12T30P140
// BEGIN SARADC RNL
// @RNL(author="saradc topology") {
// (-14,59) @TEXT("Settling window / delay chain and selected taps",size=1.9,halign="start",textcolor="#223d52");
// #XDEL1 @SET-SYMBOL $S_DEL250D1BWP12T30P140;
// #XDEL1 @PLACE(0,25) => @ORIENT("R0");
// #XDEL2 @SET-SYMBOL $S_DEL250D1BWP12T30P140;
// #XDEL2 @PLACE(27,25) => @ORIENT("R0");
// #XDEL3 @SET-SYMBOL $S_DEL250D1BWP12T30P140;
// #XDEL3 @PLACE(54,25) => @ORIENT("R0");
// #XDEL4 @SET-SYMBOL $S_DEL250D1BWP12T30P140;
// #XDEL4 @PLACE(81,25) => @ORIENT("R0");
// #XDEL5 @SET-SYMBOL $S_DEL250D1BWP12T30P140;
// #XDEL5 @PLACE(108,25) => @ORIENT("R0");
// #XDEL6 @SET-SYMBOL $S_DEL250D1BWP12T30P140;
// #XDEL6 @PLACE(135,25) => @ORIENT("R0");
// #XDEL7 @SET-SYMBOL $S_DEL250D1BWP12T30P140;
// #XDEL7 @PLACE(162,25) => @ORIENT("R0");
// #XDEL8 @SET-SYMBOL $S_DEL250D1BWP12T30P140;
// #XDEL8 @PLACE(189,25) => @ORIENT("R0");
// #XDEL9 @SET-SYMBOL $S_DEL250D1BWP12T30P140;
// #XDEL9 @PLACE(216,25) => @ORIENT("R0");
// #XDEL10 @SET-SYMBOL $S_DEL250D1BWP12T30P140;
// #XDEL10 @PLACE(243,25) => @ORIENT("R0");
// #XDEL11 @SET-SYMBOL $S_DEL250D1BWP12T30P140;
// #XDEL11 @PLACE(270,25) => @ORIENT("R0");
// #XTAP4 @SET-SYMBOL $S_MUX2D1BWP12T30P140;
// #XTAP4 @PLACE(0,-24) => @ORIENT("R0");
// #XTAP5 @SET-SYMBOL $S_MUX2D1BWP12T30P140;
// #XTAP5 @PLACE(54,-24) => @ORIENT("R0");
// #XTAP6 @SET-SYMBOL $S_MUX2D1BWP12T30P140;
// #XTAP6 @PLACE(108,-24) => @ORIENT("R0");
// #XTAP7 @SET-SYMBOL $S_MUX2D1BWP12T30P140;
// #XTAP7 @PLACE(162,-24) => @ORIENT("R0");
// #XTAP9 @SET-SYMBOL $S_MUX2D1BWP12T30P140;
// #XTAP9 @PLACE(216,-24) => @ORIENT("R0");
// &"T1" @WIRE(mode="straight",linecolor="#30485d",linewidth=0.16) {#XDEL1:2 (13.5,25) (13.5,25) #XDEL2:1};
// &"T2" @WIRE(mode="straight",linecolor="#30485d",linewidth=0.16) {#XDEL2:2 (40.5,25) (40.5,25) #XDEL3:1};
// &"T3" @WIRE(mode="straight",linecolor="#30485d",linewidth=0.16) {#XDEL3:2 (67.5,25) (67.5,25) #XDEL4:1};
// &"T4" @WIRE(mode="straight",linecolor="#30485d",linewidth=0.16) {#XDEL4:2 (94.5,25) (94.5,25) #XDEL5:1};
// &"T5" @WIRE(mode="straight",linecolor="#30485d",linewidth=0.16) {#XDEL5:2 (121.5,25) (121.5,25) #XDEL6:1};
// &"T6" @WIRE(mode="straight",linecolor="#30485d",linewidth=0.16) {#XDEL6:2 (148.5,25) (148.5,25) #XDEL7:1};
// &"T7" @WIRE(mode="straight",linecolor="#30485d",linewidth=0.16) {#XDEL7:2 (175.5,25) (175.5,25) #XDEL8:1};
// &"T8" @WIRE(mode="straight",linecolor="#30485d",linewidth=0.16) {#XDEL8:2 (202.5,25) (202.5,25) #XDEL9:1};
// &"T9" @WIRE(mode="straight",linecolor="#30485d",linewidth=0.16) {#XDEL9:2 (229.5,25) (229.5,25) #XDEL10:1};
// &"T10" @WIRE(mode="straight",linecolor="#30485d",linewidth=0.16) {#XDEL10:2 (256.5,25) (256.5,25) #XDEL11:1};
// &"PHASE_REQUEST" @WIRE(mode="straight",linecolor="#30485d",linewidth=0.16) {#XDEL1:1 (-16,25)};
// (-16.4,25) @TEXT("PHASE_REQUEST",size=1.1,halign="end",valign="middle");
// &"VDD" @WIRE(mode="straight",linecolor="#30485d",linewidth=0.16) {#XDEL1:3 (0,36)};
// (0,36.4) @TEXT("VDD",size=1.1,halign="middle",valign="bottom");
// &"VSS" @WIRE(mode="straight",linecolor="#30485d",linewidth=0.16) {#XDEL1:4 (0,14)};
// (0,13.6) @TEXT("VSS",size=1.1,halign="middle",valign="top");
// &"VDD" @WIRE(mode="straight",linecolor="#30485d",linewidth=0.16) {#XDEL2:3 (27,36)};
// (27,36.4) @TEXT("VDD",size=1.1,halign="middle",valign="bottom");
// &"VSS" @WIRE(mode="straight",linecolor="#30485d",linewidth=0.16) {#XDEL2:4 (27,14)};
// (27,13.6) @TEXT("VSS",size=1.1,halign="middle",valign="top");
// &"VDD" @WIRE(mode="straight",linecolor="#30485d",linewidth=0.16) {#XDEL3:3 (54,36)};
// (54,36.4) @TEXT("VDD",size=1.1,halign="middle",valign="bottom");
// &"VSS" @WIRE(mode="straight",linecolor="#30485d",linewidth=0.16) {#XDEL3:4 (54,14)};
// (54,13.6) @TEXT("VSS",size=1.1,halign="middle",valign="top");
// &"VDD" @WIRE(mode="straight",linecolor="#30485d",linewidth=0.16) {#XDEL4:3 (81,36)};
// (81,36.4) @TEXT("VDD",size=1.1,halign="middle",valign="bottom");
// &"VSS" @WIRE(mode="straight",linecolor="#30485d",linewidth=0.16) {#XDEL4:4 (81,14)};
// (81,13.6) @TEXT("VSS",size=1.1,halign="middle",valign="top");
// &"VDD" @WIRE(mode="straight",linecolor="#30485d",linewidth=0.16) {#XDEL5:3 (108,36)};
// (108,36.4) @TEXT("VDD",size=1.1,halign="middle",valign="bottom");
// &"VSS" @WIRE(mode="straight",linecolor="#30485d",linewidth=0.16) {#XDEL5:4 (108,14)};
// (108,13.6) @TEXT("VSS",size=1.1,halign="middle",valign="top");
// &"VDD" @WIRE(mode="straight",linecolor="#30485d",linewidth=0.16) {#XDEL6:3 (135,36)};
// (135,36.4) @TEXT("VDD",size=1.1,halign="middle",valign="bottom");
// &"VSS" @WIRE(mode="straight",linecolor="#30485d",linewidth=0.16) {#XDEL6:4 (135,14)};
// (135,13.6) @TEXT("VSS",size=1.1,halign="middle",valign="top");
// &"VDD" @WIRE(mode="straight",linecolor="#30485d",linewidth=0.16) {#XDEL7:3 (162,36)};
// (162,36.4) @TEXT("VDD",size=1.1,halign="middle",valign="bottom");
// &"VSS" @WIRE(mode="straight",linecolor="#30485d",linewidth=0.16) {#XDEL7:4 (162,14)};
// (162,13.6) @TEXT("VSS",size=1.1,halign="middle",valign="top");
// &"VDD" @WIRE(mode="straight",linecolor="#30485d",linewidth=0.16) {#XDEL8:3 (189,36)};
// (189,36.4) @TEXT("VDD",size=1.1,halign="middle",valign="bottom");
// &"VSS" @WIRE(mode="straight",linecolor="#30485d",linewidth=0.16) {#XDEL8:4 (189,14)};
// (189,13.6) @TEXT("VSS",size=1.1,halign="middle",valign="top");
// &"VDD" @WIRE(mode="straight",linecolor="#30485d",linewidth=0.16) {#XDEL9:3 (216,36)};
// (216,36.4) @TEXT("VDD",size=1.1,halign="middle",valign="bottom");
// &"VSS" @WIRE(mode="straight",linecolor="#30485d",linewidth=0.16) {#XDEL9:4 (216,14)};
// (216,13.6) @TEXT("VSS",size=1.1,halign="middle",valign="top");
// &"VDD" @WIRE(mode="straight",linecolor="#30485d",linewidth=0.16) {#XDEL10:3 (243,36)};
// (243,36.4) @TEXT("VDD",size=1.1,halign="middle",valign="bottom");
// &"VSS" @WIRE(mode="straight",linecolor="#30485d",linewidth=0.16) {#XDEL10:4 (243,14)};
// (243,13.6) @TEXT("VSS",size=1.1,halign="middle",valign="top");
// &"T11" @WIRE(mode="straight",linecolor="#30485d",linewidth=0.16) {#XDEL11:2 (286,25)};
// (286.4,25) @TEXT("T11",size=1.1,halign="start",valign="middle");
// &"VDD" @WIRE(mode="straight",linecolor="#30485d",linewidth=0.16) {#XDEL11:3 (270,36)};
// (270,36.4) @TEXT("VDD",size=1.1,halign="middle",valign="bottom");
// &"VSS" @WIRE(mode="straight",linecolor="#30485d",linewidth=0.16) {#XDEL11:4 (270,14)};
// (270,13.6) @TEXT("VSS",size=1.1,halign="middle",valign="top");
// &"T11" @WIRE(mode="straight",linecolor="#30485d",linewidth=0.16) {#XTAP9:1 (200,-20.7)};
// (199.6,-20.7) @TEXT("T11",size=1.1,halign="end",valign="middle");
// &"T9" @WIRE(mode="straight",linecolor="#30485d",linewidth=0.16) {#XTAP9:2 (200,-24)};
// (199.6,-24) @TEXT("T9",size=1.1,halign="end",valign="middle");
// &"SEL9" @WIRE(mode="straight",linecolor="#30485d",linewidth=0.16) {#XTAP9:3 (200,-27.3)};
// (199.6,-27.3) @TEXT("SEL9",size=1.1,halign="end",valign="middle");
// &"W9" @WIRE(mode="straight",linecolor="#30485d",linewidth=0.16) {#XTAP9:4 (232,-24)};
// (232.4,-24) @TEXT("W9",size=1.1,halign="start",valign="middle");
// &"VDD" @WIRE(mode="straight",linecolor="#30485d",linewidth=0.16) {#XTAP9:5 (216,-12.4)};
// (216,-12) @TEXT("VDD",size=1.1,halign="middle",valign="bottom");
// &"VSS" @WIRE(mode="straight",linecolor="#30485d",linewidth=0.16) {#XTAP9:6 (216,-35.6)};
// (216,-36) @TEXT("VSS",size=1.1,halign="middle",valign="top");
// &"W9" @WIRE(mode="straight",linecolor="#30485d",linewidth=0.16) {#XTAP7:1 (146,-20.7)};
// (145.6,-20.7) @TEXT("W9",size=1.1,halign="end",valign="middle");
// &"T7" @WIRE(mode="straight",linecolor="#30485d",linewidth=0.16) {#XTAP7:2 (146,-24)};
// (145.6,-24) @TEXT("T7",size=1.1,halign="end",valign="middle");
// &"SEL7" @WIRE(mode="straight",linecolor="#30485d",linewidth=0.16) {#XTAP7:3 (146,-27.3)};
// (145.6,-27.3) @TEXT("SEL7",size=1.1,halign="end",valign="middle");
// &"W7" @WIRE(mode="straight",linecolor="#30485d",linewidth=0.16) {#XTAP7:4 (178,-24)};
// (178.4,-24) @TEXT("W7",size=1.1,halign="start",valign="middle");
// &"VDD" @WIRE(mode="straight",linecolor="#30485d",linewidth=0.16) {#XTAP7:5 (162,-12.4)};
// (162,-12) @TEXT("VDD",size=1.1,halign="middle",valign="bottom");
// &"VSS" @WIRE(mode="straight",linecolor="#30485d",linewidth=0.16) {#XTAP7:6 (162,-35.6)};
// (162,-36) @TEXT("VSS",size=1.1,halign="middle",valign="top");
// &"W7" @WIRE(mode="straight",linecolor="#30485d",linewidth=0.16) {#XTAP6:1 (92,-20.7)};
// (91.6,-20.7) @TEXT("W7",size=1.1,halign="end",valign="middle");
// &"T6" @WIRE(mode="straight",linecolor="#30485d",linewidth=0.16) {#XTAP6:2 (92,-24)};
// (91.6,-24) @TEXT("T6",size=1.1,halign="end",valign="middle");
// &"SEL6" @WIRE(mode="straight",linecolor="#30485d",linewidth=0.16) {#XTAP6:3 (92,-27.3)};
// (91.6,-27.3) @TEXT("SEL6",size=1.1,halign="end",valign="middle");
// &"W6" @WIRE(mode="straight",linecolor="#30485d",linewidth=0.16) {#XTAP6:4 (124,-24)};
// (124.4,-24) @TEXT("W6",size=1.1,halign="start",valign="middle");
// &"VDD" @WIRE(mode="straight",linecolor="#30485d",linewidth=0.16) {#XTAP6:5 (108,-12.4)};
// (108,-12) @TEXT("VDD",size=1.1,halign="middle",valign="bottom");
// &"VSS" @WIRE(mode="straight",linecolor="#30485d",linewidth=0.16) {#XTAP6:6 (108,-35.6)};
// (108,-36) @TEXT("VSS",size=1.1,halign="middle",valign="top");
// &"W6" @WIRE(mode="straight",linecolor="#30485d",linewidth=0.16) {#XTAP5:1 (38,-20.7)};
// (37.6,-20.7) @TEXT("W6",size=1.1,halign="end",valign="middle");
// &"T5" @WIRE(mode="straight",linecolor="#30485d",linewidth=0.16) {#XTAP5:2 (38,-24)};
// (37.6,-24) @TEXT("T5",size=1.1,halign="end",valign="middle");
// &"SEL5" @WIRE(mode="straight",linecolor="#30485d",linewidth=0.16) {#XTAP5:3 (38,-27.3)};
// (37.6,-27.3) @TEXT("SEL5",size=1.1,halign="end",valign="middle");
// &"W5" @WIRE(mode="straight",linecolor="#30485d",linewidth=0.16) {#XTAP5:4 (70,-24)};
// (70.4,-24) @TEXT("W5",size=1.1,halign="start",valign="middle");
// &"VDD" @WIRE(mode="straight",linecolor="#30485d",linewidth=0.16) {#XTAP5:5 (54,-12.4)};
// (54,-12) @TEXT("VDD",size=1.1,halign="middle",valign="bottom");
// &"VSS" @WIRE(mode="straight",linecolor="#30485d",linewidth=0.16) {#XTAP5:6 (54,-35.6)};
// (54,-36) @TEXT("VSS",size=1.1,halign="middle",valign="top");
// &"W5" @WIRE(mode="straight",linecolor="#30485d",linewidth=0.16) {#XTAP4:1 (-16,-20.7)};
// (-16.4,-20.7) @TEXT("W5",size=1.1,halign="end",valign="middle");
// &"T4" @WIRE(mode="straight",linecolor="#30485d",linewidth=0.16) {#XTAP4:2 (-16,-24)};
// (-16.4,-24) @TEXT("T4",size=1.1,halign="end",valign="middle");
// &"SEL4" @WIRE(mode="straight",linecolor="#30485d",linewidth=0.16) {#XTAP4:3 (-16,-27.3)};
// (-16.4,-27.3) @TEXT("SEL4",size=1.1,halign="end",valign="middle");
// &"DELIVERED" @WIRE(mode="straight",linecolor="#30485d",linewidth=0.16) {#XTAP4:4 (16,-24)};
// (16.4,-24) @TEXT("DELIVERED",size=1.1,halign="start",valign="middle");
// &"VDD" @WIRE(mode="straight",linecolor="#30485d",linewidth=0.16) {#XTAP4:5 (0,-12.4)};
// (0,-12) @TEXT("VDD",size=1.1,halign="middle",valign="bottom");
// &"VSS" @WIRE(mode="straight",linecolor="#30485d",linewidth=0.16) {#XTAP4:6 (0,-35.6)};
// (0,-36) @TEXT("VSS",size=1.1,halign="middle",valign="top");
// }
// END SARADC RNL
ends sar8_se_window

subckt sar8_se_timing ACTIVE SAMPLE SEL9 SEL7 SEL6 SEL5 SEL4 COMP_P COMP_N CMP_CLK COMMIT DATA VDD VSS
XPR (COMP_P PR VDD VSS) BUFFD1BWP12T30P140
XNR (COMP_N NR VDD VSS) BUFFD1BWP12T30P140
XNRB (NR NRB VDD VSS) INVD1BWP12T30P140
XDATA (PR NRB DATA VDD VSS) AN2D1BWP12T30P140
XRAW (PR NR RAW VDD VSS) XOR2D1BWP12T30P140
XVD (RAW RAW_T VDD VSS) DEL200D1BWP12T30P140
XVALID (RAW RAW_T VALID VDD VSS) AN2D1BWP12T30P140
XSN (SAMPLE SN VDD VSS) INVD1BWP12T30P140
// VALID drives the inner NAND input: CMP_CLK falls first, so the internal node never floats
// when VALID falls (FF-cold terminal-voltage screen).
XW0 (VALID CMP_CLK WD VDD VSS) AN2D1BWP12T30P140
XW1 (WD SN WRITE VDD VSS) AN2D1BWP12T30P140
XCP (WRITE COMMIT VDD VSS) CKBD1BWP12T30P140
// Tracking clears PHASE, so PHASE_REQUEST and every tap settle high and READY is
// already high when sampling closes: the first trial needs no settling window.
// Each real commit toggles PHASE and launches the opposite transition.
// Two-flop Johnson phase: each register toggles on every second commit, and PHASE = PHA XOR PHB
// changes once per commit without hazards.
XPHA (COMMIT PHB_N SAMPLE VDD VSS PHA) sar8_se_store
XPHBN (PHB PHB_N VDD VSS) INVD1BWP12T30P140
XPHB (COMMIT PHA SAMPLE VDD VSS PHB) sar8_se_store
XPHX (PHA PHB PHASE VDD VSS) XOR2D1BWP12T30P140
XPHR (PHASE PHASE_REQUEST VDD VSS) INVD1BWP12T30P140
XWINDOW (PHASE_REQUEST SEL9 SEL7 SEL6 SEL5 SEL4 VDD VSS DELIVERED) sar8_se_window
XREADY (PHASE DELIVERED READY VDD VSS) XOR2D1BWP12T30P140
// Reset on the committed phase change; only the delayed edge can release reset.
XCLR (READY SN CLR_N VDD VSS) AN2D1BWP12T30P140
// The first compare waits two stages after sampling closes for the bootstrap
// gates to turn off. Reopening the sample clears LIVE through the qualifier.
XSND1 (SN SN_T1 VDD VSS) DEL250D1BWP12T30P140
XSND2 (SN_T1 SN_T2 VDD VSS) DEL250D1BWP12T30P140
XSNQ (SN SN_T2 SN_D VDD VSS) AN2D1BWP12T30P140
XLIVE (ACTIVE SN_D LIVE VDD VSS) AN2D1BWP12T30P140
XIDLE (RAW CLEARED VDD VSS) INVD1BWP12T30P140
XSET0 (LIVE CLEARED SET0 VDD VSS) AN2D1BWP12T30P140
XSET (SET0 READY SET VDD VSS) AN2D1BWP12T30P140
XHIGH (HIGH VDD VSS) TIEHBWP12T30P140
XCLOCK (HIGH SET CLR_N Q VDD VSS) LHCNDQD1BWP12T30P140
XCMP (Q CMP_CLK VDD VSS) CKBD1BWP12T30P140
// BEGIN SARADC RNL
// @RNL(author="saradc topology") {
// (-17,54) @TEXT("Asynchronous compare and commit timing",size=2.05,halign="start",textcolor="#223d52");
// (-17,37) @TEXT("Latch decision",size=1.35,halign="start",textcolor="#223d52");
// #XPR @SET-SYMBOL $S_BUFFD1BWP12T30P140;
// #XPR @PLACE(0,22) => @ORIENT("R0");
// #XNR @SET-SYMBOL $S_BUFFD1BWP12T30P140;
// #XNR @PLACE(39,22) => @ORIENT("R0");
// #XNRB @SET-SYMBOL $S_INVD1BWP12T30P140;
// #XNRB @PLACE(78,22) => @ORIENT("R0");
// #XDATA @SET-SYMBOL $S_AN2D1BWP12T30P140;
// #XDATA @PLACE(117,22) => @ORIENT("R0");
// #XRAW @SET-SYMBOL $S_XOR2D1BWP12T30P140;
// #XRAW @PLACE(156,22) => @ORIENT("R0");
// #XVD @SET-SYMBOL $S_DEL200D1BWP12T30P140;
// #XVD @PLACE(195,22) => @ORIENT("R0");
// #XVALID @SET-SYMBOL $S_AN2D1BWP12T30P140;
// #XVALID @PLACE(234,22) => @ORIENT("R0");
// (-17,-13) @TEXT("Commit and phase",size=1.35,halign="start",textcolor="#223d52");
// #XSN @SET-SYMBOL $S_INVD1BWP12T30P140;
// #XSN @PLACE(0,-28) => @ORIENT("R0");
// #XW0 @SET-SYMBOL $S_AN2D1BWP12T30P140;
// #XW0 @PLACE(39,-28) => @ORIENT("R0");
// #XW1 @SET-SYMBOL $S_AN2D1BWP12T30P140;
// #XW1 @PLACE(78,-28) => @ORIENT("R0");
// #XCP @SET-SYMBOL $S_CKBD1BWP12T30P140;
// #XCP @PLACE(117,-28) => @ORIENT("R0");
// #XPHA @SET-SYMBOL $S_sar8_se_store;
// #XPHA @PLACE(156,-28) => @ORIENT("R0");
// #XPHBN @SET-SYMBOL $S_INVD1BWP12T30P140;
// #XPHBN @PLACE(195,-28) => @ORIENT("R0");
// #XPHB @SET-SYMBOL $S_sar8_se_store;
// #XPHB @PLACE(234,-28) => @ORIENT("R0");
// #XPHX @SET-SYMBOL $S_XOR2D1BWP12T30P140;
// #XPHX @PLACE(273,-28) => @ORIENT("R0");
// (-17,-63) @TEXT("Settling window",size=1.35,halign="start",textcolor="#223d52");
// #XPHR @SET-SYMBOL $S_INVD1BWP12T30P140;
// #XPHR @PLACE(0,-78) => @ORIENT("R0");
// #XWINDOW @SET-SYMBOL $S_sar8_se_window;
// #XWINDOW @PLACE(39,-78) => @ORIENT("R0");
// #XREADY @SET-SYMBOL $S_XOR2D1BWP12T30P140;
// #XREADY @PLACE(78,-78) => @ORIENT("R0");
// #XCLR @SET-SYMBOL $S_AN2D1BWP12T30P140;
// #XCLR @PLACE(117,-78) => @ORIENT("R0");
// #XSND1 @SET-SYMBOL $S_DEL250D1BWP12T30P140;
// #XSND1 @PLACE(156,-78) => @ORIENT("R0");
// #XSND2 @SET-SYMBOL $S_DEL250D1BWP12T30P140;
// #XSND2 @PLACE(195,-78) => @ORIENT("R0");
// #XSNQ @SET-SYMBOL $S_AN2D1BWP12T30P140;
// #XSNQ @PLACE(234,-78) => @ORIENT("R0");
// (-17,-113) @TEXT("Comparator clock",size=1.35,halign="start",textcolor="#223d52");
// #XLIVE @SET-SYMBOL $S_AN2D1BWP12T30P140;
// #XLIVE @PLACE(0,-128) => @ORIENT("R0");
// #XIDLE @SET-SYMBOL $S_INVD1BWP12T30P140;
// #XIDLE @PLACE(39,-128) => @ORIENT("R0");
// #XSET0 @SET-SYMBOL $S_AN2D1BWP12T30P140;
// #XSET0 @PLACE(78,-128) => @ORIENT("R0");
// #XSET @SET-SYMBOL $S_AN2D1BWP12T30P140;
// #XSET @PLACE(117,-128) => @ORIENT("R0");
// #XHIGH @SET-SYMBOL $S_TIEHBWP12T30P140;
// #XHIGH @PLACE(156,-128) => @ORIENT("R0");
// #XCLOCK @SET-SYMBOL $S_LHCNDQD1BWP12T30P140;
// #XCLOCK @PLACE(195,-128) => @ORIENT("R0");
// #XCMP @SET-SYMBOL $S_CKBD1BWP12T30P140;
// #XCMP @PLACE(234,-128) => @ORIENT("R0");
// &"NRB" @WIRE(mode="straight",linecolor="#30485d",linewidth=0.16) {#XNRB:2 (94.5,22) (94.5,20.35) #XDATA:2};
// &"RAW_T" @WIRE(mode="straight",linecolor="#30485d",linewidth=0.16) {#XVD:2 (214.5,22) (214.5,20.35) #XVALID:2};
// &"WD" @WIRE(mode="straight",linecolor="#30485d",linewidth=0.16) {#XW0:3 (58.5,-28) (58.5,-26.35) #XW1:1};
// &"WRITE" @WIRE(mode="straight",linecolor="#30485d",linewidth=0.16) {#XW1:3 (97.5,-28) (97.5,-28) #XCP:1};
// &"PHB_N" @WIRE(mode="straight",linecolor="#30485d",linewidth=0.16) {#XPHA:2 (185.5,-26.35) (185.5,-28) #XPHBN:2};
// &"PHASE_REQUEST" @WIRE(mode="straight",linecolor="#30485d",linewidth=0.16) {#XPHR:2 (16.5,-78) (16.5,-69.75) #XWINDOW:1};
// &"DELIVERED" @WIRE(mode="straight",linecolor="#30485d",linewidth=0.16) {#XWINDOW:9 (58.5,-78) (58.5,-79.65) #XREADY:2};
// &"SN_T1" @WIRE(mode="straight",linecolor="#30485d",linewidth=0.16) {#XSND1:2 (175.5,-78) (175.5,-78) #XSND2:1};
// &"SN_T2" @WIRE(mode="straight",linecolor="#30485d",linewidth=0.16) {#XSND2:2 (214.5,-78) (214.5,-79.65) #XSNQ:2};
// &"CLEARED" @WIRE(mode="straight",linecolor="#30485d",linewidth=0.16) {#XIDLE:2 (55.5,-128) (55.5,-129.65) #XSET0:2};
// &"SET0" @WIRE(mode="straight",linecolor="#30485d",linewidth=0.16) {#XSET0:3 (97.5,-128) (97.5,-126.35) #XSET:1};
// &"HIGH" @WIRE(mode="straight",linecolor="#30485d",linewidth=0.16) {#XHIGH:1 (175.5,-128) (175.5,-124.7) #XCLOCK:1};
// &"Q" @WIRE(mode="straight",linecolor="#30485d",linewidth=0.16) {#XCLOCK:4 (214.5,-128) (214.5,-128) #XCMP:1};
// &"COMP_P" @WIRE(mode="straight",linecolor="#30485d",linewidth=0.16) {#XPR:1 (-16,22)};
// (-16.4,22) @TEXT("COMP_P",size=1.1,halign="end",valign="middle");
// &"PR" @WIRE(mode="straight",linecolor="#30485d",linewidth=0.16) {#XPR:2 (16,22)};
// (16.4,22) @TEXT("PR",size=1.1,halign="start",valign="middle");
// &"VDD" @WIRE(mode="straight",linecolor="#30485d",linewidth=0.16) {#XPR:3 (0,33)};
// (0,33.4) @TEXT("VDD",size=1.1,halign="middle",valign="bottom");
// &"VSS" @WIRE(mode="straight",linecolor="#30485d",linewidth=0.16) {#XPR:4 (0,11)};
// (0,10.6) @TEXT("VSS",size=1.1,halign="middle",valign="top");
// &"COMP_N" @WIRE(mode="straight",linecolor="#30485d",linewidth=0.16) {#XNR:1 (23,22)};
// (22.6,22) @TEXT("COMP_N",size=1.1,halign="end",valign="middle");
// &"NR" @WIRE(mode="straight",linecolor="#30485d",linewidth=0.16) {#XNR:2 (55,22)};
// (55.4,22) @TEXT("NR",size=1.1,halign="start",valign="middle");
// &"VDD" @WIRE(mode="straight",linecolor="#30485d",linewidth=0.16) {#XNR:3 (39,33)};
// (39,33.4) @TEXT("VDD",size=1.1,halign="middle",valign="bottom");
// &"VSS" @WIRE(mode="straight",linecolor="#30485d",linewidth=0.16) {#XNR:4 (39,11)};
// (39,10.6) @TEXT("VSS",size=1.1,halign="middle",valign="top");
// &"NR" @WIRE(mode="straight",linecolor="#30485d",linewidth=0.16) {#XNRB:1 (68,22)};
// (67.6,22) @TEXT("NR",size=1.1,halign="end",valign="middle");
// &"VDD" @WIRE(mode="straight",linecolor="#30485d",linewidth=0.16) {#XNRB:3 (78,32)};
// (78,32.4) @TEXT("VDD",size=1.1,halign="middle",valign="bottom");
// &"VSS" @WIRE(mode="straight",linecolor="#30485d",linewidth=0.16) {#XNRB:4 (78,12)};
// (78,11.6) @TEXT("VSS",size=1.1,halign="middle",valign="top");
// &"PR" @WIRE(mode="straight",linecolor="#30485d",linewidth=0.16) {#XDATA:1 (101,23.65)};
// (100.6,23.65) @TEXT("PR",size=1.1,halign="end",valign="middle");
// &"DATA" @WIRE(mode="straight",linecolor="#30485d",linewidth=0.16) {#XDATA:3 (133,22)};
// (133.4,22) @TEXT("DATA",size=1.1,halign="start",valign="middle");
// &"VDD" @WIRE(mode="straight",linecolor="#30485d",linewidth=0.16) {#XDATA:4 (117,33)};
// (117,33.4) @TEXT("VDD",size=1.1,halign="middle",valign="bottom");
// &"VSS" @WIRE(mode="straight",linecolor="#30485d",linewidth=0.16) {#XDATA:5 (117,11)};
// (117,10.6) @TEXT("VSS",size=1.1,halign="middle",valign="top");
// &"PR" @WIRE(mode="straight",linecolor="#30485d",linewidth=0.16) {#XRAW:1 (140,23.65)};
// (139.6,23.65) @TEXT("PR",size=1.1,halign="end",valign="middle");
// &"NR" @WIRE(mode="straight",linecolor="#30485d",linewidth=0.16) {#XRAW:2 (140,20.35)};
// (139.6,20.35) @TEXT("NR",size=1.1,halign="end",valign="middle");
// &"RAW" @WIRE(mode="straight",linecolor="#30485d",linewidth=0.16) {#XRAW:3 (172,22)};
// (172.4,22) @TEXT("RAW",size=1.1,halign="start",valign="middle");
// &"VDD" @WIRE(mode="straight",linecolor="#30485d",linewidth=0.16) {#XRAW:4 (156,33)};
// (156,33.4) @TEXT("VDD",size=1.1,halign="middle",valign="bottom");
// &"VSS" @WIRE(mode="straight",linecolor="#30485d",linewidth=0.16) {#XRAW:5 (156,11)};
// (156,10.6) @TEXT("VSS",size=1.1,halign="middle",valign="top");
// &"RAW" @WIRE(mode="straight",linecolor="#30485d",linewidth=0.16) {#XVD:1 (179,22)};
// (178.6,22) @TEXT("RAW",size=1.1,halign="end",valign="middle");
// &"VDD" @WIRE(mode="straight",linecolor="#30485d",linewidth=0.16) {#XVD:3 (195,33)};
// (195,33.4) @TEXT("VDD",size=1.1,halign="middle",valign="bottom");
// &"VSS" @WIRE(mode="straight",linecolor="#30485d",linewidth=0.16) {#XVD:4 (195,11)};
// (195,10.6) @TEXT("VSS",size=1.1,halign="middle",valign="top");
// &"RAW" @WIRE(mode="straight",linecolor="#30485d",linewidth=0.16) {#XVALID:1 (218,23.65)};
// (217.6,23.65) @TEXT("RAW",size=1.1,halign="end",valign="middle");
// &"VALID" @WIRE(mode="straight",linecolor="#30485d",linewidth=0.16) {#XVALID:3 (250,22)};
// (250.4,22) @TEXT("VALID",size=1.1,halign="start",valign="middle");
// &"VDD" @WIRE(mode="straight",linecolor="#30485d",linewidth=0.16) {#XVALID:4 (234,33)};
// (234,33.4) @TEXT("VDD",size=1.1,halign="middle",valign="bottom");
// &"VSS" @WIRE(mode="straight",linecolor="#30485d",linewidth=0.16) {#XVALID:5 (234,11)};
// (234,10.6) @TEXT("VSS",size=1.1,halign="middle",valign="top");
// &"SAMPLE" @WIRE(mode="straight",linecolor="#30485d",linewidth=0.16) {#XSN:1 (-10,-28)};
// (-10.4,-28) @TEXT("SAMPLE",size=1.1,halign="end",valign="middle");
// &"SN" @WIRE(mode="straight",linecolor="#30485d",linewidth=0.16) {#XSN:2 (10,-28)};
// (10.4,-28) @TEXT("SN",size=1.1,halign="start",valign="middle");
// &"VDD" @WIRE(mode="straight",linecolor="#30485d",linewidth=0.16) {#XSN:3 (0,-18)};
// (0,-17.6) @TEXT("VDD",size=1.1,halign="middle",valign="bottom");
// &"VSS" @WIRE(mode="straight",linecolor="#30485d",linewidth=0.16) {#XSN:4 (0,-38)};
// (0,-38.4) @TEXT("VSS",size=1.1,halign="middle",valign="top");
// &"VALID" @WIRE(mode="straight",linecolor="#30485d",linewidth=0.16) {#XW0:1 (23,-26.35)};
// (22.6,-26.35) @TEXT("VALID",size=1.1,halign="end",valign="middle");
// &"CMP_CLK" @WIRE(mode="straight",linecolor="#30485d",linewidth=0.16) {#XW0:2 (23,-29.65)};
// (22.6,-29.65) @TEXT("CMP_CLK",size=1.1,halign="end",valign="middle");
// &"VDD" @WIRE(mode="straight",linecolor="#30485d",linewidth=0.16) {#XW0:4 (39,-17)};
// (39,-16.6) @TEXT("VDD",size=1.1,halign="middle",valign="bottom");
// &"VSS" @WIRE(mode="straight",linecolor="#30485d",linewidth=0.16) {#XW0:5 (39,-39)};
// (39,-39.4) @TEXT("VSS",size=1.1,halign="middle",valign="top");
// &"SN" @WIRE(mode="straight",linecolor="#30485d",linewidth=0.16) {#XW1:2 (62,-29.65)};
// (61.6,-29.65) @TEXT("SN",size=1.1,halign="end",valign="middle");
// &"VDD" @WIRE(mode="straight",linecolor="#30485d",linewidth=0.16) {#XW1:4 (78,-17)};
// (78,-16.6) @TEXT("VDD",size=1.1,halign="middle",valign="bottom");
// &"VSS" @WIRE(mode="straight",linecolor="#30485d",linewidth=0.16) {#XW1:5 (78,-39)};
// (78,-39.4) @TEXT("VSS",size=1.1,halign="middle",valign="top");
// &"COMMIT" @WIRE(mode="straight",linecolor="#30485d",linewidth=0.16) {#XCP:2 (133,-28)};
// (133.4,-28) @TEXT("COMMIT",size=1.1,halign="start",valign="middle");
// &"VDD" @WIRE(mode="straight",linecolor="#30485d",linewidth=0.16) {#XCP:3 (117,-17)};
// (117,-16.6) @TEXT("VDD",size=1.1,halign="middle",valign="bottom");
// &"VSS" @WIRE(mode="straight",linecolor="#30485d",linewidth=0.16) {#XCP:4 (117,-39)};
// (117,-39.4) @TEXT("VSS",size=1.1,halign="middle",valign="top");
// &"COMMIT" @WIRE(mode="straight",linecolor="#30485d",linewidth=0.16) {#XPHA:1 (140,-26.35)};
// (139.6,-26.35) @TEXT("COMMIT",size=1.1,halign="end",valign="middle");
// &"SAMPLE" @WIRE(mode="straight",linecolor="#30485d",linewidth=0.16) {#XPHA:3 (140,-29.65)};
// (139.6,-29.65) @TEXT("SAMPLE",size=1.1,halign="end",valign="middle");
// &"VDD" @WIRE(mode="straight",linecolor="#30485d",linewidth=0.16) {#XPHA:4 (156,-17)};
// (156,-16.6) @TEXT("VDD",size=1.1,halign="middle",valign="bottom");
// &"VSS" @WIRE(mode="straight",linecolor="#30485d",linewidth=0.16) {#XPHA:5 (156,-39)};
// (156,-39.4) @TEXT("VSS",size=1.1,halign="middle",valign="top");
// &"PHA" @WIRE(mode="straight",linecolor="#30485d",linewidth=0.16) {#XPHA:6 (172,-29.65)};
// (172.4,-29.65) @TEXT("PHA",size=1.1,halign="start",valign="middle");
// &"PHB" @WIRE(mode="straight",linecolor="#30485d",linewidth=0.16) {#XPHBN:1 (185,-28)};
// (184.6,-28) @TEXT("PHB",size=1.1,halign="end",valign="middle");
// &"VDD" @WIRE(mode="straight",linecolor="#30485d",linewidth=0.16) {#XPHBN:3 (195,-18)};
// (195,-17.6) @TEXT("VDD",size=1.1,halign="middle",valign="bottom");
// &"VSS" @WIRE(mode="straight",linecolor="#30485d",linewidth=0.16) {#XPHBN:4 (195,-38)};
// (195,-38.4) @TEXT("VSS",size=1.1,halign="middle",valign="top");
// &"COMMIT" @WIRE(mode="straight",linecolor="#30485d",linewidth=0.16) {#XPHB:1 (218,-26.35)};
// (217.6,-26.35) @TEXT("COMMIT",size=1.1,halign="end",valign="middle");
// &"PHA" @WIRE(mode="straight",linecolor="#30485d",linewidth=0.16) {#XPHB:2 (250,-26.35)};
// (250.4,-26.35) @TEXT("PHA",size=1.1,halign="start",valign="middle");
// &"SAMPLE" @WIRE(mode="straight",linecolor="#30485d",linewidth=0.16) {#XPHB:3 (218,-29.65)};
// (217.6,-29.65) @TEXT("SAMPLE",size=1.1,halign="end",valign="middle");
// &"VDD" @WIRE(mode="straight",linecolor="#30485d",linewidth=0.16) {#XPHB:4 (234,-17)};
// (234,-16.6) @TEXT("VDD",size=1.1,halign="middle",valign="bottom");
// &"VSS" @WIRE(mode="straight",linecolor="#30485d",linewidth=0.16) {#XPHB:5 (234,-39)};
// (234,-39.4) @TEXT("VSS",size=1.1,halign="middle",valign="top");
// &"PHB" @WIRE(mode="straight",linecolor="#30485d",linewidth=0.16) {#XPHB:6 (250,-29.65)};
// (250.4,-29.65) @TEXT("PHB",size=1.1,halign="start",valign="middle");
// &"PHA" @WIRE(mode="straight",linecolor="#30485d",linewidth=0.16) {#XPHX:1 (257,-26.35)};
// (256.6,-26.35) @TEXT("PHA",size=1.1,halign="end",valign="middle");
// &"PHB" @WIRE(mode="straight",linecolor="#30485d",linewidth=0.16) {#XPHX:2 (257,-29.65)};
// (256.6,-29.65) @TEXT("PHB",size=1.1,halign="end",valign="middle");
// &"PHASE" @WIRE(mode="straight",linecolor="#30485d",linewidth=0.16) {#XPHX:3 (289,-28)};
// (289.4,-28) @TEXT("PHASE",size=1.1,halign="start",valign="middle");
// &"VDD" @WIRE(mode="straight",linecolor="#30485d",linewidth=0.16) {#XPHX:4 (273,-17)};
// (273,-16.6) @TEXT("VDD",size=1.1,halign="middle",valign="bottom");
// &"VSS" @WIRE(mode="straight",linecolor="#30485d",linewidth=0.16) {#XPHX:5 (273,-39)};
// (273,-39.4) @TEXT("VSS",size=1.1,halign="middle",valign="top");
// &"PHASE" @WIRE(mode="straight",linecolor="#30485d",linewidth=0.16) {#XPHR:1 (-10,-78)};
// (-10.4,-78) @TEXT("PHASE",size=1.1,halign="end",valign="middle");
// &"VDD" @WIRE(mode="straight",linecolor="#30485d",linewidth=0.16) {#XPHR:3 (0,-68)};
// (0,-67.6) @TEXT("VDD",size=1.1,halign="middle",valign="bottom");
// &"VSS" @WIRE(mode="straight",linecolor="#30485d",linewidth=0.16) {#XPHR:4 (0,-88)};
// (0,-88.4) @TEXT("VSS",size=1.1,halign="middle",valign="top");
// &"SEL9" @WIRE(mode="straight",linecolor="#30485d",linewidth=0.16) {#XWINDOW:2 (23,-73.05)};
// (22.6,-73.05) @TEXT("SEL9",size=1.1,halign="end",valign="middle");
// &"SEL7" @WIRE(mode="straight",linecolor="#30485d",linewidth=0.16) {#XWINDOW:3 (23,-76.35)};
// (22.6,-76.35) @TEXT("SEL7",size=1.1,halign="end",valign="middle");
// &"SEL6" @WIRE(mode="straight",linecolor="#30485d",linewidth=0.16) {#XWINDOW:4 (23,-79.65)};
// (22.6,-79.65) @TEXT("SEL6",size=1.1,halign="end",valign="middle");
// &"SEL5" @WIRE(mode="straight",linecolor="#30485d",linewidth=0.16) {#XWINDOW:5 (23,-82.95)};
// (22.6,-82.95) @TEXT("SEL5",size=1.1,halign="end",valign="middle");
// &"SEL4" @WIRE(mode="straight",linecolor="#30485d",linewidth=0.16) {#XWINDOW:6 (23,-86.25)};
// (22.6,-86.25) @TEXT("SEL4",size=1.1,halign="end",valign="middle");
// &"VDD" @WIRE(mode="straight",linecolor="#30485d",linewidth=0.16) {#XWINDOW:7 (39,-61.45)};
// (39,-61.05) @TEXT("VDD",size=1.1,halign="middle",valign="bottom");
// &"VSS" @WIRE(mode="straight",linecolor="#30485d",linewidth=0.16) {#XWINDOW:8 (39,-94.55)};
// (39,-94.95) @TEXT("VSS",size=1.1,halign="middle",valign="top");
// &"PHASE" @WIRE(mode="straight",linecolor="#30485d",linewidth=0.16) {#XREADY:1 (62,-76.35)};
// (61.6,-76.35) @TEXT("PHASE",size=1.1,halign="end",valign="middle");
// &"READY" @WIRE(mode="straight",linecolor="#30485d",linewidth=0.16) {#XREADY:3 (94,-78)};
// (94.4,-78) @TEXT("READY",size=1.1,halign="start",valign="middle");
// &"VDD" @WIRE(mode="straight",linecolor="#30485d",linewidth=0.16) {#XREADY:4 (78,-67)};
// (78,-66.6) @TEXT("VDD",size=1.1,halign="middle",valign="bottom");
// &"VSS" @WIRE(mode="straight",linecolor="#30485d",linewidth=0.16) {#XREADY:5 (78,-89)};
// (78,-89.4) @TEXT("VSS",size=1.1,halign="middle",valign="top");
// &"READY" @WIRE(mode="straight",linecolor="#30485d",linewidth=0.16) {#XCLR:1 (101,-76.35)};
// (100.6,-76.35) @TEXT("READY",size=1.1,halign="end",valign="middle");
// &"SN" @WIRE(mode="straight",linecolor="#30485d",linewidth=0.16) {#XCLR:2 (101,-79.65)};
// (100.6,-79.65) @TEXT("SN",size=1.1,halign="end",valign="middle");
// &"CLR_N" @WIRE(mode="straight",linecolor="#30485d",linewidth=0.16) {#XCLR:3 (133,-78)};
// (133.4,-78) @TEXT("CLR_N",size=1.1,halign="start",valign="middle");
// &"VDD" @WIRE(mode="straight",linecolor="#30485d",linewidth=0.16) {#XCLR:4 (117,-67)};
// (117,-66.6) @TEXT("VDD",size=1.1,halign="middle",valign="bottom");
// &"VSS" @WIRE(mode="straight",linecolor="#30485d",linewidth=0.16) {#XCLR:5 (117,-89)};
// (117,-89.4) @TEXT("VSS",size=1.1,halign="middle",valign="top");
// &"SN" @WIRE(mode="straight",linecolor="#30485d",linewidth=0.16) {#XSND1:1 (140,-78)};
// (139.6,-78) @TEXT("SN",size=1.1,halign="end",valign="middle");
// &"VDD" @WIRE(mode="straight",linecolor="#30485d",linewidth=0.16) {#XSND1:3 (156,-67)};
// (156,-66.6) @TEXT("VDD",size=1.1,halign="middle",valign="bottom");
// &"VSS" @WIRE(mode="straight",linecolor="#30485d",linewidth=0.16) {#XSND1:4 (156,-89)};
// (156,-89.4) @TEXT("VSS",size=1.1,halign="middle",valign="top");
// &"VDD" @WIRE(mode="straight",linecolor="#30485d",linewidth=0.16) {#XSND2:3 (195,-67)};
// (195,-66.6) @TEXT("VDD",size=1.1,halign="middle",valign="bottom");
// &"VSS" @WIRE(mode="straight",linecolor="#30485d",linewidth=0.16) {#XSND2:4 (195,-89)};
// (195,-89.4) @TEXT("VSS",size=1.1,halign="middle",valign="top");
// &"SN" @WIRE(mode="straight",linecolor="#30485d",linewidth=0.16) {#XSNQ:1 (218,-76.35)};
// (217.6,-76.35) @TEXT("SN",size=1.1,halign="end",valign="middle");
// &"SN_D" @WIRE(mode="straight",linecolor="#30485d",linewidth=0.16) {#XSNQ:3 (250,-78)};
// (250.4,-78) @TEXT("SN_D",size=1.1,halign="start",valign="middle");
// &"VDD" @WIRE(mode="straight",linecolor="#30485d",linewidth=0.16) {#XSNQ:4 (234,-67)};
// (234,-66.6) @TEXT("VDD",size=1.1,halign="middle",valign="bottom");
// &"VSS" @WIRE(mode="straight",linecolor="#30485d",linewidth=0.16) {#XSNQ:5 (234,-89)};
// (234,-89.4) @TEXT("VSS",size=1.1,halign="middle",valign="top");
// &"ACTIVE" @WIRE(mode="straight",linecolor="#30485d",linewidth=0.16) {#XLIVE:1 (-16,-126.35)};
// (-16.4,-126.35) @TEXT("ACTIVE",size=1.1,halign="end",valign="middle");
// &"SN_D" @WIRE(mode="straight",linecolor="#30485d",linewidth=0.16) {#XLIVE:2 (-16,-129.65)};
// (-16.4,-129.65) @TEXT("SN_D",size=1.1,halign="end",valign="middle");
// &"LIVE" @WIRE(mode="straight",linecolor="#30485d",linewidth=0.16) {#XLIVE:3 (16,-128)};
// (16.4,-128) @TEXT("LIVE",size=1.1,halign="start",valign="middle");
// &"VDD" @WIRE(mode="straight",linecolor="#30485d",linewidth=0.16) {#XLIVE:4 (0,-117)};
// (0,-116.6) @TEXT("VDD",size=1.1,halign="middle",valign="bottom");
// &"VSS" @WIRE(mode="straight",linecolor="#30485d",linewidth=0.16) {#XLIVE:5 (0,-139)};
// (0,-139.4) @TEXT("VSS",size=1.1,halign="middle",valign="top");
// &"RAW" @WIRE(mode="straight",linecolor="#30485d",linewidth=0.16) {#XIDLE:1 (29,-128)};
// (28.6,-128) @TEXT("RAW",size=1.1,halign="end",valign="middle");
// &"VDD" @WIRE(mode="straight",linecolor="#30485d",linewidth=0.16) {#XIDLE:3 (39,-118)};
// (39,-117.6) @TEXT("VDD",size=1.1,halign="middle",valign="bottom");
// &"VSS" @WIRE(mode="straight",linecolor="#30485d",linewidth=0.16) {#XIDLE:4 (39,-138)};
// (39,-138.4) @TEXT("VSS",size=1.1,halign="middle",valign="top");
// &"LIVE" @WIRE(mode="straight",linecolor="#30485d",linewidth=0.16) {#XSET0:1 (62,-126.35)};
// (61.6,-126.35) @TEXT("LIVE",size=1.1,halign="end",valign="middle");
// &"VDD" @WIRE(mode="straight",linecolor="#30485d",linewidth=0.16) {#XSET0:4 (78,-117)};
// (78,-116.6) @TEXT("VDD",size=1.1,halign="middle",valign="bottom");
// &"VSS" @WIRE(mode="straight",linecolor="#30485d",linewidth=0.16) {#XSET0:5 (78,-139)};
// (78,-139.4) @TEXT("VSS",size=1.1,halign="middle",valign="top");
// &"READY" @WIRE(mode="straight",linecolor="#30485d",linewidth=0.16) {#XSET:2 (101,-129.65)};
// (100.6,-129.65) @TEXT("READY",size=1.1,halign="end",valign="middle");
// &"SET" @WIRE(mode="straight",linecolor="#30485d",linewidth=0.16) {#XSET:3 (133,-128)};
// (133.4,-128) @TEXT("SET",size=1.1,halign="start",valign="middle");
// &"VDD" @WIRE(mode="straight",linecolor="#30485d",linewidth=0.16) {#XSET:4 (117,-117)};
// (117,-116.6) @TEXT("VDD",size=1.1,halign="middle",valign="bottom");
// &"VSS" @WIRE(mode="straight",linecolor="#30485d",linewidth=0.16) {#XSET:5 (117,-139)};
// (117,-139.4) @TEXT("VSS",size=1.1,halign="middle",valign="top");
// &"VDD" @WIRE(mode="straight",linecolor="#30485d",linewidth=0.16) {#XHIGH:2 (156,-117)};
// (156,-116.6) @TEXT("VDD",size=1.1,halign="middle",valign="bottom");
// &"VSS" @WIRE(mode="straight",linecolor="#30485d",linewidth=0.16) {#XHIGH:3 (156,-139)};
// (156,-139.4) @TEXT("VSS",size=1.1,halign="middle",valign="top");
// &"SET" @WIRE(mode="straight",linecolor="#30485d",linewidth=0.16) {#XCLOCK:2 (179,-128)};
// (178.6,-128) @TEXT("SET",size=1.1,halign="end",valign="middle");
// &"CLR_N" @WIRE(mode="straight",linecolor="#30485d",linewidth=0.16) {#XCLOCK:3 (179,-131.3)};
// (178.6,-131.3) @TEXT("CLR_N",size=1.1,halign="end",valign="middle");
// &"VDD" @WIRE(mode="straight",linecolor="#30485d",linewidth=0.16) {#XCLOCK:5 (195,-116.4)};
// (195,-116) @TEXT("VDD",size=1.1,halign="middle",valign="bottom");
// &"VSS" @WIRE(mode="straight",linecolor="#30485d",linewidth=0.16) {#XCLOCK:6 (195,-139.6)};
// (195,-140) @TEXT("VSS",size=1.1,halign="middle",valign="top");
// &"CMP_CLK" @WIRE(mode="straight",linecolor="#30485d",linewidth=0.16) {#XCMP:2 (250,-128)};
// (250.4,-128) @TEXT("CMP_CLK",size=1.1,halign="start",valign="middle");
// &"VDD" @WIRE(mode="straight",linecolor="#30485d",linewidth=0.16) {#XCMP:3 (234,-117)};
// (234,-116.6) @TEXT("VDD",size=1.1,halign="middle",valign="bottom");
// &"VSS" @WIRE(mode="straight",linecolor="#30485d",linewidth=0.16) {#XCMP:4 (234,-139)};
// (234,-139.4) @TEXT("VSS",size=1.1,halign="middle",valign="top");
// }
// END SARADC RNL
ends sar8_se_timing

subckt sar8_se_store CK DATA RESET VDD VSS Q
XDR (DATA RESET DIN VDD VSS) OR2D1BWP12T30P140
XCLR (RESET RST_N VDD VSS) INVD1BWP12T30P140
XREG (DIN CK RST_N Q VDD VSS) DFCNQD1BWP12T30P140
// BEGIN SARADC RNL
// @RNL(author="saradc topology") {
// #XDR @SET-SYMBOL $S_OR2D1BWP12T30P140;
// #XDR @PLACE(0,0) => @ORIENT("R0");
// #XCLR @SET-SYMBOL $S_INVD1BWP12T30P140;
// #XCLR @PLACE(0,-33) => @ORIENT("R0");
// #XREG @SET-SYMBOL $S_DFCNQD1BWP12T30P140;
// #XREG @PLACE(0,-66) => @ORIENT("R0");
// &"RESET" @WIRE(mode="straight",linecolor="#30485d",linewidth=0.16) {#XDR:2 (-10,-1.65) (-10,-33) #XCLR:1};
// &"DIN" @WIRE(mode="straight",linecolor="#30485d",linewidth=0.16) {#XDR:3 (3,0) (3,-62.6) #XREG:1};
// &"RST_N" @WIRE(mode="straight",linecolor="#30485d",linewidth=0.16) {#XCLR:2 (0,-33) (0,-69.4) #XREG:3};
// (-89,30) @TEXT("sar8_se_store / source-derived connections",size=1.4,halign="start",textcolor="#223d52");
// &"DATA" @WIRE(mode="straight",linecolor="#30485d",linewidth=0.16) {#XDR:1 (-16,1.65)};
// (-16.4,1.65) @TEXT("DATA",size=1.1,halign="end",valign="middle");
// &"VDD" @WIRE(mode="straight",linecolor="#30485d",linewidth=0.16) {#XDR:4 (0,11)};
// (0,11.4) @TEXT("VDD",size=1.1,halign="middle",valign="bottom");
// &"VSS" @WIRE(mode="straight",linecolor="#30485d",linewidth=0.16) {#XDR:5 (0,-11)};
// (0,-11.4) @TEXT("VSS",size=1.1,halign="middle",valign="top");
// &"VDD" @WIRE(mode="straight",linecolor="#30485d",linewidth=0.16) {#XCLR:3 (0,-23)};
// (0,-22.6) @TEXT("VDD",size=1.1,halign="middle",valign="bottom");
// &"VSS" @WIRE(mode="straight",linecolor="#30485d",linewidth=0.16) {#XCLR:4 (0,-43)};
// (0,-43.4) @TEXT("VSS",size=1.1,halign="middle",valign="top");
// &"CK" @WIRE(mode="straight",linecolor="#30485d",linewidth=0.16) {#XREG:2 (-10,-66)};
// (-10.4,-66) @TEXT("CK",size=1.1,halign="end",valign="middle");
// &"Q" @WIRE(mode="straight",linecolor="#30485d",linewidth=0.16) {#XREG:4 (10,-66)};
// (10.4,-66) @TEXT("Q",size=1.1,halign="start",valign="middle");
// &"VDD" @WIRE(mode="straight",linecolor="#30485d",linewidth=0.16) {#XREG:5 (0,-56)};
// (0,-55.6) @TEXT("VDD",size=1.1,halign="middle",valign="bottom");
// &"VSS" @WIRE(mode="straight",linecolor="#30485d",linewidth=0.16) {#XREG:6 (0,-76)};
// (0,-76.4) @TEXT("VSS",size=1.1,halign="middle",valign="top");
// }
// END SARADC RNL
ends sar8_se_store

subckt sar8_se_ctrl CMP_CLK CODE0 CODE1 CODE2 CODE3 CODE4 CODE5 CODE6 CODE7 COMP_N COMP_P D0 D1 D2 D3 D4 D5 D6 D7 COMMIT SAMPLE VDD VSS ACTIVE
XTIM (ACTIVE SAMPLE SEL9 SEL7 SEL6 SEL5 SEL4 COMP_P COMP_N CMP_CLK COMMIT DATA VDD VSS) sar8_se_timing
XWORD (CODE0 CODE1 CODE2 CODE3 CODE4 CODE5 CODE6 CODE7 DATA DONE D0 D1 D2 D3 D4 D5 D6 D7 NEXT0 NEXT1 NEXT2 NEXT3 NEXT4 NEXT5 NEXT6 NEXT7 TRIAL6 TRIAL5 TRIAL4 TRIAL3 TRIAL2 VDD VSS) sar8_next_word
// Sticky tap selects: the commit of bit k sets the select for bit k-1 until the
// next accepted sample. Each feeds only the window multiplexers.
// The OR is INV+INV+ND2: a trial glitch while the select is already set must not lift a
// floating PMOS stack node above the rail (FF-cold terminal-voltage screen).
XSEL9_QB (SEL9 SEL9_QB VDD VSS) INVD1BWP12T30P140
XSEL9_TB (TRIAL6 SEL9_TB VDD VSS) INVD1BWP12T30P140
XSEL9_D (SEL9_QB SEL9_TB SEL9_D VDD VSS) ND2D1BWP12T30P140
XSEL9 (COMMIT SEL9_D SAMPLE VDD VSS SEL9) sar8_se_store
XSEL7_QB (SEL7 SEL7_QB VDD VSS) INVD1BWP12T30P140
XSEL7_TB (TRIAL5 SEL7_TB VDD VSS) INVD1BWP12T30P140
XSEL7_D (SEL7_QB SEL7_TB SEL7_D VDD VSS) ND2D1BWP12T30P140
XSEL7 (COMMIT SEL7_D SAMPLE VDD VSS SEL7) sar8_se_store
XSEL6_QB (SEL6 SEL6_QB VDD VSS) INVD1BWP12T30P140
XSEL6_TB (TRIAL4 SEL6_TB VDD VSS) INVD1BWP12T30P140
XSEL6_D (SEL6_QB SEL6_TB SEL6_D VDD VSS) ND2D1BWP12T30P140
XSEL6 (COMMIT SEL6_D SAMPLE VDD VSS SEL6) sar8_se_store
XSEL5_QB (SEL5 SEL5_QB VDD VSS) INVD1BWP12T30P140
XSEL5_TB (TRIAL3 SEL5_TB VDD VSS) INVD1BWP12T30P140
XSEL5_D (SEL5_QB SEL5_TB SEL5_D VDD VSS) ND2D1BWP12T30P140
XSEL5 (COMMIT SEL5_D SAMPLE VDD VSS SEL5) sar8_se_store
XSEL4_QB (SEL4 SEL4_QB VDD VSS) INVD1BWP12T30P140
XSEL4_TB (TRIAL2 SEL4_TB VDD VSS) INVD1BWP12T30P140
XSEL4_D (SEL4_QB SEL4_TB SEL4_D VDD VSS) ND2D1BWP12T30P140
XSEL4 (COMMIT SEL4_D SAMPLE VDD VSS SEL4) sar8_se_store
XDONE (COMMIT CODE0 SAMPLE VDD VSS DONE) sar8_se_store
XACTIVE (DONE ACTIVE VDD VSS) INVD1BWP12T30P140
XBIT0 (COMMIT NEXT0 SAMPLE VDD VSS CODE0) sar8_se_store
XBIT1 (COMMIT NEXT1 SAMPLE VDD VSS CODE1) sar8_se_store
XBIT2 (COMMIT NEXT2 SAMPLE VDD VSS CODE2) sar8_se_store
XBIT3 (COMMIT NEXT3 SAMPLE VDD VSS CODE3) sar8_se_store
XBIT4 (COMMIT NEXT4 SAMPLE VDD VSS CODE4) sar8_se_store
XBIT5 (COMMIT NEXT5 SAMPLE VDD VSS CODE5) sar8_se_store
XBIT6 (COMMIT NEXT6 SAMPLE VDD VSS CODE6) sar8_se_store
XMSBD (NEXT7 MSBD VDD VSS) INVD1BWP12T30P140
XBIT7 (COMMIT MSBD SAMPLE VDD VSS MSBQ) sar8_se_store
XMSBQ (MSBQ CODE7 VDD VSS) INVD1BWP12T30P140
// BEGIN SARADC RNL
// @RNL(author="saradc topology") {
// (-18,84) @TEXT("Single-edge SAR",size=2.15,halign="start",textcolor="#223d52");
// (-18,67) @TEXT("Compare / timing",size=1.25,halign="start",textcolor="#223d52");
// (56,67) @TEXT("Next trial word",size=1.25,halign="start",textcolor="#223d52");
// (147,67) @TEXT("Completion",size=1.25,halign="start",textcolor="#223d52");
// #XTIM @SET-SYMBOL $S_sar8_se_timing;
// #XTIM @PLACE(0,44) => @ORIENT("R0");
// #XWORD @SET-SYMBOL $S_sar8_next_word;
// #XWORD @PLACE(62,44) => @ORIENT("R0");
// #XDONE @SET-SYMBOL $S_sar8_se_store;
// #XDONE @PLACE(124,44) => @ORIENT("R0");
// #XACTIVE @SET-SYMBOL $S_INVD1BWP12T30P140;
// #XACTIVE @PLACE(186,44) => @ORIENT("R0");
// (-18,20) @TEXT("Registered settling taps",size=1.35,halign="start",textcolor="#223d52");
// #XSEL9_QB @SET-SYMBOL $S_INVD1BWP12T30P140;
// #XSEL9_QB @PLACE(0,0) => @ORIENT("R0");
// #XSEL9_TB @SET-SYMBOL $S_INVD1BWP12T30P140;
// #XSEL9_TB @PLACE(34,0) => @ORIENT("R0");
// #XSEL9_D @SET-SYMBOL $S_ND2D1BWP12T30P140;
// #XSEL9_D @PLACE(68,0) => @ORIENT("R0");
// #XSEL9 @SET-SYMBOL $S_sar8_se_store;
// #XSEL9 @PLACE(102,0) => @ORIENT("R0");
// #XSEL7_QB @SET-SYMBOL $S_INVD1BWP12T30P140;
// #XSEL7_QB @PLACE(0,-30) => @ORIENT("R0");
// #XSEL7_TB @SET-SYMBOL $S_INVD1BWP12T30P140;
// #XSEL7_TB @PLACE(34,-30) => @ORIENT("R0");
// #XSEL7_D @SET-SYMBOL $S_ND2D1BWP12T30P140;
// #XSEL7_D @PLACE(68,-30) => @ORIENT("R0");
// #XSEL7 @SET-SYMBOL $S_sar8_se_store;
// #XSEL7 @PLACE(102,-30) => @ORIENT("R0");
// #XSEL6_QB @SET-SYMBOL $S_INVD1BWP12T30P140;
// #XSEL6_QB @PLACE(0,-60) => @ORIENT("R0");
// #XSEL6_TB @SET-SYMBOL $S_INVD1BWP12T30P140;
// #XSEL6_TB @PLACE(34,-60) => @ORIENT("R0");
// #XSEL6_D @SET-SYMBOL $S_ND2D1BWP12T30P140;
// #XSEL6_D @PLACE(68,-60) => @ORIENT("R0");
// #XSEL6 @SET-SYMBOL $S_sar8_se_store;
// #XSEL6 @PLACE(102,-60) => @ORIENT("R0");
// #XSEL5_QB @SET-SYMBOL $S_INVD1BWP12T30P140;
// #XSEL5_QB @PLACE(0,-90) => @ORIENT("R0");
// #XSEL5_TB @SET-SYMBOL $S_INVD1BWP12T30P140;
// #XSEL5_TB @PLACE(34,-90) => @ORIENT("R0");
// #XSEL5_D @SET-SYMBOL $S_ND2D1BWP12T30P140;
// #XSEL5_D @PLACE(68,-90) => @ORIENT("R0");
// #XSEL5 @SET-SYMBOL $S_sar8_se_store;
// #XSEL5 @PLACE(102,-90) => @ORIENT("R0");
// #XSEL4_QB @SET-SYMBOL $S_INVD1BWP12T30P140;
// #XSEL4_QB @PLACE(0,-120) => @ORIENT("R0");
// #XSEL4_TB @SET-SYMBOL $S_INVD1BWP12T30P140;
// #XSEL4_TB @PLACE(34,-120) => @ORIENT("R0");
// #XSEL4_D @SET-SYMBOL $S_ND2D1BWP12T30P140;
// #XSEL4_D @PLACE(68,-120) => @ORIENT("R0");
// #XSEL4 @SET-SYMBOL $S_sar8_se_store;
// #XSEL4 @PLACE(102,-120) => @ORIENT("R0");
// (136,20) @TEXT("Bit stores",size=1.35,halign="start",textcolor="#223d52");
// #XBIT0 @SET-SYMBOL $S_sar8_se_store;
// #XBIT0 @PLACE(157,0) => @ORIENT("R0");
// #XBIT1 @SET-SYMBOL $S_sar8_se_store;
// #XBIT1 @PLACE(194,0) => @ORIENT("R0");
// #XBIT2 @SET-SYMBOL $S_sar8_se_store;
// #XBIT2 @PLACE(157,-31) => @ORIENT("R0");
// #XBIT3 @SET-SYMBOL $S_sar8_se_store;
// #XBIT3 @PLACE(194,-31) => @ORIENT("R0");
// #XBIT4 @SET-SYMBOL $S_sar8_se_store;
// #XBIT4 @PLACE(157,-62) => @ORIENT("R0");
// #XBIT5 @SET-SYMBOL $S_sar8_se_store;
// #XBIT5 @PLACE(194,-62) => @ORIENT("R0");
// #XBIT6 @SET-SYMBOL $S_sar8_se_store;
// #XBIT6 @PLACE(157,-93) => @ORIENT("R0");
// #XBIT7 @SET-SYMBOL $S_sar8_se_store;
// #XBIT7 @PLACE(194,-93) => @ORIENT("R0");
// #XMSBD @SET-SYMBOL $S_INVD1BWP12T30P140;
// #XMSBD @PLACE(157,-129) => @ORIENT("R0");
// #XMSBQ @SET-SYMBOL $S_INVD1BWP12T30P140;
// #XMSBQ @PLACE(194,-129) => @ORIENT("R0");
// &"SEL9_TB" @WIRE(mode="straight",linecolor="#30485d",linewidth=0.16) {#XSEL9_TB:2 (51,0) (51,-1.7) #XSEL9_D:2};
// &"SEL9_D" @WIRE(mode="straight",linecolor="#30485d",linewidth=0.16) {#XSEL9_D:3 (95,0) (95,1.65) #XSEL9:2};
// &"SEL7_TB" @WIRE(mode="straight",linecolor="#30485d",linewidth=0.16) {#XSEL7_TB:2 (51,-30) (51,-31.7) #XSEL7_D:2};
// &"SEL7_D" @WIRE(mode="straight",linecolor="#30485d",linewidth=0.16) {#XSEL7_D:3 (95,-30) (95,-28.35) #XSEL7:2};
// &"SEL6_TB" @WIRE(mode="straight",linecolor="#30485d",linewidth=0.16) {#XSEL6_TB:2 (51,-60) (51,-61.7) #XSEL6_D:2};
// &"SEL6_D" @WIRE(mode="straight",linecolor="#30485d",linewidth=0.16) {#XSEL6_D:3 (95,-60) (95,-58.35) #XSEL6:2};
// &"SEL5_TB" @WIRE(mode="straight",linecolor="#30485d",linewidth=0.16) {#XSEL5_TB:2 (51,-90) (51,-91.7) #XSEL5_D:2};
// &"SEL5_D" @WIRE(mode="straight",linecolor="#30485d",linewidth=0.16) {#XSEL5_D:3 (95,-90) (95,-88.35) #XSEL5:2};
// &"SEL4_TB" @WIRE(mode="straight",linecolor="#30485d",linewidth=0.16) {#XSEL4_TB:2 (51,-120) (51,-121.7) #XSEL4_D:2};
// &"SEL4_D" @WIRE(mode="straight",linecolor="#30485d",linewidth=0.16) {#XSEL4_D:3 (95,-120) (95,-118.35) #XSEL4:2};
// &"MSBQ" @WIRE(mode="straight",linecolor="#30485d",linewidth=0.16) {#XBIT7:6 (197,-94.65) (197,-129) #XMSBQ:1};
// &"ACTIVE" @WIRE(mode="straight",linecolor="#30485d",linewidth=0.16) {#XTIM:1 (16,48.95)};
// (16.4,48.95) @TEXT("ACTIVE",size=1.1,halign="start",valign="middle");
// &"SAMPLE" @WIRE(mode="straight",linecolor="#30485d",linewidth=0.16) {#XTIM:2 (-16,55.55)};
// (-16.4,55.55) @TEXT("SAMPLE",size=1.1,halign="end",valign="middle");
// &"SEL9" @WIRE(mode="straight",linecolor="#30485d",linewidth=0.16) {#XTIM:3 (-16,52.25)};
// (-16.4,52.25) @TEXT("SEL9",size=1.1,halign="end",valign="middle");
// &"SEL7" @WIRE(mode="straight",linecolor="#30485d",linewidth=0.16) {#XTIM:4 (-16,48.95)};
// (-16.4,48.95) @TEXT("SEL7",size=1.1,halign="end",valign="middle");
// &"SEL6" @WIRE(mode="straight",linecolor="#30485d",linewidth=0.16) {#XTIM:5 (-16,45.65)};
// (-16.4,45.65) @TEXT("SEL6",size=1.1,halign="end",valign="middle");
// &"SEL5" @WIRE(mode="straight",linecolor="#30485d",linewidth=0.16) {#XTIM:6 (-16,42.35)};
// (-16.4,42.35) @TEXT("SEL5",size=1.1,halign="end",valign="middle");
// &"SEL4" @WIRE(mode="straight",linecolor="#30485d",linewidth=0.16) {#XTIM:7 (-16,39.05)};
// (-16.4,39.05) @TEXT("SEL4",size=1.1,halign="end",valign="middle");
// &"COMP_P" @WIRE(mode="straight",linecolor="#30485d",linewidth=0.16) {#XTIM:8 (-16,35.75)};
// (-16.4,35.75) @TEXT("COMP_P",size=1.1,halign="end",valign="middle");
// &"COMP_N" @WIRE(mode="straight",linecolor="#30485d",linewidth=0.16) {#XTIM:9 (-16,32.45)};
// (-16.4,32.45) @TEXT("COMP_N",size=1.1,halign="end",valign="middle");
// &"CMP_CLK" @WIRE(mode="straight",linecolor="#30485d",linewidth=0.16) {#XTIM:10 (16,45.65)};
// (16.4,45.65) @TEXT("CMP_CLK",size=1.1,halign="start",valign="middle");
// &"COMMIT" @WIRE(mode="straight",linecolor="#30485d",linewidth=0.16) {#XTIM:11 (16,42.35)};
// (16.4,42.35) @TEXT("COMMIT",size=1.1,halign="start",valign="middle");
// &"DATA" @WIRE(mode="straight",linecolor="#30485d",linewidth=0.16) {#XTIM:12 (16,39.05)};
// (16.4,39.05) @TEXT("DATA",size=1.1,halign="start",valign="middle");
// &"VDD" @WIRE(mode="straight",linecolor="#30485d",linewidth=0.16) {#XTIM:13 (0,63.85)};
// (0,64.25) @TEXT("VDD",size=1.1,halign="middle",valign="bottom");
// &"VSS" @WIRE(mode="straight",linecolor="#30485d",linewidth=0.16) {#XTIM:14 (0,24.15)};
// (0,23.75) @TEXT("VSS",size=1.1,halign="middle",valign="top");
// {&"CODE0" &"CODE1" &"CODE2" &"CODE3" &"CODE4" &"CODE5" &"CODE6" &"CODE7"} @WIRE(mode="straight",linewidth=0.3) {#XWORD:1 (78,50.6)};
// (78.4,50.6) @TEXT("CODE[7:0]",size=1.1,halign="start",valign="middle");
// &"DATA" @WIRE(mode="straight",linecolor="#30485d",linewidth=0.16) {#XWORD:9 (78,47.3)};
// (78.4,47.3) @TEXT("DATA",size=1.1,halign="start",valign="middle");
// &"DONE" @WIRE(mode="straight",linecolor="#30485d",linewidth=0.16) {#XWORD:10 (46,44)};
// (45.6,44) @TEXT("DONE",size=1.1,halign="end",valign="middle");
// {&"D0" &"D1" &"D2" &"D3" &"D4" &"D5" &"D6" &"D7"} @WIRE(mode="straight",linewidth=0.3) {#XWORD:11 (78,44)};
// (78.4,44) @TEXT("D[7:0]",size=1.1,halign="start",valign="middle");
// {&"NEXT0" &"NEXT1" &"NEXT2" &"NEXT3" &"NEXT4" &"NEXT5" &"NEXT6" &"NEXT7"} @WIRE(mode="straight",linewidth=0.3) {#XWORD:19 (78,40.7)};
// (78.4,40.7) @TEXT("NEXT[7:0]",size=1.1,halign="start",valign="middle");
// {&"TRIAL6" &"TRIAL5" &"TRIAL4" &"TRIAL3" &"TRIAL2"} @WIRE(mode="straight",linewidth=0.3) {#XWORD:27 (78,37.4)};
// (78.4,37.4) @TEXT("TRIAL[2:6]",size=1.1,halign="start",valign="middle");
// &"VDD" @WIRE(mode="straight",linecolor="#30485d",linewidth=0.16) {#XWORD:32 (62,58.9)};
// (62,59.3) @TEXT("VDD",size=1.1,halign="middle",valign="bottom");
// &"VSS" @WIRE(mode="straight",linecolor="#30485d",linewidth=0.16) {#XWORD:33 (62,29.1)};
// (62,28.7) @TEXT("VSS",size=1.1,halign="middle",valign="top");
// &"SEL9" @WIRE(mode="straight",linecolor="#30485d",linewidth=0.16) {#XSEL9_QB:1 (-10,0)};
// (-10.4,0) @TEXT("SEL9",size=1.1,halign="end",valign="middle");
// &"SEL9_QB" @WIRE(mode="straight",linecolor="#30485d",linewidth=0.16) {#XSEL9_QB:2 (10,0)};
// (10.4,0) @TEXT("SEL9_QB",size=1.1,halign="start",valign="middle");
// &"VDD" @WIRE(mode="straight",linecolor="#30485d",linewidth=0.16) {#XSEL9_QB:3 (0,10)};
// (0,10.4) @TEXT("VDD",size=1.1,halign="middle",valign="bottom");
// &"VSS" @WIRE(mode="straight",linecolor="#30485d",linewidth=0.16) {#XSEL9_QB:4 (0,-10)};
// (0,-10.4) @TEXT("VSS",size=1.1,halign="middle",valign="top");
// &"TRIAL6" @WIRE(mode="straight",linecolor="#30485d",linewidth=0.16) {#XSEL9_TB:1 (24,0)};
// (23.6,0) @TEXT("TRIAL6",size=1.1,halign="end",valign="middle");
// &"VDD" @WIRE(mode="straight",linecolor="#30485d",linewidth=0.16) {#XSEL9_TB:3 (34,10)};
// (34,10.4) @TEXT("VDD",size=1.1,halign="middle",valign="bottom");
// &"VSS" @WIRE(mode="straight",linecolor="#30485d",linewidth=0.16) {#XSEL9_TB:4 (34,-10)};
// (34,-10.4) @TEXT("VSS",size=1.1,halign="middle",valign="top");
// &"SEL9_QB" @WIRE(mode="straight",linecolor="#30485d",linewidth=0.16) {#XSEL9_D:1 (58,1.7)};
// (57.6,1.7) @TEXT("SEL9_QB",size=1.1,halign="end",valign="middle");
// &"VDD" @WIRE(mode="straight",linecolor="#30485d",linewidth=0.16) {#XSEL9_D:4 (68,10)};
// (68,10.4) @TEXT("VDD",size=1.1,halign="middle",valign="bottom");
// &"VSS" @WIRE(mode="straight",linecolor="#30485d",linewidth=0.16) {#XSEL9_D:5 (68,-10)};
// (68,-10.4) @TEXT("VSS",size=1.1,halign="middle",valign="top");
// &"COMMIT" @WIRE(mode="straight",linecolor="#30485d",linewidth=0.16) {#XSEL9:1 (86,1.65)};
// (85.6,1.65) @TEXT("COMMIT",size=1.1,halign="end",valign="middle");
// &"SAMPLE" @WIRE(mode="straight",linecolor="#30485d",linewidth=0.16) {#XSEL9:3 (86,-1.65)};
// (85.6,-1.65) @TEXT("SAMPLE",size=1.1,halign="end",valign="middle");
// &"VDD" @WIRE(mode="straight",linecolor="#30485d",linewidth=0.16) {#XSEL9:4 (102,11)};
// (102,11.4) @TEXT("VDD",size=1.1,halign="middle",valign="bottom");
// &"VSS" @WIRE(mode="straight",linecolor="#30485d",linewidth=0.16) {#XSEL9:5 (102,-11)};
// (102,-11.4) @TEXT("VSS",size=1.1,halign="middle",valign="top");
// &"SEL9" @WIRE(mode="straight",linecolor="#30485d",linewidth=0.16) {#XSEL9:6 (118,-1.65)};
// (118.4,-1.65) @TEXT("SEL9",size=1.1,halign="start",valign="middle");
// &"SEL7" @WIRE(mode="straight",linecolor="#30485d",linewidth=0.16) {#XSEL7_QB:1 (-10,-30)};
// (-10.4,-30) @TEXT("SEL7",size=1.1,halign="end",valign="middle");
// &"SEL7_QB" @WIRE(mode="straight",linecolor="#30485d",linewidth=0.16) {#XSEL7_QB:2 (10,-30)};
// (10.4,-30) @TEXT("SEL7_QB",size=1.1,halign="start",valign="middle");
// &"VDD" @WIRE(mode="straight",linecolor="#30485d",linewidth=0.16) {#XSEL7_QB:3 (0,-20)};
// (0,-19.6) @TEXT("VDD",size=1.1,halign="middle",valign="bottom");
// &"VSS" @WIRE(mode="straight",linecolor="#30485d",linewidth=0.16) {#XSEL7_QB:4 (0,-40)};
// (0,-40.4) @TEXT("VSS",size=1.1,halign="middle",valign="top");
// &"TRIAL5" @WIRE(mode="straight",linecolor="#30485d",linewidth=0.16) {#XSEL7_TB:1 (24,-30)};
// (23.6,-30) @TEXT("TRIAL5",size=1.1,halign="end",valign="middle");
// &"VDD" @WIRE(mode="straight",linecolor="#30485d",linewidth=0.16) {#XSEL7_TB:3 (34,-20)};
// (34,-19.6) @TEXT("VDD",size=1.1,halign="middle",valign="bottom");
// &"VSS" @WIRE(mode="straight",linecolor="#30485d",linewidth=0.16) {#XSEL7_TB:4 (34,-40)};
// (34,-40.4) @TEXT("VSS",size=1.1,halign="middle",valign="top");
// &"SEL7_QB" @WIRE(mode="straight",linecolor="#30485d",linewidth=0.16) {#XSEL7_D:1 (58,-28.3)};
// (57.6,-28.3) @TEXT("SEL7_QB",size=1.1,halign="end",valign="middle");
// &"VDD" @WIRE(mode="straight",linecolor="#30485d",linewidth=0.16) {#XSEL7_D:4 (68,-20)};
// (68,-19.6) @TEXT("VDD",size=1.1,halign="middle",valign="bottom");
// &"VSS" @WIRE(mode="straight",linecolor="#30485d",linewidth=0.16) {#XSEL7_D:5 (68,-40)};
// (68,-40.4) @TEXT("VSS",size=1.1,halign="middle",valign="top");
// &"COMMIT" @WIRE(mode="straight",linecolor="#30485d",linewidth=0.16) {#XSEL7:1 (86,-28.35)};
// (85.6,-28.35) @TEXT("COMMIT",size=1.1,halign="end",valign="middle");
// &"SAMPLE" @WIRE(mode="straight",linecolor="#30485d",linewidth=0.16) {#XSEL7:3 (86,-31.65)};
// (85.6,-31.65) @TEXT("SAMPLE",size=1.1,halign="end",valign="middle");
// &"VDD" @WIRE(mode="straight",linecolor="#30485d",linewidth=0.16) {#XSEL7:4 (102,-19)};
// (102,-18.6) @TEXT("VDD",size=1.1,halign="middle",valign="bottom");
// &"VSS" @WIRE(mode="straight",linecolor="#30485d",linewidth=0.16) {#XSEL7:5 (102,-41)};
// (102,-41.4) @TEXT("VSS",size=1.1,halign="middle",valign="top");
// &"SEL7" @WIRE(mode="straight",linecolor="#30485d",linewidth=0.16) {#XSEL7:6 (118,-31.65)};
// (118.4,-31.65) @TEXT("SEL7",size=1.1,halign="start",valign="middle");
// &"SEL6" @WIRE(mode="straight",linecolor="#30485d",linewidth=0.16) {#XSEL6_QB:1 (-10,-60)};
// (-10.4,-60) @TEXT("SEL6",size=1.1,halign="end",valign="middle");
// &"SEL6_QB" @WIRE(mode="straight",linecolor="#30485d",linewidth=0.16) {#XSEL6_QB:2 (10,-60)};
// (10.4,-60) @TEXT("SEL6_QB",size=1.1,halign="start",valign="middle");
// &"VDD" @WIRE(mode="straight",linecolor="#30485d",linewidth=0.16) {#XSEL6_QB:3 (0,-50)};
// (0,-49.6) @TEXT("VDD",size=1.1,halign="middle",valign="bottom");
// &"VSS" @WIRE(mode="straight",linecolor="#30485d",linewidth=0.16) {#XSEL6_QB:4 (0,-70)};
// (0,-70.4) @TEXT("VSS",size=1.1,halign="middle",valign="top");
// &"TRIAL4" @WIRE(mode="straight",linecolor="#30485d",linewidth=0.16) {#XSEL6_TB:1 (24,-60)};
// (23.6,-60) @TEXT("TRIAL4",size=1.1,halign="end",valign="middle");
// &"VDD" @WIRE(mode="straight",linecolor="#30485d",linewidth=0.16) {#XSEL6_TB:3 (34,-50)};
// (34,-49.6) @TEXT("VDD",size=1.1,halign="middle",valign="bottom");
// &"VSS" @WIRE(mode="straight",linecolor="#30485d",linewidth=0.16) {#XSEL6_TB:4 (34,-70)};
// (34,-70.4) @TEXT("VSS",size=1.1,halign="middle",valign="top");
// &"SEL6_QB" @WIRE(mode="straight",linecolor="#30485d",linewidth=0.16) {#XSEL6_D:1 (58,-58.3)};
// (57.6,-58.3) @TEXT("SEL6_QB",size=1.1,halign="end",valign="middle");
// &"VDD" @WIRE(mode="straight",linecolor="#30485d",linewidth=0.16) {#XSEL6_D:4 (68,-50)};
// (68,-49.6) @TEXT("VDD",size=1.1,halign="middle",valign="bottom");
// &"VSS" @WIRE(mode="straight",linecolor="#30485d",linewidth=0.16) {#XSEL6_D:5 (68,-70)};
// (68,-70.4) @TEXT("VSS",size=1.1,halign="middle",valign="top");
// &"COMMIT" @WIRE(mode="straight",linecolor="#30485d",linewidth=0.16) {#XSEL6:1 (86,-58.35)};
// (85.6,-58.35) @TEXT("COMMIT",size=1.1,halign="end",valign="middle");
// &"SAMPLE" @WIRE(mode="straight",linecolor="#30485d",linewidth=0.16) {#XSEL6:3 (86,-61.65)};
// (85.6,-61.65) @TEXT("SAMPLE",size=1.1,halign="end",valign="middle");
// &"VDD" @WIRE(mode="straight",linecolor="#30485d",linewidth=0.16) {#XSEL6:4 (102,-49)};
// (102,-48.6) @TEXT("VDD",size=1.1,halign="middle",valign="bottom");
// &"VSS" @WIRE(mode="straight",linecolor="#30485d",linewidth=0.16) {#XSEL6:5 (102,-71)};
// (102,-71.4) @TEXT("VSS",size=1.1,halign="middle",valign="top");
// &"SEL6" @WIRE(mode="straight",linecolor="#30485d",linewidth=0.16) {#XSEL6:6 (118,-61.65)};
// (118.4,-61.65) @TEXT("SEL6",size=1.1,halign="start",valign="middle");
// &"SEL5" @WIRE(mode="straight",linecolor="#30485d",linewidth=0.16) {#XSEL5_QB:1 (-10,-90)};
// (-10.4,-90) @TEXT("SEL5",size=1.1,halign="end",valign="middle");
// &"SEL5_QB" @WIRE(mode="straight",linecolor="#30485d",linewidth=0.16) {#XSEL5_QB:2 (10,-90)};
// (10.4,-90) @TEXT("SEL5_QB",size=1.1,halign="start",valign="middle");
// &"VDD" @WIRE(mode="straight",linecolor="#30485d",linewidth=0.16) {#XSEL5_QB:3 (0,-80)};
// (0,-79.6) @TEXT("VDD",size=1.1,halign="middle",valign="bottom");
// &"VSS" @WIRE(mode="straight",linecolor="#30485d",linewidth=0.16) {#XSEL5_QB:4 (0,-100)};
// (0,-100.4) @TEXT("VSS",size=1.1,halign="middle",valign="top");
// &"TRIAL3" @WIRE(mode="straight",linecolor="#30485d",linewidth=0.16) {#XSEL5_TB:1 (24,-90)};
// (23.6,-90) @TEXT("TRIAL3",size=1.1,halign="end",valign="middle");
// &"VDD" @WIRE(mode="straight",linecolor="#30485d",linewidth=0.16) {#XSEL5_TB:3 (34,-80)};
// (34,-79.6) @TEXT("VDD",size=1.1,halign="middle",valign="bottom");
// &"VSS" @WIRE(mode="straight",linecolor="#30485d",linewidth=0.16) {#XSEL5_TB:4 (34,-100)};
// (34,-100.4) @TEXT("VSS",size=1.1,halign="middle",valign="top");
// &"SEL5_QB" @WIRE(mode="straight",linecolor="#30485d",linewidth=0.16) {#XSEL5_D:1 (58,-88.3)};
// (57.6,-88.3) @TEXT("SEL5_QB",size=1.1,halign="end",valign="middle");
// &"VDD" @WIRE(mode="straight",linecolor="#30485d",linewidth=0.16) {#XSEL5_D:4 (68,-80)};
// (68,-79.6) @TEXT("VDD",size=1.1,halign="middle",valign="bottom");
// &"VSS" @WIRE(mode="straight",linecolor="#30485d",linewidth=0.16) {#XSEL5_D:5 (68,-100)};
// (68,-100.4) @TEXT("VSS",size=1.1,halign="middle",valign="top");
// &"COMMIT" @WIRE(mode="straight",linecolor="#30485d",linewidth=0.16) {#XSEL5:1 (86,-88.35)};
// (85.6,-88.35) @TEXT("COMMIT",size=1.1,halign="end",valign="middle");
// &"SAMPLE" @WIRE(mode="straight",linecolor="#30485d",linewidth=0.16) {#XSEL5:3 (86,-91.65)};
// (85.6,-91.65) @TEXT("SAMPLE",size=1.1,halign="end",valign="middle");
// &"VDD" @WIRE(mode="straight",linecolor="#30485d",linewidth=0.16) {#XSEL5:4 (102,-79)};
// (102,-78.6) @TEXT("VDD",size=1.1,halign="middle",valign="bottom");
// &"VSS" @WIRE(mode="straight",linecolor="#30485d",linewidth=0.16) {#XSEL5:5 (102,-101)};
// (102,-101.4) @TEXT("VSS",size=1.1,halign="middle",valign="top");
// &"SEL5" @WIRE(mode="straight",linecolor="#30485d",linewidth=0.16) {#XSEL5:6 (118,-91.65)};
// (118.4,-91.65) @TEXT("SEL5",size=1.1,halign="start",valign="middle");
// &"SEL4" @WIRE(mode="straight",linecolor="#30485d",linewidth=0.16) {#XSEL4_QB:1 (-10,-120)};
// (-10.4,-120) @TEXT("SEL4",size=1.1,halign="end",valign="middle");
// &"SEL4_QB" @WIRE(mode="straight",linecolor="#30485d",linewidth=0.16) {#XSEL4_QB:2 (10,-120)};
// (10.4,-120) @TEXT("SEL4_QB",size=1.1,halign="start",valign="middle");
// &"VDD" @WIRE(mode="straight",linecolor="#30485d",linewidth=0.16) {#XSEL4_QB:3 (0,-110)};
// (0,-109.6) @TEXT("VDD",size=1.1,halign="middle",valign="bottom");
// &"VSS" @WIRE(mode="straight",linecolor="#30485d",linewidth=0.16) {#XSEL4_QB:4 (0,-130)};
// (0,-130.4) @TEXT("VSS",size=1.1,halign="middle",valign="top");
// &"TRIAL2" @WIRE(mode="straight",linecolor="#30485d",linewidth=0.16) {#XSEL4_TB:1 (24,-120)};
// (23.6,-120) @TEXT("TRIAL2",size=1.1,halign="end",valign="middle");
// &"VDD" @WIRE(mode="straight",linecolor="#30485d",linewidth=0.16) {#XSEL4_TB:3 (34,-110)};
// (34,-109.6) @TEXT("VDD",size=1.1,halign="middle",valign="bottom");
// &"VSS" @WIRE(mode="straight",linecolor="#30485d",linewidth=0.16) {#XSEL4_TB:4 (34,-130)};
// (34,-130.4) @TEXT("VSS",size=1.1,halign="middle",valign="top");
// &"SEL4_QB" @WIRE(mode="straight",linecolor="#30485d",linewidth=0.16) {#XSEL4_D:1 (58,-118.3)};
// (57.6,-118.3) @TEXT("SEL4_QB",size=1.1,halign="end",valign="middle");
// &"VDD" @WIRE(mode="straight",linecolor="#30485d",linewidth=0.16) {#XSEL4_D:4 (68,-110)};
// (68,-109.6) @TEXT("VDD",size=1.1,halign="middle",valign="bottom");
// &"VSS" @WIRE(mode="straight",linecolor="#30485d",linewidth=0.16) {#XSEL4_D:5 (68,-130)};
// (68,-130.4) @TEXT("VSS",size=1.1,halign="middle",valign="top");
// &"COMMIT" @WIRE(mode="straight",linecolor="#30485d",linewidth=0.16) {#XSEL4:1 (86,-118.35)};
// (85.6,-118.35) @TEXT("COMMIT",size=1.1,halign="end",valign="middle");
// &"SAMPLE" @WIRE(mode="straight",linecolor="#30485d",linewidth=0.16) {#XSEL4:3 (86,-121.65)};
// (85.6,-121.65) @TEXT("SAMPLE",size=1.1,halign="end",valign="middle");
// &"VDD" @WIRE(mode="straight",linecolor="#30485d",linewidth=0.16) {#XSEL4:4 (102,-109)};
// (102,-108.6) @TEXT("VDD",size=1.1,halign="middle",valign="bottom");
// &"VSS" @WIRE(mode="straight",linecolor="#30485d",linewidth=0.16) {#XSEL4:5 (102,-131)};
// (102,-131.4) @TEXT("VSS",size=1.1,halign="middle",valign="top");
// &"SEL4" @WIRE(mode="straight",linecolor="#30485d",linewidth=0.16) {#XSEL4:6 (118,-121.65)};
// (118.4,-121.65) @TEXT("SEL4",size=1.1,halign="start",valign="middle");
// &"COMMIT" @WIRE(mode="straight",linecolor="#30485d",linewidth=0.16) {#XDONE:1 (108,45.65)};
// (107.6,45.65) @TEXT("COMMIT",size=1.1,halign="end",valign="middle");
// &"CODE0" @WIRE(mode="straight",linecolor="#30485d",linewidth=0.16) {#XDONE:2 (140,45.65)};
// (140.4,45.65) @TEXT("CODE0",size=1.1,halign="start",valign="middle");
// &"SAMPLE" @WIRE(mode="straight",linecolor="#30485d",linewidth=0.16) {#XDONE:3 (108,42.35)};
// (107.6,42.35) @TEXT("SAMPLE",size=1.1,halign="end",valign="middle");
// &"VDD" @WIRE(mode="straight",linecolor="#30485d",linewidth=0.16) {#XDONE:4 (124,55)};
// (124,55.4) @TEXT("VDD",size=1.1,halign="middle",valign="bottom");
// &"VSS" @WIRE(mode="straight",linecolor="#30485d",linewidth=0.16) {#XDONE:5 (124,33)};
// (124,32.6) @TEXT("VSS",size=1.1,halign="middle",valign="top");
// &"DONE" @WIRE(mode="straight",linecolor="#30485d",linewidth=0.16) {#XDONE:6 (140,42.35)};
// (140.4,42.35) @TEXT("DONE",size=1.1,halign="start",valign="middle");
// &"DONE" @WIRE(mode="straight",linecolor="#30485d",linewidth=0.16) {#XACTIVE:1 (176,44)};
// (175.6,44) @TEXT("DONE",size=1.1,halign="end",valign="middle");
// &"ACTIVE" @WIRE(mode="straight",linecolor="#30485d",linewidth=0.16) {#XACTIVE:2 (196,44)};
// (196.4,44) @TEXT("ACTIVE",size=1.1,halign="start",valign="middle");
// &"VDD" @WIRE(mode="straight",linecolor="#30485d",linewidth=0.16) {#XACTIVE:3 (186,54)};
// (186,54.4) @TEXT("VDD",size=1.1,halign="middle",valign="bottom");
// &"VSS" @WIRE(mode="straight",linecolor="#30485d",linewidth=0.16) {#XACTIVE:4 (186,34)};
// (186,33.6) @TEXT("VSS",size=1.1,halign="middle",valign="top");
// &"COMMIT" @WIRE(mode="straight",linecolor="#30485d",linewidth=0.16) {#XBIT0:1 (141,1.65)};
// (140.6,1.65) @TEXT("COMMIT",size=1.1,halign="end",valign="middle");
// &"NEXT0" @WIRE(mode="straight",linecolor="#30485d",linewidth=0.16) {#XBIT0:2 (173,1.65)};
// (173.4,1.65) @TEXT("NEXT0",size=1.1,halign="start",valign="middle");
// &"SAMPLE" @WIRE(mode="straight",linecolor="#30485d",linewidth=0.16) {#XBIT0:3 (141,-1.65)};
// (140.6,-1.65) @TEXT("SAMPLE",size=1.1,halign="end",valign="middle");
// &"VDD" @WIRE(mode="straight",linecolor="#30485d",linewidth=0.16) {#XBIT0:4 (157,11)};
// (157,11.4) @TEXT("VDD",size=1.1,halign="middle",valign="bottom");
// &"VSS" @WIRE(mode="straight",linecolor="#30485d",linewidth=0.16) {#XBIT0:5 (157,-11)};
// (157,-11.4) @TEXT("VSS",size=1.1,halign="middle",valign="top");
// &"CODE0" @WIRE(mode="straight",linecolor="#30485d",linewidth=0.16) {#XBIT0:6 (173,-1.65)};
// (173.4,-1.65) @TEXT("CODE0",size=1.1,halign="start",valign="middle");
// &"COMMIT" @WIRE(mode="straight",linecolor="#30485d",linewidth=0.16) {#XBIT1:1 (178,1.65)};
// (177.6,1.65) @TEXT("COMMIT",size=1.1,halign="end",valign="middle");
// &"NEXT1" @WIRE(mode="straight",linecolor="#30485d",linewidth=0.16) {#XBIT1:2 (210,1.65)};
// (210.4,1.65) @TEXT("NEXT1",size=1.1,halign="start",valign="middle");
// &"SAMPLE" @WIRE(mode="straight",linecolor="#30485d",linewidth=0.16) {#XBIT1:3 (178,-1.65)};
// (177.6,-1.65) @TEXT("SAMPLE",size=1.1,halign="end",valign="middle");
// &"VDD" @WIRE(mode="straight",linecolor="#30485d",linewidth=0.16) {#XBIT1:4 (194,11)};
// (194,11.4) @TEXT("VDD",size=1.1,halign="middle",valign="bottom");
// &"VSS" @WIRE(mode="straight",linecolor="#30485d",linewidth=0.16) {#XBIT1:5 (194,-11)};
// (194,-11.4) @TEXT("VSS",size=1.1,halign="middle",valign="top");
// &"CODE1" @WIRE(mode="straight",linecolor="#30485d",linewidth=0.16) {#XBIT1:6 (210,-1.65)};
// (210.4,-1.65) @TEXT("CODE1",size=1.1,halign="start",valign="middle");
// &"COMMIT" @WIRE(mode="straight",linecolor="#30485d",linewidth=0.16) {#XBIT2:1 (141,-29.35)};
// (140.6,-29.35) @TEXT("COMMIT",size=1.1,halign="end",valign="middle");
// &"NEXT2" @WIRE(mode="straight",linecolor="#30485d",linewidth=0.16) {#XBIT2:2 (173,-29.35)};
// (173.4,-29.35) @TEXT("NEXT2",size=1.1,halign="start",valign="middle");
// &"SAMPLE" @WIRE(mode="straight",linecolor="#30485d",linewidth=0.16) {#XBIT2:3 (141,-32.65)};
// (140.6,-32.65) @TEXT("SAMPLE",size=1.1,halign="end",valign="middle");
// &"VDD" @WIRE(mode="straight",linecolor="#30485d",linewidth=0.16) {#XBIT2:4 (157,-20)};
// (157,-19.6) @TEXT("VDD",size=1.1,halign="middle",valign="bottom");
// &"VSS" @WIRE(mode="straight",linecolor="#30485d",linewidth=0.16) {#XBIT2:5 (157,-42)};
// (157,-42.4) @TEXT("VSS",size=1.1,halign="middle",valign="top");
// &"CODE2" @WIRE(mode="straight",linecolor="#30485d",linewidth=0.16) {#XBIT2:6 (173,-32.65)};
// (173.4,-32.65) @TEXT("CODE2",size=1.1,halign="start",valign="middle");
// &"COMMIT" @WIRE(mode="straight",linecolor="#30485d",linewidth=0.16) {#XBIT3:1 (178,-29.35)};
// (177.6,-29.35) @TEXT("COMMIT",size=1.1,halign="end",valign="middle");
// &"NEXT3" @WIRE(mode="straight",linecolor="#30485d",linewidth=0.16) {#XBIT3:2 (210,-29.35)};
// (210.4,-29.35) @TEXT("NEXT3",size=1.1,halign="start",valign="middle");
// &"SAMPLE" @WIRE(mode="straight",linecolor="#30485d",linewidth=0.16) {#XBIT3:3 (178,-32.65)};
// (177.6,-32.65) @TEXT("SAMPLE",size=1.1,halign="end",valign="middle");
// &"VDD" @WIRE(mode="straight",linecolor="#30485d",linewidth=0.16) {#XBIT3:4 (194,-20)};
// (194,-19.6) @TEXT("VDD",size=1.1,halign="middle",valign="bottom");
// &"VSS" @WIRE(mode="straight",linecolor="#30485d",linewidth=0.16) {#XBIT3:5 (194,-42)};
// (194,-42.4) @TEXT("VSS",size=1.1,halign="middle",valign="top");
// &"CODE3" @WIRE(mode="straight",linecolor="#30485d",linewidth=0.16) {#XBIT3:6 (210,-32.65)};
// (210.4,-32.65) @TEXT("CODE3",size=1.1,halign="start",valign="middle");
// &"COMMIT" @WIRE(mode="straight",linecolor="#30485d",linewidth=0.16) {#XBIT4:1 (141,-60.35)};
// (140.6,-60.35) @TEXT("COMMIT",size=1.1,halign="end",valign="middle");
// &"NEXT4" @WIRE(mode="straight",linecolor="#30485d",linewidth=0.16) {#XBIT4:2 (173,-60.35)};
// (173.4,-60.35) @TEXT("NEXT4",size=1.1,halign="start",valign="middle");
// &"SAMPLE" @WIRE(mode="straight",linecolor="#30485d",linewidth=0.16) {#XBIT4:3 (141,-63.65)};
// (140.6,-63.65) @TEXT("SAMPLE",size=1.1,halign="end",valign="middle");
// &"VDD" @WIRE(mode="straight",linecolor="#30485d",linewidth=0.16) {#XBIT4:4 (157,-51)};
// (157,-50.6) @TEXT("VDD",size=1.1,halign="middle",valign="bottom");
// &"VSS" @WIRE(mode="straight",linecolor="#30485d",linewidth=0.16) {#XBIT4:5 (157,-73)};
// (157,-73.4) @TEXT("VSS",size=1.1,halign="middle",valign="top");
// &"CODE4" @WIRE(mode="straight",linecolor="#30485d",linewidth=0.16) {#XBIT4:6 (173,-63.65)};
// (173.4,-63.65) @TEXT("CODE4",size=1.1,halign="start",valign="middle");
// &"COMMIT" @WIRE(mode="straight",linecolor="#30485d",linewidth=0.16) {#XBIT5:1 (178,-60.35)};
// (177.6,-60.35) @TEXT("COMMIT",size=1.1,halign="end",valign="middle");
// &"NEXT5" @WIRE(mode="straight",linecolor="#30485d",linewidth=0.16) {#XBIT5:2 (210,-60.35)};
// (210.4,-60.35) @TEXT("NEXT5",size=1.1,halign="start",valign="middle");
// &"SAMPLE" @WIRE(mode="straight",linecolor="#30485d",linewidth=0.16) {#XBIT5:3 (178,-63.65)};
// (177.6,-63.65) @TEXT("SAMPLE",size=1.1,halign="end",valign="middle");
// &"VDD" @WIRE(mode="straight",linecolor="#30485d",linewidth=0.16) {#XBIT5:4 (194,-51)};
// (194,-50.6) @TEXT("VDD",size=1.1,halign="middle",valign="bottom");
// &"VSS" @WIRE(mode="straight",linecolor="#30485d",linewidth=0.16) {#XBIT5:5 (194,-73)};
// (194,-73.4) @TEXT("VSS",size=1.1,halign="middle",valign="top");
// &"CODE5" @WIRE(mode="straight",linecolor="#30485d",linewidth=0.16) {#XBIT5:6 (210,-63.65)};
// (210.4,-63.65) @TEXT("CODE5",size=1.1,halign="start",valign="middle");
// &"COMMIT" @WIRE(mode="straight",linecolor="#30485d",linewidth=0.16) {#XBIT6:1 (141,-91.35)};
// (140.6,-91.35) @TEXT("COMMIT",size=1.1,halign="end",valign="middle");
// &"NEXT6" @WIRE(mode="straight",linecolor="#30485d",linewidth=0.16) {#XBIT6:2 (173,-91.35)};
// (173.4,-91.35) @TEXT("NEXT6",size=1.1,halign="start",valign="middle");
// &"SAMPLE" @WIRE(mode="straight",linecolor="#30485d",linewidth=0.16) {#XBIT6:3 (141,-94.65)};
// (140.6,-94.65) @TEXT("SAMPLE",size=1.1,halign="end",valign="middle");
// &"VDD" @WIRE(mode="straight",linecolor="#30485d",linewidth=0.16) {#XBIT6:4 (157,-82)};
// (157,-81.6) @TEXT("VDD",size=1.1,halign="middle",valign="bottom");
// &"VSS" @WIRE(mode="straight",linecolor="#30485d",linewidth=0.16) {#XBIT6:5 (157,-104)};
// (157,-104.4) @TEXT("VSS",size=1.1,halign="middle",valign="top");
// &"CODE6" @WIRE(mode="straight",linecolor="#30485d",linewidth=0.16) {#XBIT6:6 (173,-94.65)};
// (173.4,-94.65) @TEXT("CODE6",size=1.1,halign="start",valign="middle");
// &"NEXT7" @WIRE(mode="straight",linecolor="#30485d",linewidth=0.16) {#XMSBD:1 (147,-129)};
// (146.6,-129) @TEXT("NEXT7",size=1.1,halign="end",valign="middle");
// &"MSBD" @WIRE(mode="straight",linecolor="#30485d",linewidth=0.16) {#XMSBD:2 (167,-129)};
// (167.4,-129) @TEXT("MSBD",size=1.1,halign="start",valign="middle");
// &"VDD" @WIRE(mode="straight",linecolor="#30485d",linewidth=0.16) {#XMSBD:3 (157,-119)};
// (157,-118.6) @TEXT("VDD",size=1.1,halign="middle",valign="bottom");
// &"VSS" @WIRE(mode="straight",linecolor="#30485d",linewidth=0.16) {#XMSBD:4 (157,-139)};
// (157,-139.4) @TEXT("VSS",size=1.1,halign="middle",valign="top");
// &"COMMIT" @WIRE(mode="straight",linecolor="#30485d",linewidth=0.16) {#XBIT7:1 (178,-91.35)};
// (177.6,-91.35) @TEXT("COMMIT",size=1.1,halign="end",valign="middle");
// &"MSBD" @WIRE(mode="straight",linecolor="#30485d",linewidth=0.16) {#XBIT7:2 (210,-91.35)};
// (210.4,-91.35) @TEXT("MSBD",size=1.1,halign="start",valign="middle");
// &"SAMPLE" @WIRE(mode="straight",linecolor="#30485d",linewidth=0.16) {#XBIT7:3 (178,-94.65)};
// (177.6,-94.65) @TEXT("SAMPLE",size=1.1,halign="end",valign="middle");
// &"VDD" @WIRE(mode="straight",linecolor="#30485d",linewidth=0.16) {#XBIT7:4 (194,-82)};
// (194,-81.6) @TEXT("VDD",size=1.1,halign="middle",valign="bottom");
// &"VSS" @WIRE(mode="straight",linecolor="#30485d",linewidth=0.16) {#XBIT7:5 (194,-104)};
// (194,-104.4) @TEXT("VSS",size=1.1,halign="middle",valign="top");
// &"CODE7" @WIRE(mode="straight",linecolor="#30485d",linewidth=0.16) {#XMSBQ:2 (204,-129)};
// (204.4,-129) @TEXT("CODE7",size=1.1,halign="start",valign="middle");
// &"VDD" @WIRE(mode="straight",linecolor="#30485d",linewidth=0.16) {#XMSBQ:3 (194,-119)};
// (194,-118.6) @TEXT("VDD",size=1.1,halign="middle",valign="bottom");
// &"VSS" @WIRE(mode="straight",linecolor="#30485d",linewidth=0.16) {#XMSBQ:4 (194,-139)};
// (194,-139.4) @TEXT("VSS",size=1.1,halign="middle",valign="top");
// }
// END SARADC RNL
ends sar8_se_ctrl

subckt sar8_se_acquire REQUEST VDD VSS TRACK
XDEL (REQUEST TAP VDD VSS) DEL200D1BWP12T30P140
XQUAL (REQUEST TAP ACCEPTED VDD VSS) AN2D1BWP12T30P140
XOUT (ACCEPTED TRACK VDD VSS) CKBD1BWP12T30P140
// BEGIN SARADC RNL
// @RNL(author="saradc topology") {
// #XDEL @SET-SYMBOL $S_DEL200D1BWP12T30P140;
// #XDEL @PLACE(0,0) => @ORIENT("R0");
// #XQUAL @SET-SYMBOL $S_AN2D1BWP12T30P140;
// #XQUAL @PLACE(0,-33) => @ORIENT("R0");
// #XOUT @SET-SYMBOL $S_CKBD1BWP12T30P140;
// #XOUT @PLACE(0,-66) => @ORIENT("R0");
// &"REQUEST" @WIRE(mode="straight",linecolor="#30485d",linewidth=0.16) {#XDEL:1 (-13,0) (-13,-31.35) #XQUAL:1};
// &"TAP" @WIRE(mode="straight",linecolor="#30485d",linewidth=0.16) {#XDEL:2 (0,0) (0,-34.65) #XQUAL:2};
// &"ACCEPTED" @WIRE(mode="straight",linecolor="#30485d",linewidth=0.16) {#XQUAL:3 (0,-33) (0,-66) #XOUT:1};
// (-89,30) @TEXT("sar8_se_acquire / source-derived connections",size=1.4,halign="start",textcolor="#223d52");
// &"VDD" @WIRE(mode="straight",linecolor="#30485d",linewidth=0.16) {#XDEL:3 (0,11)};
// (0,11.4) @TEXT("VDD",size=1.1,halign="middle",valign="bottom");
// &"VSS" @WIRE(mode="straight",linecolor="#30485d",linewidth=0.16) {#XDEL:4 (0,-11)};
// (0,-11.4) @TEXT("VSS",size=1.1,halign="middle",valign="top");
// &"VDD" @WIRE(mode="straight",linecolor="#30485d",linewidth=0.16) {#XQUAL:4 (0,-22)};
// (0,-21.6) @TEXT("VDD",size=1.1,halign="middle",valign="bottom");
// &"VSS" @WIRE(mode="straight",linecolor="#30485d",linewidth=0.16) {#XQUAL:5 (0,-44)};
// (0,-44.4) @TEXT("VSS",size=1.1,halign="middle",valign="top");
// &"TRACK" @WIRE(mode="straight",linecolor="#30485d",linewidth=0.16) {#XOUT:2 (16,-66)};
// (16.4,-66) @TEXT("TRACK",size=1.1,halign="start",valign="middle");
// &"VDD" @WIRE(mode="straight",linecolor="#30485d",linewidth=0.16) {#XOUT:3 (0,-55)};
// (0,-54.6) @TEXT("VDD",size=1.1,halign="middle",valign="bottom");
// &"VSS" @WIRE(mode="straight",linecolor="#30485d",linewidth=0.16) {#XOUT:4 (0,-77)};
// (0,-77.4) @TEXT("VSS",size=1.1,halign="middle",valign="top");
// }
// END SARADC RNL
ends sar8_se_acquire
