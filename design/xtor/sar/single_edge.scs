// Single-edge SAR. All logic and delay devices are native standard cells.
// BEGIN SARADC RNL
// @RNL(type="header") { @VERSION("0.3");
// @USE-PACKAGE(name="sar8",version="0.1",path="../../rnl/sar8.rnl");
// @USE-PACKAGE(name="rnl-std-fill") {}; }
// END SARADC RNL
subckt sar8_next_word CODE0 CODE1 CODE2 CODE3 CODE4 CODE5 CODE6 CODE7 DATA DONE D0 D1 D2 D3 D4 D5 D6 D7 NEXT0 NEXT1 NEXT2 NEXT3 NEXT4 NEXT5 NEXT6 NEXT7 TRIAL6 TRIAL5 TRIAL4 TRIAL3 TRIAL2 VDD VSS
// Prefix ORs identify the current trial and are evaluated before DATA arrives.
X01 (CODE0 CODE1 ANY01 VDD VSS) OR2D1BWP12T30P140
X23 (CODE2 CODE3 ANY23 VDD VSS) OR2D1BWP12T30P140
X45 (CODE4 CODE5 ANY45 VDD VSS) OR2D1BWP12T30P140
X02 (ANY01 CODE2 ANY02 VDD VSS) OR2D1BWP12T30P140
X03 (ANY01 ANY23 ANY03 VDD VSS) OR2D1BWP12T30P140
X04 (ANY03 CODE4 LOW_BITS VDD VSS) OR2D1BWP12T30P140
X05 (ANY03 ANY45 ANY05 VDD VSS) OR2D1BWP12T30P140
X06 (ANY05 CODE6 ANY06 VDD VSS) OR2D1BWP12T30P140
XREAD0 (CODE0 DONE D0 VDD VSS) AN2D1BWP12T30P140
XEMPTY1 (CODE0 EMPTY1 VDD VSS) INVD1BWP12T30P140
XTRIAL1 (EMPTY1 CODE1 TRIAL1 VDD VSS) AN2D1BWP12T30P140
XVISIBLE1 (CODE0 DONE VISIBLE1 VDD VSS) OR2D1BWP12T30P140
XREAD1 (CODE1 VISIBLE1 D1 VDD VSS) AN2D1BWP12T30P140
XEMPTY2 (ANY01 EMPTY2 VDD VSS) INVD1BWP12T30P140
XTRIAL2 (EMPTY2 CODE2 TRIAL2 VDD VSS) AN2D1BWP12T30P140
XVISIBLE2 (ANY01 DONE VISIBLE2 VDD VSS) OR2D1BWP12T30P140
XREAD2 (CODE2 VISIBLE2 D2 VDD VSS) AN2D1BWP12T30P140
XEMPTY3 (ANY02 EMPTY3 VDD VSS) INVD1BWP12T30P140
XTRIAL3 (EMPTY3 CODE3 TRIAL3 VDD VSS) AN2D1BWP12T30P140
XVISIBLE3 (ANY02 DONE VISIBLE3 VDD VSS) OR2D1BWP12T30P140
XREAD3 (CODE3 VISIBLE3 D3 VDD VSS) AN2D1BWP12T30P140
XEMPTY4 (ANY03 EMPTY4 VDD VSS) INVD1BWP12T30P140
XTRIAL4 (EMPTY4 CODE4 TRIAL4 VDD VSS) AN2D1BWP12T30P140
XVISIBLE4 (ANY03 DONE VISIBLE4 VDD VSS) OR2D1BWP12T30P140
XREAD4 (CODE4 VISIBLE4 D4 VDD VSS) AN2D1BWP12T30P140
XEMPTY5 (LOW_BITS EMPTY5 VDD VSS) INVD1BWP12T30P140
XTRIAL5 (EMPTY5 CODE5 TRIAL5 VDD VSS) AN2D1BWP12T30P140
XVISIBLE5 (LOW_BITS DONE VISIBLE5 VDD VSS) OR2D1BWP12T30P140
XREAD5 (CODE5 VISIBLE5 D5 VDD VSS) AN2D1BWP12T30P140
XEMPTY6 (ANY05 EMPTY6 VDD VSS) INVD1BWP12T30P140
XTRIAL6 (EMPTY6 CODE6 TRIAL6 VDD VSS) AN2D1BWP12T30P140
XVISIBLE6 (ANY05 DONE VISIBLE6 VDD VSS) OR2D1BWP12T30P140
XREAD6 (CODE6 VISIBLE6 D6 VDD VSS) AN2D1BWP12T30P140
XEMPTY7 (ANY06 EMPTY7 VDD VSS) INVD1BWP12T30P140
XTRIAL7 (EMPTY7 CODE7 TRIAL7 VDD VSS) AN2D1BWP12T30P140
XVISIBLE7 (ANY06 DONE VISIBLE7 VDD VSS) OR2D1BWP12T30P140
XREAD7 (CODE7 VISIBLE7 D7 VDD VSS) AN2D1BWP12T30P140
XBASE0 (D0 TRIAL1 BASE0 VDD VSS) OR2D1BWP12T30P140
XKEEP0 (CODE0 DATA KEEP0 VDD VSS) AN2D1BWP12T30P140
XNEXT0 (BASE0 KEEP0 NEXT0 VDD VSS) OR2D1BWP12T30P140
XBASE1 (D1 TRIAL2 BASE1 VDD VSS) OR2D1BWP12T30P140
XKEEP1 (TRIAL1 DATA KEEP1 VDD VSS) AN2D1BWP12T30P140
XNEXT1 (BASE1 KEEP1 NEXT1 VDD VSS) OR2D1BWP12T30P140
XBASE2 (D2 TRIAL3 BASE2 VDD VSS) OR2D1BWP12T30P140
XKEEP2 (TRIAL2 DATA KEEP2 VDD VSS) AN2D1BWP12T30P140
XNEXT2 (BASE2 KEEP2 NEXT2 VDD VSS) OR2D1BWP12T30P140
XBASE3 (D3 TRIAL4 BASE3 VDD VSS) OR2D1BWP12T30P140
XKEEP3 (TRIAL3 DATA KEEP3 VDD VSS) AN2D1BWP12T30P140
XNEXT3 (BASE3 KEEP3 NEXT3 VDD VSS) OR2D1BWP12T30P140
XBASE4 (D4 TRIAL5 BASE4 VDD VSS) OR2D1BWP12T30P140
XKEEP4 (TRIAL4 DATA KEEP4 VDD VSS) AN2D1BWP12T30P140
XNEXT4 (BASE4 KEEP4 NEXT4 VDD VSS) OR2D1BWP12T30P140
XBASE5 (D5 TRIAL6 BASE5 VDD VSS) OR2D1BWP12T30P140
XKEEP5 (TRIAL5 DATA KEEP5 VDD VSS) AN2D1BWP12T30P140
XNEXT5 (BASE5 KEEP5 NEXT5 VDD VSS) OR2D1BWP12T30P140
XBASE6 (D6 TRIAL7 BASE6 VDD VSS) OR2D1BWP12T30P140
XKEEP6 (TRIAL6 DATA KEEP6 VDD VSS) AN2D1BWP12T30P140
XNEXT6 (BASE6 KEEP6 NEXT6 VDD VSS) OR2D1BWP12T30P140
XKEEP7 (TRIAL7 DATA KEEP7 VDD VSS) AN2D1BWP12T30P140
XNEXT7 (D7 KEEP7 NEXT7 VDD VSS) OR2D1BWP12T30P140
// BEGIN SARADC RNL
// @RNL(author="saradc topology") {
// #X01 @SET-SYMBOL $S_OR2D1BWP12T30P140;
// #X01 @PLACE(0,0) => @ORIENT("R0");
// #X23 @SET-SYMBOL $S_OR2D1BWP12T30P140;
// #X23 @PLACE(0,-33) => @ORIENT("R0");
// #X45 @SET-SYMBOL $S_OR2D1BWP12T30P140;
// #X45 @PLACE(0,-66) => @ORIENT("R0");
// #X02 @SET-SYMBOL $S_OR2D1BWP12T30P140;
// #X02 @PLACE(0,-99) => @ORIENT("R0");
// #X03 @SET-SYMBOL $S_OR2D1BWP12T30P140;
// #X03 @PLACE(0,-132) => @ORIENT("R0");
// #X04 @SET-SYMBOL $S_OR2D1BWP12T30P140;
// #X04 @PLACE(0,-165) => @ORIENT("R0");
// #X05 @SET-SYMBOL $S_OR2D1BWP12T30P140;
// #X05 @PLACE(0,-198) => @ORIENT("R0");
// #X06 @SET-SYMBOL $S_OR2D1BWP12T30P140;
// #X06 @PLACE(0,-231) => @ORIENT("R0");
// #XREAD0 @SET-SYMBOL $S_AN2D1BWP12T30P140;
// #XREAD0 @PLACE(0,-264) => @ORIENT("R0");
// #XEMPTY1 @SET-SYMBOL $S_INVD1BWP12T30P140;
// #XEMPTY1 @PLACE(0,-297) => @ORIENT("R0");
// #XTRIAL1 @SET-SYMBOL $S_AN2D1BWP12T30P140;
// #XTRIAL1 @PLACE(0,-330) => @ORIENT("R0");
// #XVISIBLE1 @SET-SYMBOL $S_OR2D1BWP12T30P140;
// #XVISIBLE1 @PLACE(0,-363) => @ORIENT("R0");
// #XREAD1 @SET-SYMBOL $S_AN2D1BWP12T30P140;
// #XREAD1 @PLACE(55,0) => @ORIENT("R0");
// #XEMPTY2 @SET-SYMBOL $S_INVD1BWP12T30P140;
// #XEMPTY2 @PLACE(55,-33) => @ORIENT("R0");
// #XTRIAL2 @SET-SYMBOL $S_AN2D1BWP12T30P140;
// #XTRIAL2 @PLACE(55,-66) => @ORIENT("R0");
// #XVISIBLE2 @SET-SYMBOL $S_OR2D1BWP12T30P140;
// #XVISIBLE2 @PLACE(55,-99) => @ORIENT("R0");
// #XREAD2 @SET-SYMBOL $S_AN2D1BWP12T30P140;
// #XREAD2 @PLACE(55,-132) => @ORIENT("R0");
// #XEMPTY3 @SET-SYMBOL $S_INVD1BWP12T30P140;
// #XEMPTY3 @PLACE(55,-165) => @ORIENT("R0");
// #XTRIAL3 @SET-SYMBOL $S_AN2D1BWP12T30P140;
// #XTRIAL3 @PLACE(55,-198) => @ORIENT("R0");
// #XVISIBLE3 @SET-SYMBOL $S_OR2D1BWP12T30P140;
// #XVISIBLE3 @PLACE(55,-231) => @ORIENT("R0");
// #XREAD3 @SET-SYMBOL $S_AN2D1BWP12T30P140;
// #XREAD3 @PLACE(55,-264) => @ORIENT("R0");
// #XEMPTY4 @SET-SYMBOL $S_INVD1BWP12T30P140;
// #XEMPTY4 @PLACE(55,-297) => @ORIENT("R0");
// #XTRIAL4 @SET-SYMBOL $S_AN2D1BWP12T30P140;
// #XTRIAL4 @PLACE(55,-330) => @ORIENT("R0");
// #XVISIBLE4 @SET-SYMBOL $S_OR2D1BWP12T30P140;
// #XVISIBLE4 @PLACE(55,-363) => @ORIENT("R0");
// #XREAD4 @SET-SYMBOL $S_AN2D1BWP12T30P140;
// #XREAD4 @PLACE(110,0) => @ORIENT("R0");
// #XEMPTY5 @SET-SYMBOL $S_INVD1BWP12T30P140;
// #XEMPTY5 @PLACE(110,-33) => @ORIENT("R0");
// #XTRIAL5 @SET-SYMBOL $S_AN2D1BWP12T30P140;
// #XTRIAL5 @PLACE(110,-66) => @ORIENT("R0");
// #XVISIBLE5 @SET-SYMBOL $S_OR2D1BWP12T30P140;
// #XVISIBLE5 @PLACE(110,-99) => @ORIENT("R0");
// #XREAD5 @SET-SYMBOL $S_AN2D1BWP12T30P140;
// #XREAD5 @PLACE(110,-132) => @ORIENT("R0");
// #XEMPTY6 @SET-SYMBOL $S_INVD1BWP12T30P140;
// #XEMPTY6 @PLACE(110,-165) => @ORIENT("R0");
// #XTRIAL6 @SET-SYMBOL $S_AN2D1BWP12T30P140;
// #XTRIAL6 @PLACE(110,-198) => @ORIENT("R0");
// #XVISIBLE6 @SET-SYMBOL $S_OR2D1BWP12T30P140;
// #XVISIBLE6 @PLACE(110,-231) => @ORIENT("R0");
// #XREAD6 @SET-SYMBOL $S_AN2D1BWP12T30P140;
// #XREAD6 @PLACE(110,-264) => @ORIENT("R0");
// #XEMPTY7 @SET-SYMBOL $S_INVD1BWP12T30P140;
// #XEMPTY7 @PLACE(110,-297) => @ORIENT("R0");
// #XTRIAL7 @SET-SYMBOL $S_AN2D1BWP12T30P140;
// #XTRIAL7 @PLACE(110,-330) => @ORIENT("R0");
// #XVISIBLE7 @SET-SYMBOL $S_OR2D1BWP12T30P140;
// #XVISIBLE7 @PLACE(110,-363) => @ORIENT("R0");
// #XREAD7 @SET-SYMBOL $S_AN2D1BWP12T30P140;
// #XREAD7 @PLACE(165,0) => @ORIENT("R0");
// #XBASE0 @SET-SYMBOL $S_OR2D1BWP12T30P140;
// #XBASE0 @PLACE(165,-33) => @ORIENT("R0");
// #XKEEP0 @SET-SYMBOL $S_AN2D1BWP12T30P140;
// #XKEEP0 @PLACE(165,-66) => @ORIENT("R0");
// #XNEXT0 @SET-SYMBOL $S_OR2D1BWP12T30P140;
// #XNEXT0 @PLACE(165,-99) => @ORIENT("R0");
// #XBASE1 @SET-SYMBOL $S_OR2D1BWP12T30P140;
// #XBASE1 @PLACE(165,-132) => @ORIENT("R0");
// #XKEEP1 @SET-SYMBOL $S_AN2D1BWP12T30P140;
// #XKEEP1 @PLACE(165,-165) => @ORIENT("R0");
// #XNEXT1 @SET-SYMBOL $S_OR2D1BWP12T30P140;
// #XNEXT1 @PLACE(165,-198) => @ORIENT("R0");
// #XBASE2 @SET-SYMBOL $S_OR2D1BWP12T30P140;
// #XBASE2 @PLACE(165,-231) => @ORIENT("R0");
// #XKEEP2 @SET-SYMBOL $S_AN2D1BWP12T30P140;
// #XKEEP2 @PLACE(165,-264) => @ORIENT("R0");
// #XNEXT2 @SET-SYMBOL $S_OR2D1BWP12T30P140;
// #XNEXT2 @PLACE(165,-297) => @ORIENT("R0");
// #XBASE3 @SET-SYMBOL $S_OR2D1BWP12T30P140;
// #XBASE3 @PLACE(165,-330) => @ORIENT("R0");
// #XKEEP3 @SET-SYMBOL $S_AN2D1BWP12T30P140;
// #XKEEP3 @PLACE(165,-363) => @ORIENT("R0");
// #XNEXT3 @SET-SYMBOL $S_OR2D1BWP12T30P140;
// #XNEXT3 @PLACE(220,0) => @ORIENT("R0");
// #XBASE4 @SET-SYMBOL $S_OR2D1BWP12T30P140;
// #XBASE4 @PLACE(220,-33) => @ORIENT("R0");
// #XKEEP4 @SET-SYMBOL $S_AN2D1BWP12T30P140;
// #XKEEP4 @PLACE(220,-66) => @ORIENT("R0");
// #XNEXT4 @SET-SYMBOL $S_OR2D1BWP12T30P140;
// #XNEXT4 @PLACE(220,-99) => @ORIENT("R0");
// #XBASE5 @SET-SYMBOL $S_OR2D1BWP12T30P140;
// #XBASE5 @PLACE(220,-132) => @ORIENT("R0");
// #XKEEP5 @SET-SYMBOL $S_AN2D1BWP12T30P140;
// #XKEEP5 @PLACE(220,-165) => @ORIENT("R0");
// #XNEXT5 @SET-SYMBOL $S_OR2D1BWP12T30P140;
// #XNEXT5 @PLACE(220,-198) => @ORIENT("R0");
// #XBASE6 @SET-SYMBOL $S_OR2D1BWP12T30P140;
// #XBASE6 @PLACE(220,-231) => @ORIENT("R0");
// #XKEEP6 @SET-SYMBOL $S_AN2D1BWP12T30P140;
// #XKEEP6 @PLACE(220,-264) => @ORIENT("R0");
// #XNEXT6 @SET-SYMBOL $S_OR2D1BWP12T30P140;
// #XNEXT6 @PLACE(220,-297) => @ORIENT("R0");
// #XKEEP7 @SET-SYMBOL $S_AN2D1BWP12T30P140;
// #XKEEP7 @PLACE(220,-330) => @ORIENT("R0");
// #XNEXT7 @SET-SYMBOL $S_OR2D1BWP12T30P140;
// #XNEXT7 @PLACE(220,-363) => @ORIENT("R0");
// &"ANY23" @WIRE(mode="straight",linecolor="#30485d",linewidth=0.16) {#X23:3 (0,-33) (0,-133.65) #X03:2};
// &"EMPTY1" @WIRE(mode="straight",linecolor="#30485d",linewidth=0.16) {#XEMPTY1:2 (-3,-297) (-3,-328.35) #XTRIAL1:1};
// &"EMPTY2" @WIRE(mode="straight",linecolor="#30485d",linewidth=0.16) {#XEMPTY2:2 (52,-33) (52,-64.35) #XTRIAL2:1};
// &"VISIBLE2" @WIRE(mode="straight",linecolor="#30485d",linewidth=0.16) {#XVISIBLE2:3 (55,-99) (55,-133.65) #XREAD2:2};
// &"D2" @WIRE(mode="straight",linecolor="#30485d",linewidth=0.16) {#XREAD2:3 (110,-132) (110,-229.35) #XBASE2:1};
// &"EMPTY3" @WIRE(mode="straight",linecolor="#30485d",linewidth=0.16) {#XEMPTY3:2 (52,-165) (52,-196.35) #XTRIAL3:1};
// &"VISIBLE3" @WIRE(mode="straight",linecolor="#30485d",linewidth=0.16) {#XVISIBLE3:3 (55,-231) (55,-265.65) #XREAD3:2};
// &"D3" @WIRE(mode="straight",linecolor="#30485d",linewidth=0.16) {#XREAD3:3 (110,-264) (110,-328.35) #XBASE3:1};
// &"EMPTY4" @WIRE(mode="straight",linecolor="#30485d",linewidth=0.16) {#XEMPTY4:2 (52,-297) (52,-328.35) #XTRIAL4:1};
// &"D4" @WIRE(mode="straight",linecolor="#30485d",linewidth=0.16) {#XREAD4:3 (165,0) (165,-31.35) #XBASE4:1};
// &"EMPTY5" @WIRE(mode="straight",linecolor="#30485d",linewidth=0.16) {#XEMPTY5:2 (107,-33) (107,-64.35) #XTRIAL5:1};
// &"VISIBLE5" @WIRE(mode="straight",linecolor="#30485d",linewidth=0.16) {#XVISIBLE5:3 (110,-99) (110,-133.65) #XREAD5:2};
// &"D5" @WIRE(mode="straight",linecolor="#30485d",linewidth=0.16) {#XREAD5:3 (165,-132) (165,-130.35) #XBASE5:1};
// &"EMPTY6" @WIRE(mode="straight",linecolor="#30485d",linewidth=0.16) {#XEMPTY6:2 (107,-165) (107,-196.35) #XTRIAL6:1};
// &"VISIBLE6" @WIRE(mode="straight",linecolor="#30485d",linewidth=0.16) {#XVISIBLE6:3 (110,-231) (110,-265.65) #XREAD6:2};
// &"D6" @WIRE(mode="straight",linecolor="#30485d",linewidth=0.16) {#XREAD6:3 (165,-264) (165,-229.35) #XBASE6:1};
// &"EMPTY7" @WIRE(mode="straight",linecolor="#30485d",linewidth=0.16) {#XEMPTY7:2 (107,-297) (107,-328.35) #XTRIAL7:1};
// &"BASE0" @WIRE(mode="straight",linecolor="#30485d",linewidth=0.16) {#XBASE0:3 (165,-33) (165,-97.35) #XNEXT0:1};
// &"KEEP0" @WIRE(mode="straight",linecolor="#30485d",linewidth=0.16) {#XKEEP0:3 (165,-66) (165,-100.65) #XNEXT0:2};
// &"BASE1" @WIRE(mode="straight",linecolor="#30485d",linewidth=0.16) {#XBASE1:3 (165,-132) (165,-196.35) #XNEXT1:1};
// &"KEEP1" @WIRE(mode="straight",linecolor="#30485d",linewidth=0.16) {#XKEEP1:3 (165,-165) (165,-199.65) #XNEXT1:2};
// &"BASE2" @WIRE(mode="straight",linecolor="#30485d",linewidth=0.16) {#XBASE2:3 (165,-231) (165,-295.35) #XNEXT2:1};
// &"KEEP2" @WIRE(mode="straight",linecolor="#30485d",linewidth=0.16) {#XKEEP2:3 (165,-264) (165,-298.65) #XNEXT2:2};
// &"BASE4" @WIRE(mode="straight",linecolor="#30485d",linewidth=0.16) {#XBASE4:3 (220,-33) (220,-97.35) #XNEXT4:1};
// &"KEEP4" @WIRE(mode="straight",linecolor="#30485d",linewidth=0.16) {#XKEEP4:3 (220,-66) (220,-100.65) #XNEXT4:2};
// &"BASE5" @WIRE(mode="straight",linecolor="#30485d",linewidth=0.16) {#XBASE5:3 (220,-132) (220,-196.35) #XNEXT5:1};
// &"KEEP5" @WIRE(mode="straight",linecolor="#30485d",linewidth=0.16) {#XKEEP5:3 (220,-165) (220,-199.65) #XNEXT5:2};
// &"BASE6" @WIRE(mode="straight",linecolor="#30485d",linewidth=0.16) {#XBASE6:3 (220,-231) (220,-295.35) #XNEXT6:1};
// &"KEEP6" @WIRE(mode="straight",linecolor="#30485d",linewidth=0.16) {#XKEEP6:3 (220,-264) (220,-298.65) #XNEXT6:2};
// &"KEEP7" @WIRE(mode="straight",linecolor="#30485d",linewidth=0.16) {#XKEEP7:3 (220,-330) (220,-364.65) #XNEXT7:2};
// (-89,30) @TEXT("sar8_next_word / source-derived connections",size=1.4,halign="start",textcolor="#223d52");
// &"CODE0" @WIRE(mode="straight",linecolor="#30485d",linewidth=0.16) {#X01:1 (-16,1.65)};
// (-16.4,1.65) @TEXT("CODE0",size=1.1,halign="end",valign="middle");
// &"CODE1" @WIRE(mode="straight",linecolor="#30485d",linewidth=0.16) {#X01:2 (-16,-1.65)};
// (-16.4,-1.65) @TEXT("CODE1",size=1.1,halign="end",valign="middle");
// &"ANY01" @WIRE(mode="straight",linecolor="#30485d",linewidth=0.16) {#X01:3 (16,0)};
// (16.4,0) @TEXT("ANY01",size=1.1,halign="start",valign="middle");
// &"VDD" @WIRE(mode="straight",linecolor="#30485d",linewidth=0.16) {#X01:4 (0,11)};
// (0,11.4) @TEXT("VDD",size=1.1,halign="middle",valign="bottom");
// &"VSS" @WIRE(mode="straight",linecolor="#30485d",linewidth=0.16) {#X01:5 (0,-11)};
// (0,-11.4) @TEXT("VSS",size=1.1,halign="middle",valign="top");
// &"CODE2" @WIRE(mode="straight",linecolor="#30485d",linewidth=0.16) {#X23:1 (-16,-31.35)};
// (-16.4,-31.35) @TEXT("CODE2",size=1.1,halign="end",valign="middle");
// &"CODE3" @WIRE(mode="straight",linecolor="#30485d",linewidth=0.16) {#X23:2 (-16,-34.65)};
// (-16.4,-34.65) @TEXT("CODE3",size=1.1,halign="end",valign="middle");
// &"VDD" @WIRE(mode="straight",linecolor="#30485d",linewidth=0.16) {#X23:4 (0,-22)};
// (0,-21.6) @TEXT("VDD",size=1.1,halign="middle",valign="bottom");
// &"VSS" @WIRE(mode="straight",linecolor="#30485d",linewidth=0.16) {#X23:5 (0,-44)};
// (0,-44.4) @TEXT("VSS",size=1.1,halign="middle",valign="top");
// &"CODE4" @WIRE(mode="straight",linecolor="#30485d",linewidth=0.16) {#X45:1 (-16,-64.35)};
// (-16.4,-64.35) @TEXT("CODE4",size=1.1,halign="end",valign="middle");
// &"CODE5" @WIRE(mode="straight",linecolor="#30485d",linewidth=0.16) {#X45:2 (-16,-67.65)};
// (-16.4,-67.65) @TEXT("CODE5",size=1.1,halign="end",valign="middle");
// &"ANY45" @WIRE(mode="straight",linecolor="#30485d",linewidth=0.16) {#X45:3 (16,-66)};
// (16.4,-66) @TEXT("ANY45",size=1.1,halign="start",valign="middle");
// &"VDD" @WIRE(mode="straight",linecolor="#30485d",linewidth=0.16) {#X45:4 (0,-55)};
// (0,-54.6) @TEXT("VDD",size=1.1,halign="middle",valign="bottom");
// &"VSS" @WIRE(mode="straight",linecolor="#30485d",linewidth=0.16) {#X45:5 (0,-77)};
// (0,-77.4) @TEXT("VSS",size=1.1,halign="middle",valign="top");
// &"ANY01" @WIRE(mode="straight",linecolor="#30485d",linewidth=0.16) {#X02:1 (-16,-97.35)};
// (-16.4,-97.35) @TEXT("ANY01",size=1.1,halign="end",valign="middle");
// &"CODE2" @WIRE(mode="straight",linecolor="#30485d",linewidth=0.16) {#X02:2 (-16,-100.65)};
// (-16.4,-100.65) @TEXT("CODE2",size=1.1,halign="end",valign="middle");
// &"ANY02" @WIRE(mode="straight",linecolor="#30485d",linewidth=0.16) {#X02:3 (16,-99)};
// (16.4,-99) @TEXT("ANY02",size=1.1,halign="start",valign="middle");
// &"VDD" @WIRE(mode="straight",linecolor="#30485d",linewidth=0.16) {#X02:4 (0,-88)};
// (0,-87.6) @TEXT("VDD",size=1.1,halign="middle",valign="bottom");
// &"VSS" @WIRE(mode="straight",linecolor="#30485d",linewidth=0.16) {#X02:5 (0,-110)};
// (0,-110.4) @TEXT("VSS",size=1.1,halign="middle",valign="top");
// &"ANY01" @WIRE(mode="straight",linecolor="#30485d",linewidth=0.16) {#X03:1 (-16,-130.35)};
// (-16.4,-130.35) @TEXT("ANY01",size=1.1,halign="end",valign="middle");
// &"ANY03" @WIRE(mode="straight",linecolor="#30485d",linewidth=0.16) {#X03:3 (16,-132)};
// (16.4,-132) @TEXT("ANY03",size=1.1,halign="start",valign="middle");
// &"VDD" @WIRE(mode="straight",linecolor="#30485d",linewidth=0.16) {#X03:4 (0,-121)};
// (0,-120.6) @TEXT("VDD",size=1.1,halign="middle",valign="bottom");
// &"VSS" @WIRE(mode="straight",linecolor="#30485d",linewidth=0.16) {#X03:5 (0,-143)};
// (0,-143.4) @TEXT("VSS",size=1.1,halign="middle",valign="top");
// &"ANY03" @WIRE(mode="straight",linecolor="#30485d",linewidth=0.16) {#X04:1 (-16,-163.35)};
// (-16.4,-163.35) @TEXT("ANY03",size=1.1,halign="end",valign="middle");
// &"CODE4" @WIRE(mode="straight",linecolor="#30485d",linewidth=0.16) {#X04:2 (-16,-166.65)};
// (-16.4,-166.65) @TEXT("CODE4",size=1.1,halign="end",valign="middle");
// &"LOW_BITS" @WIRE(mode="straight",linecolor="#30485d",linewidth=0.16) {#X04:3 (16,-165)};
// (16.4,-165) @TEXT("LOW_BITS",size=1.1,halign="start",valign="middle");
// &"VDD" @WIRE(mode="straight",linecolor="#30485d",linewidth=0.16) {#X04:4 (0,-154)};
// (0,-153.6) @TEXT("VDD",size=1.1,halign="middle",valign="bottom");
// &"VSS" @WIRE(mode="straight",linecolor="#30485d",linewidth=0.16) {#X04:5 (0,-176)};
// (0,-176.4) @TEXT("VSS",size=1.1,halign="middle",valign="top");
// &"ANY03" @WIRE(mode="straight",linecolor="#30485d",linewidth=0.16) {#X05:1 (-16,-196.35)};
// (-16.4,-196.35) @TEXT("ANY03",size=1.1,halign="end",valign="middle");
// &"ANY45" @WIRE(mode="straight",linecolor="#30485d",linewidth=0.16) {#X05:2 (-16,-199.65)};
// (-16.4,-199.65) @TEXT("ANY45",size=1.1,halign="end",valign="middle");
// &"ANY05" @WIRE(mode="straight",linecolor="#30485d",linewidth=0.16) {#X05:3 (16,-198)};
// (16.4,-198) @TEXT("ANY05",size=1.1,halign="start",valign="middle");
// &"VDD" @WIRE(mode="straight",linecolor="#30485d",linewidth=0.16) {#X05:4 (0,-187)};
// (0,-186.6) @TEXT("VDD",size=1.1,halign="middle",valign="bottom");
// &"VSS" @WIRE(mode="straight",linecolor="#30485d",linewidth=0.16) {#X05:5 (0,-209)};
// (0,-209.4) @TEXT("VSS",size=1.1,halign="middle",valign="top");
// &"ANY05" @WIRE(mode="straight",linecolor="#30485d",linewidth=0.16) {#X06:1 (-16,-229.35)};
// (-16.4,-229.35) @TEXT("ANY05",size=1.1,halign="end",valign="middle");
// &"CODE6" @WIRE(mode="straight",linecolor="#30485d",linewidth=0.16) {#X06:2 (-16,-232.65)};
// (-16.4,-232.65) @TEXT("CODE6",size=1.1,halign="end",valign="middle");
// &"ANY06" @WIRE(mode="straight",linecolor="#30485d",linewidth=0.16) {#X06:3 (16,-231)};
// (16.4,-231) @TEXT("ANY06",size=1.1,halign="start",valign="middle");
// &"VDD" @WIRE(mode="straight",linecolor="#30485d",linewidth=0.16) {#X06:4 (0,-220)};
// (0,-219.6) @TEXT("VDD",size=1.1,halign="middle",valign="bottom");
// &"VSS" @WIRE(mode="straight",linecolor="#30485d",linewidth=0.16) {#X06:5 (0,-242)};
// (0,-242.4) @TEXT("VSS",size=1.1,halign="middle",valign="top");
// &"CODE0" @WIRE(mode="straight",linecolor="#30485d",linewidth=0.16) {#XREAD0:1 (-16,-262.35)};
// (-16.4,-262.35) @TEXT("CODE0",size=1.1,halign="end",valign="middle");
// &"DONE" @WIRE(mode="straight",linecolor="#30485d",linewidth=0.16) {#XREAD0:2 (-16,-265.65)};
// (-16.4,-265.65) @TEXT("DONE",size=1.1,halign="end",valign="middle");
// &"D0" @WIRE(mode="straight",linecolor="#30485d",linewidth=0.16) {#XREAD0:3 (16,-264)};
// (16.4,-264) @TEXT("D0",size=1.1,halign="start",valign="middle");
// &"VDD" @WIRE(mode="straight",linecolor="#30485d",linewidth=0.16) {#XREAD0:4 (0,-253)};
// (0,-252.6) @TEXT("VDD",size=1.1,halign="middle",valign="bottom");
// &"VSS" @WIRE(mode="straight",linecolor="#30485d",linewidth=0.16) {#XREAD0:5 (0,-275)};
// (0,-275.4) @TEXT("VSS",size=1.1,halign="middle",valign="top");
// &"CODE0" @WIRE(mode="straight",linecolor="#30485d",linewidth=0.16) {#XEMPTY1:1 (-10,-297)};
// (-10.4,-297) @TEXT("CODE0",size=1.1,halign="end",valign="middle");
// &"VDD" @WIRE(mode="straight",linecolor="#30485d",linewidth=0.16) {#XEMPTY1:3 (0,-287)};
// (0,-286.6) @TEXT("VDD",size=1.1,halign="middle",valign="bottom");
// &"VSS" @WIRE(mode="straight",linecolor="#30485d",linewidth=0.16) {#XEMPTY1:4 (0,-307)};
// (0,-307.4) @TEXT("VSS",size=1.1,halign="middle",valign="top");
// &"CODE1" @WIRE(mode="straight",linecolor="#30485d",linewidth=0.16) {#XTRIAL1:2 (-16,-331.65)};
// (-16.4,-331.65) @TEXT("CODE1",size=1.1,halign="end",valign="middle");
// &"TRIAL1" @WIRE(mode="straight",linecolor="#30485d",linewidth=0.16) {#XTRIAL1:3 (16,-330)};
// (16.4,-330) @TEXT("TRIAL1",size=1.1,halign="start",valign="middle");
// &"VDD" @WIRE(mode="straight",linecolor="#30485d",linewidth=0.16) {#XTRIAL1:4 (0,-319)};
// (0,-318.6) @TEXT("VDD",size=1.1,halign="middle",valign="bottom");
// &"VSS" @WIRE(mode="straight",linecolor="#30485d",linewidth=0.16) {#XTRIAL1:5 (0,-341)};
// (0,-341.4) @TEXT("VSS",size=1.1,halign="middle",valign="top");
// &"CODE0" @WIRE(mode="straight",linecolor="#30485d",linewidth=0.16) {#XVISIBLE1:1 (-16,-361.35)};
// (-16.4,-361.35) @TEXT("CODE0",size=1.1,halign="end",valign="middle");
// &"DONE" @WIRE(mode="straight",linecolor="#30485d",linewidth=0.16) {#XVISIBLE1:2 (-16,-364.65)};
// (-16.4,-364.65) @TEXT("DONE",size=1.1,halign="end",valign="middle");
// &"VISIBLE1" @WIRE(mode="straight",linecolor="#30485d",linewidth=0.16) {#XVISIBLE1:3 (16,-363)};
// (16.4,-363) @TEXT("VISIBLE1",size=1.1,halign="start",valign="middle");
// &"VDD" @WIRE(mode="straight",linecolor="#30485d",linewidth=0.16) {#XVISIBLE1:4 (0,-352)};
// (0,-351.6) @TEXT("VDD",size=1.1,halign="middle",valign="bottom");
// &"VSS" @WIRE(mode="straight",linecolor="#30485d",linewidth=0.16) {#XVISIBLE1:5 (0,-374)};
// (0,-374.4) @TEXT("VSS",size=1.1,halign="middle",valign="top");
// &"CODE1" @WIRE(mode="straight",linecolor="#30485d",linewidth=0.16) {#XREAD1:1 (39,1.65)};
// (38.6,1.65) @TEXT("CODE1",size=1.1,halign="end",valign="middle");
// &"VISIBLE1" @WIRE(mode="straight",linecolor="#30485d",linewidth=0.16) {#XREAD1:2 (39,-1.65)};
// (38.6,-1.65) @TEXT("VISIBLE1",size=1.1,halign="end",valign="middle");
// &"D1" @WIRE(mode="straight",linecolor="#30485d",linewidth=0.16) {#XREAD1:3 (71,0)};
// (71.4,0) @TEXT("D1",size=1.1,halign="start",valign="middle");
// &"VDD" @WIRE(mode="straight",linecolor="#30485d",linewidth=0.16) {#XREAD1:4 (55,11)};
// (55,11.4) @TEXT("VDD",size=1.1,halign="middle",valign="bottom");
// &"VSS" @WIRE(mode="straight",linecolor="#30485d",linewidth=0.16) {#XREAD1:5 (55,-11)};
// (55,-11.4) @TEXT("VSS",size=1.1,halign="middle",valign="top");
// &"ANY01" @WIRE(mode="straight",linecolor="#30485d",linewidth=0.16) {#XEMPTY2:1 (45,-33)};
// (44.6,-33) @TEXT("ANY01",size=1.1,halign="end",valign="middle");
// &"VDD" @WIRE(mode="straight",linecolor="#30485d",linewidth=0.16) {#XEMPTY2:3 (55,-23)};
// (55,-22.6) @TEXT("VDD",size=1.1,halign="middle",valign="bottom");
// &"VSS" @WIRE(mode="straight",linecolor="#30485d",linewidth=0.16) {#XEMPTY2:4 (55,-43)};
// (55,-43.4) @TEXT("VSS",size=1.1,halign="middle",valign="top");
// &"CODE2" @WIRE(mode="straight",linecolor="#30485d",linewidth=0.16) {#XTRIAL2:2 (39,-67.65)};
// (38.6,-67.65) @TEXT("CODE2",size=1.1,halign="end",valign="middle");
// &"TRIAL2" @WIRE(mode="straight",linecolor="#30485d",linewidth=0.16) {#XTRIAL2:3 (71,-66)};
// (71.4,-66) @TEXT("TRIAL2",size=1.1,halign="start",valign="middle");
// &"VDD" @WIRE(mode="straight",linecolor="#30485d",linewidth=0.16) {#XTRIAL2:4 (55,-55)};
// (55,-54.6) @TEXT("VDD",size=1.1,halign="middle",valign="bottom");
// &"VSS" @WIRE(mode="straight",linecolor="#30485d",linewidth=0.16) {#XTRIAL2:5 (55,-77)};
// (55,-77.4) @TEXT("VSS",size=1.1,halign="middle",valign="top");
// &"ANY01" @WIRE(mode="straight",linecolor="#30485d",linewidth=0.16) {#XVISIBLE2:1 (39,-97.35)};
// (38.6,-97.35) @TEXT("ANY01",size=1.1,halign="end",valign="middle");
// &"DONE" @WIRE(mode="straight",linecolor="#30485d",linewidth=0.16) {#XVISIBLE2:2 (39,-100.65)};
// (38.6,-100.65) @TEXT("DONE",size=1.1,halign="end",valign="middle");
// &"VDD" @WIRE(mode="straight",linecolor="#30485d",linewidth=0.16) {#XVISIBLE2:4 (55,-88)};
// (55,-87.6) @TEXT("VDD",size=1.1,halign="middle",valign="bottom");
// &"VSS" @WIRE(mode="straight",linecolor="#30485d",linewidth=0.16) {#XVISIBLE2:5 (55,-110)};
// (55,-110.4) @TEXT("VSS",size=1.1,halign="middle",valign="top");
// &"CODE2" @WIRE(mode="straight",linecolor="#30485d",linewidth=0.16) {#XREAD2:1 (39,-130.35)};
// (38.6,-130.35) @TEXT("CODE2",size=1.1,halign="end",valign="middle");
// &"VDD" @WIRE(mode="straight",linecolor="#30485d",linewidth=0.16) {#XREAD2:4 (55,-121)};
// (55,-120.6) @TEXT("VDD",size=1.1,halign="middle",valign="bottom");
// &"VSS" @WIRE(mode="straight",linecolor="#30485d",linewidth=0.16) {#XREAD2:5 (55,-143)};
// (55,-143.4) @TEXT("VSS",size=1.1,halign="middle",valign="top");
// &"ANY02" @WIRE(mode="straight",linecolor="#30485d",linewidth=0.16) {#XEMPTY3:1 (45,-165)};
// (44.6,-165) @TEXT("ANY02",size=1.1,halign="end",valign="middle");
// &"VDD" @WIRE(mode="straight",linecolor="#30485d",linewidth=0.16) {#XEMPTY3:3 (55,-155)};
// (55,-154.6) @TEXT("VDD",size=1.1,halign="middle",valign="bottom");
// &"VSS" @WIRE(mode="straight",linecolor="#30485d",linewidth=0.16) {#XEMPTY3:4 (55,-175)};
// (55,-175.4) @TEXT("VSS",size=1.1,halign="middle",valign="top");
// &"CODE3" @WIRE(mode="straight",linecolor="#30485d",linewidth=0.16) {#XTRIAL3:2 (39,-199.65)};
// (38.6,-199.65) @TEXT("CODE3",size=1.1,halign="end",valign="middle");
// &"TRIAL3" @WIRE(mode="straight",linecolor="#30485d",linewidth=0.16) {#XTRIAL3:3 (71,-198)};
// (71.4,-198) @TEXT("TRIAL3",size=1.1,halign="start",valign="middle");
// &"VDD" @WIRE(mode="straight",linecolor="#30485d",linewidth=0.16) {#XTRIAL3:4 (55,-187)};
// (55,-186.6) @TEXT("VDD",size=1.1,halign="middle",valign="bottom");
// &"VSS" @WIRE(mode="straight",linecolor="#30485d",linewidth=0.16) {#XTRIAL3:5 (55,-209)};
// (55,-209.4) @TEXT("VSS",size=1.1,halign="middle",valign="top");
// &"ANY02" @WIRE(mode="straight",linecolor="#30485d",linewidth=0.16) {#XVISIBLE3:1 (39,-229.35)};
// (38.6,-229.35) @TEXT("ANY02",size=1.1,halign="end",valign="middle");
// &"DONE" @WIRE(mode="straight",linecolor="#30485d",linewidth=0.16) {#XVISIBLE3:2 (39,-232.65)};
// (38.6,-232.65) @TEXT("DONE",size=1.1,halign="end",valign="middle");
// &"VDD" @WIRE(mode="straight",linecolor="#30485d",linewidth=0.16) {#XVISIBLE3:4 (55,-220)};
// (55,-219.6) @TEXT("VDD",size=1.1,halign="middle",valign="bottom");
// &"VSS" @WIRE(mode="straight",linecolor="#30485d",linewidth=0.16) {#XVISIBLE3:5 (55,-242)};
// (55,-242.4) @TEXT("VSS",size=1.1,halign="middle",valign="top");
// &"CODE3" @WIRE(mode="straight",linecolor="#30485d",linewidth=0.16) {#XREAD3:1 (39,-262.35)};
// (38.6,-262.35) @TEXT("CODE3",size=1.1,halign="end",valign="middle");
// &"VDD" @WIRE(mode="straight",linecolor="#30485d",linewidth=0.16) {#XREAD3:4 (55,-253)};
// (55,-252.6) @TEXT("VDD",size=1.1,halign="middle",valign="bottom");
// &"VSS" @WIRE(mode="straight",linecolor="#30485d",linewidth=0.16) {#XREAD3:5 (55,-275)};
// (55,-275.4) @TEXT("VSS",size=1.1,halign="middle",valign="top");
// &"ANY03" @WIRE(mode="straight",linecolor="#30485d",linewidth=0.16) {#XEMPTY4:1 (45,-297)};
// (44.6,-297) @TEXT("ANY03",size=1.1,halign="end",valign="middle");
// &"VDD" @WIRE(mode="straight",linecolor="#30485d",linewidth=0.16) {#XEMPTY4:3 (55,-287)};
// (55,-286.6) @TEXT("VDD",size=1.1,halign="middle",valign="bottom");
// &"VSS" @WIRE(mode="straight",linecolor="#30485d",linewidth=0.16) {#XEMPTY4:4 (55,-307)};
// (55,-307.4) @TEXT("VSS",size=1.1,halign="middle",valign="top");
// &"CODE4" @WIRE(mode="straight",linecolor="#30485d",linewidth=0.16) {#XTRIAL4:2 (39,-331.65)};
// (38.6,-331.65) @TEXT("CODE4",size=1.1,halign="end",valign="middle");
// &"TRIAL4" @WIRE(mode="straight",linecolor="#30485d",linewidth=0.16) {#XTRIAL4:3 (71,-330)};
// (71.4,-330) @TEXT("TRIAL4",size=1.1,halign="start",valign="middle");
// &"VDD" @WIRE(mode="straight",linecolor="#30485d",linewidth=0.16) {#XTRIAL4:4 (55,-319)};
// (55,-318.6) @TEXT("VDD",size=1.1,halign="middle",valign="bottom");
// &"VSS" @WIRE(mode="straight",linecolor="#30485d",linewidth=0.16) {#XTRIAL4:5 (55,-341)};
// (55,-341.4) @TEXT("VSS",size=1.1,halign="middle",valign="top");
// &"ANY03" @WIRE(mode="straight",linecolor="#30485d",linewidth=0.16) {#XVISIBLE4:1 (39,-361.35)};
// (38.6,-361.35) @TEXT("ANY03",size=1.1,halign="end",valign="middle");
// &"DONE" @WIRE(mode="straight",linecolor="#30485d",linewidth=0.16) {#XVISIBLE4:2 (39,-364.65)};
// (38.6,-364.65) @TEXT("DONE",size=1.1,halign="end",valign="middle");
// &"VISIBLE4" @WIRE(mode="straight",linecolor="#30485d",linewidth=0.16) {#XVISIBLE4:3 (71,-363)};
// (71.4,-363) @TEXT("VISIBLE4",size=1.1,halign="start",valign="middle");
// &"VDD" @WIRE(mode="straight",linecolor="#30485d",linewidth=0.16) {#XVISIBLE4:4 (55,-352)};
// (55,-351.6) @TEXT("VDD",size=1.1,halign="middle",valign="bottom");
// &"VSS" @WIRE(mode="straight",linecolor="#30485d",linewidth=0.16) {#XVISIBLE4:5 (55,-374)};
// (55,-374.4) @TEXT("VSS",size=1.1,halign="middle",valign="top");
// &"CODE4" @WIRE(mode="straight",linecolor="#30485d",linewidth=0.16) {#XREAD4:1 (94,1.65)};
// (93.6,1.65) @TEXT("CODE4",size=1.1,halign="end",valign="middle");
// &"VISIBLE4" @WIRE(mode="straight",linecolor="#30485d",linewidth=0.16) {#XREAD4:2 (94,-1.65)};
// (93.6,-1.65) @TEXT("VISIBLE4",size=1.1,halign="end",valign="middle");
// &"VDD" @WIRE(mode="straight",linecolor="#30485d",linewidth=0.16) {#XREAD4:4 (110,11)};
// (110,11.4) @TEXT("VDD",size=1.1,halign="middle",valign="bottom");
// &"VSS" @WIRE(mode="straight",linecolor="#30485d",linewidth=0.16) {#XREAD4:5 (110,-11)};
// (110,-11.4) @TEXT("VSS",size=1.1,halign="middle",valign="top");
// &"LOW_BITS" @WIRE(mode="straight",linecolor="#30485d",linewidth=0.16) {#XEMPTY5:1 (100,-33)};
// (99.6,-33) @TEXT("LOW_BITS",size=1.1,halign="end",valign="middle");
// &"VDD" @WIRE(mode="straight",linecolor="#30485d",linewidth=0.16) {#XEMPTY5:3 (110,-23)};
// (110,-22.6) @TEXT("VDD",size=1.1,halign="middle",valign="bottom");
// &"VSS" @WIRE(mode="straight",linecolor="#30485d",linewidth=0.16) {#XEMPTY5:4 (110,-43)};
// (110,-43.4) @TEXT("VSS",size=1.1,halign="middle",valign="top");
// &"CODE5" @WIRE(mode="straight",linecolor="#30485d",linewidth=0.16) {#XTRIAL5:2 (94,-67.65)};
// (93.6,-67.65) @TEXT("CODE5",size=1.1,halign="end",valign="middle");
// &"TRIAL5" @WIRE(mode="straight",linecolor="#30485d",linewidth=0.16) {#XTRIAL5:3 (126,-66)};
// (126.4,-66) @TEXT("TRIAL5",size=1.1,halign="start",valign="middle");
// &"VDD" @WIRE(mode="straight",linecolor="#30485d",linewidth=0.16) {#XTRIAL5:4 (110,-55)};
// (110,-54.6) @TEXT("VDD",size=1.1,halign="middle",valign="bottom");
// &"VSS" @WIRE(mode="straight",linecolor="#30485d",linewidth=0.16) {#XTRIAL5:5 (110,-77)};
// (110,-77.4) @TEXT("VSS",size=1.1,halign="middle",valign="top");
// &"LOW_BITS" @WIRE(mode="straight",linecolor="#30485d",linewidth=0.16) {#XVISIBLE5:1 (94,-97.35)};
// (93.6,-97.35) @TEXT("LOW_BITS",size=1.1,halign="end",valign="middle");
// &"DONE" @WIRE(mode="straight",linecolor="#30485d",linewidth=0.16) {#XVISIBLE5:2 (94,-100.65)};
// (93.6,-100.65) @TEXT("DONE",size=1.1,halign="end",valign="middle");
// &"VDD" @WIRE(mode="straight",linecolor="#30485d",linewidth=0.16) {#XVISIBLE5:4 (110,-88)};
// (110,-87.6) @TEXT("VDD",size=1.1,halign="middle",valign="bottom");
// &"VSS" @WIRE(mode="straight",linecolor="#30485d",linewidth=0.16) {#XVISIBLE5:5 (110,-110)};
// (110,-110.4) @TEXT("VSS",size=1.1,halign="middle",valign="top");
// &"CODE5" @WIRE(mode="straight",linecolor="#30485d",linewidth=0.16) {#XREAD5:1 (94,-130.35)};
// (93.6,-130.35) @TEXT("CODE5",size=1.1,halign="end",valign="middle");
// &"VDD" @WIRE(mode="straight",linecolor="#30485d",linewidth=0.16) {#XREAD5:4 (110,-121)};
// (110,-120.6) @TEXT("VDD",size=1.1,halign="middle",valign="bottom");
// &"VSS" @WIRE(mode="straight",linecolor="#30485d",linewidth=0.16) {#XREAD5:5 (110,-143)};
// (110,-143.4) @TEXT("VSS",size=1.1,halign="middle",valign="top");
// &"ANY05" @WIRE(mode="straight",linecolor="#30485d",linewidth=0.16) {#XEMPTY6:1 (100,-165)};
// (99.6,-165) @TEXT("ANY05",size=1.1,halign="end",valign="middle");
// &"VDD" @WIRE(mode="straight",linecolor="#30485d",linewidth=0.16) {#XEMPTY6:3 (110,-155)};
// (110,-154.6) @TEXT("VDD",size=1.1,halign="middle",valign="bottom");
// &"VSS" @WIRE(mode="straight",linecolor="#30485d",linewidth=0.16) {#XEMPTY6:4 (110,-175)};
// (110,-175.4) @TEXT("VSS",size=1.1,halign="middle",valign="top");
// &"CODE6" @WIRE(mode="straight",linecolor="#30485d",linewidth=0.16) {#XTRIAL6:2 (94,-199.65)};
// (93.6,-199.65) @TEXT("CODE6",size=1.1,halign="end",valign="middle");
// &"TRIAL6" @WIRE(mode="straight",linecolor="#30485d",linewidth=0.16) {#XTRIAL6:3 (126,-198)};
// (126.4,-198) @TEXT("TRIAL6",size=1.1,halign="start",valign="middle");
// &"VDD" @WIRE(mode="straight",linecolor="#30485d",linewidth=0.16) {#XTRIAL6:4 (110,-187)};
// (110,-186.6) @TEXT("VDD",size=1.1,halign="middle",valign="bottom");
// &"VSS" @WIRE(mode="straight",linecolor="#30485d",linewidth=0.16) {#XTRIAL6:5 (110,-209)};
// (110,-209.4) @TEXT("VSS",size=1.1,halign="middle",valign="top");
// &"ANY05" @WIRE(mode="straight",linecolor="#30485d",linewidth=0.16) {#XVISIBLE6:1 (94,-229.35)};
// (93.6,-229.35) @TEXT("ANY05",size=1.1,halign="end",valign="middle");
// &"DONE" @WIRE(mode="straight",linecolor="#30485d",linewidth=0.16) {#XVISIBLE6:2 (94,-232.65)};
// (93.6,-232.65) @TEXT("DONE",size=1.1,halign="end",valign="middle");
// &"VDD" @WIRE(mode="straight",linecolor="#30485d",linewidth=0.16) {#XVISIBLE6:4 (110,-220)};
// (110,-219.6) @TEXT("VDD",size=1.1,halign="middle",valign="bottom");
// &"VSS" @WIRE(mode="straight",linecolor="#30485d",linewidth=0.16) {#XVISIBLE6:5 (110,-242)};
// (110,-242.4) @TEXT("VSS",size=1.1,halign="middle",valign="top");
// &"CODE6" @WIRE(mode="straight",linecolor="#30485d",linewidth=0.16) {#XREAD6:1 (94,-262.35)};
// (93.6,-262.35) @TEXT("CODE6",size=1.1,halign="end",valign="middle");
// &"VDD" @WIRE(mode="straight",linecolor="#30485d",linewidth=0.16) {#XREAD6:4 (110,-253)};
// (110,-252.6) @TEXT("VDD",size=1.1,halign="middle",valign="bottom");
// &"VSS" @WIRE(mode="straight",linecolor="#30485d",linewidth=0.16) {#XREAD6:5 (110,-275)};
// (110,-275.4) @TEXT("VSS",size=1.1,halign="middle",valign="top");
// &"ANY06" @WIRE(mode="straight",linecolor="#30485d",linewidth=0.16) {#XEMPTY7:1 (100,-297)};
// (99.6,-297) @TEXT("ANY06",size=1.1,halign="end",valign="middle");
// &"VDD" @WIRE(mode="straight",linecolor="#30485d",linewidth=0.16) {#XEMPTY7:3 (110,-287)};
// (110,-286.6) @TEXT("VDD",size=1.1,halign="middle",valign="bottom");
// &"VSS" @WIRE(mode="straight",linecolor="#30485d",linewidth=0.16) {#XEMPTY7:4 (110,-307)};
// (110,-307.4) @TEXT("VSS",size=1.1,halign="middle",valign="top");
// &"CODE7" @WIRE(mode="straight",linecolor="#30485d",linewidth=0.16) {#XTRIAL7:2 (94,-331.65)};
// (93.6,-331.65) @TEXT("CODE7",size=1.1,halign="end",valign="middle");
// &"TRIAL7" @WIRE(mode="straight",linecolor="#30485d",linewidth=0.16) {#XTRIAL7:3 (126,-330)};
// (126.4,-330) @TEXT("TRIAL7",size=1.1,halign="start",valign="middle");
// &"VDD" @WIRE(mode="straight",linecolor="#30485d",linewidth=0.16) {#XTRIAL7:4 (110,-319)};
// (110,-318.6) @TEXT("VDD",size=1.1,halign="middle",valign="bottom");
// &"VSS" @WIRE(mode="straight",linecolor="#30485d",linewidth=0.16) {#XTRIAL7:5 (110,-341)};
// (110,-341.4) @TEXT("VSS",size=1.1,halign="middle",valign="top");
// &"ANY06" @WIRE(mode="straight",linecolor="#30485d",linewidth=0.16) {#XVISIBLE7:1 (94,-361.35)};
// (93.6,-361.35) @TEXT("ANY06",size=1.1,halign="end",valign="middle");
// &"DONE" @WIRE(mode="straight",linecolor="#30485d",linewidth=0.16) {#XVISIBLE7:2 (94,-364.65)};
// (93.6,-364.65) @TEXT("DONE",size=1.1,halign="end",valign="middle");
// &"VISIBLE7" @WIRE(mode="straight",linecolor="#30485d",linewidth=0.16) {#XVISIBLE7:3 (126,-363)};
// (126.4,-363) @TEXT("VISIBLE7",size=1.1,halign="start",valign="middle");
// &"VDD" @WIRE(mode="straight",linecolor="#30485d",linewidth=0.16) {#XVISIBLE7:4 (110,-352)};
// (110,-351.6) @TEXT("VDD",size=1.1,halign="middle",valign="bottom");
// &"VSS" @WIRE(mode="straight",linecolor="#30485d",linewidth=0.16) {#XVISIBLE7:5 (110,-374)};
// (110,-374.4) @TEXT("VSS",size=1.1,halign="middle",valign="top");
// &"CODE7" @WIRE(mode="straight",linecolor="#30485d",linewidth=0.16) {#XREAD7:1 (149,1.65)};
// (148.6,1.65) @TEXT("CODE7",size=1.1,halign="end",valign="middle");
// &"VISIBLE7" @WIRE(mode="straight",linecolor="#30485d",linewidth=0.16) {#XREAD7:2 (149,-1.65)};
// (148.6,-1.65) @TEXT("VISIBLE7",size=1.1,halign="end",valign="middle");
// &"D7" @WIRE(mode="straight",linecolor="#30485d",linewidth=0.16) {#XREAD7:3 (181,0)};
// (181.4,0) @TEXT("D7",size=1.1,halign="start",valign="middle");
// &"VDD" @WIRE(mode="straight",linecolor="#30485d",linewidth=0.16) {#XREAD7:4 (165,11)};
// (165,11.4) @TEXT("VDD",size=1.1,halign="middle",valign="bottom");
// &"VSS" @WIRE(mode="straight",linecolor="#30485d",linewidth=0.16) {#XREAD7:5 (165,-11)};
// (165,-11.4) @TEXT("VSS",size=1.1,halign="middle",valign="top");
// &"D0" @WIRE(mode="straight",linecolor="#30485d",linewidth=0.16) {#XBASE0:1 (149,-31.35)};
// (148.6,-31.35) @TEXT("D0",size=1.1,halign="end",valign="middle");
// &"TRIAL1" @WIRE(mode="straight",linecolor="#30485d",linewidth=0.16) {#XBASE0:2 (149,-34.65)};
// (148.6,-34.65) @TEXT("TRIAL1",size=1.1,halign="end",valign="middle");
// &"VDD" @WIRE(mode="straight",linecolor="#30485d",linewidth=0.16) {#XBASE0:4 (165,-22)};
// (165,-21.6) @TEXT("VDD",size=1.1,halign="middle",valign="bottom");
// &"VSS" @WIRE(mode="straight",linecolor="#30485d",linewidth=0.16) {#XBASE0:5 (165,-44)};
// (165,-44.4) @TEXT("VSS",size=1.1,halign="middle",valign="top");
// &"CODE0" @WIRE(mode="straight",linecolor="#30485d",linewidth=0.16) {#XKEEP0:1 (149,-64.35)};
// (148.6,-64.35) @TEXT("CODE0",size=1.1,halign="end",valign="middle");
// &"DATA" @WIRE(mode="straight",linecolor="#30485d",linewidth=0.16) {#XKEEP0:2 (149,-67.65)};
// (148.6,-67.65) @TEXT("DATA",size=1.1,halign="end",valign="middle");
// &"VDD" @WIRE(mode="straight",linecolor="#30485d",linewidth=0.16) {#XKEEP0:4 (165,-55)};
// (165,-54.6) @TEXT("VDD",size=1.1,halign="middle",valign="bottom");
// &"VSS" @WIRE(mode="straight",linecolor="#30485d",linewidth=0.16) {#XKEEP0:5 (165,-77)};
// (165,-77.4) @TEXT("VSS",size=1.1,halign="middle",valign="top");
// &"NEXT0" @WIRE(mode="straight",linecolor="#30485d",linewidth=0.16) {#XNEXT0:3 (181,-99)};
// (181.4,-99) @TEXT("NEXT0",size=1.1,halign="start",valign="middle");
// &"VDD" @WIRE(mode="straight",linecolor="#30485d",linewidth=0.16) {#XNEXT0:4 (165,-88)};
// (165,-87.6) @TEXT("VDD",size=1.1,halign="middle",valign="bottom");
// &"VSS" @WIRE(mode="straight",linecolor="#30485d",linewidth=0.16) {#XNEXT0:5 (165,-110)};
// (165,-110.4) @TEXT("VSS",size=1.1,halign="middle",valign="top");
// &"D1" @WIRE(mode="straight",linecolor="#30485d",linewidth=0.16) {#XBASE1:1 (149,-130.35)};
// (148.6,-130.35) @TEXT("D1",size=1.1,halign="end",valign="middle");
// &"TRIAL2" @WIRE(mode="straight",linecolor="#30485d",linewidth=0.16) {#XBASE1:2 (149,-133.65)};
// (148.6,-133.65) @TEXT("TRIAL2",size=1.1,halign="end",valign="middle");
// &"VDD" @WIRE(mode="straight",linecolor="#30485d",linewidth=0.16) {#XBASE1:4 (165,-121)};
// (165,-120.6) @TEXT("VDD",size=1.1,halign="middle",valign="bottom");
// &"VSS" @WIRE(mode="straight",linecolor="#30485d",linewidth=0.16) {#XBASE1:5 (165,-143)};
// (165,-143.4) @TEXT("VSS",size=1.1,halign="middle",valign="top");
// &"TRIAL1" @WIRE(mode="straight",linecolor="#30485d",linewidth=0.16) {#XKEEP1:1 (149,-163.35)};
// (148.6,-163.35) @TEXT("TRIAL1",size=1.1,halign="end",valign="middle");
// &"DATA" @WIRE(mode="straight",linecolor="#30485d",linewidth=0.16) {#XKEEP1:2 (149,-166.65)};
// (148.6,-166.65) @TEXT("DATA",size=1.1,halign="end",valign="middle");
// &"VDD" @WIRE(mode="straight",linecolor="#30485d",linewidth=0.16) {#XKEEP1:4 (165,-154)};
// (165,-153.6) @TEXT("VDD",size=1.1,halign="middle",valign="bottom");
// &"VSS" @WIRE(mode="straight",linecolor="#30485d",linewidth=0.16) {#XKEEP1:5 (165,-176)};
// (165,-176.4) @TEXT("VSS",size=1.1,halign="middle",valign="top");
// &"NEXT1" @WIRE(mode="straight",linecolor="#30485d",linewidth=0.16) {#XNEXT1:3 (181,-198)};
// (181.4,-198) @TEXT("NEXT1",size=1.1,halign="start",valign="middle");
// &"VDD" @WIRE(mode="straight",linecolor="#30485d",linewidth=0.16) {#XNEXT1:4 (165,-187)};
// (165,-186.6) @TEXT("VDD",size=1.1,halign="middle",valign="bottom");
// &"VSS" @WIRE(mode="straight",linecolor="#30485d",linewidth=0.16) {#XNEXT1:5 (165,-209)};
// (165,-209.4) @TEXT("VSS",size=1.1,halign="middle",valign="top");
// &"TRIAL3" @WIRE(mode="straight",linecolor="#30485d",linewidth=0.16) {#XBASE2:2 (149,-232.65)};
// (148.6,-232.65) @TEXT("TRIAL3",size=1.1,halign="end",valign="middle");
// &"VDD" @WIRE(mode="straight",linecolor="#30485d",linewidth=0.16) {#XBASE2:4 (165,-220)};
// (165,-219.6) @TEXT("VDD",size=1.1,halign="middle",valign="bottom");
// &"VSS" @WIRE(mode="straight",linecolor="#30485d",linewidth=0.16) {#XBASE2:5 (165,-242)};
// (165,-242.4) @TEXT("VSS",size=1.1,halign="middle",valign="top");
// &"TRIAL2" @WIRE(mode="straight",linecolor="#30485d",linewidth=0.16) {#XKEEP2:1 (149,-262.35)};
// (148.6,-262.35) @TEXT("TRIAL2",size=1.1,halign="end",valign="middle");
// &"DATA" @WIRE(mode="straight",linecolor="#30485d",linewidth=0.16) {#XKEEP2:2 (149,-265.65)};
// (148.6,-265.65) @TEXT("DATA",size=1.1,halign="end",valign="middle");
// &"VDD" @WIRE(mode="straight",linecolor="#30485d",linewidth=0.16) {#XKEEP2:4 (165,-253)};
// (165,-252.6) @TEXT("VDD",size=1.1,halign="middle",valign="bottom");
// &"VSS" @WIRE(mode="straight",linecolor="#30485d",linewidth=0.16) {#XKEEP2:5 (165,-275)};
// (165,-275.4) @TEXT("VSS",size=1.1,halign="middle",valign="top");
// &"NEXT2" @WIRE(mode="straight",linecolor="#30485d",linewidth=0.16) {#XNEXT2:3 (181,-297)};
// (181.4,-297) @TEXT("NEXT2",size=1.1,halign="start",valign="middle");
// &"VDD" @WIRE(mode="straight",linecolor="#30485d",linewidth=0.16) {#XNEXT2:4 (165,-286)};
// (165,-285.6) @TEXT("VDD",size=1.1,halign="middle",valign="bottom");
// &"VSS" @WIRE(mode="straight",linecolor="#30485d",linewidth=0.16) {#XNEXT2:5 (165,-308)};
// (165,-308.4) @TEXT("VSS",size=1.1,halign="middle",valign="top");
// &"TRIAL4" @WIRE(mode="straight",linecolor="#30485d",linewidth=0.16) {#XBASE3:2 (149,-331.65)};
// (148.6,-331.65) @TEXT("TRIAL4",size=1.1,halign="end",valign="middle");
// &"BASE3" @WIRE(mode="straight",linecolor="#30485d",linewidth=0.16) {#XBASE3:3 (181,-330)};
// (181.4,-330) @TEXT("BASE3",size=1.1,halign="start",valign="middle");
// &"VDD" @WIRE(mode="straight",linecolor="#30485d",linewidth=0.16) {#XBASE3:4 (165,-319)};
// (165,-318.6) @TEXT("VDD",size=1.1,halign="middle",valign="bottom");
// &"VSS" @WIRE(mode="straight",linecolor="#30485d",linewidth=0.16) {#XBASE3:5 (165,-341)};
// (165,-341.4) @TEXT("VSS",size=1.1,halign="middle",valign="top");
// &"TRIAL3" @WIRE(mode="straight",linecolor="#30485d",linewidth=0.16) {#XKEEP3:1 (149,-361.35)};
// (148.6,-361.35) @TEXT("TRIAL3",size=1.1,halign="end",valign="middle");
// &"DATA" @WIRE(mode="straight",linecolor="#30485d",linewidth=0.16) {#XKEEP3:2 (149,-364.65)};
// (148.6,-364.65) @TEXT("DATA",size=1.1,halign="end",valign="middle");
// &"KEEP3" @WIRE(mode="straight",linecolor="#30485d",linewidth=0.16) {#XKEEP3:3 (181,-363)};
// (181.4,-363) @TEXT("KEEP3",size=1.1,halign="start",valign="middle");
// &"VDD" @WIRE(mode="straight",linecolor="#30485d",linewidth=0.16) {#XKEEP3:4 (165,-352)};
// (165,-351.6) @TEXT("VDD",size=1.1,halign="middle",valign="bottom");
// &"VSS" @WIRE(mode="straight",linecolor="#30485d",linewidth=0.16) {#XKEEP3:5 (165,-374)};
// (165,-374.4) @TEXT("VSS",size=1.1,halign="middle",valign="top");
// &"BASE3" @WIRE(mode="straight",linecolor="#30485d",linewidth=0.16) {#XNEXT3:1 (204,1.65)};
// (203.6,1.65) @TEXT("BASE3",size=1.1,halign="end",valign="middle");
// &"KEEP3" @WIRE(mode="straight",linecolor="#30485d",linewidth=0.16) {#XNEXT3:2 (204,-1.65)};
// (203.6,-1.65) @TEXT("KEEP3",size=1.1,halign="end",valign="middle");
// &"NEXT3" @WIRE(mode="straight",linecolor="#30485d",linewidth=0.16) {#XNEXT3:3 (236,0)};
// (236.4,0) @TEXT("NEXT3",size=1.1,halign="start",valign="middle");
// &"VDD" @WIRE(mode="straight",linecolor="#30485d",linewidth=0.16) {#XNEXT3:4 (220,11)};
// (220,11.4) @TEXT("VDD",size=1.1,halign="middle",valign="bottom");
// &"VSS" @WIRE(mode="straight",linecolor="#30485d",linewidth=0.16) {#XNEXT3:5 (220,-11)};
// (220,-11.4) @TEXT("VSS",size=1.1,halign="middle",valign="top");
// &"TRIAL5" @WIRE(mode="straight",linecolor="#30485d",linewidth=0.16) {#XBASE4:2 (204,-34.65)};
// (203.6,-34.65) @TEXT("TRIAL5",size=1.1,halign="end",valign="middle");
// &"VDD" @WIRE(mode="straight",linecolor="#30485d",linewidth=0.16) {#XBASE4:4 (220,-22)};
// (220,-21.6) @TEXT("VDD",size=1.1,halign="middle",valign="bottom");
// &"VSS" @WIRE(mode="straight",linecolor="#30485d",linewidth=0.16) {#XBASE4:5 (220,-44)};
// (220,-44.4) @TEXT("VSS",size=1.1,halign="middle",valign="top");
// &"TRIAL4" @WIRE(mode="straight",linecolor="#30485d",linewidth=0.16) {#XKEEP4:1 (204,-64.35)};
// (203.6,-64.35) @TEXT("TRIAL4",size=1.1,halign="end",valign="middle");
// &"DATA" @WIRE(mode="straight",linecolor="#30485d",linewidth=0.16) {#XKEEP4:2 (204,-67.65)};
// (203.6,-67.65) @TEXT("DATA",size=1.1,halign="end",valign="middle");
// &"VDD" @WIRE(mode="straight",linecolor="#30485d",linewidth=0.16) {#XKEEP4:4 (220,-55)};
// (220,-54.6) @TEXT("VDD",size=1.1,halign="middle",valign="bottom");
// &"VSS" @WIRE(mode="straight",linecolor="#30485d",linewidth=0.16) {#XKEEP4:5 (220,-77)};
// (220,-77.4) @TEXT("VSS",size=1.1,halign="middle",valign="top");
// &"NEXT4" @WIRE(mode="straight",linecolor="#30485d",linewidth=0.16) {#XNEXT4:3 (236,-99)};
// (236.4,-99) @TEXT("NEXT4",size=1.1,halign="start",valign="middle");
// &"VDD" @WIRE(mode="straight",linecolor="#30485d",linewidth=0.16) {#XNEXT4:4 (220,-88)};
// (220,-87.6) @TEXT("VDD",size=1.1,halign="middle",valign="bottom");
// &"VSS" @WIRE(mode="straight",linecolor="#30485d",linewidth=0.16) {#XNEXT4:5 (220,-110)};
// (220,-110.4) @TEXT("VSS",size=1.1,halign="middle",valign="top");
// &"TRIAL6" @WIRE(mode="straight",linecolor="#30485d",linewidth=0.16) {#XBASE5:2 (204,-133.65)};
// (203.6,-133.65) @TEXT("TRIAL6",size=1.1,halign="end",valign="middle");
// &"VDD" @WIRE(mode="straight",linecolor="#30485d",linewidth=0.16) {#XBASE5:4 (220,-121)};
// (220,-120.6) @TEXT("VDD",size=1.1,halign="middle",valign="bottom");
// &"VSS" @WIRE(mode="straight",linecolor="#30485d",linewidth=0.16) {#XBASE5:5 (220,-143)};
// (220,-143.4) @TEXT("VSS",size=1.1,halign="middle",valign="top");
// &"TRIAL5" @WIRE(mode="straight",linecolor="#30485d",linewidth=0.16) {#XKEEP5:1 (204,-163.35)};
// (203.6,-163.35) @TEXT("TRIAL5",size=1.1,halign="end",valign="middle");
// &"DATA" @WIRE(mode="straight",linecolor="#30485d",linewidth=0.16) {#XKEEP5:2 (204,-166.65)};
// (203.6,-166.65) @TEXT("DATA",size=1.1,halign="end",valign="middle");
// &"VDD" @WIRE(mode="straight",linecolor="#30485d",linewidth=0.16) {#XKEEP5:4 (220,-154)};
// (220,-153.6) @TEXT("VDD",size=1.1,halign="middle",valign="bottom");
// &"VSS" @WIRE(mode="straight",linecolor="#30485d",linewidth=0.16) {#XKEEP5:5 (220,-176)};
// (220,-176.4) @TEXT("VSS",size=1.1,halign="middle",valign="top");
// &"NEXT5" @WIRE(mode="straight",linecolor="#30485d",linewidth=0.16) {#XNEXT5:3 (236,-198)};
// (236.4,-198) @TEXT("NEXT5",size=1.1,halign="start",valign="middle");
// &"VDD" @WIRE(mode="straight",linecolor="#30485d",linewidth=0.16) {#XNEXT5:4 (220,-187)};
// (220,-186.6) @TEXT("VDD",size=1.1,halign="middle",valign="bottom");
// &"VSS" @WIRE(mode="straight",linecolor="#30485d",linewidth=0.16) {#XNEXT5:5 (220,-209)};
// (220,-209.4) @TEXT("VSS",size=1.1,halign="middle",valign="top");
// &"TRIAL7" @WIRE(mode="straight",linecolor="#30485d",linewidth=0.16) {#XBASE6:2 (204,-232.65)};
// (203.6,-232.65) @TEXT("TRIAL7",size=1.1,halign="end",valign="middle");
// &"VDD" @WIRE(mode="straight",linecolor="#30485d",linewidth=0.16) {#XBASE6:4 (220,-220)};
// (220,-219.6) @TEXT("VDD",size=1.1,halign="middle",valign="bottom");
// &"VSS" @WIRE(mode="straight",linecolor="#30485d",linewidth=0.16) {#XBASE6:5 (220,-242)};
// (220,-242.4) @TEXT("VSS",size=1.1,halign="middle",valign="top");
// &"TRIAL6" @WIRE(mode="straight",linecolor="#30485d",linewidth=0.16) {#XKEEP6:1 (204,-262.35)};
// (203.6,-262.35) @TEXT("TRIAL6",size=1.1,halign="end",valign="middle");
// &"DATA" @WIRE(mode="straight",linecolor="#30485d",linewidth=0.16) {#XKEEP6:2 (204,-265.65)};
// (203.6,-265.65) @TEXT("DATA",size=1.1,halign="end",valign="middle");
// &"VDD" @WIRE(mode="straight",linecolor="#30485d",linewidth=0.16) {#XKEEP6:4 (220,-253)};
// (220,-252.6) @TEXT("VDD",size=1.1,halign="middle",valign="bottom");
// &"VSS" @WIRE(mode="straight",linecolor="#30485d",linewidth=0.16) {#XKEEP6:5 (220,-275)};
// (220,-275.4) @TEXT("VSS",size=1.1,halign="middle",valign="top");
// &"NEXT6" @WIRE(mode="straight",linecolor="#30485d",linewidth=0.16) {#XNEXT6:3 (236,-297)};
// (236.4,-297) @TEXT("NEXT6",size=1.1,halign="start",valign="middle");
// &"VDD" @WIRE(mode="straight",linecolor="#30485d",linewidth=0.16) {#XNEXT6:4 (220,-286)};
// (220,-285.6) @TEXT("VDD",size=1.1,halign="middle",valign="bottom");
// &"VSS" @WIRE(mode="straight",linecolor="#30485d",linewidth=0.16) {#XNEXT6:5 (220,-308)};
// (220,-308.4) @TEXT("VSS",size=1.1,halign="middle",valign="top");
// &"TRIAL7" @WIRE(mode="straight",linecolor="#30485d",linewidth=0.16) {#XKEEP7:1 (204,-328.35)};
// (203.6,-328.35) @TEXT("TRIAL7",size=1.1,halign="end",valign="middle");
// &"DATA" @WIRE(mode="straight",linecolor="#30485d",linewidth=0.16) {#XKEEP7:2 (204,-331.65)};
// (203.6,-331.65) @TEXT("DATA",size=1.1,halign="end",valign="middle");
// &"VDD" @WIRE(mode="straight",linecolor="#30485d",linewidth=0.16) {#XKEEP7:4 (220,-319)};
// (220,-318.6) @TEXT("VDD",size=1.1,halign="middle",valign="bottom");
// &"VSS" @WIRE(mode="straight",linecolor="#30485d",linewidth=0.16) {#XKEEP7:5 (220,-341)};
// (220,-341.4) @TEXT("VSS",size=1.1,halign="middle",valign="top");
// &"D7" @WIRE(mode="straight",linecolor="#30485d",linewidth=0.16) {#XNEXT7:1 (204,-361.35)};
// (203.6,-361.35) @TEXT("D7",size=1.1,halign="end",valign="middle");
// &"NEXT7" @WIRE(mode="straight",linecolor="#30485d",linewidth=0.16) {#XNEXT7:3 (236,-363)};
// (236.4,-363) @TEXT("NEXT7",size=1.1,halign="start",valign="middle");
// &"VDD" @WIRE(mode="straight",linecolor="#30485d",linewidth=0.16) {#XNEXT7:4 (220,-352)};
// (220,-351.6) @TEXT("VDD",size=1.1,halign="middle",valign="bottom");
// &"VSS" @WIRE(mode="straight",linecolor="#30485d",linewidth=0.16) {#XNEXT7:5 (220,-374)};
// (220,-374.4) @TEXT("VSS",size=1.1,halign="middle",valign="top");
// }
// END SARADC RNL
ends sar8_next_word

subckt sar8_se_window PHASE_REQUEST SEL9 SEL7 SEL6 SEL5 SEL4 VDD VSS DELIVERED
// A transition propagates once per decision. Both polarities traverse real DEL cells.
// Taps by compared bit: 6:T11 5:T9 4:T7 3:T6 2:T5 1,0:T4. Each SELn rises once per
// conversion, on the commit before its first use, and only shortens the window.
XDEL1 (PHASE_REQUEST T1 VDD VSS) DEL250D1BWP12T30P140
XDEL2 (T1 T2 VDD VSS) DEL250D1BWP12T30P140
XDEL3 (T2 T3 VDD VSS) DEL250D1BWP12T30P140
XDEL4 (T3 T4 VDD VSS) DEL250D1BWP12T30P140
XDEL5 (T4 T5 VDD VSS) DEL250D1BWP12T30P140
XDEL6 (T5 T6 VDD VSS) DEL250D1BWP12T30P140
XDEL7 (T6 T7 VDD VSS) DEL250D1BWP12T30P140
XDEL8 (T7 T8 VDD VSS) DEL250D1BWP12T30P140
XDEL9 (T8 T9 VDD VSS) DEL250D1BWP12T30P140
XDEL10 (T9 T10 VDD VSS) DEL250D1BWP12T30P140
XDEL11 (T10 T11 VDD VSS) DEL250D1BWP12T30P140
XTAP9 (T11 T9 SEL9 W9 VDD VSS) MUX2D1BWP12T30P140
XTAP7 (W9 T7 SEL7 W7 VDD VSS) MUX2D1BWP12T30P140
XTAP6 (W7 T6 SEL6 W6 VDD VSS) MUX2D1BWP12T30P140
XTAP5 (W6 T5 SEL5 W5 VDD VSS) MUX2D1BWP12T30P140
XTAP4 (W5 T4 SEL4 DELIVERED VDD VSS) MUX2D1BWP12T30P140
// BEGIN SARADC RNL
// @RNL(author="saradc topology") {
// #XDEL1 @SET-SYMBOL $S_DEL250D1BWP12T30P140;
// #XDEL1 @PLACE(0,0) => @ORIENT("R0");
// #XDEL2 @SET-SYMBOL $S_DEL250D1BWP12T30P140;
// #XDEL2 @PLACE(0,-33) => @ORIENT("R0");
// #XDEL3 @SET-SYMBOL $S_DEL250D1BWP12T30P140;
// #XDEL3 @PLACE(0,-66) => @ORIENT("R0");
// #XDEL4 @SET-SYMBOL $S_DEL250D1BWP12T30P140;
// #XDEL4 @PLACE(0,-99) => @ORIENT("R0");
// #XDEL5 @SET-SYMBOL $S_DEL250D1BWP12T30P140;
// #XDEL5 @PLACE(0,-132) => @ORIENT("R0");
// #XDEL6 @SET-SYMBOL $S_DEL250D1BWP12T30P140;
// #XDEL6 @PLACE(0,-165) => @ORIENT("R0");
// #XDEL7 @SET-SYMBOL $S_DEL250D1BWP12T30P140;
// #XDEL7 @PLACE(0,-198) => @ORIENT("R0");
// #XDEL8 @SET-SYMBOL $S_DEL250D1BWP12T30P140;
// #XDEL8 @PLACE(0,-231) => @ORIENT("R0");
// #XDEL9 @SET-SYMBOL $S_DEL250D1BWP12T30P140;
// #XDEL9 @PLACE(0,-264) => @ORIENT("R0");
// #XDEL10 @SET-SYMBOL $S_DEL250D1BWP12T30P140;
// #XDEL10 @PLACE(0,-297) => @ORIENT("R0");
// #XDEL11 @SET-SYMBOL $S_DEL250D1BWP12T30P140;
// #XDEL11 @PLACE(0,-330) => @ORIENT("R0");
// #XTAP9 @SET-SYMBOL $S_MUX2D1BWP12T30P140;
// #XTAP9 @PLACE(0,-363) => @ORIENT("R0");
// #XTAP7 @SET-SYMBOL $S_MUX2D1BWP12T30P140;
// #XTAP7 @PLACE(55,0) => @ORIENT("R0");
// #XTAP6 @SET-SYMBOL $S_MUX2D1BWP12T30P140;
// #XTAP6 @PLACE(55,-33) => @ORIENT("R0");
// #XTAP5 @SET-SYMBOL $S_MUX2D1BWP12T30P140;
// #XTAP5 @PLACE(55,-66) => @ORIENT("R0");
// #XTAP4 @SET-SYMBOL $S_MUX2D1BWP12T30P140;
// #XTAP4 @PLACE(55,-99) => @ORIENT("R0");
// &"T1" @WIRE(mode="straight",linecolor="#30485d",linewidth=0.16) {#XDEL1:2 (0,0) (0,-33) #XDEL2:1};
// &"T2" @WIRE(mode="straight",linecolor="#30485d",linewidth=0.16) {#XDEL2:2 (0,-33) (0,-66) #XDEL3:1};
// &"T3" @WIRE(mode="straight",linecolor="#30485d",linewidth=0.16) {#XDEL3:2 (0,-66) (0,-99) #XDEL4:1};
// &"T8" @WIRE(mode="straight",linecolor="#30485d",linewidth=0.16) {#XDEL8:2 (0,-231) (0,-264) #XDEL9:1};
// &"T10" @WIRE(mode="straight",linecolor="#30485d",linewidth=0.16) {#XDEL10:2 (0,-297) (0,-330) #XDEL11:1};
// &"T11" @WIRE(mode="straight",linecolor="#30485d",linewidth=0.16) {#XDEL11:2 (0,-330) (0,-359.7) #XTAP9:1};
// &"W7" @WIRE(mode="straight",linecolor="#30485d",linewidth=0.16) {#XTAP7:4 (55,0) (55,-29.7) #XTAP6:1};
// &"W6" @WIRE(mode="straight",linecolor="#30485d",linewidth=0.16) {#XTAP6:4 (55,-33) (55,-62.7) #XTAP5:1};
// &"W5" @WIRE(mode="straight",linecolor="#30485d",linewidth=0.16) {#XTAP5:4 (55,-66) (55,-95.7) #XTAP4:1};
// (-89,30) @TEXT("sar8_se_window / source-derived connections",size=1.4,halign="start",textcolor="#223d52");
// &"PHASE_REQUEST" @WIRE(mode="straight",linecolor="#30485d",linewidth=0.16) {#XDEL1:1 (-16,0)};
// (-16.4,0) @TEXT("PHASE_REQUEST",size=1.1,halign="end",valign="middle");
// &"VDD" @WIRE(mode="straight",linecolor="#30485d",linewidth=0.16) {#XDEL1:3 (0,11)};
// (0,11.4) @TEXT("VDD",size=1.1,halign="middle",valign="bottom");
// &"VSS" @WIRE(mode="straight",linecolor="#30485d",linewidth=0.16) {#XDEL1:4 (0,-11)};
// (0,-11.4) @TEXT("VSS",size=1.1,halign="middle",valign="top");
// &"VDD" @WIRE(mode="straight",linecolor="#30485d",linewidth=0.16) {#XDEL2:3 (0,-22)};
// (0,-21.6) @TEXT("VDD",size=1.1,halign="middle",valign="bottom");
// &"VSS" @WIRE(mode="straight",linecolor="#30485d",linewidth=0.16) {#XDEL2:4 (0,-44)};
// (0,-44.4) @TEXT("VSS",size=1.1,halign="middle",valign="top");
// &"VDD" @WIRE(mode="straight",linecolor="#30485d",linewidth=0.16) {#XDEL3:3 (0,-55)};
// (0,-54.6) @TEXT("VDD",size=1.1,halign="middle",valign="bottom");
// &"VSS" @WIRE(mode="straight",linecolor="#30485d",linewidth=0.16) {#XDEL3:4 (0,-77)};
// (0,-77.4) @TEXT("VSS",size=1.1,halign="middle",valign="top");
// &"T4" @WIRE(mode="straight",linecolor="#30485d",linewidth=0.16) {#XDEL4:2 (16,-99)};
// (16.4,-99) @TEXT("T4",size=1.1,halign="start",valign="middle");
// &"VDD" @WIRE(mode="straight",linecolor="#30485d",linewidth=0.16) {#XDEL4:3 (0,-88)};
// (0,-87.6) @TEXT("VDD",size=1.1,halign="middle",valign="bottom");
// &"VSS" @WIRE(mode="straight",linecolor="#30485d",linewidth=0.16) {#XDEL4:4 (0,-110)};
// (0,-110.4) @TEXT("VSS",size=1.1,halign="middle",valign="top");
// &"T4" @WIRE(mode="straight",linecolor="#30485d",linewidth=0.16) {#XDEL5:1 (-16,-132)};
// (-16.4,-132) @TEXT("T4",size=1.1,halign="end",valign="middle");
// &"T5" @WIRE(mode="straight",linecolor="#30485d",linewidth=0.16) {#XDEL5:2 (16,-132)};
// (16.4,-132) @TEXT("T5",size=1.1,halign="start",valign="middle");
// &"VDD" @WIRE(mode="straight",linecolor="#30485d",linewidth=0.16) {#XDEL5:3 (0,-121)};
// (0,-120.6) @TEXT("VDD",size=1.1,halign="middle",valign="bottom");
// &"VSS" @WIRE(mode="straight",linecolor="#30485d",linewidth=0.16) {#XDEL5:4 (0,-143)};
// (0,-143.4) @TEXT("VSS",size=1.1,halign="middle",valign="top");
// &"T5" @WIRE(mode="straight",linecolor="#30485d",linewidth=0.16) {#XDEL6:1 (-16,-165)};
// (-16.4,-165) @TEXT("T5",size=1.1,halign="end",valign="middle");
// &"T6" @WIRE(mode="straight",linecolor="#30485d",linewidth=0.16) {#XDEL6:2 (16,-165)};
// (16.4,-165) @TEXT("T6",size=1.1,halign="start",valign="middle");
// &"VDD" @WIRE(mode="straight",linecolor="#30485d",linewidth=0.16) {#XDEL6:3 (0,-154)};
// (0,-153.6) @TEXT("VDD",size=1.1,halign="middle",valign="bottom");
// &"VSS" @WIRE(mode="straight",linecolor="#30485d",linewidth=0.16) {#XDEL6:4 (0,-176)};
// (0,-176.4) @TEXT("VSS",size=1.1,halign="middle",valign="top");
// &"T6" @WIRE(mode="straight",linecolor="#30485d",linewidth=0.16) {#XDEL7:1 (-16,-198)};
// (-16.4,-198) @TEXT("T6",size=1.1,halign="end",valign="middle");
// &"T7" @WIRE(mode="straight",linecolor="#30485d",linewidth=0.16) {#XDEL7:2 (16,-198)};
// (16.4,-198) @TEXT("T7",size=1.1,halign="start",valign="middle");
// &"VDD" @WIRE(mode="straight",linecolor="#30485d",linewidth=0.16) {#XDEL7:3 (0,-187)};
// (0,-186.6) @TEXT("VDD",size=1.1,halign="middle",valign="bottom");
// &"VSS" @WIRE(mode="straight",linecolor="#30485d",linewidth=0.16) {#XDEL7:4 (0,-209)};
// (0,-209.4) @TEXT("VSS",size=1.1,halign="middle",valign="top");
// &"T7" @WIRE(mode="straight",linecolor="#30485d",linewidth=0.16) {#XDEL8:1 (-16,-231)};
// (-16.4,-231) @TEXT("T7",size=1.1,halign="end",valign="middle");
// &"VDD" @WIRE(mode="straight",linecolor="#30485d",linewidth=0.16) {#XDEL8:3 (0,-220)};
// (0,-219.6) @TEXT("VDD",size=1.1,halign="middle",valign="bottom");
// &"VSS" @WIRE(mode="straight",linecolor="#30485d",linewidth=0.16) {#XDEL8:4 (0,-242)};
// (0,-242.4) @TEXT("VSS",size=1.1,halign="middle",valign="top");
// &"T9" @WIRE(mode="straight",linecolor="#30485d",linewidth=0.16) {#XDEL9:2 (16,-264)};
// (16.4,-264) @TEXT("T9",size=1.1,halign="start",valign="middle");
// &"VDD" @WIRE(mode="straight",linecolor="#30485d",linewidth=0.16) {#XDEL9:3 (0,-253)};
// (0,-252.6) @TEXT("VDD",size=1.1,halign="middle",valign="bottom");
// &"VSS" @WIRE(mode="straight",linecolor="#30485d",linewidth=0.16) {#XDEL9:4 (0,-275)};
// (0,-275.4) @TEXT("VSS",size=1.1,halign="middle",valign="top");
// &"T9" @WIRE(mode="straight",linecolor="#30485d",linewidth=0.16) {#XDEL10:1 (-16,-297)};
// (-16.4,-297) @TEXT("T9",size=1.1,halign="end",valign="middle");
// &"VDD" @WIRE(mode="straight",linecolor="#30485d",linewidth=0.16) {#XDEL10:3 (0,-286)};
// (0,-285.6) @TEXT("VDD",size=1.1,halign="middle",valign="bottom");
// &"VSS" @WIRE(mode="straight",linecolor="#30485d",linewidth=0.16) {#XDEL10:4 (0,-308)};
// (0,-308.4) @TEXT("VSS",size=1.1,halign="middle",valign="top");
// &"VDD" @WIRE(mode="straight",linecolor="#30485d",linewidth=0.16) {#XDEL11:3 (0,-319)};
// (0,-318.6) @TEXT("VDD",size=1.1,halign="middle",valign="bottom");
// &"VSS" @WIRE(mode="straight",linecolor="#30485d",linewidth=0.16) {#XDEL11:4 (0,-341)};
// (0,-341.4) @TEXT("VSS",size=1.1,halign="middle",valign="top");
// &"T9" @WIRE(mode="straight",linecolor="#30485d",linewidth=0.16) {#XTAP9:2 (-16,-363)};
// (-16.4,-363) @TEXT("T9",size=1.1,halign="end",valign="middle");
// &"SEL9" @WIRE(mode="straight",linecolor="#30485d",linewidth=0.16) {#XTAP9:3 (-16,-366.3)};
// (-16.4,-366.3) @TEXT("SEL9",size=1.1,halign="end",valign="middle");
// &"W9" @WIRE(mode="straight",linecolor="#30485d",linewidth=0.16) {#XTAP9:4 (16,-363)};
// (16.4,-363) @TEXT("W9",size=1.1,halign="start",valign="middle");
// &"VDD" @WIRE(mode="straight",linecolor="#30485d",linewidth=0.16) {#XTAP9:5 (0,-351.4)};
// (0,-351) @TEXT("VDD",size=1.1,halign="middle",valign="bottom");
// &"VSS" @WIRE(mode="straight",linecolor="#30485d",linewidth=0.16) {#XTAP9:6 (0,-374.6)};
// (0,-375) @TEXT("VSS",size=1.1,halign="middle",valign="top");
// &"W9" @WIRE(mode="straight",linecolor="#30485d",linewidth=0.16) {#XTAP7:1 (39,3.3)};
// (38.6,3.3) @TEXT("W9",size=1.1,halign="end",valign="middle");
// &"T7" @WIRE(mode="straight",linecolor="#30485d",linewidth=0.16) {#XTAP7:2 (39,0)};
// (38.6,0) @TEXT("T7",size=1.1,halign="end",valign="middle");
// &"SEL7" @WIRE(mode="straight",linecolor="#30485d",linewidth=0.16) {#XTAP7:3 (39,-3.3)};
// (38.6,-3.3) @TEXT("SEL7",size=1.1,halign="end",valign="middle");
// &"VDD" @WIRE(mode="straight",linecolor="#30485d",linewidth=0.16) {#XTAP7:5 (55,11.6)};
// (55,12) @TEXT("VDD",size=1.1,halign="middle",valign="bottom");
// &"VSS" @WIRE(mode="straight",linecolor="#30485d",linewidth=0.16) {#XTAP7:6 (55,-11.6)};
// (55,-12) @TEXT("VSS",size=1.1,halign="middle",valign="top");
// &"T6" @WIRE(mode="straight",linecolor="#30485d",linewidth=0.16) {#XTAP6:2 (39,-33)};
// (38.6,-33) @TEXT("T6",size=1.1,halign="end",valign="middle");
// &"SEL6" @WIRE(mode="straight",linecolor="#30485d",linewidth=0.16) {#XTAP6:3 (39,-36.3)};
// (38.6,-36.3) @TEXT("SEL6",size=1.1,halign="end",valign="middle");
// &"VDD" @WIRE(mode="straight",linecolor="#30485d",linewidth=0.16) {#XTAP6:5 (55,-21.4)};
// (55,-21) @TEXT("VDD",size=1.1,halign="middle",valign="bottom");
// &"VSS" @WIRE(mode="straight",linecolor="#30485d",linewidth=0.16) {#XTAP6:6 (55,-44.6)};
// (55,-45) @TEXT("VSS",size=1.1,halign="middle",valign="top");
// &"T5" @WIRE(mode="straight",linecolor="#30485d",linewidth=0.16) {#XTAP5:2 (39,-66)};
// (38.6,-66) @TEXT("T5",size=1.1,halign="end",valign="middle");
// &"SEL5" @WIRE(mode="straight",linecolor="#30485d",linewidth=0.16) {#XTAP5:3 (39,-69.3)};
// (38.6,-69.3) @TEXT("SEL5",size=1.1,halign="end",valign="middle");
// &"VDD" @WIRE(mode="straight",linecolor="#30485d",linewidth=0.16) {#XTAP5:5 (55,-54.4)};
// (55,-54) @TEXT("VDD",size=1.1,halign="middle",valign="bottom");
// &"VSS" @WIRE(mode="straight",linecolor="#30485d",linewidth=0.16) {#XTAP5:6 (55,-77.6)};
// (55,-78) @TEXT("VSS",size=1.1,halign="middle",valign="top");
// &"T4" @WIRE(mode="straight",linecolor="#30485d",linewidth=0.16) {#XTAP4:2 (39,-99)};
// (38.6,-99) @TEXT("T4",size=1.1,halign="end",valign="middle");
// &"SEL4" @WIRE(mode="straight",linecolor="#30485d",linewidth=0.16) {#XTAP4:3 (39,-102.3)};
// (38.6,-102.3) @TEXT("SEL4",size=1.1,halign="end",valign="middle");
// &"DELIVERED" @WIRE(mode="straight",linecolor="#30485d",linewidth=0.16) {#XTAP4:4 (71,-99)};
// (71.4,-99) @TEXT("DELIVERED",size=1.1,halign="start",valign="middle");
// &"VDD" @WIRE(mode="straight",linecolor="#30485d",linewidth=0.16) {#XTAP4:5 (55,-87.4)};
// (55,-87) @TEXT("VDD",size=1.1,halign="middle",valign="bottom");
// &"VSS" @WIRE(mode="straight",linecolor="#30485d",linewidth=0.16) {#XTAP4:6 (55,-110.6)};
// (55,-111) @TEXT("VSS",size=1.1,halign="middle",valign="top");
// }
// END SARADC RNL
ends sar8_se_window

subckt sar8_se_timing ACTIVE SAMPLE SEL9 SEL7 SEL6 SEL5 SEL4 COMP_P COMP_N CMP_CLK COMMIT DATA VDD VSS
XPR (COMP_P PR VDD VSS) BUFFD1BWP12T30P140
XNR (COMP_N NR VDD VSS) BUFFD1BWP12T30P140
XNRB (NR NRB VDD VSS) INVD1BWP12T30P140
XDATA (PR NRB DATA VDD VSS) AN2D1BWP12T30P140
XRAW (PR NR RAW VDD VSS) XOR2D1BWP12T30P140
XVD (RAW RAW_T VDD VSS) DEL200D1BWP12T30P140
XVALID (RAW RAW_T VALID VDD VSS) AN2D1BWP12T30P140
XSN (SAMPLE SN VDD VSS) INVD1BWP12T30P140
// VALID drives the inner NAND input: CMP_CLK falls first, so the internal node never floats
// when VALID falls (FF-cold terminal-voltage screen).
XW0 (VALID CMP_CLK WD VDD VSS) AN2D1BWP12T30P140
XW1 (WD SN WRITE VDD VSS) AN2D1BWP12T30P140
XCP (WRITE COMMIT VDD VSS) CKBD1BWP12T30P140
// Tracking clears PHASE, so PHASE_REQUEST and every tap settle high and READY is
// already high when sampling closes: the first trial needs no settling window.
// Each real commit toggles PHASE and launches the opposite transition.
// Two-flop Johnson phase: each register toggles on every second commit, and PHASE = PHA XOR PHB
// changes once per commit without hazards.
XPHA (COMMIT PHB_N SAMPLE VDD VSS PHA) sar8_se_store
XPHBN (PHB PHB_N VDD VSS) INVD1BWP12T30P140
XPHB (COMMIT PHA SAMPLE VDD VSS PHB) sar8_se_store
XPHX (PHA PHB PHASE VDD VSS) XOR2D1BWP12T30P140
XPHR (PHASE PHASE_REQUEST VDD VSS) INVD1BWP12T30P140
XWINDOW (PHASE_REQUEST SEL9 SEL7 SEL6 SEL5 SEL4 VDD VSS DELIVERED) sar8_se_window
XREADY (PHASE DELIVERED READY VDD VSS) XOR2D1BWP12T30P140
// Reset on the committed phase change; only the delayed edge can release reset.
XCLR (READY SN CLR_N VDD VSS) AN2D1BWP12T30P140
// The first compare waits two stages after sampling closes for the bootstrap
// gates to turn off. Reopening the sample clears LIVE through the qualifier.
XSND1 (SN SN_T1 VDD VSS) DEL250D1BWP12T30P140
XSND2 (SN_T1 SN_T2 VDD VSS) DEL250D1BWP12T30P140
XSNQ (SN SN_T2 SN_D VDD VSS) AN2D1BWP12T30P140
XLIVE (ACTIVE SN_D LIVE VDD VSS) AN2D1BWP12T30P140
XIDLE (RAW CLEARED VDD VSS) INVD1BWP12T30P140
XSET0 (LIVE CLEARED SET0 VDD VSS) AN2D1BWP12T30P140
XSET (SET0 READY SET VDD VSS) AN2D1BWP12T30P140
XHIGH (HIGH VDD VSS) TIEHBWP12T30P140
XCLOCK (HIGH SET CLR_N Q VDD VSS) LHCNDQD1BWP12T30P140
XCMP (Q CMP_CLK VDD VSS) CKBD1BWP12T30P140
// BEGIN SARADC RNL
// @RNL(author="saradc topology") {
// #XPR @SET-SYMBOL $S_BUFFD1BWP12T30P140;
// #XPR @PLACE(0,0) => @ORIENT("R0");
// #XNR @SET-SYMBOL $S_BUFFD1BWP12T30P140;
// #XNR @PLACE(0,-33) => @ORIENT("R0");
// #XNRB @SET-SYMBOL $S_INVD1BWP12T30P140;
// #XNRB @PLACE(0,-66) => @ORIENT("R0");
// #XDATA @SET-SYMBOL $S_AN2D1BWP12T30P140;
// #XDATA @PLACE(0,-99) => @ORIENT("R0");
// #XRAW @SET-SYMBOL $S_XOR2D1BWP12T30P140;
// #XRAW @PLACE(0,-132) => @ORIENT("R0");
// #XVD @SET-SYMBOL $S_DEL200D1BWP12T30P140;
// #XVD @PLACE(0,-165) => @ORIENT("R0");
// #XVALID @SET-SYMBOL $S_AN2D1BWP12T30P140;
// #XVALID @PLACE(0,-198) => @ORIENT("R0");
// #XSN @SET-SYMBOL $S_INVD1BWP12T30P140;
// #XSN @PLACE(0,-231) => @ORIENT("R0");
// #XW0 @SET-SYMBOL $S_AN2D1BWP12T30P140;
// #XW0 @PLACE(0,-264) => @ORIENT("R0");
// #XW1 @SET-SYMBOL $S_AN2D1BWP12T30P140;
// #XW1 @PLACE(0,-297) => @ORIENT("R0");
// #XCP @SET-SYMBOL $S_CKBD1BWP12T30P140;
// #XCP @PLACE(0,-330) => @ORIENT("R0");
// #XPHA @SET-SYMBOL $S_sar8_se_store;
// #XPHA @PLACE(0,-363) => @ORIENT("R0");
// #XPHBN @SET-SYMBOL $S_INVD1BWP12T30P140;
// #XPHBN @PLACE(55,0) => @ORIENT("R0");
// #XPHB @SET-SYMBOL $S_sar8_se_store;
// #XPHB @PLACE(55,-33) => @ORIENT("R0");
// #XPHX @SET-SYMBOL $S_XOR2D1BWP12T30P140;
// #XPHX @PLACE(55,-66) => @ORIENT("R0");
// #XPHR @SET-SYMBOL $S_INVD1BWP12T30P140;
// #XPHR @PLACE(55,-99) => @ORIENT("R0");
// #XWINDOW @SET-SYMBOL $S_sar8_se_window;
// #XWINDOW @PLACE(55,-132) => @ORIENT("R0");
// #XREADY @SET-SYMBOL $S_XOR2D1BWP12T30P140;
// #XREADY @PLACE(55,-165) => @ORIENT("R0");
// #XCLR @SET-SYMBOL $S_AN2D1BWP12T30P140;
// #XCLR @PLACE(55,-198) => @ORIENT("R0");
// #XSND1 @SET-SYMBOL $S_DEL250D1BWP12T30P140;
// #XSND1 @PLACE(55,-231) => @ORIENT("R0");
// #XSND2 @SET-SYMBOL $S_DEL250D1BWP12T30P140;
// #XSND2 @PLACE(55,-264) => @ORIENT("R0");
// #XSNQ @SET-SYMBOL $S_AN2D1BWP12T30P140;
// #XSNQ @PLACE(55,-297) => @ORIENT("R0");
// #XLIVE @SET-SYMBOL $S_AN2D1BWP12T30P140;
// #XLIVE @PLACE(55,-330) => @ORIENT("R0");
// #XIDLE @SET-SYMBOL $S_INVD1BWP12T30P140;
// #XIDLE @PLACE(55,-363) => @ORIENT("R0");
// #XSET0 @SET-SYMBOL $S_AN2D1BWP12T30P140;
// #XSET0 @PLACE(110,0) => @ORIENT("R0");
// #XSET @SET-SYMBOL $S_AN2D1BWP12T30P140;
// #XSET @PLACE(110,-33) => @ORIENT("R0");
// #XHIGH @SET-SYMBOL $S_TIEHBWP12T30P140;
// #XHIGH @PLACE(110,-66) => @ORIENT("R0");
// #XCLOCK @SET-SYMBOL $S_LHCNDQD1BWP12T30P140;
// #XCLOCK @PLACE(110,-99) => @ORIENT("R0");
// #XCMP @SET-SYMBOL $S_CKBD1BWP12T30P140;
// #XCMP @PLACE(110,-132) => @ORIENT("R0");
// &"NRB" @WIRE(mode="straight",linecolor="#30485d",linewidth=0.16) {#XNRB:2 (-3,-66) (-3,-100.65) #XDATA:2};
// &"RAW_T" @WIRE(mode="straight",linecolor="#30485d",linewidth=0.16) {#XVD:2 (0,-165) (0,-199.65) #XVALID:2};
// &"VALID" @WIRE(mode="straight",linecolor="#30485d",linewidth=0.16) {#XVALID:3 (0,-198) (0,-262.35) #XW0:1};
// &"WD" @WIRE(mode="straight",linecolor="#30485d",linewidth=0.16) {#XW0:3 (0,-264) (0,-295.35) #XW1:1};
// &"WRITE" @WIRE(mode="straight",linecolor="#30485d",linewidth=0.16) {#XW1:3 (0,-297) (0,-330) #XCP:1};
// &"PHASE_REQUEST" @WIRE(mode="straight",linecolor="#30485d",linewidth=0.16) {#XPHR:2 (52,-99) (52,-123.75) #XWINDOW:1};
// &"DELIVERED" @WIRE(mode="straight",linecolor="#30485d",linewidth=0.16) {#XWINDOW:9 (55,-132) (55,-166.65) #XREADY:2};
// &"CLR_N" @WIRE(mode="straight",linecolor="#30485d",linewidth=0.16) {#XCLR:3 (82.5,-198) (82.5,-102.3) #XCLOCK:3};
// &"SN_T1" @WIRE(mode="straight",linecolor="#30485d",linewidth=0.16) {#XSND1:2 (55,-231) (55,-264) #XSND2:1};
// &"SN_T2" @WIRE(mode="straight",linecolor="#30485d",linewidth=0.16) {#XSND2:2 (55,-264) (55,-298.65) #XSNQ:2};
// &"SN_D" @WIRE(mode="straight",linecolor="#30485d",linewidth=0.16) {#XSNQ:3 (55,-297) (55,-331.65) #XLIVE:2};
// &"SET0" @WIRE(mode="straight",linecolor="#30485d",linewidth=0.16) {#XSET0:3 (110,0) (110,-31.35) #XSET:1};
// &"SET" @WIRE(mode="straight",linecolor="#30485d",linewidth=0.16) {#XSET:3 (110,-33) (110,-99) #XCLOCK:2};
// &"HIGH" @WIRE(mode="straight",linecolor="#30485d",linewidth=0.16) {#XHIGH:1 (110,-66) (110,-95.7) #XCLOCK:1};
// &"Q" @WIRE(mode="straight",linecolor="#30485d",linewidth=0.16) {#XCLOCK:4 (110,-99) (110,-132) #XCMP:1};
// (-89,30) @TEXT("sar8_se_timing / source-derived connections",size=1.4,halign="start",textcolor="#223d52");
// &"COMP_P" @WIRE(mode="straight",linecolor="#30485d",linewidth=0.16) {#XPR:1 (-16,0)};
// (-16.4,0) @TEXT("COMP_P",size=1.1,halign="end",valign="middle");
// &"PR" @WIRE(mode="straight",linecolor="#30485d",linewidth=0.16) {#XPR:2 (16,0)};
// (16.4,0) @TEXT("PR",size=1.1,halign="start",valign="middle");
// &"VDD" @WIRE(mode="straight",linecolor="#30485d",linewidth=0.16) {#XPR:3 (0,11)};
// (0,11.4) @TEXT("VDD",size=1.1,halign="middle",valign="bottom");
// &"VSS" @WIRE(mode="straight",linecolor="#30485d",linewidth=0.16) {#XPR:4 (0,-11)};
// (0,-11.4) @TEXT("VSS",size=1.1,halign="middle",valign="top");
// &"COMP_N" @WIRE(mode="straight",linecolor="#30485d",linewidth=0.16) {#XNR:1 (-16,-33)};
// (-16.4,-33) @TEXT("COMP_N",size=1.1,halign="end",valign="middle");
// &"NR" @WIRE(mode="straight",linecolor="#30485d",linewidth=0.16) {#XNR:2 (16,-33)};
// (16.4,-33) @TEXT("NR",size=1.1,halign="start",valign="middle");
// &"VDD" @WIRE(mode="straight",linecolor="#30485d",linewidth=0.16) {#XNR:3 (0,-22)};
// (0,-21.6) @TEXT("VDD",size=1.1,halign="middle",valign="bottom");
// &"VSS" @WIRE(mode="straight",linecolor="#30485d",linewidth=0.16) {#XNR:4 (0,-44)};
// (0,-44.4) @TEXT("VSS",size=1.1,halign="middle",valign="top");
// &"NR" @WIRE(mode="straight",linecolor="#30485d",linewidth=0.16) {#XNRB:1 (-10,-66)};
// (-10.4,-66) @TEXT("NR",size=1.1,halign="end",valign="middle");
// &"VDD" @WIRE(mode="straight",linecolor="#30485d",linewidth=0.16) {#XNRB:3 (0,-56)};
// (0,-55.6) @TEXT("VDD",size=1.1,halign="middle",valign="bottom");
// &"VSS" @WIRE(mode="straight",linecolor="#30485d",linewidth=0.16) {#XNRB:4 (0,-76)};
// (0,-76.4) @TEXT("VSS",size=1.1,halign="middle",valign="top");
// &"PR" @WIRE(mode="straight",linecolor="#30485d",linewidth=0.16) {#XDATA:1 (-16,-97.35)};
// (-16.4,-97.35) @TEXT("PR",size=1.1,halign="end",valign="middle");
// &"DATA" @WIRE(mode="straight",linecolor="#30485d",linewidth=0.16) {#XDATA:3 (16,-99)};
// (16.4,-99) @TEXT("DATA",size=1.1,halign="start",valign="middle");
// &"VDD" @WIRE(mode="straight",linecolor="#30485d",linewidth=0.16) {#XDATA:4 (0,-88)};
// (0,-87.6) @TEXT("VDD",size=1.1,halign="middle",valign="bottom");
// &"VSS" @WIRE(mode="straight",linecolor="#30485d",linewidth=0.16) {#XDATA:5 (0,-110)};
// (0,-110.4) @TEXT("VSS",size=1.1,halign="middle",valign="top");
// &"PR" @WIRE(mode="straight",linecolor="#30485d",linewidth=0.16) {#XRAW:1 (-16,-130.35)};
// (-16.4,-130.35) @TEXT("PR",size=1.1,halign="end",valign="middle");
// &"NR" @WIRE(mode="straight",linecolor="#30485d",linewidth=0.16) {#XRAW:2 (-16,-133.65)};
// (-16.4,-133.65) @TEXT("NR",size=1.1,halign="end",valign="middle");
// &"RAW" @WIRE(mode="straight",linecolor="#30485d",linewidth=0.16) {#XRAW:3 (16,-132)};
// (16.4,-132) @TEXT("RAW",size=1.1,halign="start",valign="middle");
// &"VDD" @WIRE(mode="straight",linecolor="#30485d",linewidth=0.16) {#XRAW:4 (0,-121)};
// (0,-120.6) @TEXT("VDD",size=1.1,halign="middle",valign="bottom");
// &"VSS" @WIRE(mode="straight",linecolor="#30485d",linewidth=0.16) {#XRAW:5 (0,-143)};
// (0,-143.4) @TEXT("VSS",size=1.1,halign="middle",valign="top");
// &"RAW" @WIRE(mode="straight",linecolor="#30485d",linewidth=0.16) {#XVD:1 (-16,-165)};
// (-16.4,-165) @TEXT("RAW",size=1.1,halign="end",valign="middle");
// &"VDD" @WIRE(mode="straight",linecolor="#30485d",linewidth=0.16) {#XVD:3 (0,-154)};
// (0,-153.6) @TEXT("VDD",size=1.1,halign="middle",valign="bottom");
// &"VSS" @WIRE(mode="straight",linecolor="#30485d",linewidth=0.16) {#XVD:4 (0,-176)};
// (0,-176.4) @TEXT("VSS",size=1.1,halign="middle",valign="top");
// &"RAW" @WIRE(mode="straight",linecolor="#30485d",linewidth=0.16) {#XVALID:1 (-16,-196.35)};
// (-16.4,-196.35) @TEXT("RAW",size=1.1,halign="end",valign="middle");
// &"VDD" @WIRE(mode="straight",linecolor="#30485d",linewidth=0.16) {#XVALID:4 (0,-187)};
// (0,-186.6) @TEXT("VDD",size=1.1,halign="middle",valign="bottom");
// &"VSS" @WIRE(mode="straight",linecolor="#30485d",linewidth=0.16) {#XVALID:5 (0,-209)};
// (0,-209.4) @TEXT("VSS",size=1.1,halign="middle",valign="top");
// &"SAMPLE" @WIRE(mode="straight",linecolor="#30485d",linewidth=0.16) {#XSN:1 (-10,-231)};
// (-10.4,-231) @TEXT("SAMPLE",size=1.1,halign="end",valign="middle");
// &"SN" @WIRE(mode="straight",linecolor="#30485d",linewidth=0.16) {#XSN:2 (10,-231)};
// (10.4,-231) @TEXT("SN",size=1.1,halign="start",valign="middle");
// &"VDD" @WIRE(mode="straight",linecolor="#30485d",linewidth=0.16) {#XSN:3 (0,-221)};
// (0,-220.6) @TEXT("VDD",size=1.1,halign="middle",valign="bottom");
// &"VSS" @WIRE(mode="straight",linecolor="#30485d",linewidth=0.16) {#XSN:4 (0,-241)};
// (0,-241.4) @TEXT("VSS",size=1.1,halign="middle",valign="top");
// &"CMP_CLK" @WIRE(mode="straight",linecolor="#30485d",linewidth=0.16) {#XW0:2 (-16,-265.65)};
// (-16.4,-265.65) @TEXT("CMP_CLK",size=1.1,halign="end",valign="middle");
// &"VDD" @WIRE(mode="straight",linecolor="#30485d",linewidth=0.16) {#XW0:4 (0,-253)};
// (0,-252.6) @TEXT("VDD",size=1.1,halign="middle",valign="bottom");
// &"VSS" @WIRE(mode="straight",linecolor="#30485d",linewidth=0.16) {#XW0:5 (0,-275)};
// (0,-275.4) @TEXT("VSS",size=1.1,halign="middle",valign="top");
// &"SN" @WIRE(mode="straight",linecolor="#30485d",linewidth=0.16) {#XW1:2 (-16,-298.65)};
// (-16.4,-298.65) @TEXT("SN",size=1.1,halign="end",valign="middle");
// &"VDD" @WIRE(mode="straight",linecolor="#30485d",linewidth=0.16) {#XW1:4 (0,-286)};
// (0,-285.6) @TEXT("VDD",size=1.1,halign="middle",valign="bottom");
// &"VSS" @WIRE(mode="straight",linecolor="#30485d",linewidth=0.16) {#XW1:5 (0,-308)};
// (0,-308.4) @TEXT("VSS",size=1.1,halign="middle",valign="top");
// &"COMMIT" @WIRE(mode="straight",linecolor="#30485d",linewidth=0.16) {#XCP:2 (16,-330)};
// (16.4,-330) @TEXT("COMMIT",size=1.1,halign="start",valign="middle");
// &"VDD" @WIRE(mode="straight",linecolor="#30485d",linewidth=0.16) {#XCP:3 (0,-319)};
// (0,-318.6) @TEXT("VDD",size=1.1,halign="middle",valign="bottom");
// &"VSS" @WIRE(mode="straight",linecolor="#30485d",linewidth=0.16) {#XCP:4 (0,-341)};
// (0,-341.4) @TEXT("VSS",size=1.1,halign="middle",valign="top");
// &"COMMIT" @WIRE(mode="straight",linecolor="#30485d",linewidth=0.16) {#XPHA:1 (-16,-361.35)};
// (-16.4,-361.35) @TEXT("COMMIT",size=1.1,halign="end",valign="middle");
// &"PHB_N" @WIRE(mode="straight",linecolor="#30485d",linewidth=0.16) {#XPHA:2 (16,-361.35)};
// (16.4,-361.35) @TEXT("PHB_N",size=1.1,halign="start",valign="middle");
// &"SAMPLE" @WIRE(mode="straight",linecolor="#30485d",linewidth=0.16) {#XPHA:3 (-16,-364.65)};
// (-16.4,-364.65) @TEXT("SAMPLE",size=1.1,halign="end",valign="middle");
// &"VDD" @WIRE(mode="straight",linecolor="#30485d",linewidth=0.16) {#XPHA:4 (0,-352)};
// (0,-351.6) @TEXT("VDD",size=1.1,halign="middle",valign="bottom");
// &"VSS" @WIRE(mode="straight",linecolor="#30485d",linewidth=0.16) {#XPHA:5 (0,-374)};
// (0,-374.4) @TEXT("VSS",size=1.1,halign="middle",valign="top");
// &"PHA" @WIRE(mode="straight",linecolor="#30485d",linewidth=0.16) {#XPHA:6 (16,-364.65)};
// (16.4,-364.65) @TEXT("PHA",size=1.1,halign="start",valign="middle");
// &"PHB" @WIRE(mode="straight",linecolor="#30485d",linewidth=0.16) {#XPHBN:1 (45,0)};
// (44.6,0) @TEXT("PHB",size=1.1,halign="end",valign="middle");
// &"PHB_N" @WIRE(mode="straight",linecolor="#30485d",linewidth=0.16) {#XPHBN:2 (65,0)};
// (65.4,0) @TEXT("PHB_N",size=1.1,halign="start",valign="middle");
// &"VDD" @WIRE(mode="straight",linecolor="#30485d",linewidth=0.16) {#XPHBN:3 (55,10)};
// (55,10.4) @TEXT("VDD",size=1.1,halign="middle",valign="bottom");
// &"VSS" @WIRE(mode="straight",linecolor="#30485d",linewidth=0.16) {#XPHBN:4 (55,-10)};
// (55,-10.4) @TEXT("VSS",size=1.1,halign="middle",valign="top");
// &"COMMIT" @WIRE(mode="straight",linecolor="#30485d",linewidth=0.16) {#XPHB:1 (39,-31.35)};
// (38.6,-31.35) @TEXT("COMMIT",size=1.1,halign="end",valign="middle");
// &"PHA" @WIRE(mode="straight",linecolor="#30485d",linewidth=0.16) {#XPHB:2 (71,-31.35)};
// (71.4,-31.35) @TEXT("PHA",size=1.1,halign="start",valign="middle");
// &"SAMPLE" @WIRE(mode="straight",linecolor="#30485d",linewidth=0.16) {#XPHB:3 (39,-34.65)};
// (38.6,-34.65) @TEXT("SAMPLE",size=1.1,halign="end",valign="middle");
// &"VDD" @WIRE(mode="straight",linecolor="#30485d",linewidth=0.16) {#XPHB:4 (55,-22)};
// (55,-21.6) @TEXT("VDD",size=1.1,halign="middle",valign="bottom");
// &"VSS" @WIRE(mode="straight",linecolor="#30485d",linewidth=0.16) {#XPHB:5 (55,-44)};
// (55,-44.4) @TEXT("VSS",size=1.1,halign="middle",valign="top");
// &"PHB" @WIRE(mode="straight",linecolor="#30485d",linewidth=0.16) {#XPHB:6 (71,-34.65)};
// (71.4,-34.65) @TEXT("PHB",size=1.1,halign="start",valign="middle");
// &"PHA" @WIRE(mode="straight",linecolor="#30485d",linewidth=0.16) {#XPHX:1 (39,-64.35)};
// (38.6,-64.35) @TEXT("PHA",size=1.1,halign="end",valign="middle");
// &"PHB" @WIRE(mode="straight",linecolor="#30485d",linewidth=0.16) {#XPHX:2 (39,-67.65)};
// (38.6,-67.65) @TEXT("PHB",size=1.1,halign="end",valign="middle");
// &"PHASE" @WIRE(mode="straight",linecolor="#30485d",linewidth=0.16) {#XPHX:3 (71,-66)};
// (71.4,-66) @TEXT("PHASE",size=1.1,halign="start",valign="middle");
// &"VDD" @WIRE(mode="straight",linecolor="#30485d",linewidth=0.16) {#XPHX:4 (55,-55)};
// (55,-54.6) @TEXT("VDD",size=1.1,halign="middle",valign="bottom");
// &"VSS" @WIRE(mode="straight",linecolor="#30485d",linewidth=0.16) {#XPHX:5 (55,-77)};
// (55,-77.4) @TEXT("VSS",size=1.1,halign="middle",valign="top");
// &"PHASE" @WIRE(mode="straight",linecolor="#30485d",linewidth=0.16) {#XPHR:1 (45,-99)};
// (44.6,-99) @TEXT("PHASE",size=1.1,halign="end",valign="middle");
// &"VDD" @WIRE(mode="straight",linecolor="#30485d",linewidth=0.16) {#XPHR:3 (55,-89)};
// (55,-88.6) @TEXT("VDD",size=1.1,halign="middle",valign="bottom");
// &"VSS" @WIRE(mode="straight",linecolor="#30485d",linewidth=0.16) {#XPHR:4 (55,-109)};
// (55,-109.4) @TEXT("VSS",size=1.1,halign="middle",valign="top");
// &"SEL9" @WIRE(mode="straight",linecolor="#30485d",linewidth=0.16) {#XWINDOW:2 (39,-127.05)};
// (38.6,-127.05) @TEXT("SEL9",size=1.1,halign="end",valign="middle");
// &"SEL7" @WIRE(mode="straight",linecolor="#30485d",linewidth=0.16) {#XWINDOW:3 (39,-130.35)};
// (38.6,-130.35) @TEXT("SEL7",size=1.1,halign="end",valign="middle");
// &"SEL6" @WIRE(mode="straight",linecolor="#30485d",linewidth=0.16) {#XWINDOW:4 (39,-133.65)};
// (38.6,-133.65) @TEXT("SEL6",size=1.1,halign="end",valign="middle");
// &"SEL5" @WIRE(mode="straight",linecolor="#30485d",linewidth=0.16) {#XWINDOW:5 (39,-136.95)};
// (38.6,-136.95) @TEXT("SEL5",size=1.1,halign="end",valign="middle");
// &"SEL4" @WIRE(mode="straight",linecolor="#30485d",linewidth=0.16) {#XWINDOW:6 (39,-140.25)};
// (38.6,-140.25) @TEXT("SEL4",size=1.1,halign="end",valign="middle");
// &"VDD" @WIRE(mode="straight",linecolor="#30485d",linewidth=0.16) {#XWINDOW:7 (55,-115.45)};
// (55,-115.05) @TEXT("VDD",size=1.1,halign="middle",valign="bottom");
// &"VSS" @WIRE(mode="straight",linecolor="#30485d",linewidth=0.16) {#XWINDOW:8 (55,-148.55)};
// (55,-148.95) @TEXT("VSS",size=1.1,halign="middle",valign="top");
// &"PHASE" @WIRE(mode="straight",linecolor="#30485d",linewidth=0.16) {#XREADY:1 (39,-163.35)};
// (38.6,-163.35) @TEXT("PHASE",size=1.1,halign="end",valign="middle");
// &"READY" @WIRE(mode="straight",linecolor="#30485d",linewidth=0.16) {#XREADY:3 (71,-165)};
// (71.4,-165) @TEXT("READY",size=1.1,halign="start",valign="middle");
// &"VDD" @WIRE(mode="straight",linecolor="#30485d",linewidth=0.16) {#XREADY:4 (55,-154)};
// (55,-153.6) @TEXT("VDD",size=1.1,halign="middle",valign="bottom");
// &"VSS" @WIRE(mode="straight",linecolor="#30485d",linewidth=0.16) {#XREADY:5 (55,-176)};
// (55,-176.4) @TEXT("VSS",size=1.1,halign="middle",valign="top");
// &"READY" @WIRE(mode="straight",linecolor="#30485d",linewidth=0.16) {#XCLR:1 (39,-196.35)};
// (38.6,-196.35) @TEXT("READY",size=1.1,halign="end",valign="middle");
// &"SN" @WIRE(mode="straight",linecolor="#30485d",linewidth=0.16) {#XCLR:2 (39,-199.65)};
// (38.6,-199.65) @TEXT("SN",size=1.1,halign="end",valign="middle");
// &"VDD" @WIRE(mode="straight",linecolor="#30485d",linewidth=0.16) {#XCLR:4 (55,-187)};
// (55,-186.6) @TEXT("VDD",size=1.1,halign="middle",valign="bottom");
// &"VSS" @WIRE(mode="straight",linecolor="#30485d",linewidth=0.16) {#XCLR:5 (55,-209)};
// (55,-209.4) @TEXT("VSS",size=1.1,halign="middle",valign="top");
// &"SN" @WIRE(mode="straight",linecolor="#30485d",linewidth=0.16) {#XSND1:1 (39,-231)};
// (38.6,-231) @TEXT("SN",size=1.1,halign="end",valign="middle");
// &"VDD" @WIRE(mode="straight",linecolor="#30485d",linewidth=0.16) {#XSND1:3 (55,-220)};
// (55,-219.6) @TEXT("VDD",size=1.1,halign="middle",valign="bottom");
// &"VSS" @WIRE(mode="straight",linecolor="#30485d",linewidth=0.16) {#XSND1:4 (55,-242)};
// (55,-242.4) @TEXT("VSS",size=1.1,halign="middle",valign="top");
// &"VDD" @WIRE(mode="straight",linecolor="#30485d",linewidth=0.16) {#XSND2:3 (55,-253)};
// (55,-252.6) @TEXT("VDD",size=1.1,halign="middle",valign="bottom");
// &"VSS" @WIRE(mode="straight",linecolor="#30485d",linewidth=0.16) {#XSND2:4 (55,-275)};
// (55,-275.4) @TEXT("VSS",size=1.1,halign="middle",valign="top");
// &"SN" @WIRE(mode="straight",linecolor="#30485d",linewidth=0.16) {#XSNQ:1 (39,-295.35)};
// (38.6,-295.35) @TEXT("SN",size=1.1,halign="end",valign="middle");
// &"VDD" @WIRE(mode="straight",linecolor="#30485d",linewidth=0.16) {#XSNQ:4 (55,-286)};
// (55,-285.6) @TEXT("VDD",size=1.1,halign="middle",valign="bottom");
// &"VSS" @WIRE(mode="straight",linecolor="#30485d",linewidth=0.16) {#XSNQ:5 (55,-308)};
// (55,-308.4) @TEXT("VSS",size=1.1,halign="middle",valign="top");
// &"ACTIVE" @WIRE(mode="straight",linecolor="#30485d",linewidth=0.16) {#XLIVE:1 (39,-328.35)};
// (38.6,-328.35) @TEXT("ACTIVE",size=1.1,halign="end",valign="middle");
// &"LIVE" @WIRE(mode="straight",linecolor="#30485d",linewidth=0.16) {#XLIVE:3 (71,-330)};
// (71.4,-330) @TEXT("LIVE",size=1.1,halign="start",valign="middle");
// &"VDD" @WIRE(mode="straight",linecolor="#30485d",linewidth=0.16) {#XLIVE:4 (55,-319)};
// (55,-318.6) @TEXT("VDD",size=1.1,halign="middle",valign="bottom");
// &"VSS" @WIRE(mode="straight",linecolor="#30485d",linewidth=0.16) {#XLIVE:5 (55,-341)};
// (55,-341.4) @TEXT("VSS",size=1.1,halign="middle",valign="top");
// &"RAW" @WIRE(mode="straight",linecolor="#30485d",linewidth=0.16) {#XIDLE:1 (45,-363)};
// (44.6,-363) @TEXT("RAW",size=1.1,halign="end",valign="middle");
// &"CLEARED" @WIRE(mode="straight",linecolor="#30485d",linewidth=0.16) {#XIDLE:2 (65,-363)};
// (65.4,-363) @TEXT("CLEARED",size=1.1,halign="start",valign="middle");
// &"VDD" @WIRE(mode="straight",linecolor="#30485d",linewidth=0.16) {#XIDLE:3 (55,-353)};
// (55,-352.6) @TEXT("VDD",size=1.1,halign="middle",valign="bottom");
// &"VSS" @WIRE(mode="straight",linecolor="#30485d",linewidth=0.16) {#XIDLE:4 (55,-373)};
// (55,-373.4) @TEXT("VSS",size=1.1,halign="middle",valign="top");
// &"LIVE" @WIRE(mode="straight",linecolor="#30485d",linewidth=0.16) {#XSET0:1 (94,1.65)};
// (93.6,1.65) @TEXT("LIVE",size=1.1,halign="end",valign="middle");
// &"CLEARED" @WIRE(mode="straight",linecolor="#30485d",linewidth=0.16) {#XSET0:2 (94,-1.65)};
// (93.6,-1.65) @TEXT("CLEARED",size=1.1,halign="end",valign="middle");
// &"VDD" @WIRE(mode="straight",linecolor="#30485d",linewidth=0.16) {#XSET0:4 (110,11)};
// (110,11.4) @TEXT("VDD",size=1.1,halign="middle",valign="bottom");
// &"VSS" @WIRE(mode="straight",linecolor="#30485d",linewidth=0.16) {#XSET0:5 (110,-11)};
// (110,-11.4) @TEXT("VSS",size=1.1,halign="middle",valign="top");
// &"READY" @WIRE(mode="straight",linecolor="#30485d",linewidth=0.16) {#XSET:2 (94,-34.65)};
// (93.6,-34.65) @TEXT("READY",size=1.1,halign="end",valign="middle");
// &"VDD" @WIRE(mode="straight",linecolor="#30485d",linewidth=0.16) {#XSET:4 (110,-22)};
// (110,-21.6) @TEXT("VDD",size=1.1,halign="middle",valign="bottom");
// &"VSS" @WIRE(mode="straight",linecolor="#30485d",linewidth=0.16) {#XSET:5 (110,-44)};
// (110,-44.4) @TEXT("VSS",size=1.1,halign="middle",valign="top");
// &"VDD" @WIRE(mode="straight",linecolor="#30485d",linewidth=0.16) {#XHIGH:2 (110,-55)};
// (110,-54.6) @TEXT("VDD",size=1.1,halign="middle",valign="bottom");
// &"VSS" @WIRE(mode="straight",linecolor="#30485d",linewidth=0.16) {#XHIGH:3 (110,-77)};
// (110,-77.4) @TEXT("VSS",size=1.1,halign="middle",valign="top");
// &"VDD" @WIRE(mode="straight",linecolor="#30485d",linewidth=0.16) {#XCLOCK:5 (110,-87.4)};
// (110,-87) @TEXT("VDD",size=1.1,halign="middle",valign="bottom");
// &"VSS" @WIRE(mode="straight",linecolor="#30485d",linewidth=0.16) {#XCLOCK:6 (110,-110.6)};
// (110,-111) @TEXT("VSS",size=1.1,halign="middle",valign="top");
// &"CMP_CLK" @WIRE(mode="straight",linecolor="#30485d",linewidth=0.16) {#XCMP:2 (126,-132)};
// (126.4,-132) @TEXT("CMP_CLK",size=1.1,halign="start",valign="middle");
// &"VDD" @WIRE(mode="straight",linecolor="#30485d",linewidth=0.16) {#XCMP:3 (110,-121)};
// (110,-120.6) @TEXT("VDD",size=1.1,halign="middle",valign="bottom");
// &"VSS" @WIRE(mode="straight",linecolor="#30485d",linewidth=0.16) {#XCMP:4 (110,-143)};
// (110,-143.4) @TEXT("VSS",size=1.1,halign="middle",valign="top");
// }
// END SARADC RNL
ends sar8_se_timing

subckt sar8_se_store CK DATA RESET VDD VSS Q
XDR (DATA RESET DIN VDD VSS) OR2D1BWP12T30P140
XCLR (RESET RST_N VDD VSS) INVD1BWP12T30P140
XREG (DIN CK RST_N Q VDD VSS) DFCNQD1BWP12T30P140
// BEGIN SARADC RNL
// @RNL(author="saradc topology") {
// #XDR @SET-SYMBOL $S_OR2D1BWP12T30P140;
// #XDR @PLACE(0,0) => @ORIENT("R0");
// #XCLR @SET-SYMBOL $S_INVD1BWP12T30P140;
// #XCLR @PLACE(0,-33) => @ORIENT("R0");
// #XREG @SET-SYMBOL $S_DFCNQD1BWP12T30P140;
// #XREG @PLACE(0,-66) => @ORIENT("R0");
// &"RESET" @WIRE(mode="straight",linecolor="#30485d",linewidth=0.16) {#XDR:2 (-10,-1.65) (-10,-33) #XCLR:1};
// &"DIN" @WIRE(mode="straight",linecolor="#30485d",linewidth=0.16) {#XDR:3 (3,0) (3,-62.6) #XREG:1};
// &"RST_N" @WIRE(mode="straight",linecolor="#30485d",linewidth=0.16) {#XCLR:2 (0,-33) (0,-69.4) #XREG:3};
// (-89,30) @TEXT("sar8_se_store / source-derived connections",size=1.4,halign="start",textcolor="#223d52");
// &"DATA" @WIRE(mode="straight",linecolor="#30485d",linewidth=0.16) {#XDR:1 (-16,1.65)};
// (-16.4,1.65) @TEXT("DATA",size=1.1,halign="end",valign="middle");
// &"VDD" @WIRE(mode="straight",linecolor="#30485d",linewidth=0.16) {#XDR:4 (0,11)};
// (0,11.4) @TEXT("VDD",size=1.1,halign="middle",valign="bottom");
// &"VSS" @WIRE(mode="straight",linecolor="#30485d",linewidth=0.16) {#XDR:5 (0,-11)};
// (0,-11.4) @TEXT("VSS",size=1.1,halign="middle",valign="top");
// &"VDD" @WIRE(mode="straight",linecolor="#30485d",linewidth=0.16) {#XCLR:3 (0,-23)};
// (0,-22.6) @TEXT("VDD",size=1.1,halign="middle",valign="bottom");
// &"VSS" @WIRE(mode="straight",linecolor="#30485d",linewidth=0.16) {#XCLR:4 (0,-43)};
// (0,-43.4) @TEXT("VSS",size=1.1,halign="middle",valign="top");
// &"CK" @WIRE(mode="straight",linecolor="#30485d",linewidth=0.16) {#XREG:2 (-10,-66)};
// (-10.4,-66) @TEXT("CK",size=1.1,halign="end",valign="middle");
// &"Q" @WIRE(mode="straight",linecolor="#30485d",linewidth=0.16) {#XREG:4 (10,-66)};
// (10.4,-66) @TEXT("Q",size=1.1,halign="start",valign="middle");
// &"VDD" @WIRE(mode="straight",linecolor="#30485d",linewidth=0.16) {#XREG:5 (0,-56)};
// (0,-55.6) @TEXT("VDD",size=1.1,halign="middle",valign="bottom");
// &"VSS" @WIRE(mode="straight",linecolor="#30485d",linewidth=0.16) {#XREG:6 (0,-76)};
// (0,-76.4) @TEXT("VSS",size=1.1,halign="middle",valign="top");
// }
// END SARADC RNL
ends sar8_se_store

subckt sar8_se_ctrl CMP_CLK CODE0 CODE1 CODE2 CODE3 CODE4 CODE5 CODE6 CODE7 COMP_N COMP_P D0 D1 D2 D3 D4 D5 D6 D7 COMMIT SAMPLE VDD VSS ACTIVE
XTIM (ACTIVE SAMPLE SEL9 SEL7 SEL6 SEL5 SEL4 COMP_P COMP_N CMP_CLK COMMIT DATA VDD VSS) sar8_se_timing
XWORD (CODE0 CODE1 CODE2 CODE3 CODE4 CODE5 CODE6 CODE7 DATA DONE D0 D1 D2 D3 D4 D5 D6 D7 NEXT0 NEXT1 NEXT2 NEXT3 NEXT4 NEXT5 NEXT6 NEXT7 TRIAL6 TRIAL5 TRIAL4 TRIAL3 TRIAL2 VDD VSS) sar8_next_word
// Sticky tap selects: the commit of bit k sets the select for bit k-1 until the
// next accepted sample. Each feeds only the window multiplexers.
// The OR is INV+INV+ND2: a trial glitch while the select is already set must not lift a
// floating PMOS stack node above the rail (FF-cold terminal-voltage screen).
XSEL9_QB (SEL9 SEL9_QB VDD VSS) INVD1BWP12T30P140
XSEL9_TB (TRIAL6 SEL9_TB VDD VSS) INVD1BWP12T30P140
XSEL9_D (SEL9_QB SEL9_TB SEL9_D VDD VSS) ND2D1BWP12T30P140
XSEL9 (COMMIT SEL9_D SAMPLE VDD VSS SEL9) sar8_se_store
XSEL7_QB (SEL7 SEL7_QB VDD VSS) INVD1BWP12T30P140
XSEL7_TB (TRIAL5 SEL7_TB VDD VSS) INVD1BWP12T30P140
XSEL7_D (SEL7_QB SEL7_TB SEL7_D VDD VSS) ND2D1BWP12T30P140
XSEL7 (COMMIT SEL7_D SAMPLE VDD VSS SEL7) sar8_se_store
XSEL6_QB (SEL6 SEL6_QB VDD VSS) INVD1BWP12T30P140
XSEL6_TB (TRIAL4 SEL6_TB VDD VSS) INVD1BWP12T30P140
XSEL6_D (SEL6_QB SEL6_TB SEL6_D VDD VSS) ND2D1BWP12T30P140
XSEL6 (COMMIT SEL6_D SAMPLE VDD VSS SEL6) sar8_se_store
XSEL5_QB (SEL5 SEL5_QB VDD VSS) INVD1BWP12T30P140
XSEL5_TB (TRIAL3 SEL5_TB VDD VSS) INVD1BWP12T30P140
XSEL5_D (SEL5_QB SEL5_TB SEL5_D VDD VSS) ND2D1BWP12T30P140
XSEL5 (COMMIT SEL5_D SAMPLE VDD VSS SEL5) sar8_se_store
XSEL4_QB (SEL4 SEL4_QB VDD VSS) INVD1BWP12T30P140
XSEL4_TB (TRIAL2 SEL4_TB VDD VSS) INVD1BWP12T30P140
XSEL4_D (SEL4_QB SEL4_TB SEL4_D VDD VSS) ND2D1BWP12T30P140
XSEL4 (COMMIT SEL4_D SAMPLE VDD VSS SEL4) sar8_se_store
XDONE (COMMIT CODE0 SAMPLE VDD VSS DONE) sar8_se_store
XACTIVE (DONE ACTIVE VDD VSS) INVD1BWP12T30P140
XBIT0 (COMMIT NEXT0 SAMPLE VDD VSS CODE0) sar8_se_store
XBIT1 (COMMIT NEXT1 SAMPLE VDD VSS CODE1) sar8_se_store
XBIT2 (COMMIT NEXT2 SAMPLE VDD VSS CODE2) sar8_se_store
XBIT3 (COMMIT NEXT3 SAMPLE VDD VSS CODE3) sar8_se_store
XBIT4 (COMMIT NEXT4 SAMPLE VDD VSS CODE4) sar8_se_store
XBIT5 (COMMIT NEXT5 SAMPLE VDD VSS CODE5) sar8_se_store
XBIT6 (COMMIT NEXT6 SAMPLE VDD VSS CODE6) sar8_se_store
XMSBD (NEXT7 MSBD VDD VSS) INVD1BWP12T30P140
XBIT7 (COMMIT MSBD SAMPLE VDD VSS MSBQ) sar8_se_store
XMSBQ (MSBQ CODE7 VDD VSS) INVD1BWP12T30P140
// BEGIN SARADC RNL
// @RNL(author="saradc topology") {
// #XTIM @SET-SYMBOL $S_sar8_se_timing;
// #XTIM @PLACE(0,0) => @ORIENT("R0");
// #XWORD @SET-SYMBOL $S_sar8_next_word;
// #XWORD @PLACE(0,-33) => @ORIENT("R0");
// #XSEL9_QB @SET-SYMBOL $S_INVD1BWP12T30P140;
// #XSEL9_QB @PLACE(0,-66) => @ORIENT("R0");
// #XSEL9_TB @SET-SYMBOL $S_INVD1BWP12T30P140;
// #XSEL9_TB @PLACE(0,-99) => @ORIENT("R0");
// #XSEL9_D @SET-SYMBOL $S_ND2D1BWP12T30P140;
// #XSEL9_D @PLACE(0,-132) => @ORIENT("R0");
// #XSEL9 @SET-SYMBOL $S_sar8_se_store;
// #XSEL9 @PLACE(0,-165) => @ORIENT("R0");
// #XSEL7_QB @SET-SYMBOL $S_INVD1BWP12T30P140;
// #XSEL7_QB @PLACE(0,-198) => @ORIENT("R0");
// #XSEL7_TB @SET-SYMBOL $S_INVD1BWP12T30P140;
// #XSEL7_TB @PLACE(0,-231) => @ORIENT("R0");
// #XSEL7_D @SET-SYMBOL $S_ND2D1BWP12T30P140;
// #XSEL7_D @PLACE(0,-264) => @ORIENT("R0");
// #XSEL7 @SET-SYMBOL $S_sar8_se_store;
// #XSEL7 @PLACE(0,-297) => @ORIENT("R0");
// #XSEL6_QB @SET-SYMBOL $S_INVD1BWP12T30P140;
// #XSEL6_QB @PLACE(0,-330) => @ORIENT("R0");
// #XSEL6_TB @SET-SYMBOL $S_INVD1BWP12T30P140;
// #XSEL6_TB @PLACE(0,-363) => @ORIENT("R0");
// #XSEL6_D @SET-SYMBOL $S_ND2D1BWP12T30P140;
// #XSEL6_D @PLACE(55,0) => @ORIENT("R0");
// #XSEL6 @SET-SYMBOL $S_sar8_se_store;
// #XSEL6 @PLACE(55,-33) => @ORIENT("R0");
// #XSEL5_QB @SET-SYMBOL $S_INVD1BWP12T30P140;
// #XSEL5_QB @PLACE(55,-66) => @ORIENT("R0");
// #XSEL5_TB @SET-SYMBOL $S_INVD1BWP12T30P140;
// #XSEL5_TB @PLACE(55,-99) => @ORIENT("R0");
// #XSEL5_D @SET-SYMBOL $S_ND2D1BWP12T30P140;
// #XSEL5_D @PLACE(55,-132) => @ORIENT("R0");
// #XSEL5 @SET-SYMBOL $S_sar8_se_store;
// #XSEL5 @PLACE(55,-165) => @ORIENT("R0");
// #XSEL4_QB @SET-SYMBOL $S_INVD1BWP12T30P140;
// #XSEL4_QB @PLACE(55,-198) => @ORIENT("R0");
// #XSEL4_TB @SET-SYMBOL $S_INVD1BWP12T30P140;
// #XSEL4_TB @PLACE(55,-231) => @ORIENT("R0");
// #XSEL4_D @SET-SYMBOL $S_ND2D1BWP12T30P140;
// #XSEL4_D @PLACE(55,-264) => @ORIENT("R0");
// #XSEL4 @SET-SYMBOL $S_sar8_se_store;
// #XSEL4 @PLACE(55,-297) => @ORIENT("R0");
// #XDONE @SET-SYMBOL $S_sar8_se_store;
// #XDONE @PLACE(55,-330) => @ORIENT("R0");
// #XACTIVE @SET-SYMBOL $S_INVD1BWP12T30P140;
// #XACTIVE @PLACE(55,-363) => @ORIENT("R0");
// #XBIT0 @SET-SYMBOL $S_sar8_se_store;
// #XBIT0 @PLACE(110,0) => @ORIENT("R0");
// #XBIT1 @SET-SYMBOL $S_sar8_se_store;
// #XBIT1 @PLACE(110,-33) => @ORIENT("R0");
// #XBIT2 @SET-SYMBOL $S_sar8_se_store;
// #XBIT2 @PLACE(110,-66) => @ORIENT("R0");
// #XBIT3 @SET-SYMBOL $S_sar8_se_store;
// #XBIT3 @PLACE(110,-99) => @ORIENT("R0");
// #XBIT4 @SET-SYMBOL $S_sar8_se_store;
// #XBIT4 @PLACE(110,-132) => @ORIENT("R0");
// #XBIT5 @SET-SYMBOL $S_sar8_se_store;
// #XBIT5 @PLACE(110,-165) => @ORIENT("R0");
// #XBIT6 @SET-SYMBOL $S_sar8_se_store;
// #XBIT6 @PLACE(110,-198) => @ORIENT("R0");
// #XMSBD @SET-SYMBOL $S_INVD1BWP12T30P140;
// #XMSBD @PLACE(110,-231) => @ORIENT("R0");
// #XBIT7 @SET-SYMBOL $S_sar8_se_store;
// #XBIT7 @PLACE(110,-264) => @ORIENT("R0");
// #XMSBQ @SET-SYMBOL $S_INVD1BWP12T30P140;
// #XMSBQ @PLACE(110,-297) => @ORIENT("R0");
// &"DATA" @WIRE(mode="straight",linecolor="#30485d",linewidth=0.16) {#XTIM:12 (13,-4.95) (13,-11.55) #XWORD:9};
// &"NEXT0" @WIRE(mode="straight",linecolor="#30485d",linewidth=0.16) {#XWORD:19 (68,-18.15) (68,1.65) #XBIT0:2};
// &"NEXT1" @WIRE(mode="straight",linecolor="#30485d",linewidth=0.16) {#XWORD:20 (68,-21.45) (68,-31.35) #XBIT1:2};
// &"NEXT2" @WIRE(mode="straight",linecolor="#30485d",linewidth=0.16) {#XWORD:21 (68,-24.75) (68,-64.35) #XBIT2:2};
// &"NEXT3" @WIRE(mode="straight",linecolor="#30485d",linewidth=0.16) {#XWORD:22 (68,-28.05) (68,-97.35) #XBIT3:2};
// &"NEXT4" @WIRE(mode="straight",linecolor="#30485d",linewidth=0.16) {#XWORD:23 (68,-31.35) (68,-130.35) #XBIT4:2};
// &"TRIAL6" @WIRE(mode="straight",linecolor="#30485d",linewidth=0.16) {#XWORD:27 (3,-44.55) (3,-99) #XSEL9_TB:1};
// &"TRIAL3" @WIRE(mode="straight",linecolor="#30485d",linewidth=0.16) {#XWORD:30 (30.5,-54.45) (30.5,-99) #XSEL5_TB:1};
// &"SEL9_QB" @WIRE(mode="straight",linecolor="#30485d",linewidth=0.16) {#XSEL9_QB:2 (0,-66) (0,-130.3) #XSEL9_D:1};
// &"SEL9_TB" @WIRE(mode="straight",linecolor="#30485d",linewidth=0.16) {#XSEL9_TB:2 (0,-99) (0,-133.7) #XSEL9_D:2};
// &"SEL9_D" @WIRE(mode="straight",linecolor="#30485d",linewidth=0.16) {#XSEL9_D:3 (10,-132) (10,-163.35) #XSEL9:2};
// &"SEL7_QB" @WIRE(mode="straight",linecolor="#30485d",linewidth=0.16) {#XSEL7_QB:2 (0,-198) (0,-262.3) #XSEL7_D:1};
// &"SEL7_TB" @WIRE(mode="straight",linecolor="#30485d",linewidth=0.16) {#XSEL7_TB:2 (0,-231) (0,-265.7) #XSEL7_D:2};
// &"SEL7_D" @WIRE(mode="straight",linecolor="#30485d",linewidth=0.16) {#XSEL7_D:3 (10,-264) (10,-295.35) #XSEL7:2};
// &"SEL6_D" @WIRE(mode="straight",linecolor="#30485d",linewidth=0.16) {#XSEL6_D:3 (65,0) (65,-31.35) #XSEL6:2};
// &"SEL5_QB" @WIRE(mode="straight",linecolor="#30485d",linewidth=0.16) {#XSEL5_QB:2 (55,-66) (55,-130.3) #XSEL5_D:1};
// &"SEL5_TB" @WIRE(mode="straight",linecolor="#30485d",linewidth=0.16) {#XSEL5_TB:2 (55,-99) (55,-133.7) #XSEL5_D:2};
// &"SEL5_D" @WIRE(mode="straight",linecolor="#30485d",linewidth=0.16) {#XSEL5_D:3 (65,-132) (65,-163.35) #XSEL5:2};
// &"SEL4_QB" @WIRE(mode="straight",linecolor="#30485d",linewidth=0.16) {#XSEL4_QB:2 (55,-198) (55,-262.3) #XSEL4_D:1};
// &"SEL4_TB" @WIRE(mode="straight",linecolor="#30485d",linewidth=0.16) {#XSEL4_TB:2 (55,-231) (55,-265.7) #XSEL4_D:2};
// &"SEL4_D" @WIRE(mode="straight",linecolor="#30485d",linewidth=0.16) {#XSEL4_D:3 (65,-264) (65,-295.35) #XSEL4:2};
// &"MSBD" @WIRE(mode="straight",linecolor="#30485d",linewidth=0.16) {#XMSBD:2 (120,-231) (120,-262.35) #XBIT7:2};
// &"MSBQ" @WIRE(mode="straight",linecolor="#30485d",linewidth=0.16) {#XBIT7:6 (113,-265.65) (113,-297) #XMSBQ:1};
// (-89,30) @TEXT("sar8_se_ctrl / source-derived connections",size=1.4,halign="start",textcolor="#223d52");
// &"ACTIVE" @WIRE(mode="straight",linecolor="#30485d",linewidth=0.16) {#XTIM:1 (16,4.95)};
// (16.4,4.95) @TEXT("ACTIVE",size=1.1,halign="start",valign="middle");
// &"SAMPLE" @WIRE(mode="straight",linecolor="#30485d",linewidth=0.16) {#XTIM:2 (-16,11.55)};
// (-16.4,11.55) @TEXT("SAMPLE",size=1.1,halign="end",valign="middle");
// &"SEL9" @WIRE(mode="straight",linecolor="#30485d",linewidth=0.16) {#XTIM:3 (-16,8.25)};
// (-16.4,8.25) @TEXT("SEL9",size=1.1,halign="end",valign="middle");
// &"SEL7" @WIRE(mode="straight",linecolor="#30485d",linewidth=0.16) {#XTIM:4 (-16,4.95)};
// (-16.4,4.95) @TEXT("SEL7",size=1.1,halign="end",valign="middle");
// &"SEL6" @WIRE(mode="straight",linecolor="#30485d",linewidth=0.16) {#XTIM:5 (-16,1.65)};
// (-16.4,1.65) @TEXT("SEL6",size=1.1,halign="end",valign="middle");
// &"SEL5" @WIRE(mode="straight",linecolor="#30485d",linewidth=0.16) {#XTIM:6 (-16,-1.65)};
// (-16.4,-1.65) @TEXT("SEL5",size=1.1,halign="end",valign="middle");
// &"SEL4" @WIRE(mode="straight",linecolor="#30485d",linewidth=0.16) {#XTIM:7 (-16,-4.95)};
// (-16.4,-4.95) @TEXT("SEL4",size=1.1,halign="end",valign="middle");
// &"COMP_P" @WIRE(mode="straight",linecolor="#30485d",linewidth=0.16) {#XTIM:8 (-16,-8.25)};
// (-16.4,-8.25) @TEXT("COMP_P",size=1.1,halign="end",valign="middle");
// &"COMP_N" @WIRE(mode="straight",linecolor="#30485d",linewidth=0.16) {#XTIM:9 (-16,-11.55)};
// (-16.4,-11.55) @TEXT("COMP_N",size=1.1,halign="end",valign="middle");
// &"CMP_CLK" @WIRE(mode="straight",linecolor="#30485d",linewidth=0.16) {#XTIM:10 (16,1.65)};
// (16.4,1.65) @TEXT("CMP_CLK",size=1.1,halign="start",valign="middle");
// &"COMMIT" @WIRE(mode="straight",linecolor="#30485d",linewidth=0.16) {#XTIM:11 (16,-1.65)};
// (16.4,-1.65) @TEXT("COMMIT",size=1.1,halign="start",valign="middle");
// &"VDD" @WIRE(mode="straight",linecolor="#30485d",linewidth=0.16) {#XTIM:13 (0,19.85)};
// (0,20.25) @TEXT("VDD",size=1.1,halign="middle",valign="bottom");
// &"VSS" @WIRE(mode="straight",linecolor="#30485d",linewidth=0.16) {#XTIM:14 (0,-19.85)};
// (0,-20.25) @TEXT("VSS",size=1.1,halign="middle",valign="top");
// {&"CODE0" &"CODE1" &"CODE2" &"CODE3" &"CODE4" &"CODE5" &"CODE6" &"CODE7"} @WIRE(mode="straight",linewidth=0.3) {#XWORD:1 (16,-8.25)};
// (16.4,-8.25) @TEXT("CODE[7:0]",size=1.1,halign="start",valign="middle");
// &"DONE" @WIRE(mode="straight",linecolor="#30485d",linewidth=0.16) {#XWORD:10 (-16,-33)};
// (-16.4,-33) @TEXT("DONE",size=1.1,halign="end",valign="middle");
// {&"D0" &"D1" &"D2" &"D3" &"D4" &"D5" &"D6" &"D7"} @WIRE(mode="straight",linewidth=0.3) {#XWORD:11 (16,-14.85)};
// (16.4,-14.85) @TEXT("D[7:0]",size=1.1,halign="start",valign="middle");
// &"NEXT5" @WIRE(mode="straight",linecolor="#30485d",linewidth=0.16) {#XWORD:24 (16,-34.65)};
// (16.4,-34.65) @TEXT("NEXT5",size=1.1,halign="start",valign="middle");
// &"NEXT6" @WIRE(mode="straight",linecolor="#30485d",linewidth=0.16) {#XWORD:25 (16,-37.95)};
// (16.4,-37.95) @TEXT("NEXT6",size=1.1,halign="start",valign="middle");
// &"NEXT7" @WIRE(mode="straight",linecolor="#30485d",linewidth=0.16) {#XWORD:26 (16,-41.25)};
// (16.4,-41.25) @TEXT("NEXT7",size=1.1,halign="start",valign="middle");
// &"TRIAL5" @WIRE(mode="straight",linecolor="#30485d",linewidth=0.16) {#XWORD:28 (16,-47.85)};
// (16.4,-47.85) @TEXT("TRIAL5",size=1.1,halign="start",valign="middle");
// &"TRIAL4" @WIRE(mode="straight",linecolor="#30485d",linewidth=0.16) {#XWORD:29 (16,-51.15)};
// (16.4,-51.15) @TEXT("TRIAL4",size=1.1,halign="start",valign="middle");
// &"TRIAL2" @WIRE(mode="straight",linecolor="#30485d",linewidth=0.16) {#XWORD:31 (16,-57.75)};
// (16.4,-57.75) @TEXT("TRIAL2",size=1.1,halign="start",valign="middle");
// &"VDD" @WIRE(mode="straight",linecolor="#30485d",linewidth=0.16) {#XWORD:32 (0,0.05)};
// (0,0.45) @TEXT("VDD",size=1.1,halign="middle",valign="bottom");
// &"VSS" @WIRE(mode="straight",linecolor="#30485d",linewidth=0.16) {#XWORD:33 (0,-66.05)};
// (0,-66.45) @TEXT("VSS",size=1.1,halign="middle",valign="top");
// &"SEL9" @WIRE(mode="straight",linecolor="#30485d",linewidth=0.16) {#XSEL9_QB:1 (-10,-66)};
// (-10.4,-66) @TEXT("SEL9",size=1.1,halign="end",valign="middle");
// &"VDD" @WIRE(mode="straight",linecolor="#30485d",linewidth=0.16) {#XSEL9_QB:3 (0,-56)};
// (0,-55.6) @TEXT("VDD",size=1.1,halign="middle",valign="bottom");
// &"VSS" @WIRE(mode="straight",linecolor="#30485d",linewidth=0.16) {#XSEL9_QB:4 (0,-76)};
// (0,-76.4) @TEXT("VSS",size=1.1,halign="middle",valign="top");
// &"VDD" @WIRE(mode="straight",linecolor="#30485d",linewidth=0.16) {#XSEL9_TB:3 (0,-89)};
// (0,-88.6) @TEXT("VDD",size=1.1,halign="middle",valign="bottom");
// &"VSS" @WIRE(mode="straight",linecolor="#30485d",linewidth=0.16) {#XSEL9_TB:4 (0,-109)};
// (0,-109.4) @TEXT("VSS",size=1.1,halign="middle",valign="top");
// &"VDD" @WIRE(mode="straight",linecolor="#30485d",linewidth=0.16) {#XSEL9_D:4 (0,-122)};
// (0,-121.6) @TEXT("VDD",size=1.1,halign="middle",valign="bottom");
// &"VSS" @WIRE(mode="straight",linecolor="#30485d",linewidth=0.16) {#XSEL9_D:5 (0,-142)};
// (0,-142.4) @TEXT("VSS",size=1.1,halign="middle",valign="top");
// &"COMMIT" @WIRE(mode="straight",linecolor="#30485d",linewidth=0.16) {#XSEL9:1 (-16,-163.35)};
// (-16.4,-163.35) @TEXT("COMMIT",size=1.1,halign="end",valign="middle");
// &"SAMPLE" @WIRE(mode="straight",linecolor="#30485d",linewidth=0.16) {#XSEL9:3 (-16,-166.65)};
// (-16.4,-166.65) @TEXT("SAMPLE",size=1.1,halign="end",valign="middle");
// &"VDD" @WIRE(mode="straight",linecolor="#30485d",linewidth=0.16) {#XSEL9:4 (0,-154)};
// (0,-153.6) @TEXT("VDD",size=1.1,halign="middle",valign="bottom");
// &"VSS" @WIRE(mode="straight",linecolor="#30485d",linewidth=0.16) {#XSEL9:5 (0,-176)};
// (0,-176.4) @TEXT("VSS",size=1.1,halign="middle",valign="top");
// &"SEL9" @WIRE(mode="straight",linecolor="#30485d",linewidth=0.16) {#XSEL9:6 (16,-166.65)};
// (16.4,-166.65) @TEXT("SEL9",size=1.1,halign="start",valign="middle");
// &"SEL7" @WIRE(mode="straight",linecolor="#30485d",linewidth=0.16) {#XSEL7_QB:1 (-10,-198)};
// (-10.4,-198) @TEXT("SEL7",size=1.1,halign="end",valign="middle");
// &"VDD" @WIRE(mode="straight",linecolor="#30485d",linewidth=0.16) {#XSEL7_QB:3 (0,-188)};
// (0,-187.6) @TEXT("VDD",size=1.1,halign="middle",valign="bottom");
// &"VSS" @WIRE(mode="straight",linecolor="#30485d",linewidth=0.16) {#XSEL7_QB:4 (0,-208)};
// (0,-208.4) @TEXT("VSS",size=1.1,halign="middle",valign="top");
// &"TRIAL5" @WIRE(mode="straight",linecolor="#30485d",linewidth=0.16) {#XSEL7_TB:1 (-10,-231)};
// (-10.4,-231) @TEXT("TRIAL5",size=1.1,halign="end",valign="middle");
// &"VDD" @WIRE(mode="straight",linecolor="#30485d",linewidth=0.16) {#XSEL7_TB:3 (0,-221)};
// (0,-220.6) @TEXT("VDD",size=1.1,halign="middle",valign="bottom");
// &"VSS" @WIRE(mode="straight",linecolor="#30485d",linewidth=0.16) {#XSEL7_TB:4 (0,-241)};
// (0,-241.4) @TEXT("VSS",size=1.1,halign="middle",valign="top");
// &"VDD" @WIRE(mode="straight",linecolor="#30485d",linewidth=0.16) {#XSEL7_D:4 (0,-254)};
// (0,-253.6) @TEXT("VDD",size=1.1,halign="middle",valign="bottom");
// &"VSS" @WIRE(mode="straight",linecolor="#30485d",linewidth=0.16) {#XSEL7_D:5 (0,-274)};
// (0,-274.4) @TEXT("VSS",size=1.1,halign="middle",valign="top");
// &"COMMIT" @WIRE(mode="straight",linecolor="#30485d",linewidth=0.16) {#XSEL7:1 (-16,-295.35)};
// (-16.4,-295.35) @TEXT("COMMIT",size=1.1,halign="end",valign="middle");
// &"SAMPLE" @WIRE(mode="straight",linecolor="#30485d",linewidth=0.16) {#XSEL7:3 (-16,-298.65)};
// (-16.4,-298.65) @TEXT("SAMPLE",size=1.1,halign="end",valign="middle");
// &"VDD" @WIRE(mode="straight",linecolor="#30485d",linewidth=0.16) {#XSEL7:4 (0,-286)};
// (0,-285.6) @TEXT("VDD",size=1.1,halign="middle",valign="bottom");
// &"VSS" @WIRE(mode="straight",linecolor="#30485d",linewidth=0.16) {#XSEL7:5 (0,-308)};
// (0,-308.4) @TEXT("VSS",size=1.1,halign="middle",valign="top");
// &"SEL7" @WIRE(mode="straight",linecolor="#30485d",linewidth=0.16) {#XSEL7:6 (16,-298.65)};
// (16.4,-298.65) @TEXT("SEL7",size=1.1,halign="start",valign="middle");
// &"SEL6" @WIRE(mode="straight",linecolor="#30485d",linewidth=0.16) {#XSEL6_QB:1 (-10,-330)};
// (-10.4,-330) @TEXT("SEL6",size=1.1,halign="end",valign="middle");
// &"SEL6_QB" @WIRE(mode="straight",linecolor="#30485d",linewidth=0.16) {#XSEL6_QB:2 (10,-330)};
// (10.4,-330) @TEXT("SEL6_QB",size=1.1,halign="start",valign="middle");
// &"VDD" @WIRE(mode="straight",linecolor="#30485d",linewidth=0.16) {#XSEL6_QB:3 (0,-320)};
// (0,-319.6) @TEXT("VDD",size=1.1,halign="middle",valign="bottom");
// &"VSS" @WIRE(mode="straight",linecolor="#30485d",linewidth=0.16) {#XSEL6_QB:4 (0,-340)};
// (0,-340.4) @TEXT("VSS",size=1.1,halign="middle",valign="top");
// &"TRIAL4" @WIRE(mode="straight",linecolor="#30485d",linewidth=0.16) {#XSEL6_TB:1 (-10,-363)};
// (-10.4,-363) @TEXT("TRIAL4",size=1.1,halign="end",valign="middle");
// &"SEL6_TB" @WIRE(mode="straight",linecolor="#30485d",linewidth=0.16) {#XSEL6_TB:2 (10,-363)};
// (10.4,-363) @TEXT("SEL6_TB",size=1.1,halign="start",valign="middle");
// &"VDD" @WIRE(mode="straight",linecolor="#30485d",linewidth=0.16) {#XSEL6_TB:3 (0,-353)};
// (0,-352.6) @TEXT("VDD",size=1.1,halign="middle",valign="bottom");
// &"VSS" @WIRE(mode="straight",linecolor="#30485d",linewidth=0.16) {#XSEL6_TB:4 (0,-373)};
// (0,-373.4) @TEXT("VSS",size=1.1,halign="middle",valign="top");
// &"SEL6_QB" @WIRE(mode="straight",linecolor="#30485d",linewidth=0.16) {#XSEL6_D:1 (45,1.7)};
// (44.6,1.7) @TEXT("SEL6_QB",size=1.1,halign="end",valign="middle");
// &"SEL6_TB" @WIRE(mode="straight",linecolor="#30485d",linewidth=0.16) {#XSEL6_D:2 (45,-1.7)};
// (44.6,-1.7) @TEXT("SEL6_TB",size=1.1,halign="end",valign="middle");
// &"VDD" @WIRE(mode="straight",linecolor="#30485d",linewidth=0.16) {#XSEL6_D:4 (55,10)};
// (55,10.4) @TEXT("VDD",size=1.1,halign="middle",valign="bottom");
// &"VSS" @WIRE(mode="straight",linecolor="#30485d",linewidth=0.16) {#XSEL6_D:5 (55,-10)};
// (55,-10.4) @TEXT("VSS",size=1.1,halign="middle",valign="top");
// &"COMMIT" @WIRE(mode="straight",linecolor="#30485d",linewidth=0.16) {#XSEL6:1 (39,-31.35)};
// (38.6,-31.35) @TEXT("COMMIT",size=1.1,halign="end",valign="middle");
// &"SAMPLE" @WIRE(mode="straight",linecolor="#30485d",linewidth=0.16) {#XSEL6:3 (39,-34.65)};
// (38.6,-34.65) @TEXT("SAMPLE",size=1.1,halign="end",valign="middle");
// &"VDD" @WIRE(mode="straight",linecolor="#30485d",linewidth=0.16) {#XSEL6:4 (55,-22)};
// (55,-21.6) @TEXT("VDD",size=1.1,halign="middle",valign="bottom");
// &"VSS" @WIRE(mode="straight",linecolor="#30485d",linewidth=0.16) {#XSEL6:5 (55,-44)};
// (55,-44.4) @TEXT("VSS",size=1.1,halign="middle",valign="top");
// &"SEL6" @WIRE(mode="straight",linecolor="#30485d",linewidth=0.16) {#XSEL6:6 (71,-34.65)};
// (71.4,-34.65) @TEXT("SEL6",size=1.1,halign="start",valign="middle");
// &"SEL5" @WIRE(mode="straight",linecolor="#30485d",linewidth=0.16) {#XSEL5_QB:1 (45,-66)};
// (44.6,-66) @TEXT("SEL5",size=1.1,halign="end",valign="middle");
// &"VDD" @WIRE(mode="straight",linecolor="#30485d",linewidth=0.16) {#XSEL5_QB:3 (55,-56)};
// (55,-55.6) @TEXT("VDD",size=1.1,halign="middle",valign="bottom");
// &"VSS" @WIRE(mode="straight",linecolor="#30485d",linewidth=0.16) {#XSEL5_QB:4 (55,-76)};
// (55,-76.4) @TEXT("VSS",size=1.1,halign="middle",valign="top");
// &"VDD" @WIRE(mode="straight",linecolor="#30485d",linewidth=0.16) {#XSEL5_TB:3 (55,-89)};
// (55,-88.6) @TEXT("VDD",size=1.1,halign="middle",valign="bottom");
// &"VSS" @WIRE(mode="straight",linecolor="#30485d",linewidth=0.16) {#XSEL5_TB:4 (55,-109)};
// (55,-109.4) @TEXT("VSS",size=1.1,halign="middle",valign="top");
// &"VDD" @WIRE(mode="straight",linecolor="#30485d",linewidth=0.16) {#XSEL5_D:4 (55,-122)};
// (55,-121.6) @TEXT("VDD",size=1.1,halign="middle",valign="bottom");
// &"VSS" @WIRE(mode="straight",linecolor="#30485d",linewidth=0.16) {#XSEL5_D:5 (55,-142)};
// (55,-142.4) @TEXT("VSS",size=1.1,halign="middle",valign="top");
// &"COMMIT" @WIRE(mode="straight",linecolor="#30485d",linewidth=0.16) {#XSEL5:1 (39,-163.35)};
// (38.6,-163.35) @TEXT("COMMIT",size=1.1,halign="end",valign="middle");
// &"SAMPLE" @WIRE(mode="straight",linecolor="#30485d",linewidth=0.16) {#XSEL5:3 (39,-166.65)};
// (38.6,-166.65) @TEXT("SAMPLE",size=1.1,halign="end",valign="middle");
// &"VDD" @WIRE(mode="straight",linecolor="#30485d",linewidth=0.16) {#XSEL5:4 (55,-154)};
// (55,-153.6) @TEXT("VDD",size=1.1,halign="middle",valign="bottom");
// &"VSS" @WIRE(mode="straight",linecolor="#30485d",linewidth=0.16) {#XSEL5:5 (55,-176)};
// (55,-176.4) @TEXT("VSS",size=1.1,halign="middle",valign="top");
// &"SEL5" @WIRE(mode="straight",linecolor="#30485d",linewidth=0.16) {#XSEL5:6 (71,-166.65)};
// (71.4,-166.65) @TEXT("SEL5",size=1.1,halign="start",valign="middle");
// &"SEL4" @WIRE(mode="straight",linecolor="#30485d",linewidth=0.16) {#XSEL4_QB:1 (45,-198)};
// (44.6,-198) @TEXT("SEL4",size=1.1,halign="end",valign="middle");
// &"VDD" @WIRE(mode="straight",linecolor="#30485d",linewidth=0.16) {#XSEL4_QB:3 (55,-188)};
// (55,-187.6) @TEXT("VDD",size=1.1,halign="middle",valign="bottom");
// &"VSS" @WIRE(mode="straight",linecolor="#30485d",linewidth=0.16) {#XSEL4_QB:4 (55,-208)};
// (55,-208.4) @TEXT("VSS",size=1.1,halign="middle",valign="top");
// &"TRIAL2" @WIRE(mode="straight",linecolor="#30485d",linewidth=0.16) {#XSEL4_TB:1 (45,-231)};
// (44.6,-231) @TEXT("TRIAL2",size=1.1,halign="end",valign="middle");
// &"VDD" @WIRE(mode="straight",linecolor="#30485d",linewidth=0.16) {#XSEL4_TB:3 (55,-221)};
// (55,-220.6) @TEXT("VDD",size=1.1,halign="middle",valign="bottom");
// &"VSS" @WIRE(mode="straight",linecolor="#30485d",linewidth=0.16) {#XSEL4_TB:4 (55,-241)};
// (55,-241.4) @TEXT("VSS",size=1.1,halign="middle",valign="top");
// &"VDD" @WIRE(mode="straight",linecolor="#30485d",linewidth=0.16) {#XSEL4_D:4 (55,-254)};
// (55,-253.6) @TEXT("VDD",size=1.1,halign="middle",valign="bottom");
// &"VSS" @WIRE(mode="straight",linecolor="#30485d",linewidth=0.16) {#XSEL4_D:5 (55,-274)};
// (55,-274.4) @TEXT("VSS",size=1.1,halign="middle",valign="top");
// &"COMMIT" @WIRE(mode="straight",linecolor="#30485d",linewidth=0.16) {#XSEL4:1 (39,-295.35)};
// (38.6,-295.35) @TEXT("COMMIT",size=1.1,halign="end",valign="middle");
// &"SAMPLE" @WIRE(mode="straight",linecolor="#30485d",linewidth=0.16) {#XSEL4:3 (39,-298.65)};
// (38.6,-298.65) @TEXT("SAMPLE",size=1.1,halign="end",valign="middle");
// &"VDD" @WIRE(mode="straight",linecolor="#30485d",linewidth=0.16) {#XSEL4:4 (55,-286)};
// (55,-285.6) @TEXT("VDD",size=1.1,halign="middle",valign="bottom");
// &"VSS" @WIRE(mode="straight",linecolor="#30485d",linewidth=0.16) {#XSEL4:5 (55,-308)};
// (55,-308.4) @TEXT("VSS",size=1.1,halign="middle",valign="top");
// &"SEL4" @WIRE(mode="straight",linecolor="#30485d",linewidth=0.16) {#XSEL4:6 (71,-298.65)};
// (71.4,-298.65) @TEXT("SEL4",size=1.1,halign="start",valign="middle");
// &"COMMIT" @WIRE(mode="straight",linecolor="#30485d",linewidth=0.16) {#XDONE:1 (39,-328.35)};
// (38.6,-328.35) @TEXT("COMMIT",size=1.1,halign="end",valign="middle");
// &"CODE0" @WIRE(mode="straight",linecolor="#30485d",linewidth=0.16) {#XDONE:2 (71,-328.35)};
// (71.4,-328.35) @TEXT("CODE0",size=1.1,halign="start",valign="middle");
// &"SAMPLE" @WIRE(mode="straight",linecolor="#30485d",linewidth=0.16) {#XDONE:3 (39,-331.65)};
// (38.6,-331.65) @TEXT("SAMPLE",size=1.1,halign="end",valign="middle");
// &"VDD" @WIRE(mode="straight",linecolor="#30485d",linewidth=0.16) {#XDONE:4 (55,-319)};
// (55,-318.6) @TEXT("VDD",size=1.1,halign="middle",valign="bottom");
// &"VSS" @WIRE(mode="straight",linecolor="#30485d",linewidth=0.16) {#XDONE:5 (55,-341)};
// (55,-341.4) @TEXT("VSS",size=1.1,halign="middle",valign="top");
// &"DONE" @WIRE(mode="straight",linecolor="#30485d",linewidth=0.16) {#XDONE:6 (71,-331.65)};
// (71.4,-331.65) @TEXT("DONE",size=1.1,halign="start",valign="middle");
// &"DONE" @WIRE(mode="straight",linecolor="#30485d",linewidth=0.16) {#XACTIVE:1 (45,-363)};
// (44.6,-363) @TEXT("DONE",size=1.1,halign="end",valign="middle");
// &"ACTIVE" @WIRE(mode="straight",linecolor="#30485d",linewidth=0.16) {#XACTIVE:2 (65,-363)};
// (65.4,-363) @TEXT("ACTIVE",size=1.1,halign="start",valign="middle");
// &"VDD" @WIRE(mode="straight",linecolor="#30485d",linewidth=0.16) {#XACTIVE:3 (55,-353)};
// (55,-352.6) @TEXT("VDD",size=1.1,halign="middle",valign="bottom");
// &"VSS" @WIRE(mode="straight",linecolor="#30485d",linewidth=0.16) {#XACTIVE:4 (55,-373)};
// (55,-373.4) @TEXT("VSS",size=1.1,halign="middle",valign="top");
// &"COMMIT" @WIRE(mode="straight",linecolor="#30485d",linewidth=0.16) {#XBIT0:1 (94,1.65)};
// (93.6,1.65) @TEXT("COMMIT",size=1.1,halign="end",valign="middle");
// &"SAMPLE" @WIRE(mode="straight",linecolor="#30485d",linewidth=0.16) {#XBIT0:3 (94,-1.65)};
// (93.6,-1.65) @TEXT("SAMPLE",size=1.1,halign="end",valign="middle");
// &"VDD" @WIRE(mode="straight",linecolor="#30485d",linewidth=0.16) {#XBIT0:4 (110,11)};
// (110,11.4) @TEXT("VDD",size=1.1,halign="middle",valign="bottom");
// &"VSS" @WIRE(mode="straight",linecolor="#30485d",linewidth=0.16) {#XBIT0:5 (110,-11)};
// (110,-11.4) @TEXT("VSS",size=1.1,halign="middle",valign="top");
// &"CODE0" @WIRE(mode="straight",linecolor="#30485d",linewidth=0.16) {#XBIT0:6 (126,-1.65)};
// (126.4,-1.65) @TEXT("CODE0",size=1.1,halign="start",valign="middle");
// &"COMMIT" @WIRE(mode="straight",linecolor="#30485d",linewidth=0.16) {#XBIT1:1 (94,-31.35)};
// (93.6,-31.35) @TEXT("COMMIT",size=1.1,halign="end",valign="middle");
// &"SAMPLE" @WIRE(mode="straight",linecolor="#30485d",linewidth=0.16) {#XBIT1:3 (94,-34.65)};
// (93.6,-34.65) @TEXT("SAMPLE",size=1.1,halign="end",valign="middle");
// &"VDD" @WIRE(mode="straight",linecolor="#30485d",linewidth=0.16) {#XBIT1:4 (110,-22)};
// (110,-21.6) @TEXT("VDD",size=1.1,halign="middle",valign="bottom");
// &"VSS" @WIRE(mode="straight",linecolor="#30485d",linewidth=0.16) {#XBIT1:5 (110,-44)};
// (110,-44.4) @TEXT("VSS",size=1.1,halign="middle",valign="top");
// &"CODE1" @WIRE(mode="straight",linecolor="#30485d",linewidth=0.16) {#XBIT1:6 (126,-34.65)};
// (126.4,-34.65) @TEXT("CODE1",size=1.1,halign="start",valign="middle");
// &"COMMIT" @WIRE(mode="straight",linecolor="#30485d",linewidth=0.16) {#XBIT2:1 (94,-64.35)};
// (93.6,-64.35) @TEXT("COMMIT",size=1.1,halign="end",valign="middle");
// &"SAMPLE" @WIRE(mode="straight",linecolor="#30485d",linewidth=0.16) {#XBIT2:3 (94,-67.65)};
// (93.6,-67.65) @TEXT("SAMPLE",size=1.1,halign="end",valign="middle");
// &"VDD" @WIRE(mode="straight",linecolor="#30485d",linewidth=0.16) {#XBIT2:4 (110,-55)};
// (110,-54.6) @TEXT("VDD",size=1.1,halign="middle",valign="bottom");
// &"VSS" @WIRE(mode="straight",linecolor="#30485d",linewidth=0.16) {#XBIT2:5 (110,-77)};
// (110,-77.4) @TEXT("VSS",size=1.1,halign="middle",valign="top");
// &"CODE2" @WIRE(mode="straight",linecolor="#30485d",linewidth=0.16) {#XBIT2:6 (126,-67.65)};
// (126.4,-67.65) @TEXT("CODE2",size=1.1,halign="start",valign="middle");
// &"COMMIT" @WIRE(mode="straight",linecolor="#30485d",linewidth=0.16) {#XBIT3:1 (94,-97.35)};
// (93.6,-97.35) @TEXT("COMMIT",size=1.1,halign="end",valign="middle");
// &"SAMPLE" @WIRE(mode="straight",linecolor="#30485d",linewidth=0.16) {#XBIT3:3 (94,-100.65)};
// (93.6,-100.65) @TEXT("SAMPLE",size=1.1,halign="end",valign="middle");
// &"VDD" @WIRE(mode="straight",linecolor="#30485d",linewidth=0.16) {#XBIT3:4 (110,-88)};
// (110,-87.6) @TEXT("VDD",size=1.1,halign="middle",valign="bottom");
// &"VSS" @WIRE(mode="straight",linecolor="#30485d",linewidth=0.16) {#XBIT3:5 (110,-110)};
// (110,-110.4) @TEXT("VSS",size=1.1,halign="middle",valign="top");
// &"CODE3" @WIRE(mode="straight",linecolor="#30485d",linewidth=0.16) {#XBIT3:6 (126,-100.65)};
// (126.4,-100.65) @TEXT("CODE3",size=1.1,halign="start",valign="middle");
// &"COMMIT" @WIRE(mode="straight",linecolor="#30485d",linewidth=0.16) {#XBIT4:1 (94,-130.35)};
// (93.6,-130.35) @TEXT("COMMIT",size=1.1,halign="end",valign="middle");
// &"SAMPLE" @WIRE(mode="straight",linecolor="#30485d",linewidth=0.16) {#XBIT4:3 (94,-133.65)};
// (93.6,-133.65) @TEXT("SAMPLE",size=1.1,halign="end",valign="middle");
// &"VDD" @WIRE(mode="straight",linecolor="#30485d",linewidth=0.16) {#XBIT4:4 (110,-121)};
// (110,-120.6) @TEXT("VDD",size=1.1,halign="middle",valign="bottom");
// &"VSS" @WIRE(mode="straight",linecolor="#30485d",linewidth=0.16) {#XBIT4:5 (110,-143)};
// (110,-143.4) @TEXT("VSS",size=1.1,halign="middle",valign="top");
// &"CODE4" @WIRE(mode="straight",linecolor="#30485d",linewidth=0.16) {#XBIT4:6 (126,-133.65)};
// (126.4,-133.65) @TEXT("CODE4",size=1.1,halign="start",valign="middle");
// &"COMMIT" @WIRE(mode="straight",linecolor="#30485d",linewidth=0.16) {#XBIT5:1 (94,-163.35)};
// (93.6,-163.35) @TEXT("COMMIT",size=1.1,halign="end",valign="middle");
// &"NEXT5" @WIRE(mode="straight",linecolor="#30485d",linewidth=0.16) {#XBIT5:2 (126,-163.35)};
// (126.4,-163.35) @TEXT("NEXT5",size=1.1,halign="start",valign="middle");
// &"SAMPLE" @WIRE(mode="straight",linecolor="#30485d",linewidth=0.16) {#XBIT5:3 (94,-166.65)};
// (93.6,-166.65) @TEXT("SAMPLE",size=1.1,halign="end",valign="middle");
// &"VDD" @WIRE(mode="straight",linecolor="#30485d",linewidth=0.16) {#XBIT5:4 (110,-154)};
// (110,-153.6) @TEXT("VDD",size=1.1,halign="middle",valign="bottom");
// &"VSS" @WIRE(mode="straight",linecolor="#30485d",linewidth=0.16) {#XBIT5:5 (110,-176)};
// (110,-176.4) @TEXT("VSS",size=1.1,halign="middle",valign="top");
// &"CODE5" @WIRE(mode="straight",linecolor="#30485d",linewidth=0.16) {#XBIT5:6 (126,-166.65)};
// (126.4,-166.65) @TEXT("CODE5",size=1.1,halign="start",valign="middle");
// &"COMMIT" @WIRE(mode="straight",linecolor="#30485d",linewidth=0.16) {#XBIT6:1 (94,-196.35)};
// (93.6,-196.35) @TEXT("COMMIT",size=1.1,halign="end",valign="middle");
// &"NEXT6" @WIRE(mode="straight",linecolor="#30485d",linewidth=0.16) {#XBIT6:2 (126,-196.35)};
// (126.4,-196.35) @TEXT("NEXT6",size=1.1,halign="start",valign="middle");
// &"SAMPLE" @WIRE(mode="straight",linecolor="#30485d",linewidth=0.16) {#XBIT6:3 (94,-199.65)};
// (93.6,-199.65) @TEXT("SAMPLE",size=1.1,halign="end",valign="middle");
// &"VDD" @WIRE(mode="straight",linecolor="#30485d",linewidth=0.16) {#XBIT6:4 (110,-187)};
// (110,-186.6) @TEXT("VDD",size=1.1,halign="middle",valign="bottom");
// &"VSS" @WIRE(mode="straight",linecolor="#30485d",linewidth=0.16) {#XBIT6:5 (110,-209)};
// (110,-209.4) @TEXT("VSS",size=1.1,halign="middle",valign="top");
// &"CODE6" @WIRE(mode="straight",linecolor="#30485d",linewidth=0.16) {#XBIT6:6 (126,-199.65)};
// (126.4,-199.65) @TEXT("CODE6",size=1.1,halign="start",valign="middle");
// &"NEXT7" @WIRE(mode="straight",linecolor="#30485d",linewidth=0.16) {#XMSBD:1 (100,-231)};
// (99.6,-231) @TEXT("NEXT7",size=1.1,halign="end",valign="middle");
// &"VDD" @WIRE(mode="straight",linecolor="#30485d",linewidth=0.16) {#XMSBD:3 (110,-221)};
// (110,-220.6) @TEXT("VDD",size=1.1,halign="middle",valign="bottom");
// &"VSS" @WIRE(mode="straight",linecolor="#30485d",linewidth=0.16) {#XMSBD:4 (110,-241)};
// (110,-241.4) @TEXT("VSS",size=1.1,halign="middle",valign="top");
// &"COMMIT" @WIRE(mode="straight",linecolor="#30485d",linewidth=0.16) {#XBIT7:1 (94,-262.35)};
// (93.6,-262.35) @TEXT("COMMIT",size=1.1,halign="end",valign="middle");
// &"SAMPLE" @WIRE(mode="straight",linecolor="#30485d",linewidth=0.16) {#XBIT7:3 (94,-265.65)};
// (93.6,-265.65) @TEXT("SAMPLE",size=1.1,halign="end",valign="middle");
// &"VDD" @WIRE(mode="straight",linecolor="#30485d",linewidth=0.16) {#XBIT7:4 (110,-253)};
// (110,-252.6) @TEXT("VDD",size=1.1,halign="middle",valign="bottom");
// &"VSS" @WIRE(mode="straight",linecolor="#30485d",linewidth=0.16) {#XBIT7:5 (110,-275)};
// (110,-275.4) @TEXT("VSS",size=1.1,halign="middle",valign="top");
// &"CODE7" @WIRE(mode="straight",linecolor="#30485d",linewidth=0.16) {#XMSBQ:2 (120,-297)};
// (120.4,-297) @TEXT("CODE7",size=1.1,halign="start",valign="middle");
// &"VDD" @WIRE(mode="straight",linecolor="#30485d",linewidth=0.16) {#XMSBQ:3 (110,-287)};
// (110,-286.6) @TEXT("VDD",size=1.1,halign="middle",valign="bottom");
// &"VSS" @WIRE(mode="straight",linecolor="#30485d",linewidth=0.16) {#XMSBQ:4 (110,-307)};
// (110,-307.4) @TEXT("VSS",size=1.1,halign="middle",valign="top");
// }
// END SARADC RNL
ends sar8_se_ctrl

subckt sar8_se_acquire REQUEST VDD VSS TRACK
XDEL (REQUEST TAP VDD VSS) DEL200D1BWP12T30P140
XQUAL (REQUEST TAP ACCEPTED VDD VSS) AN2D1BWP12T30P140
XOUT (ACCEPTED TRACK VDD VSS) CKBD1BWP12T30P140
// BEGIN SARADC RNL
// @RNL(author="saradc topology") {
// #XDEL @SET-SYMBOL $S_DEL200D1BWP12T30P140;
// #XDEL @PLACE(0,0) => @ORIENT("R0");
// #XQUAL @SET-SYMBOL $S_AN2D1BWP12T30P140;
// #XQUAL @PLACE(0,-33) => @ORIENT("R0");
// #XOUT @SET-SYMBOL $S_CKBD1BWP12T30P140;
// #XOUT @PLACE(0,-66) => @ORIENT("R0");
// &"REQUEST" @WIRE(mode="straight",linecolor="#30485d",linewidth=0.16) {#XDEL:1 (-13,0) (-13,-31.35) #XQUAL:1};
// &"TAP" @WIRE(mode="straight",linecolor="#30485d",linewidth=0.16) {#XDEL:2 (0,0) (0,-34.65) #XQUAL:2};
// &"ACCEPTED" @WIRE(mode="straight",linecolor="#30485d",linewidth=0.16) {#XQUAL:3 (0,-33) (0,-66) #XOUT:1};
// (-89,30) @TEXT("sar8_se_acquire / source-derived connections",size=1.4,halign="start",textcolor="#223d52");
// &"VDD" @WIRE(mode="straight",linecolor="#30485d",linewidth=0.16) {#XDEL:3 (0,11)};
// (0,11.4) @TEXT("VDD",size=1.1,halign="middle",valign="bottom");
// &"VSS" @WIRE(mode="straight",linecolor="#30485d",linewidth=0.16) {#XDEL:4 (0,-11)};
// (0,-11.4) @TEXT("VSS",size=1.1,halign="middle",valign="top");
// &"VDD" @WIRE(mode="straight",linecolor="#30485d",linewidth=0.16) {#XQUAL:4 (0,-22)};
// (0,-21.6) @TEXT("VDD",size=1.1,halign="middle",valign="bottom");
// &"VSS" @WIRE(mode="straight",linecolor="#30485d",linewidth=0.16) {#XQUAL:5 (0,-44)};
// (0,-44.4) @TEXT("VSS",size=1.1,halign="middle",valign="top");
// &"TRACK" @WIRE(mode="straight",linecolor="#30485d",linewidth=0.16) {#XOUT:2 (16,-66)};
// (16.4,-66) @TEXT("TRACK",size=1.1,halign="start",valign="middle");
// &"VDD" @WIRE(mode="straight",linecolor="#30485d",linewidth=0.16) {#XOUT:3 (0,-55)};
// (0,-54.6) @TEXT("VDD",size=1.1,halign="middle",valign="bottom");
// &"VSS" @WIRE(mode="straight",linecolor="#30485d",linewidth=0.16) {#XOUT:4 (0,-77)};
// (0,-77.4) @TEXT("VSS",size=1.1,halign="middle",valign="top");
// }
// END SARADC RNL
ends sar8_se_acquire
