// Single-edge SAR. All logic and delay devices are native standard cells.
subckt sar8_next_word CODE0 CODE1 CODE2 CODE3 CODE4 CODE5 CODE6 CODE7 DATA DONE D0 D1 D2 D3 D4 D5 D6 D7 NEXT0 NEXT1 NEXT2 NEXT3 NEXT4 NEXT5 NEXT6 NEXT7 TRIAL5 VDD VSS
// Prefix ORs identify the current trial and are evaluated before DATA arrives.
X01 (CODE0 CODE1 ANY01 VDD VSS) OR2D1BWP12T30P140
X23 (CODE2 CODE3 ANY23 VDD VSS) OR2D1BWP12T30P140
X45 (CODE4 CODE5 ANY45 VDD VSS) OR2D1BWP12T30P140
X02 (ANY01 CODE2 ANY02 VDD VSS) OR2D1BWP12T30P140
X03 (ANY01 ANY23 ANY03 VDD VSS) OR2D1BWP12T30P140
X04 (ANY03 CODE4 LOW_BITS VDD VSS) OR2D1BWP12T30P140
X05 (ANY03 ANY45 ANY05 VDD VSS) OR2D1BWP12T30P140
X06 (ANY05 CODE6 ANY06 VDD VSS) OR2D1BWP12T30P140
XREAD0 (CODE0 DONE D0 VDD VSS) AN2D1BWP12T30P140
XEMPTY1 (CODE0 EMPTY1 VDD VSS) INVD1BWP12T30P140
XTRIAL1 (EMPTY1 CODE1 TRIAL1 VDD VSS) AN2D1BWP12T30P140
XVISIBLE1 (CODE0 DONE VISIBLE1 VDD VSS) OR2D1BWP12T30P140
XREAD1 (CODE1 VISIBLE1 D1 VDD VSS) AN2D1BWP12T30P140
XEMPTY2 (ANY01 EMPTY2 VDD VSS) INVD1BWP12T30P140
XTRIAL2 (EMPTY2 CODE2 TRIAL2 VDD VSS) AN2D1BWP12T30P140
XVISIBLE2 (ANY01 DONE VISIBLE2 VDD VSS) OR2D1BWP12T30P140
XREAD2 (CODE2 VISIBLE2 D2 VDD VSS) AN2D1BWP12T30P140
XEMPTY3 (ANY02 EMPTY3 VDD VSS) INVD1BWP12T30P140
XTRIAL3 (EMPTY3 CODE3 TRIAL3 VDD VSS) AN2D1BWP12T30P140
XVISIBLE3 (ANY02 DONE VISIBLE3 VDD VSS) OR2D1BWP12T30P140
XREAD3 (CODE3 VISIBLE3 D3 VDD VSS) AN2D1BWP12T30P140
XEMPTY4 (ANY03 EMPTY4 VDD VSS) INVD1BWP12T30P140
XTRIAL4 (EMPTY4 CODE4 TRIAL4 VDD VSS) AN2D1BWP12T30P140
XVISIBLE4 (ANY03 DONE VISIBLE4 VDD VSS) OR2D1BWP12T30P140
XREAD4 (CODE4 VISIBLE4 D4 VDD VSS) AN2D1BWP12T30P140
XEMPTY5 (LOW_BITS EMPTY5 VDD VSS) INVD1BWP12T30P140
XTRIAL5 (EMPTY5 CODE5 TRIAL5 VDD VSS) AN2D1BWP12T30P140
XVISIBLE5 (LOW_BITS DONE VISIBLE5 VDD VSS) OR2D1BWP12T30P140
XREAD5 (CODE5 VISIBLE5 D5 VDD VSS) AN2D1BWP12T30P140
XEMPTY6 (ANY05 EMPTY6 VDD VSS) INVD1BWP12T30P140
XTRIAL6 (EMPTY6 CODE6 TRIAL6 VDD VSS) AN2D1BWP12T30P140
XVISIBLE6 (ANY05 DONE VISIBLE6 VDD VSS) OR2D1BWP12T30P140
XREAD6 (CODE6 VISIBLE6 D6 VDD VSS) AN2D1BWP12T30P140
XEMPTY7 (ANY06 EMPTY7 VDD VSS) INVD1BWP12T30P140
XTRIAL7 (EMPTY7 CODE7 TRIAL7 VDD VSS) AN2D1BWP12T30P140
XVISIBLE7 (ANY06 DONE VISIBLE7 VDD VSS) OR2D1BWP12T30P140
XREAD7 (CODE7 VISIBLE7 D7 VDD VSS) AN2D1BWP12T30P140
XBASE0 (D0 TRIAL1 BASE0 VDD VSS) OR2D1BWP12T30P140
XKEEP0 (CODE0 DATA KEEP0 VDD VSS) AN2D1BWP12T30P140
XNEXT0 (BASE0 KEEP0 NEXT0 VDD VSS) OR2D1BWP12T30P140
XBASE1 (D1 TRIAL2 BASE1 VDD VSS) OR2D1BWP12T30P140
XKEEP1 (TRIAL1 DATA KEEP1 VDD VSS) AN2D1BWP12T30P140
XNEXT1 (BASE1 KEEP1 NEXT1 VDD VSS) OR2D1BWP12T30P140
XBASE2 (D2 TRIAL3 BASE2 VDD VSS) OR2D1BWP12T30P140
XKEEP2 (TRIAL2 DATA KEEP2 VDD VSS) AN2D1BWP12T30P140
XNEXT2 (BASE2 KEEP2 NEXT2 VDD VSS) OR2D1BWP12T30P140
XBASE3 (D3 TRIAL4 BASE3 VDD VSS) OR2D1BWP12T30P140
XKEEP3 (TRIAL3 DATA KEEP3 VDD VSS) AN2D1BWP12T30P140
XNEXT3 (BASE3 KEEP3 NEXT3 VDD VSS) OR2D1BWP12T30P140
XBASE4 (D4 TRIAL5 BASE4 VDD VSS) OR2D1BWP12T30P140
XKEEP4 (TRIAL4 DATA KEEP4 VDD VSS) AN2D1BWP12T30P140
XNEXT4 (BASE4 KEEP4 NEXT4 VDD VSS) OR2D1BWP12T30P140
XBASE5 (D5 TRIAL6 BASE5 VDD VSS) OR2D1BWP12T30P140
XKEEP5 (TRIAL5 DATA KEEP5 VDD VSS) AN2D1BWP12T30P140
XNEXT5 (BASE5 KEEP5 NEXT5 VDD VSS) OR2D1BWP12T30P140
XBASE6 (D6 TRIAL7 BASE6 VDD VSS) OR2D1BWP12T30P140
XKEEP6 (TRIAL6 DATA KEEP6 VDD VSS) AN2D1BWP12T30P140
XNEXT6 (BASE6 KEEP6 NEXT6 VDD VSS) OR2D1BWP12T30P140
XKEEP7 (TRIAL7 DATA KEEP7 VDD VSS) AN2D1BWP12T30P140
XNEXT7 (D7 KEEP7 NEXT7 VDD VSS) OR2D1BWP12T30P140
ends sar8_next_word

subckt sar8_se_window PHASE_REQUEST LOW_Q VDD VSS DELIVERED
// A transition propagates once per decision. Both polarities traverse real DEL cells.
XDEL1 (PHASE_REQUEST T1 VDD VSS) DEL250D1BWP12T30P140
XDEL2 (T1 T2 VDD VSS) DEL250D1BWP12T30P140
XDEL3 (T2 T3 VDD VSS) DEL250D1BWP12T30P140
XDEL4 (T3 T4 VDD VSS) DEL250D1BWP12T30P140
XDEL5 (T4 T5 VDD VSS) DEL250D1BWP12T30P140
XDEL6 (T5 T6 VDD VSS) DEL250D1BWP12T30P140
XDEL7 (T6 T7 VDD VSS) DEL250D1BWP12T30P140
XDEL8 (T7 T8 VDD VSS) DEL250D1BWP12T30P140
XDEL9 (T8 T9 VDD VSS) DEL250D1BWP12T30P140
XTAP (T9 T6 LOW_Q DELIVERED VDD VSS) MUX2D1BWP12T30P140
ends sar8_se_window

subckt sar8_se_timing ACTIVE SAMPLE LOW_Q COMP_P COMP_N CMP_CLK COMMIT DATA VDD VSS
XPR (COMP_P PR VDD VSS) BUFFD1BWP12T30P140
XNR (COMP_N NR VDD VSS) BUFFD1BWP12T30P140
XNRB (NR NRB VDD VSS) INVD1BWP12T30P140
XDATA (PR NRB DATA VDD VSS) AN2D1BWP12T30P140
XRAW (PR NR RAW VDD VSS) XOR2D1BWP12T30P140
XVD (RAW RAW_T VDD VSS) DEL200D1BWP12T30P140
XVALID (RAW RAW_T VALID VDD VSS) AN2D1BWP12T30P140
XSN (SAMPLE SN VDD VSS) INVD1BWP12T30P140
XW0 (CMP_CLK VALID WD VDD VSS) AN2D1BWP12T30P140
XW1 (WD SN WRITE VDD VSS) AN2D1BWP12T30P140
XCP (WRITE COMMIT VDD VSS) CKBD1BWP12T30P140
// During tracking PHASE and PHASE_REQUEST settle to zero. Closing the sample
// launches the first transition. Each real commit launches the opposite one.
XPHASE (COMMIT PHASE_B SAMPLE VDD VSS PHASE) sar8_se_store
XPHB (PHASE PHASE_B VDD VSS) INVD1BWP12T30P140
XLAUNCH (SN PHASE_B PHASE_REQUEST VDD VSS) AN2D1BWP12T30P140
XWINDOW (PHASE_REQUEST LOW_Q VDD VSS DELIVERED) sar8_se_window
XREADY (PHASE DELIVERED READY VDD VSS) XOR2D1BWP12T30P140
// Reset on the committed phase change; only the delayed edge can release reset.
XCLR (READY SN CLR_N VDD VSS) AN2D1BWP12T30P140
XLIVE (ACTIVE SN LIVE VDD VSS) AN2D1BWP12T30P140
XIDLE (RAW CLEARED VDD VSS) INVD1BWP12T30P140
XSET0 (LIVE CLEARED SET0 VDD VSS) AN2D1BWP12T30P140
XSET (SET0 READY SET VDD VSS) AN2D1BWP12T30P140
XHIGH (HIGH VDD VSS) TIEHBWP12T30P140
XCLOCK (HIGH SET CLR_N Q VDD VSS) LHCNDQD1BWP12T30P140
XCMP (Q CMP_CLK VDD VSS) CKBD1BWP12T30P140
ends sar8_se_timing

subckt sar8_se_store CK DATA RESET VDD VSS Q
XDR (DATA RESET DIN VDD VSS) OR2D1BWP12T30P140
XCLR (RESET RST_N VDD VSS) INVD1BWP12T30P140
XREG (DIN CK RST_N Q VDD VSS) DFCNQD1BWP12T30P140
ends sar8_se_store

subckt sar8_se_ctrl CMP_CLK CODE0 CODE1 CODE2 CODE3 CODE4 CODE5 CODE6 CODE7 COMP_N COMP_P D0 D1 D2 D3 D4 D5 D6 D7 COMMIT SAMPLE VDD VSS ACTIVE
XTIM (ACTIVE SAMPLE LOW_Q COMP_P COMP_N CMP_CLK COMMIT DATA VDD VSS) sar8_se_timing
XWORD (CODE0 CODE1 CODE2 CODE3 CODE4 CODE5 CODE6 CODE7 DATA DONE D0 D1 D2 D3 D4 D5 D6 D7 NEXT0 NEXT1 NEXT2 NEXT3 NEXT4 NEXT5 NEXT6 NEXT7 TRIAL5 VDD VSS) sar8_next_word
// The bit-5 commit selects the short tap until the next accepted sample.
XLOW_D (LOW_Q TRIAL5 LOW_D VDD VSS) OR2D1BWP12T30P140
XLOW (COMMIT LOW_D SAMPLE VDD VSS LOW_Q) sar8_se_store
XDONE (COMMIT CODE0 SAMPLE VDD VSS DONE) sar8_se_store
XACTIVE (DONE ACTIVE VDD VSS) INVD1BWP12T30P140
XBIT0 (COMMIT NEXT0 SAMPLE VDD VSS CODE0) sar8_se_store
XBIT1 (COMMIT NEXT1 SAMPLE VDD VSS CODE1) sar8_se_store
XBIT2 (COMMIT NEXT2 SAMPLE VDD VSS CODE2) sar8_se_store
XBIT3 (COMMIT NEXT3 SAMPLE VDD VSS CODE3) sar8_se_store
XBIT4 (COMMIT NEXT4 SAMPLE VDD VSS CODE4) sar8_se_store
XBIT5 (COMMIT NEXT5 SAMPLE VDD VSS CODE5) sar8_se_store
XBIT6 (COMMIT NEXT6 SAMPLE VDD VSS CODE6) sar8_se_store
XMSBD (NEXT7 MSBD VDD VSS) INVD1BWP12T30P140
XBIT7 (COMMIT MSBD SAMPLE VDD VSS MSBQ) sar8_se_store
XMSBQ (MSBQ CODE7 VDD VSS) INVD1BWP12T30P140
ends sar8_se_ctrl

subckt sar8_se_acquire REQUEST VDD VSS TRACK
XDEL (REQUEST TAP VDD VSS) DEL200D1BWP12T30P140
XQUAL (REQUEST TAP ACCEPTED VDD VSS) AN2D1BWP12T30P140
XOUT (ACCEPTED TRACK VDD VSS) CKBD1BWP12T30P140
ends sar8_se_acquire
