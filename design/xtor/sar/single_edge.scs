// Single-edge SAR. All logic and delay devices are native standard cells.
// BEGIN SARADC RNL
// @RNL(type="header") { @VERSION("0.3");
// @USE-PACKAGE(name="sar8",version="0.1",path="../../rnl/sar8.rnl");
// @USE-PACKAGE(name="rnl-std-fill") {}; }
// END SARADC RNL
subckt sar8_next_word CODE0 CODE1 CODE2 CODE3 CODE4 CODE5 CODE6 CODE7 DATA DONE D0 D1 D2 D3 D4 D5 D6 D7 NEXT0 NEXT1 NEXT2 NEXT3 NEXT4 NEXT5 NEXT6 NEXT7 TRIAL6 TRIAL5 TRIAL4 TRIAL3 TRIAL2 VDD VSS
// Prefix ORs identify the current trial and are evaluated before DATA arrives.
X01 (CODE0 CODE1 ANY01 VDD VSS) OR2D1BWP12T30P140
X23 (CODE2 CODE3 ANY23 VDD VSS) OR2D1BWP12T30P140
X45 (CODE4 CODE5 ANY45 VDD VSS) OR2D1BWP12T30P140
X02 (ANY01 CODE2 ANY02 VDD VSS) OR2D1BWP12T30P140
X03 (ANY01 ANY23 ANY03 VDD VSS) OR2D1BWP12T30P140
X04 (ANY03 CODE4 LOW_BITS VDD VSS) OR2D1BWP12T30P140
X05 (ANY03 ANY45 ANY05 VDD VSS) OR2D1BWP12T30P140
X06 (ANY05 CODE6 ANY06 VDD VSS) OR2D1BWP12T30P140
XREAD0 (CODE0 DONE D0 VDD VSS) AN2D1BWP12T30P140
XEMPTY1 (CODE0 EMPTY1 VDD VSS) INVD1BWP12T30P140
XTRIAL1 (EMPTY1 CODE1 TRIAL1 VDD VSS) AN2D1BWP12T30P140
XVISIBLE1 (CODE0 DONE VISIBLE1 VDD VSS) OR2D1BWP12T30P140
XREAD1 (CODE1 VISIBLE1 D1 VDD VSS) AN2D1BWP12T30P140
XEMPTY2 (ANY01 EMPTY2 VDD VSS) INVD1BWP12T30P140
XTRIAL2 (EMPTY2 CODE2 TRIAL2 VDD VSS) AN2D1BWP12T30P140
XVISIBLE2 (ANY01 DONE VISIBLE2 VDD VSS) OR2D1BWP12T30P140
XREAD2 (CODE2 VISIBLE2 D2 VDD VSS) AN2D1BWP12T30P140
XEMPTY3 (ANY02 EMPTY3 VDD VSS) INVD1BWP12T30P140
XTRIAL3 (EMPTY3 CODE3 TRIAL3 VDD VSS) AN2D1BWP12T30P140
XVISIBLE3 (ANY02 DONE VISIBLE3 VDD VSS) OR2D1BWP12T30P140
XREAD3 (CODE3 VISIBLE3 D3 VDD VSS) AN2D1BWP12T30P140
XEMPTY4 (ANY03 EMPTY4 VDD VSS) INVD1BWP12T30P140
XTRIAL4 (EMPTY4 CODE4 TRIAL4 VDD VSS) AN2D1BWP12T30P140
XVISIBLE4 (ANY03 DONE VISIBLE4 VDD VSS) OR2D1BWP12T30P140
XREAD4 (CODE4 VISIBLE4 D4 VDD VSS) AN2D1BWP12T30P140
XEMPTY5 (LOW_BITS EMPTY5 VDD VSS) INVD1BWP12T30P140
XTRIAL5 (EMPTY5 CODE5 TRIAL5 VDD VSS) AN2D1BWP12T30P140
XVISIBLE5 (LOW_BITS DONE VISIBLE5 VDD VSS) OR2D1BWP12T30P140
XREAD5 (CODE5 VISIBLE5 D5 VDD VSS) AN2D1BWP12T30P140
XEMPTY6 (ANY05 EMPTY6 VDD VSS) INVD1BWP12T30P140
XTRIAL6 (EMPTY6 CODE6 TRIAL6 VDD VSS) AN2D1BWP12T30P140
XVISIBLE6 (ANY05 DONE VISIBLE6 VDD VSS) OR2D1BWP12T30P140
XREAD6 (CODE6 VISIBLE6 D6 VDD VSS) AN2D1BWP12T30P140
XEMPTY7 (ANY06 EMPTY7 VDD VSS) INVD1BWP12T30P140
XTRIAL7 (EMPTY7 CODE7 TRIAL7 VDD VSS) AN2D1BWP12T30P140
XVISIBLE7 (ANY06 DONE VISIBLE7 VDD VSS) OR2D1BWP12T30P140
XREAD7 (CODE7 VISIBLE7 D7 VDD VSS) AN2D1BWP12T30P140
XBASE0 (D0 TRIAL1 BASE0 VDD VSS) OR2D1BWP12T30P140
XKEEP0 (CODE0 DATA KEEP0 VDD VSS) AN2D1BWP12T30P140
XNEXT0 (BASE0 KEEP0 NEXT0 VDD VSS) OR2D1BWP12T30P140
XBASE1 (D1 TRIAL2 BASE1 VDD VSS) OR2D1BWP12T30P140
XKEEP1 (TRIAL1 DATA KEEP1 VDD VSS) AN2D1BWP12T30P140
XNEXT1 (BASE1 KEEP1 NEXT1 VDD VSS) OR2D1BWP12T30P140
XBASE2 (D2 TRIAL3 BASE2 VDD VSS) OR2D1BWP12T30P140
XKEEP2 (TRIAL2 DATA KEEP2 VDD VSS) AN2D1BWP12T30P140
XNEXT2 (BASE2 KEEP2 NEXT2 VDD VSS) OR2D1BWP12T30P140
XBASE3 (D3 TRIAL4 BASE3 VDD VSS) OR2D1BWP12T30P140
XKEEP3 (TRIAL3 DATA KEEP3 VDD VSS) AN2D1BWP12T30P140
XNEXT3 (BASE3 KEEP3 NEXT3 VDD VSS) OR2D1BWP12T30P140
XBASE4 (D4 TRIAL5 BASE4 VDD VSS) OR2D1BWP12T30P140
XKEEP4 (TRIAL4 DATA KEEP4 VDD VSS) AN2D1BWP12T30P140
XNEXT4 (BASE4 KEEP4 NEXT4 VDD VSS) OR2D1BWP12T30P140
XBASE5 (D5 TRIAL6 BASE5 VDD VSS) OR2D1BWP12T30P140
XKEEP5 (TRIAL5 DATA KEEP5 VDD VSS) AN2D1BWP12T30P140
XNEXT5 (BASE5 KEEP5 NEXT5 VDD VSS) OR2D1BWP12T30P140
XBASE6 (D6 TRIAL7 BASE6 VDD VSS) OR2D1BWP12T30P140
XKEEP6 (TRIAL6 DATA KEEP6 VDD VSS) AN2D1BWP12T30P140
XNEXT6 (BASE6 KEEP6 NEXT6 VDD VSS) OR2D1BWP12T30P140
XKEEP7 (TRIAL7 DATA KEEP7 VDD VSS) AN2D1BWP12T30P140
XNEXT7 (D7 KEEP7 NEXT7 VDD VSS) OR2D1BWP12T30P140
// BEGIN SARADC RNL
// @RNL(author="saradc topology") {
// (-18,45) @TEXT("Next trial word",size=2,halign="start",textcolor="#223d52");
// #X01 @SET-SYMBOL $S_OR2D1BWP12T30P140;
// #X01 @PLACE(0,22) => @ORIENT("R0");
// #X23 @SET-SYMBOL $S_OR2D1BWP12T30P140;
// #X23 @PLACE(34,22) => @ORIENT("R0");
// #X45 @SET-SYMBOL $S_OR2D1BWP12T30P140;
// #X45 @PLACE(68,22) => @ORIENT("R0");
// #X02 @SET-SYMBOL $S_OR2D1BWP12T30P140;
// #X02 @PLACE(102,22) => @ORIENT("R0");
// #X03 @SET-SYMBOL $S_OR2D1BWP12T30P140;
// #X03 @PLACE(136,22) => @ORIENT("R0");
// #X04 @SET-SYMBOL $S_OR2D1BWP12T30P140;
// #X04 @PLACE(170,22) => @ORIENT("R0");
// #X05 @SET-SYMBOL $S_OR2D1BWP12T30P140;
// #X05 @PLACE(204,22) => @ORIENT("R0");
// #X06 @SET-SYMBOL $S_OR2D1BWP12T30P140;
// #X06 @PLACE(238,22) => @ORIENT("R0");
// (-24,-5) @TEXT("Bit 0",size=1.2,halign="start",textcolor="#223d52");
// #XREAD0 @SET-SYMBOL $S_AN2D1BWP12T30P140;
// #XREAD0 @PLACE(93,-12) => @ORIENT("R0");
// #XBASE0 @SET-SYMBOL $S_OR2D1BWP12T30P140;
// #XBASE0 @PLACE(124,-12) => @ORIENT("R0");
// #XKEEP0 @SET-SYMBOL $S_AN2D1BWP12T30P140;
// #XKEEP0 @PLACE(155,-12) => @ORIENT("R0");
// #XNEXT0 @SET-SYMBOL $S_OR2D1BWP12T30P140;
// #XNEXT0 @PLACE(186,-12) => @ORIENT("R0");
// (-24,-32) @TEXT("Bit 1",size=1.2,halign="start",textcolor="#223d52");
// #XEMPTY1 @SET-SYMBOL $S_INVD1BWP12T30P140;
// #XEMPTY1 @PLACE(0,-39) => @ORIENT("R0");
// #XTRIAL1 @SET-SYMBOL $S_AN2D1BWP12T30P140;
// #XTRIAL1 @PLACE(31,-39) => @ORIENT("R0");
// #XVISIBLE1 @SET-SYMBOL $S_OR2D1BWP12T30P140;
// #XVISIBLE1 @PLACE(62,-39) => @ORIENT("R0");
// #XREAD1 @SET-SYMBOL $S_AN2D1BWP12T30P140;
// #XREAD1 @PLACE(93,-39) => @ORIENT("R0");
// #XBASE1 @SET-SYMBOL $S_OR2D1BWP12T30P140;
// #XBASE1 @PLACE(124,-39) => @ORIENT("R0");
// #XKEEP1 @SET-SYMBOL $S_AN2D1BWP12T30P140;
// #XKEEP1 @PLACE(155,-39) => @ORIENT("R0");
// #XNEXT1 @SET-SYMBOL $S_OR2D1BWP12T30P140;
// #XNEXT1 @PLACE(186,-39) => @ORIENT("R0");
// (-24,-59) @TEXT("Bit 2",size=1.2,halign="start",textcolor="#223d52");
// #XEMPTY2 @SET-SYMBOL $S_INVD1BWP12T30P140;
// #XEMPTY2 @PLACE(0,-66) => @ORIENT("R0");
// #XTRIAL2 @SET-SYMBOL $S_AN2D1BWP12T30P140;
// #XTRIAL2 @PLACE(31,-66) => @ORIENT("R0");
// #XVISIBLE2 @SET-SYMBOL $S_OR2D1BWP12T30P140;
// #XVISIBLE2 @PLACE(62,-66) => @ORIENT("R0");
// #XREAD2 @SET-SYMBOL $S_AN2D1BWP12T30P140;
// #XREAD2 @PLACE(93,-66) => @ORIENT("R0");
// #XBASE2 @SET-SYMBOL $S_OR2D1BWP12T30P140;
// #XBASE2 @PLACE(124,-66) => @ORIENT("R0");
// #XKEEP2 @SET-SYMBOL $S_AN2D1BWP12T30P140;
// #XKEEP2 @PLACE(155,-66) => @ORIENT("R0");
// #XNEXT2 @SET-SYMBOL $S_OR2D1BWP12T30P140;
// #XNEXT2 @PLACE(186,-66) => @ORIENT("R0");
// (-24,-86) @TEXT("Bit 3",size=1.2,halign="start",textcolor="#223d52");
// #XEMPTY3 @SET-SYMBOL $S_INVD1BWP12T30P140;
// #XEMPTY3 @PLACE(0,-93) => @ORIENT("R0");
// #XTRIAL3 @SET-SYMBOL $S_AN2D1BWP12T30P140;
// #XTRIAL3 @PLACE(31,-93) => @ORIENT("R0");
// #XVISIBLE3 @SET-SYMBOL $S_OR2D1BWP12T30P140;
// #XVISIBLE3 @PLACE(62,-93) => @ORIENT("R0");
// #XREAD3 @SET-SYMBOL $S_AN2D1BWP12T30P140;
// #XREAD3 @PLACE(93,-93) => @ORIENT("R0");
// #XBASE3 @SET-SYMBOL $S_OR2D1BWP12T30P140;
// #XBASE3 @PLACE(124,-93) => @ORIENT("R0");
// #XKEEP3 @SET-SYMBOL $S_AN2D1BWP12T30P140;
// #XKEEP3 @PLACE(155,-93) => @ORIENT("R0");
// #XNEXT3 @SET-SYMBOL $S_OR2D1BWP12T30P140;
// #XNEXT3 @PLACE(186,-93) => @ORIENT("R0");
// (-24,-113) @TEXT("Bit 4",size=1.2,halign="start",textcolor="#223d52");
// #XEMPTY4 @SET-SYMBOL $S_INVD1BWP12T30P140;
// #XEMPTY4 @PLACE(0,-120) => @ORIENT("R0");
// #XTRIAL4 @SET-SYMBOL $S_AN2D1BWP12T30P140;
// #XTRIAL4 @PLACE(31,-120) => @ORIENT("R0");
// #XVISIBLE4 @SET-SYMBOL $S_OR2D1BWP12T30P140;
// #XVISIBLE4 @PLACE(62,-120) => @ORIENT("R0");
// #XREAD4 @SET-SYMBOL $S_AN2D1BWP12T30P140;
// #XREAD4 @PLACE(93,-120) => @ORIENT("R0");
// #XBASE4 @SET-SYMBOL $S_OR2D1BWP12T30P140;
// #XBASE4 @PLACE(124,-120) => @ORIENT("R0");
// #XKEEP4 @SET-SYMBOL $S_AN2D1BWP12T30P140;
// #XKEEP4 @PLACE(155,-120) => @ORIENT("R0");
// #XNEXT4 @SET-SYMBOL $S_OR2D1BWP12T30P140;
// #XNEXT4 @PLACE(186,-120) => @ORIENT("R0");
// (-24,-140) @TEXT("Bit 5",size=1.2,halign="start",textcolor="#223d52");
// #XEMPTY5 @SET-SYMBOL $S_INVD1BWP12T30P140;
// #XEMPTY5 @PLACE(0,-147) => @ORIENT("R0");
// #XTRIAL5 @SET-SYMBOL $S_AN2D1BWP12T30P140;
// #XTRIAL5 @PLACE(31,-147) => @ORIENT("R0");
// #XVISIBLE5 @SET-SYMBOL $S_OR2D1BWP12T30P140;
// #XVISIBLE5 @PLACE(62,-147) => @ORIENT("R0");
// #XREAD5 @SET-SYMBOL $S_AN2D1BWP12T30P140;
// #XREAD5 @PLACE(93,-147) => @ORIENT("R0");
// #XBASE5 @SET-SYMBOL $S_OR2D1BWP12T30P140;
// #XBASE5 @PLACE(124,-147) => @ORIENT("R0");
// #XKEEP5 @SET-SYMBOL $S_AN2D1BWP12T30P140;
// #XKEEP5 @PLACE(155,-147) => @ORIENT("R0");
// #XNEXT5 @SET-SYMBOL $S_OR2D1BWP12T30P140;
// #XNEXT5 @PLACE(186,-147) => @ORIENT("R0");
// (-24,-167) @TEXT("Bit 6",size=1.2,halign="start",textcolor="#223d52");
// #XEMPTY6 @SET-SYMBOL $S_INVD1BWP12T30P140;
// #XEMPTY6 @PLACE(0,-174) => @ORIENT("R0");
// #XTRIAL6 @SET-SYMBOL $S_AN2D1BWP12T30P140;
// #XTRIAL6 @PLACE(31,-174) => @ORIENT("R0");
// #XVISIBLE6 @SET-SYMBOL $S_OR2D1BWP12T30P140;
// #XVISIBLE6 @PLACE(62,-174) => @ORIENT("R0");
// #XREAD6 @SET-SYMBOL $S_AN2D1BWP12T30P140;
// #XREAD6 @PLACE(93,-174) => @ORIENT("R0");
// #XBASE6 @SET-SYMBOL $S_OR2D1BWP12T30P140;
// #XBASE6 @PLACE(124,-174) => @ORIENT("R0");
// #XKEEP6 @SET-SYMBOL $S_AN2D1BWP12T30P140;
// #XKEEP6 @PLACE(155,-174) => @ORIENT("R0");
// #XNEXT6 @SET-SYMBOL $S_OR2D1BWP12T30P140;
// #XNEXT6 @PLACE(186,-174) => @ORIENT("R0");
// (-24,-194) @TEXT("Bit 7",size=1.2,halign="start",textcolor="#223d52");
// #XEMPTY7 @SET-SYMBOL $S_INVD1BWP12T30P140;
// #XEMPTY7 @PLACE(0,-201) => @ORIENT("R0");
// #XTRIAL7 @SET-SYMBOL $S_AN2D1BWP12T30P140;
// #XTRIAL7 @PLACE(31,-201) => @ORIENT("R0");
// #XVISIBLE7 @SET-SYMBOL $S_OR2D1BWP12T30P140;
// #XVISIBLE7 @PLACE(62,-201) => @ORIENT("R0");
// #XREAD7 @SET-SYMBOL $S_AN2D1BWP12T30P140;
// #XREAD7 @PLACE(93,-201) => @ORIENT("R0");
// #XKEEP7 @SET-SYMBOL $S_AN2D1BWP12T30P140;
// #XKEEP7 @PLACE(155,-201) => @ORIENT("R0");
// #XNEXT7 @SET-SYMBOL $S_OR2D1BWP12T30P140;
// #XNEXT7 @PLACE(186,-201) => @ORIENT("R0");
// &"D0" @WIRE(mode="straight",linecolor="#30485d",linewidth=0.16) {#XREAD0:3 (111.5,-12) (111.5,-10.3) #XBASE0:1};
// &"EMPTY1" @WIRE(mode="straight",linecolor="#30485d",linewidth=0.16) {#XEMPTY1:2 (12.5,-39) (12.5,-37.35) #XTRIAL1:1};
// &"VISIBLE1" @WIRE(mode="straight",linecolor="#30485d",linewidth=0.16) {#XVISIBLE1:3 (74.5,-39) (74.5,-40.65) #XREAD1:2};
// &"D1" @WIRE(mode="straight",linecolor="#30485d",linewidth=0.16) {#XREAD1:3 (111.5,-39) (111.5,-37.3) #XBASE1:1};
// &"EMPTY2" @WIRE(mode="straight",linecolor="#30485d",linewidth=0.16) {#XEMPTY2:2 (12.5,-66) (12.5,-64.35) #XTRIAL2:1};
// &"VISIBLE2" @WIRE(mode="straight",linecolor="#30485d",linewidth=0.16) {#XVISIBLE2:3 (74.5,-66) (74.5,-67.65) #XREAD2:2};
// &"D2" @WIRE(mode="straight",linecolor="#30485d",linewidth=0.16) {#XREAD2:3 (111.5,-66) (111.5,-64.3) #XBASE2:1};
// &"EMPTY3" @WIRE(mode="straight",linecolor="#30485d",linewidth=0.16) {#XEMPTY3:2 (12.5,-93) (12.5,-91.35) #XTRIAL3:1};
// &"VISIBLE3" @WIRE(mode="straight",linecolor="#30485d",linewidth=0.16) {#XVISIBLE3:3 (74.5,-93) (74.5,-94.65) #XREAD3:2};
// &"D3" @WIRE(mode="straight",linecolor="#30485d",linewidth=0.16) {#XREAD3:3 (111.5,-93) (111.5,-91.3) #XBASE3:1};
// &"EMPTY4" @WIRE(mode="straight",linecolor="#30485d",linewidth=0.16) {#XEMPTY4:2 (12.5,-120) (12.5,-118.35) #XTRIAL4:1};
// &"VISIBLE4" @WIRE(mode="straight",linecolor="#30485d",linewidth=0.16) {#XVISIBLE4:3 (74.5,-120) (74.5,-121.65) #XREAD4:2};
// &"D4" @WIRE(mode="straight",linecolor="#30485d",linewidth=0.16) {#XREAD4:3 (111.5,-120) (111.5,-118.3) #XBASE4:1};
// &"EMPTY5" @WIRE(mode="straight",linecolor="#30485d",linewidth=0.16) {#XEMPTY5:2 (12.5,-147) (12.5,-145.35) #XTRIAL5:1};
// &"VISIBLE5" @WIRE(mode="straight",linecolor="#30485d",linewidth=0.16) {#XVISIBLE5:3 (74.5,-147) (74.5,-148.65) #XREAD5:2};
// &"D5" @WIRE(mode="straight",linecolor="#30485d",linewidth=0.16) {#XREAD5:3 (111.5,-147) (111.5,-145.3) #XBASE5:1};
// &"EMPTY6" @WIRE(mode="straight",linecolor="#30485d",linewidth=0.16) {#XEMPTY6:2 (12.5,-174) (12.5,-172.35) #XTRIAL6:1};
// &"VISIBLE6" @WIRE(mode="straight",linecolor="#30485d",linewidth=0.16) {#XVISIBLE6:3 (74.5,-174) (74.5,-175.65) #XREAD6:2};
// &"D6" @WIRE(mode="straight",linecolor="#30485d",linewidth=0.16) {#XREAD6:3 (111.5,-174) (111.5,-172.3) #XBASE6:1};
// &"EMPTY7" @WIRE(mode="straight",linecolor="#30485d",linewidth=0.16) {#XEMPTY7:2 (12.5,-201) (12.5,-199.35) #XTRIAL7:1};
// &"VISIBLE7" @WIRE(mode="straight",linecolor="#30485d",linewidth=0.16) {#XVISIBLE7:3 (74.5,-201) (74.5,-202.65) #XREAD7:2};
// &"KEEP0" @WIRE(mode="straight",linecolor="#30485d",linewidth=0.16) {#XKEEP0:3 (173.5,-12) (173.5,-13.7) #XNEXT0:2};
// &"KEEP1" @WIRE(mode="straight",linecolor="#30485d",linewidth=0.16) {#XKEEP1:3 (173.5,-39) (173.5,-40.7) #XNEXT1:2};
// &"KEEP2" @WIRE(mode="straight",linecolor="#30485d",linewidth=0.16) {#XKEEP2:3 (173.5,-66) (173.5,-67.7) #XNEXT2:2};
// &"KEEP3" @WIRE(mode="straight",linecolor="#30485d",linewidth=0.16) {#XKEEP3:3 (173.5,-93) (173.5,-94.7) #XNEXT3:2};
// &"KEEP4" @WIRE(mode="straight",linecolor="#30485d",linewidth=0.16) {#XKEEP4:3 (173.5,-120) (173.5,-121.7) #XNEXT4:2};
// &"KEEP5" @WIRE(mode="straight",linecolor="#30485d",linewidth=0.16) {#XKEEP5:3 (173.5,-147) (173.5,-148.7) #XNEXT5:2};
// &"KEEP6" @WIRE(mode="straight",linecolor="#30485d",linewidth=0.16) {#XKEEP6:3 (173.5,-174) (173.5,-175.7) #XNEXT6:2};
// &"KEEP7" @WIRE(mode="straight",linecolor="#30485d",linewidth=0.16) {#XKEEP7:3 (173.5,-201) (173.5,-202.7) #XNEXT7:2};
// &"CODE0" @WIRE(mode="straight",linecolor="#30485d",linewidth=0.16) {#X01:1 (-10,23.7)};
// (-10.4,23.7) @TEXT("CODE0",size=1.1,halign="end",valign="middle");
// &"CODE1" @WIRE(mode="straight",linecolor="#30485d",linewidth=0.16) {#X01:2 (-10,20.3)};
// (-10.4,20.3) @TEXT("CODE1",size=1.1,halign="end",valign="middle");
// &"ANY01" @WIRE(mode="straight",linecolor="#30485d",linewidth=0.16) {#X01:3 (10,22)};
// (10.4,22) @TEXT("ANY01",size=1.1,halign="start",valign="middle");
// &"VDD" @WIRE(mode="straight",linecolor="#30485d",linewidth=0.16) {#X01:4 (0,32)};
// (0,32.4) @TEXT("VDD",size=1.1,halign="middle",valign="bottom");
// &"VSS" @WIRE(mode="straight",linecolor="#30485d",linewidth=0.16) {#X01:5 (0,12)};
// (0,11.6) @TEXT("VSS",size=1.1,halign="middle",valign="top");
// &"CODE2" @WIRE(mode="straight",linecolor="#30485d",linewidth=0.16) {#X23:1 (24,23.7)};
// (23.6,23.7) @TEXT("CODE2",size=1.1,halign="end",valign="middle");
// &"CODE3" @WIRE(mode="straight",linecolor="#30485d",linewidth=0.16) {#X23:2 (24,20.3)};
// (23.6,20.3) @TEXT("CODE3",size=1.1,halign="end",valign="middle");
// &"ANY23" @WIRE(mode="straight",linecolor="#30485d",linewidth=0.16) {#X23:3 (44,22)};
// (44.4,22) @TEXT("ANY23",size=1.1,halign="start",valign="middle");
// &"VDD" @WIRE(mode="straight",linecolor="#30485d",linewidth=0.16) {#X23:4 (34,32)};
// (34,32.4) @TEXT("VDD",size=1.1,halign="middle",valign="bottom");
// &"VSS" @WIRE(mode="straight",linecolor="#30485d",linewidth=0.16) {#X23:5 (34,12)};
// (34,11.6) @TEXT("VSS",size=1.1,halign="middle",valign="top");
// &"CODE4" @WIRE(mode="straight",linecolor="#30485d",linewidth=0.16) {#X45:1 (58,23.7)};
// (57.6,23.7) @TEXT("CODE4",size=1.1,halign="end",valign="middle");
// &"CODE5" @WIRE(mode="straight",linecolor="#30485d",linewidth=0.16) {#X45:2 (58,20.3)};
// (57.6,20.3) @TEXT("CODE5",size=1.1,halign="end",valign="middle");
// &"ANY45" @WIRE(mode="straight",linecolor="#30485d",linewidth=0.16) {#X45:3 (78,22)};
// (78.4,22) @TEXT("ANY45",size=1.1,halign="start",valign="middle");
// &"VDD" @WIRE(mode="straight",linecolor="#30485d",linewidth=0.16) {#X45:4 (68,32)};
// (68,32.4) @TEXT("VDD",size=1.1,halign="middle",valign="bottom");
// &"VSS" @WIRE(mode="straight",linecolor="#30485d",linewidth=0.16) {#X45:5 (68,12)};
// (68,11.6) @TEXT("VSS",size=1.1,halign="middle",valign="top");
// &"ANY01" @WIRE(mode="straight",linecolor="#30485d",linewidth=0.16) {#X02:1 (92,23.7)};
// (91.6,23.7) @TEXT("ANY01",size=1.1,halign="end",valign="middle");
// &"CODE2" @WIRE(mode="straight",linecolor="#30485d",linewidth=0.16) {#X02:2 (92,20.3)};
// (91.6,20.3) @TEXT("CODE2",size=1.1,halign="end",valign="middle");
// &"ANY02" @WIRE(mode="straight",linecolor="#30485d",linewidth=0.16) {#X02:3 (112,22)};
// (112.4,22) @TEXT("ANY02",size=1.1,halign="start",valign="middle");
// &"VDD" @WIRE(mode="straight",linecolor="#30485d",linewidth=0.16) {#X02:4 (102,32)};
// (102,32.4) @TEXT("VDD",size=1.1,halign="middle",valign="bottom");
// &"VSS" @WIRE(mode="straight",linecolor="#30485d",linewidth=0.16) {#X02:5 (102,12)};
// (102,11.6) @TEXT("VSS",size=1.1,halign="middle",valign="top");
// &"ANY01" @WIRE(mode="straight",linecolor="#30485d",linewidth=0.16) {#X03:1 (126,23.7)};
// (125.6,23.7) @TEXT("ANY01",size=1.1,halign="end",valign="middle");
// &"ANY23" @WIRE(mode="straight",linecolor="#30485d",linewidth=0.16) {#X03:2 (126,20.3)};
// (125.6,20.3) @TEXT("ANY23",size=1.1,halign="end",valign="middle");
// &"ANY03" @WIRE(mode="straight",linecolor="#30485d",linewidth=0.16) {#X03:3 (146,22)};
// (146.4,22) @TEXT("ANY03",size=1.1,halign="start",valign="middle");
// &"VDD" @WIRE(mode="straight",linecolor="#30485d",linewidth=0.16) {#X03:4 (136,32)};
// (136,32.4) @TEXT("VDD",size=1.1,halign="middle",valign="bottom");
// &"VSS" @WIRE(mode="straight",linecolor="#30485d",linewidth=0.16) {#X03:5 (136,12)};
// (136,11.6) @TEXT("VSS",size=1.1,halign="middle",valign="top");
// &"ANY03" @WIRE(mode="straight",linecolor="#30485d",linewidth=0.16) {#X04:1 (160,23.7)};
// (159.6,23.7) @TEXT("ANY03",size=1.1,halign="end",valign="middle");
// &"CODE4" @WIRE(mode="straight",linecolor="#30485d",linewidth=0.16) {#X04:2 (160,20.3)};
// (159.6,20.3) @TEXT("CODE4",size=1.1,halign="end",valign="middle");
// &"LOW_BITS" @WIRE(mode="straight",linecolor="#30485d",linewidth=0.16) {#X04:3 (180,22)};
// (180.4,22) @TEXT("LOW_BITS",size=1.1,halign="start",valign="middle");
// &"VDD" @WIRE(mode="straight",linecolor="#30485d",linewidth=0.16) {#X04:4 (170,32)};
// (170,32.4) @TEXT("VDD",size=1.1,halign="middle",valign="bottom");
// &"VSS" @WIRE(mode="straight",linecolor="#30485d",linewidth=0.16) {#X04:5 (170,12)};
// (170,11.6) @TEXT("VSS",size=1.1,halign="middle",valign="top");
// &"ANY03" @WIRE(mode="straight",linecolor="#30485d",linewidth=0.16) {#X05:1 (194,23.7)};
// (193.6,23.7) @TEXT("ANY03",size=1.1,halign="end",valign="middle");
// &"ANY45" @WIRE(mode="straight",linecolor="#30485d",linewidth=0.16) {#X05:2 (194,20.3)};
// (193.6,20.3) @TEXT("ANY45",size=1.1,halign="end",valign="middle");
// &"ANY05" @WIRE(mode="straight",linecolor="#30485d",linewidth=0.16) {#X05:3 (214,22)};
// (214.4,22) @TEXT("ANY05",size=1.1,halign="start",valign="middle");
// &"VDD" @WIRE(mode="straight",linecolor="#30485d",linewidth=0.16) {#X05:4 (204,32)};
// (204,32.4) @TEXT("VDD",size=1.1,halign="middle",valign="bottom");
// &"VSS" @WIRE(mode="straight",linecolor="#30485d",linewidth=0.16) {#X05:5 (204,12)};
// (204,11.6) @TEXT("VSS",size=1.1,halign="middle",valign="top");
// &"ANY05" @WIRE(mode="straight",linecolor="#30485d",linewidth=0.16) {#X06:1 (228,23.7)};
// (227.6,23.7) @TEXT("ANY05",size=1.1,halign="end",valign="middle");
// &"CODE6" @WIRE(mode="straight",linecolor="#30485d",linewidth=0.16) {#X06:2 (228,20.3)};
// (227.6,20.3) @TEXT("CODE6",size=1.1,halign="end",valign="middle");
// &"ANY06" @WIRE(mode="straight",linecolor="#30485d",linewidth=0.16) {#X06:3 (248,22)};
// (248.4,22) @TEXT("ANY06",size=1.1,halign="start",valign="middle");
// &"VDD" @WIRE(mode="straight",linecolor="#30485d",linewidth=0.16) {#X06:4 (238,32)};
// (238,32.4) @TEXT("VDD",size=1.1,halign="middle",valign="bottom");
// &"VSS" @WIRE(mode="straight",linecolor="#30485d",linewidth=0.16) {#X06:5 (238,12)};
// (238,11.6) @TEXT("VSS",size=1.1,halign="middle",valign="top");
// &"CODE0" @WIRE(mode="straight",linecolor="#30485d",linewidth=0.16) {#XREAD0:1 (77,-10.35)};
// (76.6,-10.35) @TEXT("CODE0",size=1.1,halign="end",valign="middle");
// &"DONE" @WIRE(mode="straight",linecolor="#30485d",linewidth=0.16) {#XREAD0:2 (77,-13.65)};
// (76.6,-13.65) @TEXT("DONE",size=1.1,halign="end",valign="middle");
// &"VDD" @WIRE(mode="straight",linecolor="#30485d",linewidth=0.16) {#XREAD0:4 (93,-1)};
// (93,-0.6) @TEXT("VDD",size=1.1,halign="middle",valign="bottom");
// &"VSS" @WIRE(mode="straight",linecolor="#30485d",linewidth=0.16) {#XREAD0:5 (93,-23)};
// (93,-23.4) @TEXT("VSS",size=1.1,halign="middle",valign="top");
// &"CODE0" @WIRE(mode="straight",linecolor="#30485d",linewidth=0.16) {#XEMPTY1:1 (-10,-39)};
// (-10.4,-39) @TEXT("CODE0",size=1.1,halign="end",valign="middle");
// &"VDD" @WIRE(mode="straight",linecolor="#30485d",linewidth=0.16) {#XEMPTY1:3 (0,-29)};
// (0,-28.6) @TEXT("VDD",size=1.1,halign="middle",valign="bottom");
// &"VSS" @WIRE(mode="straight",linecolor="#30485d",linewidth=0.16) {#XEMPTY1:4 (0,-49)};
// (0,-49.4) @TEXT("VSS",size=1.1,halign="middle",valign="top");
// &"CODE1" @WIRE(mode="straight",linecolor="#30485d",linewidth=0.16) {#XTRIAL1:2 (15,-40.65)};
// (14.6,-40.65) @TEXT("CODE1",size=1.1,halign="end",valign="middle");
// &"TRIAL1" @WIRE(mode="straight",linecolor="#30485d",linewidth=0.16) {#XTRIAL1:3 (47,-39)};
// (47.4,-39) @TEXT("TRIAL1",size=1.1,halign="start",valign="middle");
// &"VDD" @WIRE(mode="straight",linecolor="#30485d",linewidth=0.16) {#XTRIAL1:4 (31,-28)};
// (31,-27.6) @TEXT("VDD",size=1.1,halign="middle",valign="bottom");
// &"VSS" @WIRE(mode="straight",linecolor="#30485d",linewidth=0.16) {#XTRIAL1:5 (31,-50)};
// (31,-50.4) @TEXT("VSS",size=1.1,halign="middle",valign="top");
// &"CODE0" @WIRE(mode="straight",linecolor="#30485d",linewidth=0.16) {#XVISIBLE1:1 (52,-37.3)};
// (51.6,-37.3) @TEXT("CODE0",size=1.1,halign="end",valign="middle");
// &"DONE" @WIRE(mode="straight",linecolor="#30485d",linewidth=0.16) {#XVISIBLE1:2 (52,-40.7)};
// (51.6,-40.7) @TEXT("DONE",size=1.1,halign="end",valign="middle");
// &"VDD" @WIRE(mode="straight",linecolor="#30485d",linewidth=0.16) {#XVISIBLE1:4 (62,-29)};
// (62,-28.6) @TEXT("VDD",size=1.1,halign="middle",valign="bottom");
// &"VSS" @WIRE(mode="straight",linecolor="#30485d",linewidth=0.16) {#XVISIBLE1:5 (62,-49)};
// (62,-49.4) @TEXT("VSS",size=1.1,halign="middle",valign="top");
// &"CODE1" @WIRE(mode="straight",linecolor="#30485d",linewidth=0.16) {#XREAD1:1 (77,-37.35)};
// (76.6,-37.35) @TEXT("CODE1",size=1.1,halign="end",valign="middle");
// &"VDD" @WIRE(mode="straight",linecolor="#30485d",linewidth=0.16) {#XREAD1:4 (93,-28)};
// (93,-27.6) @TEXT("VDD",size=1.1,halign="middle",valign="bottom");
// &"VSS" @WIRE(mode="straight",linecolor="#30485d",linewidth=0.16) {#XREAD1:5 (93,-50)};
// (93,-50.4) @TEXT("VSS",size=1.1,halign="middle",valign="top");
// &"ANY01" @WIRE(mode="straight",linecolor="#30485d",linewidth=0.16) {#XEMPTY2:1 (-10,-66)};
// (-10.4,-66) @TEXT("ANY01",size=1.1,halign="end",valign="middle");
// &"VDD" @WIRE(mode="straight",linecolor="#30485d",linewidth=0.16) {#XEMPTY2:3 (0,-56)};
// (0,-55.6) @TEXT("VDD",size=1.1,halign="middle",valign="bottom");
// &"VSS" @WIRE(mode="straight",linecolor="#30485d",linewidth=0.16) {#XEMPTY2:4 (0,-76)};
// (0,-76.4) @TEXT("VSS",size=1.1,halign="middle",valign="top");
// &"CODE2" @WIRE(mode="straight",linecolor="#30485d",linewidth=0.16) {#XTRIAL2:2 (15,-67.65)};
// (14.6,-67.65) @TEXT("CODE2",size=1.1,halign="end",valign="middle");
// &"TRIAL2" @WIRE(mode="straight",linecolor="#30485d",linewidth=0.16) {#XTRIAL2:3 (47,-66)};
// (47.4,-66) @TEXT("TRIAL2",size=1.1,halign="start",valign="middle");
// &"VDD" @WIRE(mode="straight",linecolor="#30485d",linewidth=0.16) {#XTRIAL2:4 (31,-55)};
// (31,-54.6) @TEXT("VDD",size=1.1,halign="middle",valign="bottom");
// &"VSS" @WIRE(mode="straight",linecolor="#30485d",linewidth=0.16) {#XTRIAL2:5 (31,-77)};
// (31,-77.4) @TEXT("VSS",size=1.1,halign="middle",valign="top");
// &"ANY01" @WIRE(mode="straight",linecolor="#30485d",linewidth=0.16) {#XVISIBLE2:1 (52,-64.3)};
// (51.6,-64.3) @TEXT("ANY01",size=1.1,halign="end",valign="middle");
// &"DONE" @WIRE(mode="straight",linecolor="#30485d",linewidth=0.16) {#XVISIBLE2:2 (52,-67.7)};
// (51.6,-67.7) @TEXT("DONE",size=1.1,halign="end",valign="middle");
// &"VDD" @WIRE(mode="straight",linecolor="#30485d",linewidth=0.16) {#XVISIBLE2:4 (62,-56)};
// (62,-55.6) @TEXT("VDD",size=1.1,halign="middle",valign="bottom");
// &"VSS" @WIRE(mode="straight",linecolor="#30485d",linewidth=0.16) {#XVISIBLE2:5 (62,-76)};
// (62,-76.4) @TEXT("VSS",size=1.1,halign="middle",valign="top");
// &"CODE2" @WIRE(mode="straight",linecolor="#30485d",linewidth=0.16) {#XREAD2:1 (77,-64.35)};
// (76.6,-64.35) @TEXT("CODE2",size=1.1,halign="end",valign="middle");
// &"VDD" @WIRE(mode="straight",linecolor="#30485d",linewidth=0.16) {#XREAD2:4 (93,-55)};
// (93,-54.6) @TEXT("VDD",size=1.1,halign="middle",valign="bottom");
// &"VSS" @WIRE(mode="straight",linecolor="#30485d",linewidth=0.16) {#XREAD2:5 (93,-77)};
// (93,-77.4) @TEXT("VSS",size=1.1,halign="middle",valign="top");
// &"ANY02" @WIRE(mode="straight",linecolor="#30485d",linewidth=0.16) {#XEMPTY3:1 (-10,-93)};
// (-10.4,-93) @TEXT("ANY02",size=1.1,halign="end",valign="middle");
// &"VDD" @WIRE(mode="straight",linecolor="#30485d",linewidth=0.16) {#XEMPTY3:3 (0,-83)};
// (0,-82.6) @TEXT("VDD",size=1.1,halign="middle",valign="bottom");
// &"VSS" @WIRE(mode="straight",linecolor="#30485d",linewidth=0.16) {#XEMPTY3:4 (0,-103)};
// (0,-103.4) @TEXT("VSS",size=1.1,halign="middle",valign="top");
// &"CODE3" @WIRE(mode="straight",linecolor="#30485d",linewidth=0.16) {#XTRIAL3:2 (15,-94.65)};
// (14.6,-94.65) @TEXT("CODE3",size=1.1,halign="end",valign="middle");
// &"TRIAL3" @WIRE(mode="straight",linecolor="#30485d",linewidth=0.16) {#XTRIAL3:3 (47,-93)};
// (47.4,-93) @TEXT("TRIAL3",size=1.1,halign="start",valign="middle");
// &"VDD" @WIRE(mode="straight",linecolor="#30485d",linewidth=0.16) {#XTRIAL3:4 (31,-82)};
// (31,-81.6) @TEXT("VDD",size=1.1,halign="middle",valign="bottom");
// &"VSS" @WIRE(mode="straight",linecolor="#30485d",linewidth=0.16) {#XTRIAL3:5 (31,-104)};
// (31,-104.4) @TEXT("VSS",size=1.1,halign="middle",valign="top");
// &"ANY02" @WIRE(mode="straight",linecolor="#30485d",linewidth=0.16) {#XVISIBLE3:1 (52,-91.3)};
// (51.6,-91.3) @TEXT("ANY02",size=1.1,halign="end",valign="middle");
// &"DONE" @WIRE(mode="straight",linecolor="#30485d",linewidth=0.16) {#XVISIBLE3:2 (52,-94.7)};
// (51.6,-94.7) @TEXT("DONE",size=1.1,halign="end",valign="middle");
// &"VDD" @WIRE(mode="straight",linecolor="#30485d",linewidth=0.16) {#XVISIBLE3:4 (62,-83)};
// (62,-82.6) @TEXT("VDD",size=1.1,halign="middle",valign="bottom");
// &"VSS" @WIRE(mode="straight",linecolor="#30485d",linewidth=0.16) {#XVISIBLE3:5 (62,-103)};
// (62,-103.4) @TEXT("VSS",size=1.1,halign="middle",valign="top");
// &"CODE3" @WIRE(mode="straight",linecolor="#30485d",linewidth=0.16) {#XREAD3:1 (77,-91.35)};
// (76.6,-91.35) @TEXT("CODE3",size=1.1,halign="end",valign="middle");
// &"VDD" @WIRE(mode="straight",linecolor="#30485d",linewidth=0.16) {#XREAD3:4 (93,-82)};
// (93,-81.6) @TEXT("VDD",size=1.1,halign="middle",valign="bottom");
// &"VSS" @WIRE(mode="straight",linecolor="#30485d",linewidth=0.16) {#XREAD3:5 (93,-104)};
// (93,-104.4) @TEXT("VSS",size=1.1,halign="middle",valign="top");
// &"ANY03" @WIRE(mode="straight",linecolor="#30485d",linewidth=0.16) {#XEMPTY4:1 (-10,-120)};
// (-10.4,-120) @TEXT("ANY03",size=1.1,halign="end",valign="middle");
// &"VDD" @WIRE(mode="straight",linecolor="#30485d",linewidth=0.16) {#XEMPTY4:3 (0,-110)};
// (0,-109.6) @TEXT("VDD",size=1.1,halign="middle",valign="bottom");
// &"VSS" @WIRE(mode="straight",linecolor="#30485d",linewidth=0.16) {#XEMPTY4:4 (0,-130)};
// (0,-130.4) @TEXT("VSS",size=1.1,halign="middle",valign="top");
// &"CODE4" @WIRE(mode="straight",linecolor="#30485d",linewidth=0.16) {#XTRIAL4:2 (15,-121.65)};
// (14.6,-121.65) @TEXT("CODE4",size=1.1,halign="end",valign="middle");
// &"TRIAL4" @WIRE(mode="straight",linecolor="#30485d",linewidth=0.16) {#XTRIAL4:3 (47,-120)};
// (47.4,-120) @TEXT("TRIAL4",size=1.1,halign="start",valign="middle");
// &"VDD" @WIRE(mode="straight",linecolor="#30485d",linewidth=0.16) {#XTRIAL4:4 (31,-109)};
// (31,-108.6) @TEXT("VDD",size=1.1,halign="middle",valign="bottom");
// &"VSS" @WIRE(mode="straight",linecolor="#30485d",linewidth=0.16) {#XTRIAL4:5 (31,-131)};
// (31,-131.4) @TEXT("VSS",size=1.1,halign="middle",valign="top");
// &"ANY03" @WIRE(mode="straight",linecolor="#30485d",linewidth=0.16) {#XVISIBLE4:1 (52,-118.3)};
// (51.6,-118.3) @TEXT("ANY03",size=1.1,halign="end",valign="middle");
// &"DONE" @WIRE(mode="straight",linecolor="#30485d",linewidth=0.16) {#XVISIBLE4:2 (52,-121.7)};
// (51.6,-121.7) @TEXT("DONE",size=1.1,halign="end",valign="middle");
// &"VDD" @WIRE(mode="straight",linecolor="#30485d",linewidth=0.16) {#XVISIBLE4:4 (62,-110)};
// (62,-109.6) @TEXT("VDD",size=1.1,halign="middle",valign="bottom");
// &"VSS" @WIRE(mode="straight",linecolor="#30485d",linewidth=0.16) {#XVISIBLE4:5 (62,-130)};
// (62,-130.4) @TEXT("VSS",size=1.1,halign="middle",valign="top");
// &"CODE4" @WIRE(mode="straight",linecolor="#30485d",linewidth=0.16) {#XREAD4:1 (77,-118.35)};
// (76.6,-118.35) @TEXT("CODE4",size=1.1,halign="end",valign="middle");
// &"VDD" @WIRE(mode="straight",linecolor="#30485d",linewidth=0.16) {#XREAD4:4 (93,-109)};
// (93,-108.6) @TEXT("VDD",size=1.1,halign="middle",valign="bottom");
// &"VSS" @WIRE(mode="straight",linecolor="#30485d",linewidth=0.16) {#XREAD4:5 (93,-131)};
// (93,-131.4) @TEXT("VSS",size=1.1,halign="middle",valign="top");
// &"LOW_BITS" @WIRE(mode="straight",linecolor="#30485d",linewidth=0.16) {#XEMPTY5:1 (-10,-147)};
// (-10.4,-147) @TEXT("LOW_BITS",size=1.1,halign="end",valign="middle");
// &"VDD" @WIRE(mode="straight",linecolor="#30485d",linewidth=0.16) {#XEMPTY5:3 (0,-137)};
// (0,-136.6) @TEXT("VDD",size=1.1,halign="middle",valign="bottom");
// &"VSS" @WIRE(mode="straight",linecolor="#30485d",linewidth=0.16) {#XEMPTY5:4 (0,-157)};
// (0,-157.4) @TEXT("VSS",size=1.1,halign="middle",valign="top");
// &"CODE5" @WIRE(mode="straight",linecolor="#30485d",linewidth=0.16) {#XTRIAL5:2 (15,-148.65)};
// (14.6,-148.65) @TEXT("CODE5",size=1.1,halign="end",valign="middle");
// &"TRIAL5" @WIRE(mode="straight",linecolor="#30485d",linewidth=0.16) {#XTRIAL5:3 (47,-147)};
// (47.4,-147) @TEXT("TRIAL5",size=1.1,halign="start",valign="middle");
// &"VDD" @WIRE(mode="straight",linecolor="#30485d",linewidth=0.16) {#XTRIAL5:4 (31,-136)};
// (31,-135.6) @TEXT("VDD",size=1.1,halign="middle",valign="bottom");
// &"VSS" @WIRE(mode="straight",linecolor="#30485d",linewidth=0.16) {#XTRIAL5:5 (31,-158)};
// (31,-158.4) @TEXT("VSS",size=1.1,halign="middle",valign="top");
// &"LOW_BITS" @WIRE(mode="straight",linecolor="#30485d",linewidth=0.16) {#XVISIBLE5:1 (52,-145.3)};
// (51.6,-145.3) @TEXT("LOW_BITS",size=1.1,halign="end",valign="middle");
// &"DONE" @WIRE(mode="straight",linecolor="#30485d",linewidth=0.16) {#XVISIBLE5:2 (52,-148.7)};
// (51.6,-148.7) @TEXT("DONE",size=1.1,halign="end",valign="middle");
// &"VDD" @WIRE(mode="straight",linecolor="#30485d",linewidth=0.16) {#XVISIBLE5:4 (62,-137)};
// (62,-136.6) @TEXT("VDD",size=1.1,halign="middle",valign="bottom");
// &"VSS" @WIRE(mode="straight",linecolor="#30485d",linewidth=0.16) {#XVISIBLE5:5 (62,-157)};
// (62,-157.4) @TEXT("VSS",size=1.1,halign="middle",valign="top");
// &"CODE5" @WIRE(mode="straight",linecolor="#30485d",linewidth=0.16) {#XREAD5:1 (77,-145.35)};
// (76.6,-145.35) @TEXT("CODE5",size=1.1,halign="end",valign="middle");
// &"VDD" @WIRE(mode="straight",linecolor="#30485d",linewidth=0.16) {#XREAD5:4 (93,-136)};
// (93,-135.6) @TEXT("VDD",size=1.1,halign="middle",valign="bottom");
// &"VSS" @WIRE(mode="straight",linecolor="#30485d",linewidth=0.16) {#XREAD5:5 (93,-158)};
// (93,-158.4) @TEXT("VSS",size=1.1,halign="middle",valign="top");
// &"ANY05" @WIRE(mode="straight",linecolor="#30485d",linewidth=0.16) {#XEMPTY6:1 (-10,-174)};
// (-10.4,-174) @TEXT("ANY05",size=1.1,halign="end",valign="middle");
// &"VDD" @WIRE(mode="straight",linecolor="#30485d",linewidth=0.16) {#XEMPTY6:3 (0,-164)};
// (0,-163.6) @TEXT("VDD",size=1.1,halign="middle",valign="bottom");
// &"VSS" @WIRE(mode="straight",linecolor="#30485d",linewidth=0.16) {#XEMPTY6:4 (0,-184)};
// (0,-184.4) @TEXT("VSS",size=1.1,halign="middle",valign="top");
// &"CODE6" @WIRE(mode="straight",linecolor="#30485d",linewidth=0.16) {#XTRIAL6:2 (15,-175.65)};
// (14.6,-175.65) @TEXT("CODE6",size=1.1,halign="end",valign="middle");
// &"TRIAL6" @WIRE(mode="straight",linecolor="#30485d",linewidth=0.16) {#XTRIAL6:3 (47,-174)};
// (47.4,-174) @TEXT("TRIAL6",size=1.1,halign="start",valign="middle");
// &"VDD" @WIRE(mode="straight",linecolor="#30485d",linewidth=0.16) {#XTRIAL6:4 (31,-163)};
// (31,-162.6) @TEXT("VDD",size=1.1,halign="middle",valign="bottom");
// &"VSS" @WIRE(mode="straight",linecolor="#30485d",linewidth=0.16) {#XTRIAL6:5 (31,-185)};
// (31,-185.4) @TEXT("VSS",size=1.1,halign="middle",valign="top");
// &"ANY05" @WIRE(mode="straight",linecolor="#30485d",linewidth=0.16) {#XVISIBLE6:1 (52,-172.3)};
// (51.6,-172.3) @TEXT("ANY05",size=1.1,halign="end",valign="middle");
// &"DONE" @WIRE(mode="straight",linecolor="#30485d",linewidth=0.16) {#XVISIBLE6:2 (52,-175.7)};
// (51.6,-175.7) @TEXT("DONE",size=1.1,halign="end",valign="middle");
// &"VDD" @WIRE(mode="straight",linecolor="#30485d",linewidth=0.16) {#XVISIBLE6:4 (62,-164)};
// (62,-163.6) @TEXT("VDD",size=1.1,halign="middle",valign="bottom");
// &"VSS" @WIRE(mode="straight",linecolor="#30485d",linewidth=0.16) {#XVISIBLE6:5 (62,-184)};
// (62,-184.4) @TEXT("VSS",size=1.1,halign="middle",valign="top");
// &"CODE6" @WIRE(mode="straight",linecolor="#30485d",linewidth=0.16) {#XREAD6:1 (77,-172.35)};
// (76.6,-172.35) @TEXT("CODE6",size=1.1,halign="end",valign="middle");
// &"VDD" @WIRE(mode="straight",linecolor="#30485d",linewidth=0.16) {#XREAD6:4 (93,-163)};
// (93,-162.6) @TEXT("VDD",size=1.1,halign="middle",valign="bottom");
// &"VSS" @WIRE(mode="straight",linecolor="#30485d",linewidth=0.16) {#XREAD6:5 (93,-185)};
// (93,-185.4) @TEXT("VSS",size=1.1,halign="middle",valign="top");
// &"ANY06" @WIRE(mode="straight",linecolor="#30485d",linewidth=0.16) {#XEMPTY7:1 (-10,-201)};
// (-10.4,-201) @TEXT("ANY06",size=1.1,halign="end",valign="middle");
// &"VDD" @WIRE(mode="straight",linecolor="#30485d",linewidth=0.16) {#XEMPTY7:3 (0,-191)};
// (0,-190.6) @TEXT("VDD",size=1.1,halign="middle",valign="bottom");
// &"VSS" @WIRE(mode="straight",linecolor="#30485d",linewidth=0.16) {#XEMPTY7:4 (0,-211)};
// (0,-211.4) @TEXT("VSS",size=1.1,halign="middle",valign="top");
// &"CODE7" @WIRE(mode="straight",linecolor="#30485d",linewidth=0.16) {#XTRIAL7:2 (15,-202.65)};
// (14.6,-202.65) @TEXT("CODE7",size=1.1,halign="end",valign="middle");
// &"TRIAL7" @WIRE(mode="straight",linecolor="#30485d",linewidth=0.16) {#XTRIAL7:3 (47,-201)};
// (47.4,-201) @TEXT("TRIAL7",size=1.1,halign="start",valign="middle");
// &"VDD" @WIRE(mode="straight",linecolor="#30485d",linewidth=0.16) {#XTRIAL7:4 (31,-190)};
// (31,-189.6) @TEXT("VDD",size=1.1,halign="middle",valign="bottom");
// &"VSS" @WIRE(mode="straight",linecolor="#30485d",linewidth=0.16) {#XTRIAL7:5 (31,-212)};
// (31,-212.4) @TEXT("VSS",size=1.1,halign="middle",valign="top");
// &"ANY06" @WIRE(mode="straight",linecolor="#30485d",linewidth=0.16) {#XVISIBLE7:1 (52,-199.3)};
// (51.6,-199.3) @TEXT("ANY06",size=1.1,halign="end",valign="middle");
// &"DONE" @WIRE(mode="straight",linecolor="#30485d",linewidth=0.16) {#XVISIBLE7:2 (52,-202.7)};
// (51.6,-202.7) @TEXT("DONE",size=1.1,halign="end",valign="middle");
// &"VDD" @WIRE(mode="straight",linecolor="#30485d",linewidth=0.16) {#XVISIBLE7:4 (62,-191)};
// (62,-190.6) @TEXT("VDD",size=1.1,halign="middle",valign="bottom");
// &"VSS" @WIRE(mode="straight",linecolor="#30485d",linewidth=0.16) {#XVISIBLE7:5 (62,-211)};
// (62,-211.4) @TEXT("VSS",size=1.1,halign="middle",valign="top");
// &"CODE7" @WIRE(mode="straight",linecolor="#30485d",linewidth=0.16) {#XREAD7:1 (77,-199.35)};
// (76.6,-199.35) @TEXT("CODE7",size=1.1,halign="end",valign="middle");
// &"D7" @WIRE(mode="straight",linecolor="#30485d",linewidth=0.16) {#XREAD7:3 (109,-201)};
// (109.4,-201) @TEXT("D7",size=1.1,halign="start",valign="middle");
// &"VDD" @WIRE(mode="straight",linecolor="#30485d",linewidth=0.16) {#XREAD7:4 (93,-190)};
// (93,-189.6) @TEXT("VDD",size=1.1,halign="middle",valign="bottom");
// &"VSS" @WIRE(mode="straight",linecolor="#30485d",linewidth=0.16) {#XREAD7:5 (93,-212)};
// (93,-212.4) @TEXT("VSS",size=1.1,halign="middle",valign="top");
// &"TRIAL1" @WIRE(mode="straight",linecolor="#30485d",linewidth=0.16) {#XBASE0:2 (114,-13.7)};
// (113.6,-13.7) @TEXT("TRIAL1",size=1.1,halign="end",valign="middle");
// &"BASE0" @WIRE(mode="straight",linecolor="#30485d",linewidth=0.16) {#XBASE0:3 (134,-12)};
// (134.4,-12) @TEXT("BASE0",size=1.1,halign="start",valign="middle");
// &"VDD" @WIRE(mode="straight",linecolor="#30485d",linewidth=0.16) {#XBASE0:4 (124,-2)};
// (124,-1.6) @TEXT("VDD",size=1.1,halign="middle",valign="bottom");
// &"VSS" @WIRE(mode="straight",linecolor="#30485d",linewidth=0.16) {#XBASE0:5 (124,-22)};
// (124,-22.4) @TEXT("VSS",size=1.1,halign="middle",valign="top");
// &"CODE0" @WIRE(mode="straight",linecolor="#30485d",linewidth=0.16) {#XKEEP0:1 (139,-10.35)};
// (138.6,-10.35) @TEXT("CODE0",size=1.1,halign="end",valign="middle");
// &"DATA" @WIRE(mode="straight",linecolor="#30485d",linewidth=0.16) {#XKEEP0:2 (139,-13.65)};
// (138.6,-13.65) @TEXT("DATA",size=1.1,halign="end",valign="middle");
// &"VDD" @WIRE(mode="straight",linecolor="#30485d",linewidth=0.16) {#XKEEP0:4 (155,-1)};
// (155,-0.6) @TEXT("VDD",size=1.1,halign="middle",valign="bottom");
// &"VSS" @WIRE(mode="straight",linecolor="#30485d",linewidth=0.16) {#XKEEP0:5 (155,-23)};
// (155,-23.4) @TEXT("VSS",size=1.1,halign="middle",valign="top");
// &"BASE0" @WIRE(mode="straight",linecolor="#30485d",linewidth=0.16) {#XNEXT0:1 (176,-10.3)};
// (175.6,-10.3) @TEXT("BASE0",size=1.1,halign="end",valign="middle");
// &"NEXT0" @WIRE(mode="straight",linecolor="#30485d",linewidth=0.16) {#XNEXT0:3 (196,-12)};
// (196.4,-12) @TEXT("NEXT0",size=1.1,halign="start",valign="middle");
// &"VDD" @WIRE(mode="straight",linecolor="#30485d",linewidth=0.16) {#XNEXT0:4 (186,-2)};
// (186,-1.6) @TEXT("VDD",size=1.1,halign="middle",valign="bottom");
// &"VSS" @WIRE(mode="straight",linecolor="#30485d",linewidth=0.16) {#XNEXT0:5 (186,-22)};
// (186,-22.4) @TEXT("VSS",size=1.1,halign="middle",valign="top");
// &"TRIAL2" @WIRE(mode="straight",linecolor="#30485d",linewidth=0.16) {#XBASE1:2 (114,-40.7)};
// (113.6,-40.7) @TEXT("TRIAL2",size=1.1,halign="end",valign="middle");
// &"BASE1" @WIRE(mode="straight",linecolor="#30485d",linewidth=0.16) {#XBASE1:3 (134,-39)};
// (134.4,-39) @TEXT("BASE1",size=1.1,halign="start",valign="middle");
// &"VDD" @WIRE(mode="straight",linecolor="#30485d",linewidth=0.16) {#XBASE1:4 (124,-29)};
// (124,-28.6) @TEXT("VDD",size=1.1,halign="middle",valign="bottom");
// &"VSS" @WIRE(mode="straight",linecolor="#30485d",linewidth=0.16) {#XBASE1:5 (124,-49)};
// (124,-49.4) @TEXT("VSS",size=1.1,halign="middle",valign="top");
// &"TRIAL1" @WIRE(mode="straight",linecolor="#30485d",linewidth=0.16) {#XKEEP1:1 (139,-37.35)};
// (138.6,-37.35) @TEXT("TRIAL1",size=1.1,halign="end",valign="middle");
// &"DATA" @WIRE(mode="straight",linecolor="#30485d",linewidth=0.16) {#XKEEP1:2 (139,-40.65)};
// (138.6,-40.65) @TEXT("DATA",size=1.1,halign="end",valign="middle");
// &"VDD" @WIRE(mode="straight",linecolor="#30485d",linewidth=0.16) {#XKEEP1:4 (155,-28)};
// (155,-27.6) @TEXT("VDD",size=1.1,halign="middle",valign="bottom");
// &"VSS" @WIRE(mode="straight",linecolor="#30485d",linewidth=0.16) {#XKEEP1:5 (155,-50)};
// (155,-50.4) @TEXT("VSS",size=1.1,halign="middle",valign="top");
// &"BASE1" @WIRE(mode="straight",linecolor="#30485d",linewidth=0.16) {#XNEXT1:1 (176,-37.3)};
// (175.6,-37.3) @TEXT("BASE1",size=1.1,halign="end",valign="middle");
// &"NEXT1" @WIRE(mode="straight",linecolor="#30485d",linewidth=0.16) {#XNEXT1:3 (196,-39)};
// (196.4,-39) @TEXT("NEXT1",size=1.1,halign="start",valign="middle");
// &"VDD" @WIRE(mode="straight",linecolor="#30485d",linewidth=0.16) {#XNEXT1:4 (186,-29)};
// (186,-28.6) @TEXT("VDD",size=1.1,halign="middle",valign="bottom");
// &"VSS" @WIRE(mode="straight",linecolor="#30485d",linewidth=0.16) {#XNEXT1:5 (186,-49)};
// (186,-49.4) @TEXT("VSS",size=1.1,halign="middle",valign="top");
// &"TRIAL3" @WIRE(mode="straight",linecolor="#30485d",linewidth=0.16) {#XBASE2:2 (114,-67.7)};
// (113.6,-67.7) @TEXT("TRIAL3",size=1.1,halign="end",valign="middle");
// &"BASE2" @WIRE(mode="straight",linecolor="#30485d",linewidth=0.16) {#XBASE2:3 (134,-66)};
// (134.4,-66) @TEXT("BASE2",size=1.1,halign="start",valign="middle");
// &"VDD" @WIRE(mode="straight",linecolor="#30485d",linewidth=0.16) {#XBASE2:4 (124,-56)};
// (124,-55.6) @TEXT("VDD",size=1.1,halign="middle",valign="bottom");
// &"VSS" @WIRE(mode="straight",linecolor="#30485d",linewidth=0.16) {#XBASE2:5 (124,-76)};
// (124,-76.4) @TEXT("VSS",size=1.1,halign="middle",valign="top");
// &"TRIAL2" @WIRE(mode="straight",linecolor="#30485d",linewidth=0.16) {#XKEEP2:1 (139,-64.35)};
// (138.6,-64.35) @TEXT("TRIAL2",size=1.1,halign="end",valign="middle");
// &"DATA" @WIRE(mode="straight",linecolor="#30485d",linewidth=0.16) {#XKEEP2:2 (139,-67.65)};
// (138.6,-67.65) @TEXT("DATA",size=1.1,halign="end",valign="middle");
// &"VDD" @WIRE(mode="straight",linecolor="#30485d",linewidth=0.16) {#XKEEP2:4 (155,-55)};
// (155,-54.6) @TEXT("VDD",size=1.1,halign="middle",valign="bottom");
// &"VSS" @WIRE(mode="straight",linecolor="#30485d",linewidth=0.16) {#XKEEP2:5 (155,-77)};
// (155,-77.4) @TEXT("VSS",size=1.1,halign="middle",valign="top");
// &"BASE2" @WIRE(mode="straight",linecolor="#30485d",linewidth=0.16) {#XNEXT2:1 (176,-64.3)};
// (175.6,-64.3) @TEXT("BASE2",size=1.1,halign="end",valign="middle");
// &"NEXT2" @WIRE(mode="straight",linecolor="#30485d",linewidth=0.16) {#XNEXT2:3 (196,-66)};
// (196.4,-66) @TEXT("NEXT2",size=1.1,halign="start",valign="middle");
// &"VDD" @WIRE(mode="straight",linecolor="#30485d",linewidth=0.16) {#XNEXT2:4 (186,-56)};
// (186,-55.6) @TEXT("VDD",size=1.1,halign="middle",valign="bottom");
// &"VSS" @WIRE(mode="straight",linecolor="#30485d",linewidth=0.16) {#XNEXT2:5 (186,-76)};
// (186,-76.4) @TEXT("VSS",size=1.1,halign="middle",valign="top");
// &"TRIAL4" @WIRE(mode="straight",linecolor="#30485d",linewidth=0.16) {#XBASE3:2 (114,-94.7)};
// (113.6,-94.7) @TEXT("TRIAL4",size=1.1,halign="end",valign="middle");
// &"BASE3" @WIRE(mode="straight",linecolor="#30485d",linewidth=0.16) {#XBASE3:3 (134,-93)};
// (134.4,-93) @TEXT("BASE3",size=1.1,halign="start",valign="middle");
// &"VDD" @WIRE(mode="straight",linecolor="#30485d",linewidth=0.16) {#XBASE3:4 (124,-83)};
// (124,-82.6) @TEXT("VDD",size=1.1,halign="middle",valign="bottom");
// &"VSS" @WIRE(mode="straight",linecolor="#30485d",linewidth=0.16) {#XBASE3:5 (124,-103)};
// (124,-103.4) @TEXT("VSS",size=1.1,halign="middle",valign="top");
// &"TRIAL3" @WIRE(mode="straight",linecolor="#30485d",linewidth=0.16) {#XKEEP3:1 (139,-91.35)};
// (138.6,-91.35) @TEXT("TRIAL3",size=1.1,halign="end",valign="middle");
// &"DATA" @WIRE(mode="straight",linecolor="#30485d",linewidth=0.16) {#XKEEP3:2 (139,-94.65)};
// (138.6,-94.65) @TEXT("DATA",size=1.1,halign="end",valign="middle");
// &"VDD" @WIRE(mode="straight",linecolor="#30485d",linewidth=0.16) {#XKEEP3:4 (155,-82)};
// (155,-81.6) @TEXT("VDD",size=1.1,halign="middle",valign="bottom");
// &"VSS" @WIRE(mode="straight",linecolor="#30485d",linewidth=0.16) {#XKEEP3:5 (155,-104)};
// (155,-104.4) @TEXT("VSS",size=1.1,halign="middle",valign="top");
// &"BASE3" @WIRE(mode="straight",linecolor="#30485d",linewidth=0.16) {#XNEXT3:1 (176,-91.3)};
// (175.6,-91.3) @TEXT("BASE3",size=1.1,halign="end",valign="middle");
// &"NEXT3" @WIRE(mode="straight",linecolor="#30485d",linewidth=0.16) {#XNEXT3:3 (196,-93)};
// (196.4,-93) @TEXT("NEXT3",size=1.1,halign="start",valign="middle");
// &"VDD" @WIRE(mode="straight",linecolor="#30485d",linewidth=0.16) {#XNEXT3:4 (186,-83)};
// (186,-82.6) @TEXT("VDD",size=1.1,halign="middle",valign="bottom");
// &"VSS" @WIRE(mode="straight",linecolor="#30485d",linewidth=0.16) {#XNEXT3:5 (186,-103)};
// (186,-103.4) @TEXT("VSS",size=1.1,halign="middle",valign="top");
// &"TRIAL5" @WIRE(mode="straight",linecolor="#30485d",linewidth=0.16) {#XBASE4:2 (114,-121.7)};
// (113.6,-121.7) @TEXT("TRIAL5",size=1.1,halign="end",valign="middle");
// &"BASE4" @WIRE(mode="straight",linecolor="#30485d",linewidth=0.16) {#XBASE4:3 (134,-120)};
// (134.4,-120) @TEXT("BASE4",size=1.1,halign="start",valign="middle");
// &"VDD" @WIRE(mode="straight",linecolor="#30485d",linewidth=0.16) {#XBASE4:4 (124,-110)};
// (124,-109.6) @TEXT("VDD",size=1.1,halign="middle",valign="bottom");
// &"VSS" @WIRE(mode="straight",linecolor="#30485d",linewidth=0.16) {#XBASE4:5 (124,-130)};
// (124,-130.4) @TEXT("VSS",size=1.1,halign="middle",valign="top");
// &"TRIAL4" @WIRE(mode="straight",linecolor="#30485d",linewidth=0.16) {#XKEEP4:1 (139,-118.35)};
// (138.6,-118.35) @TEXT("TRIAL4",size=1.1,halign="end",valign="middle");
// &"DATA" @WIRE(mode="straight",linecolor="#30485d",linewidth=0.16) {#XKEEP4:2 (139,-121.65)};
// (138.6,-121.65) @TEXT("DATA",size=1.1,halign="end",valign="middle");
// &"VDD" @WIRE(mode="straight",linecolor="#30485d",linewidth=0.16) {#XKEEP4:4 (155,-109)};
// (155,-108.6) @TEXT("VDD",size=1.1,halign="middle",valign="bottom");
// &"VSS" @WIRE(mode="straight",linecolor="#30485d",linewidth=0.16) {#XKEEP4:5 (155,-131)};
// (155,-131.4) @TEXT("VSS",size=1.1,halign="middle",valign="top");
// &"BASE4" @WIRE(mode="straight",linecolor="#30485d",linewidth=0.16) {#XNEXT4:1 (176,-118.3)};
// (175.6,-118.3) @TEXT("BASE4",size=1.1,halign="end",valign="middle");
// &"NEXT4" @WIRE(mode="straight",linecolor="#30485d",linewidth=0.16) {#XNEXT4:3 (196,-120)};
// (196.4,-120) @TEXT("NEXT4",size=1.1,halign="start",valign="middle");
// &"VDD" @WIRE(mode="straight",linecolor="#30485d",linewidth=0.16) {#XNEXT4:4 (186,-110)};
// (186,-109.6) @TEXT("VDD",size=1.1,halign="middle",valign="bottom");
// &"VSS" @WIRE(mode="straight",linecolor="#30485d",linewidth=0.16) {#XNEXT4:5 (186,-130)};
// (186,-130.4) @TEXT("VSS",size=1.1,halign="middle",valign="top");
// &"TRIAL6" @WIRE(mode="straight",linecolor="#30485d",linewidth=0.16) {#XBASE5:2 (114,-148.7)};
// (113.6,-148.7) @TEXT("TRIAL6",size=1.1,halign="end",valign="middle");
// &"BASE5" @WIRE(mode="straight",linecolor="#30485d",linewidth=0.16) {#XBASE5:3 (134,-147)};
// (134.4,-147) @TEXT("BASE5",size=1.1,halign="start",valign="middle");
// &"VDD" @WIRE(mode="straight",linecolor="#30485d",linewidth=0.16) {#XBASE5:4 (124,-137)};
// (124,-136.6) @TEXT("VDD",size=1.1,halign="middle",valign="bottom");
// &"VSS" @WIRE(mode="straight",linecolor="#30485d",linewidth=0.16) {#XBASE5:5 (124,-157)};
// (124,-157.4) @TEXT("VSS",size=1.1,halign="middle",valign="top");
// &"TRIAL5" @WIRE(mode="straight",linecolor="#30485d",linewidth=0.16) {#XKEEP5:1 (139,-145.35)};
// (138.6,-145.35) @TEXT("TRIAL5",size=1.1,halign="end",valign="middle");
// &"DATA" @WIRE(mode="straight",linecolor="#30485d",linewidth=0.16) {#XKEEP5:2 (139,-148.65)};
// (138.6,-148.65) @TEXT("DATA",size=1.1,halign="end",valign="middle");
// &"VDD" @WIRE(mode="straight",linecolor="#30485d",linewidth=0.16) {#XKEEP5:4 (155,-136)};
// (155,-135.6) @TEXT("VDD",size=1.1,halign="middle",valign="bottom");
// &"VSS" @WIRE(mode="straight",linecolor="#30485d",linewidth=0.16) {#XKEEP5:5 (155,-158)};
// (155,-158.4) @TEXT("VSS",size=1.1,halign="middle",valign="top");
// &"BASE5" @WIRE(mode="straight",linecolor="#30485d",linewidth=0.16) {#XNEXT5:1 (176,-145.3)};
// (175.6,-145.3) @TEXT("BASE5",size=1.1,halign="end",valign="middle");
// &"NEXT5" @WIRE(mode="straight",linecolor="#30485d",linewidth=0.16) {#XNEXT5:3 (196,-147)};
// (196.4,-147) @TEXT("NEXT5",size=1.1,halign="start",valign="middle");
// &"VDD" @WIRE(mode="straight",linecolor="#30485d",linewidth=0.16) {#XNEXT5:4 (186,-137)};
// (186,-136.6) @TEXT("VDD",size=1.1,halign="middle",valign="bottom");
// &"VSS" @WIRE(mode="straight",linecolor="#30485d",linewidth=0.16) {#XNEXT5:5 (186,-157)};
// (186,-157.4) @TEXT("VSS",size=1.1,halign="middle",valign="top");
// &"TRIAL7" @WIRE(mode="straight",linecolor="#30485d",linewidth=0.16) {#XBASE6:2 (114,-175.7)};
// (113.6,-175.7) @TEXT("TRIAL7",size=1.1,halign="end",valign="middle");
// &"BASE6" @WIRE(mode="straight",linecolor="#30485d",linewidth=0.16) {#XBASE6:3 (134,-174)};
// (134.4,-174) @TEXT("BASE6",size=1.1,halign="start",valign="middle");
// &"VDD" @WIRE(mode="straight",linecolor="#30485d",linewidth=0.16) {#XBASE6:4 (124,-164)};
// (124,-163.6) @TEXT("VDD",size=1.1,halign="middle",valign="bottom");
// &"VSS" @WIRE(mode="straight",linecolor="#30485d",linewidth=0.16) {#XBASE6:5 (124,-184)};
// (124,-184.4) @TEXT("VSS",size=1.1,halign="middle",valign="top");
// &"TRIAL6" @WIRE(mode="straight",linecolor="#30485d",linewidth=0.16) {#XKEEP6:1 (139,-172.35)};
// (138.6,-172.35) @TEXT("TRIAL6",size=1.1,halign="end",valign="middle");
// &"DATA" @WIRE(mode="straight",linecolor="#30485d",linewidth=0.16) {#XKEEP6:2 (139,-175.65)};
// (138.6,-175.65) @TEXT("DATA",size=1.1,halign="end",valign="middle");
// &"VDD" @WIRE(mode="straight",linecolor="#30485d",linewidth=0.16) {#XKEEP6:4 (155,-163)};
// (155,-162.6) @TEXT("VDD",size=1.1,halign="middle",valign="bottom");
// &"VSS" @WIRE(mode="straight",linecolor="#30485d",linewidth=0.16) {#XKEEP6:5 (155,-185)};
// (155,-185.4) @TEXT("VSS",size=1.1,halign="middle",valign="top");
// &"BASE6" @WIRE(mode="straight",linecolor="#30485d",linewidth=0.16) {#XNEXT6:1 (176,-172.3)};
// (175.6,-172.3) @TEXT("BASE6",size=1.1,halign="end",valign="middle");
// &"NEXT6" @WIRE(mode="straight",linecolor="#30485d",linewidth=0.16) {#XNEXT6:3 (196,-174)};
// (196.4,-174) @TEXT("NEXT6",size=1.1,halign="start",valign="middle");
// &"VDD" @WIRE(mode="straight",linecolor="#30485d",linewidth=0.16) {#XNEXT6:4 (186,-164)};
// (186,-163.6) @TEXT("VDD",size=1.1,halign="middle",valign="bottom");
// &"VSS" @WIRE(mode="straight",linecolor="#30485d",linewidth=0.16) {#XNEXT6:5 (186,-184)};
// (186,-184.4) @TEXT("VSS",size=1.1,halign="middle",valign="top");
// &"TRIAL7" @WIRE(mode="straight",linecolor="#30485d",linewidth=0.16) {#XKEEP7:1 (139,-199.35)};
// (138.6,-199.35) @TEXT("TRIAL7",size=1.1,halign="end",valign="middle");
// &"DATA" @WIRE(mode="straight",linecolor="#30485d",linewidth=0.16) {#XKEEP7:2 (139,-202.65)};
// (138.6,-202.65) @TEXT("DATA",size=1.1,halign="end",valign="middle");
// &"VDD" @WIRE(mode="straight",linecolor="#30485d",linewidth=0.16) {#XKEEP7:4 (155,-190)};
// (155,-189.6) @TEXT("VDD",size=1.1,halign="middle",valign="bottom");
// &"VSS" @WIRE(mode="straight",linecolor="#30485d",linewidth=0.16) {#XKEEP7:5 (155,-212)};
// (155,-212.4) @TEXT("VSS",size=1.1,halign="middle",valign="top");
// &"D7" @WIRE(mode="straight",linecolor="#30485d",linewidth=0.16) {#XNEXT7:1 (176,-199.3)};
// (175.6,-199.3) @TEXT("D7",size=1.1,halign="end",valign="middle");
// &"NEXT7" @WIRE(mode="straight",linecolor="#30485d",linewidth=0.16) {#XNEXT7:3 (196,-201)};
// (196.4,-201) @TEXT("NEXT7",size=1.1,halign="start",valign="middle");
// &"VDD" @WIRE(mode="straight",linecolor="#30485d",linewidth=0.16) {#XNEXT7:4 (186,-191)};
// (186,-190.6) @TEXT("VDD",size=1.1,halign="middle",valign="bottom");
// &"VSS" @WIRE(mode="straight",linecolor="#30485d",linewidth=0.16) {#XNEXT7:5 (186,-211)};
// (186,-211.4) @TEXT("VSS",size=1.1,halign="middle",valign="top");
// }
// END SARADC RNL
ends sar8_next_word

subckt sar8_se_window PHASE_REQUEST SEL9 SEL7 SEL6 SEL5 SEL4 VDD VSS DELIVERED
// A transition propagates once per decision. Both polarities traverse real DEL cells.
// Taps by compared bit: 6:T11 5:T9 4:T7 3:T6 2:T5 1,0:T4. Each SELn rises once per
// conversion, on the commit before its first use, and only shortens the window.
XDEL1 (PHASE_REQUEST T1 VDD VSS) DEL250D1BWP12T30P140
XDEL2 (T1 T2 VDD VSS) DEL250D1BWP12T30P140
XDEL3 (T2 T3 VDD VSS) DEL250D1BWP12T30P140
XDEL4 (T3 T4 VDD VSS) DEL250D1BWP12T30P140
XDEL5 (T4 T5 VDD VSS) DEL250D1BWP12T30P140
XDEL6 (T5 T6 VDD VSS) DEL250D1BWP12T30P140
XDEL7 (T6 T7 VDD VSS) DEL250D1BWP12T30P140
XDEL8 (T7 T8 VDD VSS) DEL250D1BWP12T30P140
XDEL9 (T8 T9 VDD VSS) DEL250D1BWP12T30P140
XDEL10 (T9 T10 VDD VSS) DEL250D1BWP12T30P140
XDEL11 (T10 T11 VDD VSS) DEL250D1BWP12T30P140
XTAP9 (T11 T9 SEL9 W9 VDD VSS) MUX2D1BWP12T30P140
XTAP7 (W9 T7 SEL7 W7 VDD VSS) MUX2D1BWP12T30P140
XTAP6 (W7 T6 SEL6 W6 VDD VSS) MUX2D1BWP12T30P140
XTAP5 (W6 T5 SEL5 W5 VDD VSS) MUX2D1BWP12T30P140
XTAP4 (W5 T4 SEL4 DELIVERED VDD VSS) MUX2D1BWP12T30P140
// BEGIN SARADC RNL
// @RNL(author="saradc topology") {
// (-14,59) @TEXT("Settling window / delay chain and selected taps",size=1.9,halign="start",textcolor="#223d52");
// #XDEL1 @SET-SYMBOL $S_DEL250D1BWP12T30P140;
// #XDEL1 @PLACE(0,25) => @ORIENT("R0");
// #XDEL2 @SET-SYMBOL $S_DEL250D1BWP12T30P140;
// #XDEL2 @PLACE(27,25) => @ORIENT("R0");
// #XDEL3 @SET-SYMBOL $S_DEL250D1BWP12T30P140;
// #XDEL3 @PLACE(54,25) => @ORIENT("R0");
// #XDEL4 @SET-SYMBOL $S_DEL250D1BWP12T30P140;
// #XDEL4 @PLACE(81,25) => @ORIENT("R0");
// #XDEL5 @SET-SYMBOL $S_DEL250D1BWP12T30P140;
// #XDEL5 @PLACE(108,25) => @ORIENT("R0");
// #XDEL6 @SET-SYMBOL $S_DEL250D1BWP12T30P140;
// #XDEL6 @PLACE(135,25) => @ORIENT("R0");
// #XDEL7 @SET-SYMBOL $S_DEL250D1BWP12T30P140;
// #XDEL7 @PLACE(162,25) => @ORIENT("R0");
// #XDEL8 @SET-SYMBOL $S_DEL250D1BWP12T30P140;
// #XDEL8 @PLACE(189,25) => @ORIENT("R0");
// #XDEL9 @SET-SYMBOL $S_DEL250D1BWP12T30P140;
// #XDEL9 @PLACE(216,25) => @ORIENT("R0");
// #XDEL10 @SET-SYMBOL $S_DEL250D1BWP12T30P140;
// #XDEL10 @PLACE(243,25) => @ORIENT("R0");
// #XDEL11 @SET-SYMBOL $S_DEL250D1BWP12T30P140;
// #XDEL11 @PLACE(270,25) => @ORIENT("R0");
// #XTAP4 @SET-SYMBOL $S_MUX2D1BWP12T30P140;
// #XTAP4 @PLACE(0,-24) => @ORIENT("R0");
// #XTAP5 @SET-SYMBOL $S_MUX2D1BWP12T30P140;
// #XTAP5 @PLACE(54,-24) => @ORIENT("R0");
// #XTAP6 @SET-SYMBOL $S_MUX2D1BWP12T30P140;
// #XTAP6 @PLACE(108,-24) => @ORIENT("R0");
// #XTAP7 @SET-SYMBOL $S_MUX2D1BWP12T30P140;
// #XTAP7 @PLACE(162,-24) => @ORIENT("R0");
// #XTAP9 @SET-SYMBOL $S_MUX2D1BWP12T30P140;
// #XTAP9 @PLACE(216,-24) => @ORIENT("R0");
// &"T1" @WIRE(mode="straight",linecolor="#30485d",linewidth=0.16) {#XDEL1:2 (13.5,25) (13.5,25) #XDEL2:1};
// &"T2" @WIRE(mode="straight",linecolor="#30485d",linewidth=0.16) {#XDEL2:2 (40.5,25) (40.5,25) #XDEL3:1};
// &"T3" @WIRE(mode="straight",linecolor="#30485d",linewidth=0.16) {#XDEL3:2 (67.5,25) (67.5,25) #XDEL4:1};
// &"T4" @WIRE(mode="straight",linecolor="#30485d",linewidth=0.16) {#XDEL4:2 (94.5,25) (94.5,25) #XDEL5:1};
// &"T5" @WIRE(mode="straight",linecolor="#30485d",linewidth=0.16) {#XDEL5:2 (121.5,25) (121.5,25) #XDEL6:1};
// &"T6" @WIRE(mode="straight",linecolor="#30485d",linewidth=0.16) {#XDEL6:2 (148.5,25) (148.5,25) #XDEL7:1};
// &"T7" @WIRE(mode="straight",linecolor="#30485d",linewidth=0.16) {#XDEL7:2 (175.5,25) (175.5,25) #XDEL8:1};
// &"T8" @WIRE(mode="straight",linecolor="#30485d",linewidth=0.16) {#XDEL8:2 (202.5,25) (202.5,25) #XDEL9:1};
// &"T9" @WIRE(mode="straight",linecolor="#30485d",linewidth=0.16) {#XDEL9:2 (229.5,25) (229.5,25) #XDEL10:1};
// &"T10" @WIRE(mode="straight",linecolor="#30485d",linewidth=0.16) {#XDEL10:2 (256.5,25) (256.5,25) #XDEL11:1};
// &"PHASE_REQUEST" @WIRE(mode="straight",linecolor="#30485d",linewidth=0.16) {#XDEL1:1 (-16,25)};
// (-16.4,25) @TEXT("PHASE_REQUEST",size=1.1,halign="end",valign="middle");
// &"VDD" @WIRE(mode="straight",linecolor="#30485d",linewidth=0.16) {#XDEL1:3 (0,36)};
// (0,36.4) @TEXT("VDD",size=1.1,halign="middle",valign="bottom");
// &"VSS" @WIRE(mode="straight",linecolor="#30485d",linewidth=0.16) {#XDEL1:4 (0,14)};
// (0,13.6) @TEXT("VSS",size=1.1,halign="middle",valign="top");
// &"VDD" @WIRE(mode="straight",linecolor="#30485d",linewidth=0.16) {#XDEL2:3 (27,36)};
// (27,36.4) @TEXT("VDD",size=1.1,halign="middle",valign="bottom");
// &"VSS" @WIRE(mode="straight",linecolor="#30485d",linewidth=0.16) {#XDEL2:4 (27,14)};
// (27,13.6) @TEXT("VSS",size=1.1,halign="middle",valign="top");
// &"VDD" @WIRE(mode="straight",linecolor="#30485d",linewidth=0.16) {#XDEL3:3 (54,36)};
// (54,36.4) @TEXT("VDD",size=1.1,halign="middle",valign="bottom");
// &"VSS" @WIRE(mode="straight",linecolor="#30485d",linewidth=0.16) {#XDEL3:4 (54,14)};
// (54,13.6) @TEXT("VSS",size=1.1,halign="middle",valign="top");
// &"VDD" @WIRE(mode="straight",linecolor="#30485d",linewidth=0.16) {#XDEL4:3 (81,36)};
// (81,36.4) @TEXT("VDD",size=1.1,halign="middle",valign="bottom");
// &"VSS" @WIRE(mode="straight",linecolor="#30485d",linewidth=0.16) {#XDEL4:4 (81,14)};
// (81,13.6) @TEXT("VSS",size=1.1,halign="middle",valign="top");
// &"VDD" @WIRE(mode="straight",linecolor="#30485d",linewidth=0.16) {#XDEL5:3 (108,36)};
// (108,36.4) @TEXT("VDD",size=1.1,halign="middle",valign="bottom");
// &"VSS" @WIRE(mode="straight",linecolor="#30485d",linewidth=0.16) {#XDEL5:4 (108,14)};
// (108,13.6) @TEXT("VSS",size=1.1,halign="middle",valign="top");
// &"VDD" @WIRE(mode="straight",linecolor="#30485d",linewidth=0.16) {#XDEL6:3 (135,36)};
// (135,36.4) @TEXT("VDD",size=1.1,halign="middle",valign="bottom");
// &"VSS" @WIRE(mode="straight",linecolor="#30485d",linewidth=0.16) {#XDEL6:4 (135,14)};
// (135,13.6) @TEXT("VSS",size=1.1,halign="middle",valign="top");
// &"VDD" @WIRE(mode="straight",linecolor="#30485d",linewidth=0.16) {#XDEL7:3 (162,36)};
// (162,36.4) @TEXT("VDD",size=1.1,halign="middle",valign="bottom");
// &"VSS" @WIRE(mode="straight",linecolor="#30485d",linewidth=0.16) {#XDEL7:4 (162,14)};
// (162,13.6) @TEXT("VSS",size=1.1,halign="middle",valign="top");
// &"VDD" @WIRE(mode="straight",linecolor="#30485d",linewidth=0.16) {#XDEL8:3 (189,36)};
// (189,36.4) @TEXT("VDD",size=1.1,halign="middle",valign="bottom");
// &"VSS" @WIRE(mode="straight",linecolor="#30485d",linewidth=0.16) {#XDEL8:4 (189,14)};
// (189,13.6) @TEXT("VSS",size=1.1,halign="middle",valign="top");
// &"VDD" @WIRE(mode="straight",linecolor="#30485d",linewidth=0.16) {#XDEL9:3 (216,36)};
// (216,36.4) @TEXT("VDD",size=1.1,halign="middle",valign="bottom");
// &"VSS" @WIRE(mode="straight",linecolor="#30485d",linewidth=0.16) {#XDEL9:4 (216,14)};
// (216,13.6) @TEXT("VSS",size=1.1,halign="middle",valign="top");
// &"VDD" @WIRE(mode="straight",linecolor="#30485d",linewidth=0.16) {#XDEL10:3 (243,36)};
// (243,36.4) @TEXT("VDD",size=1.1,halign="middle",valign="bottom");
// &"VSS" @WIRE(mode="straight",linecolor="#30485d",linewidth=0.16) {#XDEL10:4 (243,14)};
// (243,13.6) @TEXT("VSS",size=1.1,halign="middle",valign="top");
// &"T11" @WIRE(mode="straight",linecolor="#30485d",linewidth=0.16) {#XDEL11:2 (286,25)};
// (286.4,25) @TEXT("T11",size=1.1,halign="start",valign="middle");
// &"VDD" @WIRE(mode="straight",linecolor="#30485d",linewidth=0.16) {#XDEL11:3 (270,36)};
// (270,36.4) @TEXT("VDD",size=1.1,halign="middle",valign="bottom");
// &"VSS" @WIRE(mode="straight",linecolor="#30485d",linewidth=0.16) {#XDEL11:4 (270,14)};
// (270,13.6) @TEXT("VSS",size=1.1,halign="middle",valign="top");
// &"T11" @WIRE(mode="straight",linecolor="#30485d",linewidth=0.16) {#XTAP9:1 (200,-20.7)};
// (199.6,-20.7) @TEXT("T11",size=1.1,halign="end",valign="middle");
// &"T9" @WIRE(mode="straight",linecolor="#30485d",linewidth=0.16) {#XTAP9:2 (200,-24)};
// (199.6,-24) @TEXT("T9",size=1.1,halign="end",valign="middle");
// &"SEL9" @WIRE(mode="straight",linecolor="#30485d",linewidth=0.16) {#XTAP9:3 (200,-27.3)};
// (199.6,-27.3) @TEXT("SEL9",size=1.1,halign="end",valign="middle");
// &"W9" @WIRE(mode="straight",linecolor="#30485d",linewidth=0.16) {#XTAP9:4 (232,-24)};
// (232.4,-24) @TEXT("W9",size=1.1,halign="start",valign="middle");
// &"VDD" @WIRE(mode="straight",linecolor="#30485d",linewidth=0.16) {#XTAP9:5 (216,-12.4)};
// (216,-12) @TEXT("VDD",size=1.1,halign="middle",valign="bottom");
// &"VSS" @WIRE(mode="straight",linecolor="#30485d",linewidth=0.16) {#XTAP9:6 (216,-35.6)};
// (216,-36) @TEXT("VSS",size=1.1,halign="middle",valign="top");
// &"W9" @WIRE(mode="straight",linecolor="#30485d",linewidth=0.16) {#XTAP7:1 (146,-20.7)};
// (145.6,-20.7) @TEXT("W9",size=1.1,halign="end",valign="middle");
// &"T7" @WIRE(mode="straight",linecolor="#30485d",linewidth=0.16) {#XTAP7:2 (146,-24)};
// (145.6,-24) @TEXT("T7",size=1.1,halign="end",valign="middle");
// &"SEL7" @WIRE(mode="straight",linecolor="#30485d",linewidth=0.16) {#XTAP7:3 (146,-27.3)};
// (145.6,-27.3) @TEXT("SEL7",size=1.1,halign="end",valign="middle");
// &"W7" @WIRE(mode="straight",linecolor="#30485d",linewidth=0.16) {#XTAP7:4 (178,-24)};
// (178.4,-24) @TEXT("W7",size=1.1,halign="start",valign="middle");
// &"VDD" @WIRE(mode="straight",linecolor="#30485d",linewidth=0.16) {#XTAP7:5 (162,-12.4)};
// (162,-12) @TEXT("VDD",size=1.1,halign="middle",valign="bottom");
// &"VSS" @WIRE(mode="straight",linecolor="#30485d",linewidth=0.16) {#XTAP7:6 (162,-35.6)};
// (162,-36) @TEXT("VSS",size=1.1,halign="middle",valign="top");
// &"W7" @WIRE(mode="straight",linecolor="#30485d",linewidth=0.16) {#XTAP6:1 (92,-20.7)};
// (91.6,-20.7) @TEXT("W7",size=1.1,halign="end",valign="middle");
// &"T6" @WIRE(mode="straight",linecolor="#30485d",linewidth=0.16) {#XTAP6:2 (92,-24)};
// (91.6,-24) @TEXT("T6",size=1.1,halign="end",valign="middle");
// &"SEL6" @WIRE(mode="straight",linecolor="#30485d",linewidth=0.16) {#XTAP6:3 (92,-27.3)};
// (91.6,-27.3) @TEXT("SEL6",size=1.1,halign="end",valign="middle");
// &"W6" @WIRE(mode="straight",linecolor="#30485d",linewidth=0.16) {#XTAP6:4 (124,-24)};
// (124.4,-24) @TEXT("W6",size=1.1,halign="start",valign="middle");
// &"VDD" @WIRE(mode="straight",linecolor="#30485d",linewidth=0.16) {#XTAP6:5 (108,-12.4)};
// (108,-12) @TEXT("VDD",size=1.1,halign="middle",valign="bottom");
// &"VSS" @WIRE(mode="straight",linecolor="#30485d",linewidth=0.16) {#XTAP6:6 (108,-35.6)};
// (108,-36) @TEXT("VSS",size=1.1,halign="middle",valign="top");
// &"W6" @WIRE(mode="straight",linecolor="#30485d",linewidth=0.16) {#XTAP5:1 (38,-20.7)};
// (37.6,-20.7) @TEXT("W6",size=1.1,halign="end",valign="middle");
// &"T5" @WIRE(mode="straight",linecolor="#30485d",linewidth=0.16) {#XTAP5:2 (38,-24)};
// (37.6,-24) @TEXT("T5",size=1.1,halign="end",valign="middle");
// &"SEL5" @WIRE(mode="straight",linecolor="#30485d",linewidth=0.16) {#XTAP5:3 (38,-27.3)};
// (37.6,-27.3) @TEXT("SEL5",size=1.1,halign="end",valign="middle");
// &"W5" @WIRE(mode="straight",linecolor="#30485d",linewidth=0.16) {#XTAP5:4 (70,-24)};
// (70.4,-24) @TEXT("W5",size=1.1,halign="start",valign="middle");
// &"VDD" @WIRE(mode="straight",linecolor="#30485d",linewidth=0.16) {#XTAP5:5 (54,-12.4)};
// (54,-12) @TEXT("VDD",size=1.1,halign="middle",valign="bottom");
// &"VSS" @WIRE(mode="straight",linecolor="#30485d",linewidth=0.16) {#XTAP5:6 (54,-35.6)};
// (54,-36) @TEXT("VSS",size=1.1,halign="middle",valign="top");
// &"W5" @WIRE(mode="straight",linecolor="#30485d",linewidth=0.16) {#XTAP4:1 (-16,-20.7)};
// (-16.4,-20.7) @TEXT("W5",size=1.1,halign="end",valign="middle");
// &"T4" @WIRE(mode="straight",linecolor="#30485d",linewidth=0.16) {#XTAP4:2 (-16,-24)};
// (-16.4,-24) @TEXT("T4",size=1.1,halign="end",valign="middle");
// &"SEL4" @WIRE(mode="straight",linecolor="#30485d",linewidth=0.16) {#XTAP4:3 (-16,-27.3)};
// (-16.4,-27.3) @TEXT("SEL4",size=1.1,halign="end",valign="middle");
// &"DELIVERED" @WIRE(mode="straight",linecolor="#30485d",linewidth=0.16) {#XTAP4:4 (16,-24)};
// (16.4,-24) @TEXT("DELIVERED",size=1.1,halign="start",valign="middle");
// &"VDD" @WIRE(mode="straight",linecolor="#30485d",linewidth=0.16) {#XTAP4:5 (0,-12.4)};
// (0,-12) @TEXT("VDD",size=1.1,halign="middle",valign="bottom");
// &"VSS" @WIRE(mode="straight",linecolor="#30485d",linewidth=0.16) {#XTAP4:6 (0,-35.6)};
// (0,-36) @TEXT("VSS",size=1.1,halign="middle",valign="top");
// }
// END SARADC RNL
ends sar8_se_window

subckt sar8_se_timing ACTIVE SAMPLE SEL9 SEL7 SEL6 SEL5 SEL4 COMP_P COMP_N CMP_CLK COMMIT DATA VDD VSS
XPR (COMP_P PR VDD VSS) BUFFD1BWP12T30P140
XNR (COMP_N NR VDD VSS) BUFFD1BWP12T30P140
XNRB (NR NRB VDD VSS) INVD1BWP12T30P140
XDATA (PR NRB DATA VDD VSS) AN2D1BWP12T30P140
XRAW (PR NR RAW VDD VSS) XOR2D1BWP12T30P140
XVD (RAW RAW_T VDD VSS) DEL200D1BWP12T30P140
XVALID (RAW RAW_T VALID VDD VSS) AN2D1BWP12T30P140
XSN (SAMPLE SN VDD VSS) INVD1BWP12T30P140
// VALID drives the inner NAND input: CMP_CLK falls first, so the internal node never floats
// when VALID falls (FF-cold terminal-voltage screen).
XW0 (VALID CMP_CLK WD VDD VSS) AN2D1BWP12T30P140
XW1 (WD SN WRITE VDD VSS) AN2D1BWP12T30P140
XCP (WRITE COMMIT VDD VSS) CKBD1BWP12T30P140
// Tracking clears PHASE, so PHASE_REQUEST and every tap settle high and READY is
// already high when sampling closes: the first trial needs no settling window.
// Each real commit toggles PHASE and launches the opposite transition.
// Two-flop Johnson phase: each register toggles on every second commit, and PHASE = PHA XOR PHB
// changes once per commit without hazards.
XPHA (COMMIT PHB_N SAMPLE VDD VSS PHA) sar8_se_store
XPHBN (PHB PHB_N VDD VSS) INVD1BWP12T30P140
XPHB (COMMIT PHA SAMPLE VDD VSS PHB) sar8_se_store
XPHX (PHA PHB PHASE VDD VSS) XOR2D1BWP12T30P140
XPHR (PHASE PHASE_REQUEST VDD VSS) INVD1BWP12T30P140
XWINDOW (PHASE_REQUEST SEL9 SEL7 SEL6 SEL5 SEL4 VDD VSS DELIVERED) sar8_se_window
XREADY (PHASE DELIVERED READY VDD VSS) XOR2D1BWP12T30P140
// Reset on the committed phase change; only the delayed edge can release reset.
XCLR (READY SN CLR_N VDD VSS) AN2D1BWP12T30P140
// The first compare waits two stages after sampling closes for the bootstrap
// gates to turn off. Reopening the sample clears LIVE through the qualifier.
XSND1 (SN SN_T1 VDD VSS) DEL250D1BWP12T30P140
XSND2 (SN_T1 SN_T2 VDD VSS) DEL250D1BWP12T30P140
XSNQ (SN SN_T2 SN_D VDD VSS) AN2D1BWP12T30P140
XLIVE (ACTIVE SN_D LIVE VDD VSS) AN2D1BWP12T30P140
XIDLE (RAW CLEARED VDD VSS) INVD1BWP12T30P140
XSET0 (LIVE CLEARED SET0 VDD VSS) AN2D1BWP12T30P140
XSET (SET0 READY SET VDD VSS) AN2D1BWP12T30P140
XHIGH (HIGH VDD VSS) TIEHBWP12T30P140
XCLOCK (HIGH SET CLR_N Q VDD VSS) LHCNDQD1BWP12T30P140
XCMP (Q CMP_CLK VDD VSS) CKBD1BWP12T30P140
// BEGIN SARADC RNL
// @RNL(author="saradc topology") {
// (-17,54) @TEXT("Asynchronous compare and commit timing",size=2.05,halign="start",textcolor="#223d52");
// (-17,37) @TEXT("Latch decision",size=1.35,halign="start",textcolor="#223d52");
// #XPR @SET-SYMBOL $S_BUFFD1BWP12T30P140;
// #XPR @PLACE(0,22) => @ORIENT("R0");
// #XNR @SET-SYMBOL $S_BUFFD1BWP12T30P140;
// #XNR @PLACE(33,22) => @ORIENT("R0");
// #XNRB @SET-SYMBOL $S_INVD1BWP12T30P140;
// #XNRB @PLACE(66,22) => @ORIENT("R0");
// #XDATA @SET-SYMBOL $S_AN2D1BWP12T30P140;
// #XDATA @PLACE(99,22) => @ORIENT("R0");
// #XRAW @SET-SYMBOL $S_XOR2D1BWP12T30P140;
// #XRAW @PLACE(132,22) => @ORIENT("R0");
// #XVD @SET-SYMBOL $S_DEL200D1BWP12T30P140;
// #XVD @PLACE(165,22) => @ORIENT("R0");
// #XVALID @SET-SYMBOL $S_AN2D1BWP12T30P140;
// #XVALID @PLACE(198,22) => @ORIENT("R0");
// (-17,-6) @TEXT("Commit and phase",size=1.35,halign="start",textcolor="#223d52");
// #XSN @SET-SYMBOL $S_INVD1BWP12T30P140;
// #XSN @PLACE(0,-21) => @ORIENT("R0");
// #XW0 @SET-SYMBOL $S_AN2D1BWP12T30P140;
// #XW0 @PLACE(33,-21) => @ORIENT("R0");
// #XW1 @SET-SYMBOL $S_AN2D1BWP12T30P140;
// #XW1 @PLACE(66,-21) => @ORIENT("R0");
// #XCP @SET-SYMBOL $S_CKBD1BWP12T30P140;
// #XCP @PLACE(99,-21) => @ORIENT("R0");
// #XPHA @SET-SYMBOL $S_sar8_se_store;
// #XPHA @PLACE(132,-21) => @ORIENT("R0");
// #XPHBN @SET-SYMBOL $S_INVD1BWP12T30P140;
// #XPHBN @PLACE(165,-21) => @ORIENT("R0");
// #XPHB @SET-SYMBOL $S_sar8_se_store;
// #XPHB @PLACE(198,-21) => @ORIENT("R0");
// #XPHX @SET-SYMBOL $S_XOR2D1BWP12T30P140;
// #XPHX @PLACE(231,-21) => @ORIENT("R0");
// (-17,-49) @TEXT("Settling window",size=1.35,halign="start",textcolor="#223d52");
// #XPHR @SET-SYMBOL $S_INVD1BWP12T30P140;
// #XPHR @PLACE(0,-64) => @ORIENT("R0");
// #XWINDOW @SET-SYMBOL $S_sar8_se_window;
// #XWINDOW @PLACE(33,-64) => @ORIENT("R0");
// #XREADY @SET-SYMBOL $S_XOR2D1BWP12T30P140;
// #XREADY @PLACE(66,-64) => @ORIENT("R0");
// #XCLR @SET-SYMBOL $S_AN2D1BWP12T30P140;
// #XCLR @PLACE(99,-64) => @ORIENT("R0");
// #XSND1 @SET-SYMBOL $S_DEL250D1BWP12T30P140;
// #XSND1 @PLACE(132,-64) => @ORIENT("R0");
// #XSND2 @SET-SYMBOL $S_DEL250D1BWP12T30P140;
// #XSND2 @PLACE(165,-64) => @ORIENT("R0");
// #XSNQ @SET-SYMBOL $S_AN2D1BWP12T30P140;
// #XSNQ @PLACE(198,-64) => @ORIENT("R0");
// (-17,-92) @TEXT("Comparator clock",size=1.35,halign="start",textcolor="#223d52");
// #XLIVE @SET-SYMBOL $S_AN2D1BWP12T30P140;
// #XLIVE @PLACE(0,-107) => @ORIENT("R0");
// #XIDLE @SET-SYMBOL $S_INVD1BWP12T30P140;
// #XIDLE @PLACE(33,-107) => @ORIENT("R0");
// #XSET0 @SET-SYMBOL $S_AN2D1BWP12T30P140;
// #XSET0 @PLACE(66,-107) => @ORIENT("R0");
// #XSET @SET-SYMBOL $S_AN2D1BWP12T30P140;
// #XSET @PLACE(99,-107) => @ORIENT("R0");
// #XHIGH @SET-SYMBOL $S_TIEHBWP12T30P140;
// #XHIGH @PLACE(132,-107) => @ORIENT("R0");
// #XCLOCK @SET-SYMBOL $S_LHCNDQD1BWP12T30P140;
// #XCLOCK @PLACE(165,-107) => @ORIENT("R0");
// #XCMP @SET-SYMBOL $S_CKBD1BWP12T30P140;
// #XCMP @PLACE(198,-107) => @ORIENT("R0");
// &"NRB" @WIRE(mode="straight",linecolor="#30485d",linewidth=0.16) {#XNRB:2 (79.5,22) (79.5,20.35) #XDATA:2};
// &"RAW_T" @WIRE(mode="straight",linecolor="#30485d",linewidth=0.16) {#XVD:2 (181.5,22) (181.5,20.35) #XVALID:2};
// &"WD" @WIRE(mode="straight",linecolor="#30485d",linewidth=0.16) {#XW0:3 (49.5,-21) (49.5,-19.35) #XW1:1};
// &"WRITE" @WIRE(mode="straight",linecolor="#30485d",linewidth=0.16) {#XW1:3 (82.5,-21) (82.5,-21) #XCP:1};
// &"PHASE_REQUEST" @WIRE(mode="straight",linecolor="#30485d",linewidth=0.16) {#XPHR:2 (13.5,-64) (13.5,-55.75) #XWINDOW:1};
// &"DELIVERED" @WIRE(mode="straight",linecolor="#30485d",linewidth=0.16) {#XWINDOW:9 (49.5,-64) (49.5,-65.65) #XREADY:2};
// &"SN_T1" @WIRE(mode="straight",linecolor="#30485d",linewidth=0.16) {#XSND1:2 (148.5,-64) (148.5,-64) #XSND2:1};
// &"SN_T2" @WIRE(mode="straight",linecolor="#30485d",linewidth=0.16) {#XSND2:2 (181.5,-64) (181.5,-65.65) #XSNQ:2};
// &"CLEARED" @WIRE(mode="straight",linecolor="#30485d",linewidth=0.16) {#XIDLE:2 (46.5,-107) (46.5,-108.65) #XSET0:2};
// &"SET0" @WIRE(mode="straight",linecolor="#30485d",linewidth=0.16) {#XSET0:3 (82.5,-107) (82.5,-105.35) #XSET:1};
// &"HIGH" @WIRE(mode="straight",linecolor="#30485d",linewidth=0.16) {#XHIGH:1 (148.5,-107) (148.5,-103.7) #XCLOCK:1};
// &"Q" @WIRE(mode="straight",linecolor="#30485d",linewidth=0.16) {#XCLOCK:4 (181.5,-107) (181.5,-107) #XCMP:1};
// &"COMP_P" @WIRE(mode="straight",linecolor="#30485d",linewidth=0.16) {#XPR:1 (-10,22)};
// (-10.4,22) @TEXT("COMP_P",size=1.1,halign="end",valign="middle");
// &"PR" @WIRE(mode="straight",linecolor="#30485d",linewidth=0.16) {#XPR:2 (10,22)};
// (10.4,22) @TEXT("PR",size=1.1,halign="start",valign="middle");
// &"VDD" @WIRE(mode="straight",linecolor="#30485d",linewidth=0.16) {#XPR:3 (0,32)};
// (0,32.4) @TEXT("VDD",size=1.1,halign="middle",valign="bottom");
// &"VSS" @WIRE(mode="straight",linecolor="#30485d",linewidth=0.16) {#XPR:4 (0,12)};
// (0,11.6) @TEXT("VSS",size=1.1,halign="middle",valign="top");
// &"COMP_N" @WIRE(mode="straight",linecolor="#30485d",linewidth=0.16) {#XNR:1 (23,22)};
// (22.6,22) @TEXT("COMP_N",size=1.1,halign="end",valign="middle");
// &"NR" @WIRE(mode="straight",linecolor="#30485d",linewidth=0.16) {#XNR:2 (43,22)};
// (43.4,22) @TEXT("NR",size=1.1,halign="start",valign="middle");
// &"VDD" @WIRE(mode="straight",linecolor="#30485d",linewidth=0.16) {#XNR:3 (33,32)};
// (33,32.4) @TEXT("VDD",size=1.1,halign="middle",valign="bottom");
// &"VSS" @WIRE(mode="straight",linecolor="#30485d",linewidth=0.16) {#XNR:4 (33,12)};
// (33,11.6) @TEXT("VSS",size=1.1,halign="middle",valign="top");
// &"NR" @WIRE(mode="straight",linecolor="#30485d",linewidth=0.16) {#XNRB:1 (56,22)};
// (55.6,22) @TEXT("NR",size=1.1,halign="end",valign="middle");
// &"VDD" @WIRE(mode="straight",linecolor="#30485d",linewidth=0.16) {#XNRB:3 (66,32)};
// (66,32.4) @TEXT("VDD",size=1.1,halign="middle",valign="bottom");
// &"VSS" @WIRE(mode="straight",linecolor="#30485d",linewidth=0.16) {#XNRB:4 (66,12)};
// (66,11.6) @TEXT("VSS",size=1.1,halign="middle",valign="top");
// &"PR" @WIRE(mode="straight",linecolor="#30485d",linewidth=0.16) {#XDATA:1 (83,23.65)};
// (82.6,23.65) @TEXT("PR",size=1.1,halign="end",valign="middle");
// &"DATA" @WIRE(mode="straight",linecolor="#30485d",linewidth=0.16) {#XDATA:3 (115,22)};
// (115.4,22) @TEXT("DATA",size=1.1,halign="start",valign="middle");
// &"VDD" @WIRE(mode="straight",linecolor="#30485d",linewidth=0.16) {#XDATA:4 (99,33)};
// (99,33.4) @TEXT("VDD",size=1.1,halign="middle",valign="bottom");
// &"VSS" @WIRE(mode="straight",linecolor="#30485d",linewidth=0.16) {#XDATA:5 (99,11)};
// (99,10.6) @TEXT("VSS",size=1.1,halign="middle",valign="top");
// &"PR" @WIRE(mode="straight",linecolor="#30485d",linewidth=0.16) {#XRAW:1 (116,23.65)};
// (115.6,23.65) @TEXT("PR",size=1.1,halign="end",valign="middle");
// &"NR" @WIRE(mode="straight",linecolor="#30485d",linewidth=0.16) {#XRAW:2 (116,20.35)};
// (115.6,20.35) @TEXT("NR",size=1.1,halign="end",valign="middle");
// &"RAW" @WIRE(mode="straight",linecolor="#30485d",linewidth=0.16) {#XRAW:3 (148,22)};
// (148.4,22) @TEXT("RAW",size=1.1,halign="start",valign="middle");
// &"VDD" @WIRE(mode="straight",linecolor="#30485d",linewidth=0.16) {#XRAW:4 (132,33)};
// (132,33.4) @TEXT("VDD",size=1.1,halign="middle",valign="bottom");
// &"VSS" @WIRE(mode="straight",linecolor="#30485d",linewidth=0.16) {#XRAW:5 (132,11)};
// (132,10.6) @TEXT("VSS",size=1.1,halign="middle",valign="top");
// &"RAW" @WIRE(mode="straight",linecolor="#30485d",linewidth=0.16) {#XVD:1 (149,22)};
// (148.6,22) @TEXT("RAW",size=1.1,halign="end",valign="middle");
// &"VDD" @WIRE(mode="straight",linecolor="#30485d",linewidth=0.16) {#XVD:3 (165,33)};
// (165,33.4) @TEXT("VDD",size=1.1,halign="middle",valign="bottom");
// &"VSS" @WIRE(mode="straight",linecolor="#30485d",linewidth=0.16) {#XVD:4 (165,11)};
// (165,10.6) @TEXT("VSS",size=1.1,halign="middle",valign="top");
// &"RAW" @WIRE(mode="straight",linecolor="#30485d",linewidth=0.16) {#XVALID:1 (182,23.65)};
// (181.6,23.65) @TEXT("RAW",size=1.1,halign="end",valign="middle");
// &"VALID" @WIRE(mode="straight",linecolor="#30485d",linewidth=0.16) {#XVALID:3 (214,22)};
// (214.4,22) @TEXT("VALID",size=1.1,halign="start",valign="middle");
// &"VDD" @WIRE(mode="straight",linecolor="#30485d",linewidth=0.16) {#XVALID:4 (198,33)};
// (198,33.4) @TEXT("VDD",size=1.1,halign="middle",valign="bottom");
// &"VSS" @WIRE(mode="straight",linecolor="#30485d",linewidth=0.16) {#XVALID:5 (198,11)};
// (198,10.6) @TEXT("VSS",size=1.1,halign="middle",valign="top");
// &"SAMPLE" @WIRE(mode="straight",linecolor="#30485d",linewidth=0.16) {#XSN:1 (-10,-21)};
// (-10.4,-21) @TEXT("SAMPLE",size=1.1,halign="end",valign="middle");
// &"SN" @WIRE(mode="straight",linecolor="#30485d",linewidth=0.16) {#XSN:2 (10,-21)};
// (10.4,-21) @TEXT("SN",size=1.1,halign="start",valign="middle");
// &"VDD" @WIRE(mode="straight",linecolor="#30485d",linewidth=0.16) {#XSN:3 (0,-11)};
// (0,-10.6) @TEXT("VDD",size=1.1,halign="middle",valign="bottom");
// &"VSS" @WIRE(mode="straight",linecolor="#30485d",linewidth=0.16) {#XSN:4 (0,-31)};
// (0,-31.4) @TEXT("VSS",size=1.1,halign="middle",valign="top");
// &"VALID" @WIRE(mode="straight",linecolor="#30485d",linewidth=0.16) {#XW0:1 (17,-19.35)};
// (16.6,-19.35) @TEXT("VALID",size=1.1,halign="end",valign="middle");
// &"CMP_CLK" @WIRE(mode="straight",linecolor="#30485d",linewidth=0.16) {#XW0:2 (17,-22.65)};
// (16.6,-22.65) @TEXT("CMP_CLK",size=1.1,halign="end",valign="middle");
// &"VDD" @WIRE(mode="straight",linecolor="#30485d",linewidth=0.16) {#XW0:4 (33,-10)};
// (33,-9.6) @TEXT("VDD",size=1.1,halign="middle",valign="bottom");
// &"VSS" @WIRE(mode="straight",linecolor="#30485d",linewidth=0.16) {#XW0:5 (33,-32)};
// (33,-32.4) @TEXT("VSS",size=1.1,halign="middle",valign="top");
// &"SN" @WIRE(mode="straight",linecolor="#30485d",linewidth=0.16) {#XW1:2 (50,-22.65)};
// (49.6,-22.65) @TEXT("SN",size=1.1,halign="end",valign="middle");
// &"VDD" @WIRE(mode="straight",linecolor="#30485d",linewidth=0.16) {#XW1:4 (66,-10)};
// (66,-9.6) @TEXT("VDD",size=1.1,halign="middle",valign="bottom");
// &"VSS" @WIRE(mode="straight",linecolor="#30485d",linewidth=0.16) {#XW1:5 (66,-32)};
// (66,-32.4) @TEXT("VSS",size=1.1,halign="middle",valign="top");
// &"COMMIT" @WIRE(mode="straight",linecolor="#30485d",linewidth=0.16) {#XCP:2 (115,-21)};
// (115.4,-21) @TEXT("COMMIT",size=1.1,halign="start",valign="middle");
// &"VDD" @WIRE(mode="straight",linecolor="#30485d",linewidth=0.16) {#XCP:3 (99,-10)};
// (99,-9.6) @TEXT("VDD",size=1.1,halign="middle",valign="bottom");
// &"VSS" @WIRE(mode="straight",linecolor="#30485d",linewidth=0.16) {#XCP:4 (99,-32)};
// (99,-32.4) @TEXT("VSS",size=1.1,halign="middle",valign="top");
// &"COMMIT" @WIRE(mode="straight",linecolor="#30485d",linewidth=0.16) {#XPHA:1 (118.5,-19.35)};
// (118.1,-19.35) @TEXT("COMMIT",size=1.1,halign="end",valign="middle");
// &"PHB_N" @WIRE(mode="straight",linecolor="#30485d",linewidth=0.16) {#XPHA:2 (128,-10)};
// (128,-9.6) @TEXT("PHB_N",size=1.1,halign="middle",valign="bottom");
// &"SAMPLE" @WIRE(mode="straight",linecolor="#30485d",linewidth=0.16) {#XPHA:3 (118.5,-22.65)};
// (118.1,-22.65) @TEXT("SAMPLE",size=1.1,halign="end",valign="middle");
// &"VDD" @WIRE(mode="straight",linecolor="#30485d",linewidth=0.16) {#XPHA:4 (136,-10)};
// (136,-9.6) @TEXT("VDD",size=1.1,halign="middle",valign="bottom");
// &"VSS" @WIRE(mode="straight",linecolor="#30485d",linewidth=0.16) {#XPHA:5 (128,-32)};
// (128,-32.4) @TEXT("VSS",size=1.1,halign="middle",valign="top");
// &"PHA" @WIRE(mode="straight",linecolor="#30485d",linewidth=0.16) {#XPHA:6 (136,-32)};
// (136,-32.4) @TEXT("PHA",size=1.1,halign="middle",valign="top");
// &"PHB" @WIRE(mode="straight",linecolor="#30485d",linewidth=0.16) {#XPHBN:1 (155,-21)};
// (154.6,-21) @TEXT("PHB",size=1.1,halign="end",valign="middle");
// &"PHB_N" @WIRE(mode="straight",linecolor="#30485d",linewidth=0.16) {#XPHBN:2 (175,-21)};
// (175.4,-21) @TEXT("PHB_N",size=1.1,halign="start",valign="middle");
// &"VDD" @WIRE(mode="straight",linecolor="#30485d",linewidth=0.16) {#XPHBN:3 (165,-11)};
// (165,-10.6) @TEXT("VDD",size=1.1,halign="middle",valign="bottom");
// &"VSS" @WIRE(mode="straight",linecolor="#30485d",linewidth=0.16) {#XPHBN:4 (165,-31)};
// (165,-31.4) @TEXT("VSS",size=1.1,halign="middle",valign="top");
// &"COMMIT" @WIRE(mode="straight",linecolor="#30485d",linewidth=0.16) {#XPHB:1 (184.5,-19.35)};
// (184.1,-19.35) @TEXT("COMMIT",size=1.1,halign="end",valign="middle");
// &"PHA" @WIRE(mode="straight",linecolor="#30485d",linewidth=0.16) {#XPHB:2 (194,-10)};
// (194,-9.6) @TEXT("PHA",size=1.1,halign="middle",valign="bottom");
// &"SAMPLE" @WIRE(mode="straight",linecolor="#30485d",linewidth=0.16) {#XPHB:3 (184.5,-22.65)};
// (184.1,-22.65) @TEXT("SAMPLE",size=1.1,halign="end",valign="middle");
// &"VDD" @WIRE(mode="straight",linecolor="#30485d",linewidth=0.16) {#XPHB:4 (202,-10)};
// (202,-9.6) @TEXT("VDD",size=1.1,halign="middle",valign="bottom");
// &"VSS" @WIRE(mode="straight",linecolor="#30485d",linewidth=0.16) {#XPHB:5 (194,-32)};
// (194,-32.4) @TEXT("VSS",size=1.1,halign="middle",valign="top");
// &"PHB" @WIRE(mode="straight",linecolor="#30485d",linewidth=0.16) {#XPHB:6 (202,-32)};
// (202,-32.4) @TEXT("PHB",size=1.1,halign="middle",valign="top");
// &"PHA" @WIRE(mode="straight",linecolor="#30485d",linewidth=0.16) {#XPHX:1 (215,-19.35)};
// (214.6,-19.35) @TEXT("PHA",size=1.1,halign="end",valign="middle");
// &"PHB" @WIRE(mode="straight",linecolor="#30485d",linewidth=0.16) {#XPHX:2 (215,-22.65)};
// (214.6,-22.65) @TEXT("PHB",size=1.1,halign="end",valign="middle");
// &"PHASE" @WIRE(mode="straight",linecolor="#30485d",linewidth=0.16) {#XPHX:3 (247,-21)};
// (247.4,-21) @TEXT("PHASE",size=1.1,halign="start",valign="middle");
// &"VDD" @WIRE(mode="straight",linecolor="#30485d",linewidth=0.16) {#XPHX:4 (231,-10)};
// (231,-9.6) @TEXT("VDD",size=1.1,halign="middle",valign="bottom");
// &"VSS" @WIRE(mode="straight",linecolor="#30485d",linewidth=0.16) {#XPHX:5 (231,-32)};
// (231,-32.4) @TEXT("VSS",size=1.1,halign="middle",valign="top");
// &"PHASE" @WIRE(mode="straight",linecolor="#30485d",linewidth=0.16) {#XPHR:1 (-10,-64)};
// (-10.4,-64) @TEXT("PHASE",size=1.1,halign="end",valign="middle");
// &"VDD" @WIRE(mode="straight",linecolor="#30485d",linewidth=0.16) {#XPHR:3 (0,-54)};
// (0,-53.6) @TEXT("VDD",size=1.1,halign="middle",valign="bottom");
// &"VSS" @WIRE(mode="straight",linecolor="#30485d",linewidth=0.16) {#XPHR:4 (0,-74)};
// (0,-74.4) @TEXT("VSS",size=1.1,halign="middle",valign="top");
// &"SEL9" @WIRE(mode="straight",linecolor="#30485d",linewidth=0.16) {#XWINDOW:2 (17,-59.05)};
// (16.6,-59.05) @TEXT("SEL9",size=1.1,halign="end",valign="middle");
// &"SEL7" @WIRE(mode="straight",linecolor="#30485d",linewidth=0.16) {#XWINDOW:3 (17,-62.35)};
// (16.6,-62.35) @TEXT("SEL7",size=1.1,halign="end",valign="middle");
// &"SEL6" @WIRE(mode="straight",linecolor="#30485d",linewidth=0.16) {#XWINDOW:4 (17,-65.65)};
// (16.6,-65.65) @TEXT("SEL6",size=1.1,halign="end",valign="middle");
// &"SEL5" @WIRE(mode="straight",linecolor="#30485d",linewidth=0.16) {#XWINDOW:5 (17,-68.95)};
// (16.6,-68.95) @TEXT("SEL5",size=1.1,halign="end",valign="middle");
// &"SEL4" @WIRE(mode="straight",linecolor="#30485d",linewidth=0.16) {#XWINDOW:6 (17,-72.25)};
// (16.6,-72.25) @TEXT("SEL4",size=1.1,halign="end",valign="middle");
// &"VDD" @WIRE(mode="straight",linecolor="#30485d",linewidth=0.16) {#XWINDOW:7 (33,-47.45)};
// (33,-47.05) @TEXT("VDD",size=1.1,halign="middle",valign="bottom");
// &"VSS" @WIRE(mode="straight",linecolor="#30485d",linewidth=0.16) {#XWINDOW:8 (33,-80.55)};
// (33,-80.95) @TEXT("VSS",size=1.1,halign="middle",valign="top");
// &"PHASE" @WIRE(mode="straight",linecolor="#30485d",linewidth=0.16) {#XREADY:1 (50,-62.35)};
// (49.6,-62.35) @TEXT("PHASE",size=1.1,halign="end",valign="middle");
// &"READY" @WIRE(mode="straight",linecolor="#30485d",linewidth=0.16) {#XREADY:3 (82,-64)};
// (82.4,-64) @TEXT("READY",size=1.1,halign="start",valign="middle");
// &"VDD" @WIRE(mode="straight",linecolor="#30485d",linewidth=0.16) {#XREADY:4 (66,-53)};
// (66,-52.6) @TEXT("VDD",size=1.1,halign="middle",valign="bottom");
// &"VSS" @WIRE(mode="straight",linecolor="#30485d",linewidth=0.16) {#XREADY:5 (66,-75)};
// (66,-75.4) @TEXT("VSS",size=1.1,halign="middle",valign="top");
// &"READY" @WIRE(mode="straight",linecolor="#30485d",linewidth=0.16) {#XCLR:1 (83,-62.35)};
// (82.6,-62.35) @TEXT("READY",size=1.1,halign="end",valign="middle");
// &"SN" @WIRE(mode="straight",linecolor="#30485d",linewidth=0.16) {#XCLR:2 (83,-65.65)};
// (82.6,-65.65) @TEXT("SN",size=1.1,halign="end",valign="middle");
// &"CLR_N" @WIRE(mode="straight",linecolor="#30485d",linewidth=0.16) {#XCLR:3 (115,-64)};
// (115.4,-64) @TEXT("CLR_N",size=1.1,halign="start",valign="middle");
// &"VDD" @WIRE(mode="straight",linecolor="#30485d",linewidth=0.16) {#XCLR:4 (99,-53)};
// (99,-52.6) @TEXT("VDD",size=1.1,halign="middle",valign="bottom");
// &"VSS" @WIRE(mode="straight",linecolor="#30485d",linewidth=0.16) {#XCLR:5 (99,-75)};
// (99,-75.4) @TEXT("VSS",size=1.1,halign="middle",valign="top");
// &"SN" @WIRE(mode="straight",linecolor="#30485d",linewidth=0.16) {#XSND1:1 (116,-64)};
// (115.6,-64) @TEXT("SN",size=1.1,halign="end",valign="middle");
// &"VDD" @WIRE(mode="straight",linecolor="#30485d",linewidth=0.16) {#XSND1:3 (132,-53)};
// (132,-52.6) @TEXT("VDD",size=1.1,halign="middle",valign="bottom");
// &"VSS" @WIRE(mode="straight",linecolor="#30485d",linewidth=0.16) {#XSND1:4 (132,-75)};
// (132,-75.4) @TEXT("VSS",size=1.1,halign="middle",valign="top");
// &"VDD" @WIRE(mode="straight",linecolor="#30485d",linewidth=0.16) {#XSND2:3 (165,-53)};
// (165,-52.6) @TEXT("VDD",size=1.1,halign="middle",valign="bottom");
// &"VSS" @WIRE(mode="straight",linecolor="#30485d",linewidth=0.16) {#XSND2:4 (165,-75)};
// (165,-75.4) @TEXT("VSS",size=1.1,halign="middle",valign="top");
// &"SN" @WIRE(mode="straight",linecolor="#30485d",linewidth=0.16) {#XSNQ:1 (182,-62.35)};
// (181.6,-62.35) @TEXT("SN",size=1.1,halign="end",valign="middle");
// &"SN_D" @WIRE(mode="straight",linecolor="#30485d",linewidth=0.16) {#XSNQ:3 (214,-64)};
// (214.4,-64) @TEXT("SN_D",size=1.1,halign="start",valign="middle");
// &"VDD" @WIRE(mode="straight",linecolor="#30485d",linewidth=0.16) {#XSNQ:4 (198,-53)};
// (198,-52.6) @TEXT("VDD",size=1.1,halign="middle",valign="bottom");
// &"VSS" @WIRE(mode="straight",linecolor="#30485d",linewidth=0.16) {#XSNQ:5 (198,-75)};
// (198,-75.4) @TEXT("VSS",size=1.1,halign="middle",valign="top");
// &"ACTIVE" @WIRE(mode="straight",linecolor="#30485d",linewidth=0.16) {#XLIVE:1 (-16,-105.35)};
// (-16.4,-105.35) @TEXT("ACTIVE",size=1.1,halign="end",valign="middle");
// &"SN_D" @WIRE(mode="straight",linecolor="#30485d",linewidth=0.16) {#XLIVE:2 (-16,-108.65)};
// (-16.4,-108.65) @TEXT("SN_D",size=1.1,halign="end",valign="middle");
// &"LIVE" @WIRE(mode="straight",linecolor="#30485d",linewidth=0.16) {#XLIVE:3 (16,-107)};
// (16.4,-107) @TEXT("LIVE",size=1.1,halign="start",valign="middle");
// &"VDD" @WIRE(mode="straight",linecolor="#30485d",linewidth=0.16) {#XLIVE:4 (0,-96)};
// (0,-95.6) @TEXT("VDD",size=1.1,halign="middle",valign="bottom");
// &"VSS" @WIRE(mode="straight",linecolor="#30485d",linewidth=0.16) {#XLIVE:5 (0,-118)};
// (0,-118.4) @TEXT("VSS",size=1.1,halign="middle",valign="top");
// &"RAW" @WIRE(mode="straight",linecolor="#30485d",linewidth=0.16) {#XIDLE:1 (23,-107)};
// (22.6,-107) @TEXT("RAW",size=1.1,halign="end",valign="middle");
// &"VDD" @WIRE(mode="straight",linecolor="#30485d",linewidth=0.16) {#XIDLE:3 (33,-97)};
// (33,-96.6) @TEXT("VDD",size=1.1,halign="middle",valign="bottom");
// &"VSS" @WIRE(mode="straight",linecolor="#30485d",linewidth=0.16) {#XIDLE:4 (33,-117)};
// (33,-117.4) @TEXT("VSS",size=1.1,halign="middle",valign="top");
// &"LIVE" @WIRE(mode="straight",linecolor="#30485d",linewidth=0.16) {#XSET0:1 (50,-105.35)};
// (49.6,-105.35) @TEXT("LIVE",size=1.1,halign="end",valign="middle");
// &"VDD" @WIRE(mode="straight",linecolor="#30485d",linewidth=0.16) {#XSET0:4 (66,-96)};
// (66,-95.6) @TEXT("VDD",size=1.1,halign="middle",valign="bottom");
// &"VSS" @WIRE(mode="straight",linecolor="#30485d",linewidth=0.16) {#XSET0:5 (66,-118)};
// (66,-118.4) @TEXT("VSS",size=1.1,halign="middle",valign="top");
// &"READY" @WIRE(mode="straight",linecolor="#30485d",linewidth=0.16) {#XSET:2 (83,-108.65)};
// (82.6,-108.65) @TEXT("READY",size=1.1,halign="end",valign="middle");
// &"SET" @WIRE(mode="straight",linecolor="#30485d",linewidth=0.16) {#XSET:3 (115,-107)};
// (115.4,-107) @TEXT("SET",size=1.1,halign="start",valign="middle");
// &"VDD" @WIRE(mode="straight",linecolor="#30485d",linewidth=0.16) {#XSET:4 (99,-96)};
// (99,-95.6) @TEXT("VDD",size=1.1,halign="middle",valign="bottom");
// &"VSS" @WIRE(mode="straight",linecolor="#30485d",linewidth=0.16) {#XSET:5 (99,-118)};
// (99,-118.4) @TEXT("VSS",size=1.1,halign="middle",valign="top");
// &"VDD" @WIRE(mode="straight",linecolor="#30485d",linewidth=0.16) {#XHIGH:2 (132,-96)};
// (132,-95.6) @TEXT("VDD",size=1.1,halign="middle",valign="bottom");
// &"VSS" @WIRE(mode="straight",linecolor="#30485d",linewidth=0.16) {#XHIGH:3 (132,-118)};
// (132,-118.4) @TEXT("VSS",size=1.1,halign="middle",valign="top");
// &"SET" @WIRE(mode="straight",linecolor="#30485d",linewidth=0.16) {#XCLOCK:2 (149,-107)};
// (148.6,-107) @TEXT("SET",size=1.1,halign="end",valign="middle");
// &"CLR_N" @WIRE(mode="straight",linecolor="#30485d",linewidth=0.16) {#XCLOCK:3 (149,-110.3)};
// (148.6,-110.3) @TEXT("CLR_N",size=1.1,halign="end",valign="middle");
// &"VDD" @WIRE(mode="straight",linecolor="#30485d",linewidth=0.16) {#XCLOCK:5 (165,-95.4)};
// (165,-95) @TEXT("VDD",size=1.1,halign="middle",valign="bottom");
// &"VSS" @WIRE(mode="straight",linecolor="#30485d",linewidth=0.16) {#XCLOCK:6 (165,-118.6)};
// (165,-119) @TEXT("VSS",size=1.1,halign="middle",valign="top");
// &"CMP_CLK" @WIRE(mode="straight",linecolor="#30485d",linewidth=0.16) {#XCMP:2 (214,-107)};
// (214.4,-107) @TEXT("CMP_CLK",size=1.1,halign="start",valign="middle");
// &"VDD" @WIRE(mode="straight",linecolor="#30485d",linewidth=0.16) {#XCMP:3 (198,-96)};
// (198,-95.6) @TEXT("VDD",size=1.1,halign="middle",valign="bottom");
// &"VSS" @WIRE(mode="straight",linecolor="#30485d",linewidth=0.16) {#XCMP:4 (198,-118)};
// (198,-118.4) @TEXT("VSS",size=1.1,halign="middle",valign="top");
// }
// END SARADC RNL
ends sar8_se_timing

subckt sar8_se_store CK DATA RESET VDD VSS Q
XDR (DATA RESET DIN VDD VSS) OR2D1BWP12T30P140
XCLR (RESET RST_N VDD VSS) INVD1BWP12T30P140
XREG (DIN CK RST_N Q VDD VSS) DFCNQD1BWP12T30P140
// BEGIN SARADC RNL
// @RNL(author="saradc topology") {
// #XDR @SET-SYMBOL $S_OR2D1BWP12T30P140;
// #XDR @PLACE(0,10) => @ORIENT("R0");
// #XDR @TEXT("",key="name",size=1.65,halign="middle",textcolor="#223d52") => @PLACE(0,10);
// #XDR @TEXT("",key="model");
// #XCLR @SET-SYMBOL $S_INVD1BWP12T30P140;
// #XCLR @PLACE(0,-10) => @ORIENT("R0");
// #XCLR @TEXT("",key="name",size=1.65,halign="middle",textcolor="#223d52") => @PLACE(0,-10);
// #XCLR @TEXT("",key="model");
// #XREG @SET-SYMBOL $S_DFCNQD1BWP12T30P140;
// #XREG @PLACE(35,0) => @ORIENT("R0");
// #XREG @TEXT("",key="name",size=1.65,halign="middle",textcolor="#223d52") => @PLACE(35,0);
// #XREG @TEXT("",key="model");
// (-22,26) @TEXT("Commit register",size=2,halign="start",textcolor="#223d52");
// %sar_port1 = $IO_PORT @ATTACH &"DATA" => @PLACE(-17,11.7);
// &"DATA" @WIRE(mode="straight",linecolor="#30485d",linewidth=0.16) {%sar_port1:p #XDR:1};
// %sar_junction2 = (-17,0);
// %sar_junction2 @CIRCLE(radius=0.34,linecolor="#30485d",fill="fillcolor",fillcolor="#30485d") => @LAYER("top");
// %sar_port3 = $IO_PORT @ATTACH &"RESET" => @PLACE(-25,0) => @ORIENT("R0");
// &"RESET" @WIRE(mode="straight",linecolor="#94601a",linewidth=0.16) {%sar_port3:p %sar_junction2};
// &"RESET" @WIRE(mode="straight",linecolor="#94601a",linewidth=0.16) {%sar_junction2 (-17,8.3) #XDR:2};
// &"RESET" @WIRE(mode="straight",linecolor="#94601a",linewidth=0.16) {%sar_junction2 (-17,-10) #XCLR:1};
// &"DIN" @WIRE(mode="straight",linecolor="#30485d",linewidth=0.16) {#XDR:3 (17.5,10) (17.5,3.4) #XREG:1};
// &"RST_N" @WIRE(mode="straight",linecolor="#30485d",linewidth=0.16) {#XCLR:2 (17.5,-10) (17.5,-3.4) #XREG:3};
// %sar_port4 = $IO_PORT @ATTACH &"CK" => @PLACE(20,0);
// &"CK" @WIRE(mode="straight",linecolor="#94601a",linewidth=0.16) {%sar_port4:p #XREG:2};
// %sar_port5 = $IO_PORT @ATTACH &"Q" => @PLACE(51,0) => @ORIENT("MY");
// &"Q" @WIRE(mode="straight",linecolor="#30485d",linewidth=0.16) {#XREG:4 %sar_port5:p};
// &"VDD" @WIRE(mode="straight",linecolor="#647584",linewidth=0.16) {#XDR:4 (0,18.45)};
// (0,18.77) @TEXT("VDD",size=0.98,halign="middle",valign="bottom");
// &"VSS" @WIRE(mode="straight",linecolor="#647584",linewidth=0.16) {#XDR:5 (0,1.55)};
// (0,1.23) @TEXT("VSS",size=0.98,halign="middle",valign="top");
// &"VDD" @WIRE(mode="straight",linecolor="#647584",linewidth=0.16) {#XCLR:3 (0,-1.55)};
// (0,-1.23) @TEXT("VDD",size=0.98,halign="middle",valign="bottom");
// &"VSS" @WIRE(mode="straight",linecolor="#647584",linewidth=0.16) {#XCLR:4 (0,-18.45)};
// (0,-18.77) @TEXT("VSS",size=0.98,halign="middle",valign="top");
// &"VDD" @WIRE(mode="straight",linecolor="#647584",linewidth=0.16) {#XREG:5 (35,8.45)};
// (35,8.77) @TEXT("VDD",size=0.98,halign="middle",valign="bottom");
// &"VSS" @WIRE(mode="straight",linecolor="#647584",linewidth=0.16) {#XREG:6 (35,-8.45)};
// (35,-8.77) @TEXT("VSS",size=0.98,halign="middle",valign="top");
// }
// END SARADC RNL
ends sar8_se_store

subckt sar8_se_ctrl CMP_CLK CODE0 CODE1 CODE2 CODE3 CODE4 CODE5 CODE6 CODE7 COMP_N COMP_P D0 D1 D2 D3 D4 D5 D6 D7 COMMIT SAMPLE VDD VSS ACTIVE
XTIM (ACTIVE SAMPLE SEL9 SEL7 SEL6 SEL5 SEL4 COMP_P COMP_N CMP_CLK COMMIT DATA VDD VSS) sar8_se_timing
XWORD (CODE0 CODE1 CODE2 CODE3 CODE4 CODE5 CODE6 CODE7 DATA DONE D0 D1 D2 D3 D4 D5 D6 D7 NEXT0 NEXT1 NEXT2 NEXT3 NEXT4 NEXT5 NEXT6 NEXT7 TRIAL6 TRIAL5 TRIAL4 TRIAL3 TRIAL2 VDD VSS) sar8_next_word
// Sticky tap selects: the commit of bit k sets the select for bit k-1 until the
// next accepted sample. Each feeds only the window multiplexers.
// The OR is INV+INV+ND2: a trial glitch while the select is already set must not lift a
// floating PMOS stack node above the rail (FF-cold terminal-voltage screen).
XSEL9_QB (SEL9 SEL9_QB VDD VSS) INVD1BWP12T30P140
XSEL9_TB (TRIAL6 SEL9_TB VDD VSS) INVD1BWP12T30P140
XSEL9_D (SEL9_QB SEL9_TB SEL9_D VDD VSS) ND2D1BWP12T30P140
XSEL9 (COMMIT SEL9_D SAMPLE VDD VSS SEL9) sar8_se_store
XSEL7_QB (SEL7 SEL7_QB VDD VSS) INVD1BWP12T30P140
XSEL7_TB (TRIAL5 SEL7_TB VDD VSS) INVD1BWP12T30P140
XSEL7_D (SEL7_QB SEL7_TB SEL7_D VDD VSS) ND2D1BWP12T30P140
XSEL7 (COMMIT SEL7_D SAMPLE VDD VSS SEL7) sar8_se_store
XSEL6_QB (SEL6 SEL6_QB VDD VSS) INVD1BWP12T30P140
XSEL6_TB (TRIAL4 SEL6_TB VDD VSS) INVD1BWP12T30P140
XSEL6_D (SEL6_QB SEL6_TB SEL6_D VDD VSS) ND2D1BWP12T30P140
XSEL6 (COMMIT SEL6_D SAMPLE VDD VSS SEL6) sar8_se_store
XSEL5_QB (SEL5 SEL5_QB VDD VSS) INVD1BWP12T30P140
XSEL5_TB (TRIAL3 SEL5_TB VDD VSS) INVD1BWP12T30P140
XSEL5_D (SEL5_QB SEL5_TB SEL5_D VDD VSS) ND2D1BWP12T30P140
XSEL5 (COMMIT SEL5_D SAMPLE VDD VSS SEL5) sar8_se_store
XSEL4_QB (SEL4 SEL4_QB VDD VSS) INVD1BWP12T30P140
XSEL4_TB (TRIAL2 SEL4_TB VDD VSS) INVD1BWP12T30P140
XSEL4_D (SEL4_QB SEL4_TB SEL4_D VDD VSS) ND2D1BWP12T30P140
XSEL4 (COMMIT SEL4_D SAMPLE VDD VSS SEL4) sar8_se_store
XDONE (COMMIT CODE0 SAMPLE VDD VSS DONE) sar8_se_store
XACTIVE (DONE ACTIVE VDD VSS) INVD1BWP12T30P140
XBIT0 (COMMIT NEXT0 SAMPLE VDD VSS CODE0) sar8_se_store
XBIT1 (COMMIT NEXT1 SAMPLE VDD VSS CODE1) sar8_se_store
XBIT2 (COMMIT NEXT2 SAMPLE VDD VSS CODE2) sar8_se_store
XBIT3 (COMMIT NEXT3 SAMPLE VDD VSS CODE3) sar8_se_store
XBIT4 (COMMIT NEXT4 SAMPLE VDD VSS CODE4) sar8_se_store
XBIT5 (COMMIT NEXT5 SAMPLE VDD VSS CODE5) sar8_se_store
XBIT6 (COMMIT NEXT6 SAMPLE VDD VSS CODE6) sar8_se_store
XMSBD (NEXT7 MSBD VDD VSS) INVD1BWP12T30P140
XBIT7 (COMMIT MSBD SAMPLE VDD VSS MSBQ) sar8_se_store
XMSBQ (MSBQ CODE7 VDD VSS) INVD1BWP12T30P140
// BEGIN SARADC RNL
// @RNL(author="saradc topology") {
// (-25,92) @TEXT("SAR / Single-edge controller",size=2.55,halign="start",textcolor="#223d52");
// #XTIM @SET-SYMBOL $S_sar8_se_timing;
// #XTIM @PLACE(-2,55) => @ORIENT("R0");
// #XWORD @SET-SYMBOL $S_sar8_next_word;
// #XWORD @PLACE(64,55) => @ORIENT("R0");
// #XDONE @SET-SYMBOL $S_sar8_se_store;
// #XDONE @PLACE(136,55) => @ORIENT("R0");
// #XACTIVE @SET-SYMBOL $S_INVD1BWP12T30P140;
// #XACTIVE @PLACE(165,55) => @ORIENT("R0");
// #XTIM @TEXT("Timing",key="name",size=1.65,halign="middle",textcolor="#223d52") => @PLACE(-2,55);
// #XTIM @TEXT("",key="model");
// #XWORD @TEXT("Trial word",key="name",size=1.65,halign="middle",textcolor="#223d52") => @PLACE(64,55);
// #XWORD @TEXT("",key="model");
// #XDONE @TEXT("Last bit",key="name",size=1.65,halign="middle",textcolor="#223d52") => @PLACE(136,55);
// #XDONE @TEXT("",key="model");
// #XACTIVE @TEXT("Active",key="name",size=1.65,halign="middle",textcolor="#223d52") => @PLACE(165,64);
// #XACTIVE @TEXT("",key="model");
// {#XTIM} @GROUP;
// @RECTANGLE(linecolor="#a9b8c5",linewidth=0.16,fill="fillcolor",fillcolor="#f7f9fc") {(-25,36) (25,79)} => @LAYER("bottom");
// (-22,75) @TEXT("Compare and commit",size=1.95,halign="start",textcolor="#223d52");
// (-22,71.5) @TEXT("Latch the comparator result.",size=1.26,halign="start",textcolor="#223d52");
// {#XWORD} @GROUP;
// @RECTANGLE(linecolor="#a9b8c5",linewidth=0.16,fill="fillcolor",fillcolor="#f7f9fc") {(42,36) (90,79)} => @LAYER("bottom");
// (45,75) @TEXT("Next trial word",size=1.95,halign="start",textcolor="#223d52");
// (45,71.5) @TEXT("Build the next word and expose D.",size=1.26,halign="start",textcolor="#223d52");
// {#XDONE #XACTIVE} @GROUP;
// @RECTANGLE(linecolor="#a9b8c5",linewidth=0.16,fill="fillcolor",fillcolor="#f7f9fc") {(116,36) (190,79)} => @LAYER("bottom");
// (119,75) @TEXT("Conversion complete",size=1.95,halign="start",textcolor="#223d52");
// (119,71.5) @TEXT("Release ACTIVE after the last commit.",size=1.26,halign="start",textcolor="#223d52");
// &"DATA" @WIRE(mode="straight",linecolor="#30485d",linewidth=0.16) {#XTIM:12 (34,58.3) (34,56.65) #XWORD:9};
// &"COMMIT" @WIRE(mode="straight",linecolor="#94601a",linewidth=0.16) {#XTIM:11 (32,55) (32,83) (110,83) (110,56.65) #XDONE:1};
// (78,85) @TEXT("COMMIT",size=1.1,halign="start",textcolor="#223d52");
// %sar_junction1 = (149,47);
// %sar_junction1 @CIRCLE(radius=0.34,linecolor="#30485d",fill="fillcolor",fillcolor="#30485d") => @LAYER("top");
// &"DONE" @WIRE(mode="straight",linecolor="#30485d",linewidth=0.16) {#XDONE:6 %sar_junction1 (150,47) (150,55) #XACTIVE:1};
// &"DONE" @WIRE(mode="straight",linecolor="#30485d",linewidth=0.16) {%sar_junction1 (149,38) (94,38) (94,55) #XWORD:10};
// #XBIT7 @SET-SYMBOL $S_sar8_se_store;
// #XBIT7 @PLACE(0,-4) => @ORIENT("R0");
// #XBIT7 @TEXT("B7",key="name",size=1.65,halign="middle",textcolor="#223d52") => @PLACE(0,-4);
// #XBIT7 @TEXT("",key="model");
// #XBIT6 @SET-SYMBOL $S_sar8_se_store;
// #XBIT6 @PLACE(26,-4) => @ORIENT("R0");
// #XBIT6 @TEXT("B6",key="name",size=1.65,halign="middle",textcolor="#223d52") => @PLACE(26,-4);
// #XBIT6 @TEXT("",key="model");
// #XBIT5 @SET-SYMBOL $S_sar8_se_store;
// #XBIT5 @PLACE(52,-4) => @ORIENT("R0");
// #XBIT5 @TEXT("B5",key="name",size=1.65,halign="middle",textcolor="#223d52") => @PLACE(52,-4);
// #XBIT5 @TEXT("",key="model");
// #XBIT4 @SET-SYMBOL $S_sar8_se_store;
// #XBIT4 @PLACE(78,-4) => @ORIENT("R0");
// #XBIT4 @TEXT("B4",key="name",size=1.65,halign="middle",textcolor="#223d52") => @PLACE(78,-4);
// #XBIT4 @TEXT("",key="model");
// #XBIT3 @SET-SYMBOL $S_sar8_se_store;
// #XBIT3 @PLACE(104,-4) => @ORIENT("R0");
// #XBIT3 @TEXT("B3",key="name",size=1.65,halign="middle",textcolor="#223d52") => @PLACE(104,-4);
// #XBIT3 @TEXT("",key="model");
// #XBIT2 @SET-SYMBOL $S_sar8_se_store;
// #XBIT2 @PLACE(130,-4) => @ORIENT("R0");
// #XBIT2 @TEXT("B2",key="name",size=1.65,halign="middle",textcolor="#223d52") => @PLACE(130,-4);
// #XBIT2 @TEXT("",key="model");
// #XBIT1 @SET-SYMBOL $S_sar8_se_store;
// #XBIT1 @PLACE(156,-4) => @ORIENT("R0");
// #XBIT1 @TEXT("B1",key="name",size=1.65,halign="middle",textcolor="#223d52") => @PLACE(156,-4);
// #XBIT1 @TEXT("",key="model");
// #XBIT0 @SET-SYMBOL $S_sar8_se_store;
// #XBIT0 @PLACE(182,-4) => @ORIENT("R0");
// #XBIT0 @TEXT("B0",key="name",size=1.65,halign="middle",textcolor="#223d52") => @PLACE(182,-4);
// #XBIT0 @TEXT("",key="model");
// #XMSBD @SET-SYMBOL $S_INVD1BWP12T30P140;
// #XMSBD @PLACE(-13,5) => @ORIENT("R0");
// #XMSBQ @SET-SYMBOL $S_INVD1BWP12T30P140;
// #XMSBQ @PLACE(-10,-22) => @ORIENT("R0");
// #XMSBD @TEXT("MSB in",key="name",size=1.65,halign="middle",textcolor="#223d52") => @PLACE(-13,13);
// #XMSBD @TEXT("",key="model");
// #XMSBQ @TEXT("MSB out",key="name",size=1.65,halign="middle",textcolor="#223d52") => @PLACE(-10,-14);
// #XMSBQ @TEXT("",key="model");
// {#XBIT7 #XBIT6 #XBIT5 #XBIT4 #XBIT3 #XBIT2 #XBIT1 #XBIT0 #XMSBD #XMSBQ} @GROUP;
// @RECTANGLE(linecolor="#a9b8c5",linewidth=0.16,fill="fillcolor",fillcolor="#f7f9fc") {(-24,-35) (204,30)} => @LAYER("bottom");
// (-21,26) @TEXT("Bit registers",size=1.95,halign="start",textcolor="#223d52");
// (-21,22.5) @TEXT("COMMIT stores NEXT as CODE for the next comparison.",size=1.26,halign="start",textcolor="#223d52");
// %sar_junction2 = (101,18);
// %sar_junction2 @CIRCLE(radius=0.34,linecolor="#30485d",fill="fillcolor",fillcolor="#30485d") => @LAYER("top");
// {&"NEXT0" &"NEXT1" &"NEXT2" &"NEXT3" &"NEXT4" &"NEXT5" &"NEXT6" &"NEXT7"} @WIRE(mode="straight",linewidth=0.27,linecolor="#66538a") {#XWORD:19 (101,51.7) %sar_junction2};
// %sar_junction3 = (178,18);
// %sar_junction3 @CIRCLE(radius=0.34,linecolor="#30485d",fill="fillcolor",fillcolor="#30485d") => @LAYER("top");
// %sar_junction4 = (186,-31);
// %sar_junction4 @CIRCLE(radius=0.34,linecolor="#30485d",fill="fillcolor",fillcolor="#30485d") => @LAYER("top");
// &"NEXT0" @WIRE(mode="straight",linecolor="#30485d",linewidth=0.16) {%sar_junction3 #XBIT0:2};
// &"CODE0" @WIRE(mode="straight",linecolor="#30485d",linewidth=0.16) {#XBIT0:6 %sar_junction4};
// %sar_junction5 = (152,18);
// %sar_junction5 @CIRCLE(radius=0.34,linecolor="#30485d",fill="fillcolor",fillcolor="#30485d") => @LAYER("top");
// %sar_junction6 = (160,-31);
// %sar_junction6 @CIRCLE(radius=0.34,linecolor="#30485d",fill="fillcolor",fillcolor="#30485d") => @LAYER("top");
// &"NEXT1" @WIRE(mode="straight",linecolor="#30485d",linewidth=0.16) {%sar_junction5 #XBIT1:2};
// &"CODE1" @WIRE(mode="straight",linecolor="#30485d",linewidth=0.16) {#XBIT1:6 %sar_junction6};
// %sar_junction7 = (126,18);
// %sar_junction7 @CIRCLE(radius=0.34,linecolor="#30485d",fill="fillcolor",fillcolor="#30485d") => @LAYER("top");
// %sar_junction8 = (134,-31);
// %sar_junction8 @CIRCLE(radius=0.34,linecolor="#30485d",fill="fillcolor",fillcolor="#30485d") => @LAYER("top");
// &"NEXT2" @WIRE(mode="straight",linecolor="#30485d",linewidth=0.16) {%sar_junction7 #XBIT2:2};
// &"CODE2" @WIRE(mode="straight",linecolor="#30485d",linewidth=0.16) {#XBIT2:6 %sar_junction8};
// %sar_junction9 = (100,18);
// %sar_junction9 @CIRCLE(radius=0.34,linecolor="#30485d",fill="fillcolor",fillcolor="#30485d") => @LAYER("top");
// %sar_junction10 = (108,-31);
// %sar_junction10 @CIRCLE(radius=0.34,linecolor="#30485d",fill="fillcolor",fillcolor="#30485d") => @LAYER("top");
// &"NEXT3" @WIRE(mode="straight",linecolor="#30485d",linewidth=0.16) {%sar_junction9 #XBIT3:2};
// &"CODE3" @WIRE(mode="straight",linecolor="#30485d",linewidth=0.16) {#XBIT3:6 %sar_junction10};
// %sar_junction11 = (74,18);
// %sar_junction11 @CIRCLE(radius=0.34,linecolor="#30485d",fill="fillcolor",fillcolor="#30485d") => @LAYER("top");
// %sar_junction12 = (82,-31);
// %sar_junction12 @CIRCLE(radius=0.34,linecolor="#30485d",fill="fillcolor",fillcolor="#30485d") => @LAYER("top");
// &"NEXT4" @WIRE(mode="straight",linecolor="#30485d",linewidth=0.16) {%sar_junction11 #XBIT4:2};
// &"CODE4" @WIRE(mode="straight",linecolor="#30485d",linewidth=0.16) {#XBIT4:6 %sar_junction12};
// %sar_junction13 = (48,18);
// %sar_junction13 @CIRCLE(radius=0.34,linecolor="#30485d",fill="fillcolor",fillcolor="#30485d") => @LAYER("top");
// %sar_junction14 = (56,-31);
// %sar_junction14 @CIRCLE(radius=0.34,linecolor="#30485d",fill="fillcolor",fillcolor="#30485d") => @LAYER("top");
// &"NEXT5" @WIRE(mode="straight",linecolor="#30485d",linewidth=0.16) {%sar_junction13 #XBIT5:2};
// &"CODE5" @WIRE(mode="straight",linecolor="#30485d",linewidth=0.16) {#XBIT5:6 %sar_junction14};
// %sar_junction15 = (22,18);
// %sar_junction15 @CIRCLE(radius=0.34,linecolor="#30485d",fill="fillcolor",fillcolor="#30485d") => @LAYER("top");
// %sar_junction16 = (30,-31);
// %sar_junction16 @CIRCLE(radius=0.34,linecolor="#30485d",fill="fillcolor",fillcolor="#30485d") => @LAYER("top");
// &"NEXT6" @WIRE(mode="straight",linecolor="#30485d",linewidth=0.16) {%sar_junction15 #XBIT6:2};
// &"CODE6" @WIRE(mode="straight",linecolor="#30485d",linewidth=0.16) {#XBIT6:6 %sar_junction16};
// &"MSBD" @WIRE(mode="straight",linecolor="#30485d",linewidth=0.16) {#XMSBD:2 (-4,5) #XBIT7:2};
// &"MSBQ" @WIRE(mode="straight",linecolor="#30485d",linewidth=0.16) {#XBIT7:6 (4,-18) (-19,-18) (-19,-22) #XMSBQ:1};
// %sar_junction17 = (-21,18);
// %sar_junction17 @CIRCLE(radius=0.34,linecolor="#30485d",fill="fillcolor",fillcolor="#30485d") => @LAYER("top");
// %sar_junction18 = (-3,-31);
// %sar_junction18 @CIRCLE(radius=0.34,linecolor="#30485d",fill="fillcolor",fillcolor="#30485d") => @LAYER("top");
// &"NEXT7" @WIRE(mode="straight",linecolor="#30485d",linewidth=0.16) {%sar_junction17 (-21,5) #XMSBD:1};
// &"CODE7" @WIRE(mode="straight",linecolor="#30485d",linewidth=0.16) {#XMSBQ:2 %sar_junction18};
// {&"NEXT0" &"NEXT1" &"NEXT2" &"NEXT3" &"NEXT4" &"NEXT5" &"NEXT6" &"NEXT7"} @WIRE(mode="straight",linewidth=0.27,linecolor="#66538a") {%sar_junction17 %sar_junction15 %sar_junction13 %sar_junction11 %sar_junction9 %sar_junction2 %sar_junction7 %sar_junction5 %sar_junction3};
// {&"CODE0" &"CODE1" &"CODE2" &"CODE3" &"CODE4" &"CODE5" &"CODE6" &"CODE7"} @WIRE(mode="straight",linewidth=0.27,linecolor="#66538a") {#XWORD:1 (35,53.35) (35,32) (-28,32) (-28,-31) %sar_junction18 %sar_junction16 %sar_junction14 %sar_junction12 %sar_junction10 %sar_junction8 %sar_junction6 %sar_junction4};
// (152,20.2) @TEXT("NEXT[7:0]",size=1.15,halign="start",textcolor="#223d52");
// (152,-28.8) @TEXT("CODE[7:0]",size=1.15,halign="start",textcolor="#223d52");
// #XSEL9_QB @SET-SYMBOL $S_INVD1BWP12T30P140;
// #XSEL9_QB @PLACE(0,-60) => @ORIENT("R0");
// #XSEL9_QB @TEXT("",key="name",size=1.65,halign="middle",textcolor="#223d52") => @PLACE(0,-60);
// #XSEL9_QB @TEXT("",key="model");
// #XSEL9_TB @SET-SYMBOL $S_INVD1BWP12T30P140;
// #XSEL9_TB @PLACE(2,-76) => @ORIENT("R0");
// #XSEL9_TB @TEXT("",key="name",size=1.65,halign="middle",textcolor="#223d52") => @PLACE(2,-76);
// #XSEL9_TB @TEXT("",key="model");
// #XSEL9_D @SET-SYMBOL $S_ND2D1BWP12T30P140;
// #XSEL9_D @PLACE(16,-67) => @ORIENT("R0");
// #XSEL9_D @TEXT("",key="name",size=1.65,halign="middle",textcolor="#223d52") => @PLACE(16,-67);
// #XSEL9_D @TEXT("",key="model");
// #XSEL9 @SET-SYMBOL $S_sar8_se_store;
// #XSEL9 @PLACE(22,-88) => @ORIENT("R0");
// #XSEL9 @TEXT("Tap 9",key="name",size=1.65,halign="middle",textcolor="#223d52") => @PLACE(22,-88);
// #XSEL9 @TEXT("",key="model");
// &"SEL9_QB" @WIRE(mode="straight",linecolor="#30485d",linewidth=0.16) {#XSEL9_QB:2 (8,-60) (8,-65.3) #XSEL9_D:1};
// &"SEL9_TB" @WIRE(mode="straight",linecolor="#30485d",linewidth=0.16) {#XSEL9_TB:2 (9,-76) (9,-68.7) #XSEL9_D:2};
// &"SEL9_D" @WIRE(mode="straight",linecolor="#30485d",linewidth=0.16) {#XSEL9_D:3 (27,-67) (27,-77) (18,-77) #XSEL9:2};
// #XSEL7_QB @SET-SYMBOL $S_INVD1BWP12T30P140;
// #XSEL7_QB @PLACE(41,-60) => @ORIENT("R0");
// #XSEL7_QB @TEXT("",key="name",size=1.65,halign="middle",textcolor="#223d52") => @PLACE(41,-60);
// #XSEL7_QB @TEXT("",key="model");
// #XSEL7_TB @SET-SYMBOL $S_INVD1BWP12T30P140;
// #XSEL7_TB @PLACE(43,-76) => @ORIENT("R0");
// #XSEL7_TB @TEXT("",key="name",size=1.65,halign="middle",textcolor="#223d52") => @PLACE(43,-76);
// #XSEL7_TB @TEXT("",key="model");
// #XSEL7_D @SET-SYMBOL $S_ND2D1BWP12T30P140;
// #XSEL7_D @PLACE(57,-67) => @ORIENT("R0");
// #XSEL7_D @TEXT("",key="name",size=1.65,halign="middle",textcolor="#223d52") => @PLACE(57,-67);
// #XSEL7_D @TEXT("",key="model");
// #XSEL7 @SET-SYMBOL $S_sar8_se_store;
// #XSEL7 @PLACE(63,-88) => @ORIENT("R0");
// #XSEL7 @TEXT("Tap 7",key="name",size=1.65,halign="middle",textcolor="#223d52") => @PLACE(63,-88);
// #XSEL7 @TEXT("",key="model");
// &"SEL7_QB" @WIRE(mode="straight",linecolor="#30485d",linewidth=0.16) {#XSEL7_QB:2 (49,-60) (49,-65.3) #XSEL7_D:1};
// &"SEL7_TB" @WIRE(mode="straight",linecolor="#30485d",linewidth=0.16) {#XSEL7_TB:2 (50,-76) (50,-68.7) #XSEL7_D:2};
// &"SEL7_D" @WIRE(mode="straight",linecolor="#30485d",linewidth=0.16) {#XSEL7_D:3 (68,-67) (68,-77) (59,-77) #XSEL7:2};
// #XSEL6_QB @SET-SYMBOL $S_INVD1BWP12T30P140;
// #XSEL6_QB @PLACE(82,-60) => @ORIENT("R0");
// #XSEL6_QB @TEXT("",key="name",size=1.65,halign="middle",textcolor="#223d52") => @PLACE(82,-60);
// #XSEL6_QB @TEXT("",key="model");
// #XSEL6_TB @SET-SYMBOL $S_INVD1BWP12T30P140;
// #XSEL6_TB @PLACE(84,-76) => @ORIENT("R0");
// #XSEL6_TB @TEXT("",key="name",size=1.65,halign="middle",textcolor="#223d52") => @PLACE(84,-76);
// #XSEL6_TB @TEXT("",key="model");
// #XSEL6_D @SET-SYMBOL $S_ND2D1BWP12T30P140;
// #XSEL6_D @PLACE(98,-67) => @ORIENT("R0");
// #XSEL6_D @TEXT("",key="name",size=1.65,halign="middle",textcolor="#223d52") => @PLACE(98,-67);
// #XSEL6_D @TEXT("",key="model");
// #XSEL6 @SET-SYMBOL $S_sar8_se_store;
// #XSEL6 @PLACE(104,-88) => @ORIENT("R0");
// #XSEL6 @TEXT("Tap 6",key="name",size=1.65,halign="middle",textcolor="#223d52") => @PLACE(104,-88);
// #XSEL6 @TEXT("",key="model");
// &"SEL6_QB" @WIRE(mode="straight",linecolor="#30485d",linewidth=0.16) {#XSEL6_QB:2 (90,-60) (90,-65.3) #XSEL6_D:1};
// &"SEL6_TB" @WIRE(mode="straight",linecolor="#30485d",linewidth=0.16) {#XSEL6_TB:2 (91,-76) (91,-68.7) #XSEL6_D:2};
// &"SEL6_D" @WIRE(mode="straight",linecolor="#30485d",linewidth=0.16) {#XSEL6_D:3 (109,-67) (109,-77) (100,-77) #XSEL6:2};
// #XSEL5_QB @SET-SYMBOL $S_INVD1BWP12T30P140;
// #XSEL5_QB @PLACE(123,-60) => @ORIENT("R0");
// #XSEL5_QB @TEXT("",key="name",size=1.65,halign="middle",textcolor="#223d52") => @PLACE(123,-60);
// #XSEL5_QB @TEXT("",key="model");
// #XSEL5_TB @SET-SYMBOL $S_INVD1BWP12T30P140;
// #XSEL5_TB @PLACE(125,-76) => @ORIENT("R0");
// #XSEL5_TB @TEXT("",key="name",size=1.65,halign="middle",textcolor="#223d52") => @PLACE(125,-76);
// #XSEL5_TB @TEXT("",key="model");
// #XSEL5_D @SET-SYMBOL $S_ND2D1BWP12T30P140;
// #XSEL5_D @PLACE(139,-67) => @ORIENT("R0");
// #XSEL5_D @TEXT("",key="name",size=1.65,halign="middle",textcolor="#223d52") => @PLACE(139,-67);
// #XSEL5_D @TEXT("",key="model");
// #XSEL5 @SET-SYMBOL $S_sar8_se_store;
// #XSEL5 @PLACE(145,-88) => @ORIENT("R0");
// #XSEL5 @TEXT("Tap 5",key="name",size=1.65,halign="middle",textcolor="#223d52") => @PLACE(145,-88);
// #XSEL5 @TEXT("",key="model");
// &"SEL5_QB" @WIRE(mode="straight",linecolor="#30485d",linewidth=0.16) {#XSEL5_QB:2 (131,-60) (131,-65.3) #XSEL5_D:1};
// &"SEL5_TB" @WIRE(mode="straight",linecolor="#30485d",linewidth=0.16) {#XSEL5_TB:2 (132,-76) (132,-68.7) #XSEL5_D:2};
// &"SEL5_D" @WIRE(mode="straight",linecolor="#30485d",linewidth=0.16) {#XSEL5_D:3 (150,-67) (150,-77) (141,-77) #XSEL5:2};
// #XSEL4_QB @SET-SYMBOL $S_INVD1BWP12T30P140;
// #XSEL4_QB @PLACE(164,-60) => @ORIENT("R0");
// #XSEL4_QB @TEXT("",key="name",size=1.65,halign="middle",textcolor="#223d52") => @PLACE(164,-60);
// #XSEL4_QB @TEXT("",key="model");
// #XSEL4_TB @SET-SYMBOL $S_INVD1BWP12T30P140;
// #XSEL4_TB @PLACE(166,-76) => @ORIENT("R0");
// #XSEL4_TB @TEXT("",key="name",size=1.65,halign="middle",textcolor="#223d52") => @PLACE(166,-76);
// #XSEL4_TB @TEXT("",key="model");
// #XSEL4_D @SET-SYMBOL $S_ND2D1BWP12T30P140;
// #XSEL4_D @PLACE(180,-67) => @ORIENT("R0");
// #XSEL4_D @TEXT("",key="name",size=1.65,halign="middle",textcolor="#223d52") => @PLACE(180,-67);
// #XSEL4_D @TEXT("",key="model");
// #XSEL4 @SET-SYMBOL $S_sar8_se_store;
// #XSEL4 @PLACE(186,-88) => @ORIENT("R0");
// #XSEL4 @TEXT("Tap 4",key="name",size=1.65,halign="middle",textcolor="#223d52") => @PLACE(186,-88);
// #XSEL4 @TEXT("",key="model");
// &"SEL4_QB" @WIRE(mode="straight",linecolor="#30485d",linewidth=0.16) {#XSEL4_QB:2 (172,-60) (172,-65.3) #XSEL4_D:1};
// &"SEL4_TB" @WIRE(mode="straight",linecolor="#30485d",linewidth=0.16) {#XSEL4_TB:2 (173,-76) (173,-68.7) #XSEL4_D:2};
// &"SEL4_D" @WIRE(mode="straight",linecolor="#30485d",linewidth=0.16) {#XSEL4_D:3 (191,-67) (191,-77) (182,-77) #XSEL4:2};
// &"VDD" @WIRE(mode="straight",linecolor="#647584",linewidth=0.16) {#XSEL9_QB:3 (0,-51.55)};
// (0,-51.23) @TEXT("VDD",size=0.98,halign="middle",valign="bottom");
// &"VSS" @WIRE(mode="straight",linecolor="#647584",linewidth=0.16) {#XSEL9_QB:4 (0,-68.45)};
// (0,-68.77) @TEXT("VSS",size=0.98,halign="middle",valign="top");
// &"VDD" @WIRE(mode="straight",linecolor="#647584",linewidth=0.16) {#XSEL9_TB:3 (2,-67.55)};
// (2,-67.23) @TEXT("VDD",size=0.98,halign="middle",valign="bottom");
// &"VSS" @WIRE(mode="straight",linecolor="#647584",linewidth=0.16) {#XSEL9_TB:4 (2,-84.45)};
// (2,-84.77) @TEXT("VSS",size=0.98,halign="middle",valign="top");
// &"VDD" @WIRE(mode="straight",linecolor="#647584",linewidth=0.16) {#XSEL9_D:4 (16,-58.55)};
// (16,-58.23) @TEXT("VDD",size=0.98,halign="middle",valign="bottom");
// &"VSS" @WIRE(mode="straight",linecolor="#647584",linewidth=0.16) {#XSEL9_D:5 (16,-75.45)};
// (16,-75.77) @TEXT("VSS",size=0.98,halign="middle",valign="top");
// &"VDD" @WIRE(mode="straight",linecolor="#647584",linewidth=0.16) {#XSEL9:4 (26,-78.55)};
// (26,-78.23) @TEXT("VDD",size=0.98,halign="middle",valign="bottom");
// &"VSS" @WIRE(mode="straight",linecolor="#647584",linewidth=0.16) {#XSEL9:5 (18,-97.45)};
// (18,-97.77) @TEXT("VSS",size=0.98,halign="middle",valign="top");
// &"VDD" @WIRE(mode="straight",linecolor="#647584",linewidth=0.16) {#XSEL7_QB:3 (41,-51.55)};
// (41,-51.23) @TEXT("VDD",size=0.98,halign="middle",valign="bottom");
// &"VSS" @WIRE(mode="straight",linecolor="#647584",linewidth=0.16) {#XSEL7_QB:4 (41,-68.45)};
// (41,-68.77) @TEXT("VSS",size=0.98,halign="middle",valign="top");
// &"VDD" @WIRE(mode="straight",linecolor="#647584",linewidth=0.16) {#XSEL7_TB:3 (43,-67.55)};
// (43,-67.23) @TEXT("VDD",size=0.98,halign="middle",valign="bottom");
// &"VSS" @WIRE(mode="straight",linecolor="#647584",linewidth=0.16) {#XSEL7_TB:4 (43,-84.45)};
// (43,-84.77) @TEXT("VSS",size=0.98,halign="middle",valign="top");
// &"VDD" @WIRE(mode="straight",linecolor="#647584",linewidth=0.16) {#XSEL7_D:4 (57,-58.55)};
// (57,-58.23) @TEXT("VDD",size=0.98,halign="middle",valign="bottom");
// &"VSS" @WIRE(mode="straight",linecolor="#647584",linewidth=0.16) {#XSEL7_D:5 (57,-75.45)};
// (57,-75.77) @TEXT("VSS",size=0.98,halign="middle",valign="top");
// &"VDD" @WIRE(mode="straight",linecolor="#647584",linewidth=0.16) {#XSEL7:4 (67,-78.55)};
// (67,-78.23) @TEXT("VDD",size=0.98,halign="middle",valign="bottom");
// &"VSS" @WIRE(mode="straight",linecolor="#647584",linewidth=0.16) {#XSEL7:5 (59,-97.45)};
// (59,-97.77) @TEXT("VSS",size=0.98,halign="middle",valign="top");
// &"VDD" @WIRE(mode="straight",linecolor="#647584",linewidth=0.16) {#XSEL6_QB:3 (82,-51.55)};
// (82,-51.23) @TEXT("VDD",size=0.98,halign="middle",valign="bottom");
// &"VSS" @WIRE(mode="straight",linecolor="#647584",linewidth=0.16) {#XSEL6_QB:4 (82,-68.45)};
// (82,-68.77) @TEXT("VSS",size=0.98,halign="middle",valign="top");
// &"VDD" @WIRE(mode="straight",linecolor="#647584",linewidth=0.16) {#XSEL6_TB:3 (84,-67.55)};
// (84,-67.23) @TEXT("VDD",size=0.98,halign="middle",valign="bottom");
// &"VSS" @WIRE(mode="straight",linecolor="#647584",linewidth=0.16) {#XSEL6_TB:4 (84,-84.45)};
// (84,-84.77) @TEXT("VSS",size=0.98,halign="middle",valign="top");
// &"VDD" @WIRE(mode="straight",linecolor="#647584",linewidth=0.16) {#XSEL6_D:4 (98,-58.55)};
// (98,-58.23) @TEXT("VDD",size=0.98,halign="middle",valign="bottom");
// &"VSS" @WIRE(mode="straight",linecolor="#647584",linewidth=0.16) {#XSEL6_D:5 (98,-75.45)};
// (98,-75.77) @TEXT("VSS",size=0.98,halign="middle",valign="top");
// &"VDD" @WIRE(mode="straight",linecolor="#647584",linewidth=0.16) {#XSEL6:4 (108,-78.55)};
// (108,-78.23) @TEXT("VDD",size=0.98,halign="middle",valign="bottom");
// &"VSS" @WIRE(mode="straight",linecolor="#647584",linewidth=0.16) {#XSEL6:5 (100,-97.45)};
// (100,-97.77) @TEXT("VSS",size=0.98,halign="middle",valign="top");
// &"VDD" @WIRE(mode="straight",linecolor="#647584",linewidth=0.16) {#XSEL5_QB:3 (123,-51.55)};
// (123,-51.23) @TEXT("VDD",size=0.98,halign="middle",valign="bottom");
// &"VSS" @WIRE(mode="straight",linecolor="#647584",linewidth=0.16) {#XSEL5_QB:4 (123,-68.45)};
// (123,-68.77) @TEXT("VSS",size=0.98,halign="middle",valign="top");
// &"VDD" @WIRE(mode="straight",linecolor="#647584",linewidth=0.16) {#XSEL5_TB:3 (125,-67.55)};
// (125,-67.23) @TEXT("VDD",size=0.98,halign="middle",valign="bottom");
// &"VSS" @WIRE(mode="straight",linecolor="#647584",linewidth=0.16) {#XSEL5_TB:4 (125,-84.45)};
// (125,-84.77) @TEXT("VSS",size=0.98,halign="middle",valign="top");
// &"VDD" @WIRE(mode="straight",linecolor="#647584",linewidth=0.16) {#XSEL5_D:4 (139,-58.55)};
// (139,-58.23) @TEXT("VDD",size=0.98,halign="middle",valign="bottom");
// &"VSS" @WIRE(mode="straight",linecolor="#647584",linewidth=0.16) {#XSEL5_D:5 (139,-75.45)};
// (139,-75.77) @TEXT("VSS",size=0.98,halign="middle",valign="top");
// &"VDD" @WIRE(mode="straight",linecolor="#647584",linewidth=0.16) {#XSEL5:4 (149,-78.55)};
// (149,-78.23) @TEXT("VDD",size=0.98,halign="middle",valign="bottom");
// &"VSS" @WIRE(mode="straight",linecolor="#647584",linewidth=0.16) {#XSEL5:5 (141,-97.45)};
// (141,-97.77) @TEXT("VSS",size=0.98,halign="middle",valign="top");
// &"VDD" @WIRE(mode="straight",linecolor="#647584",linewidth=0.16) {#XSEL4_QB:3 (164,-51.55)};
// (164,-51.23) @TEXT("VDD",size=0.98,halign="middle",valign="bottom");
// &"VSS" @WIRE(mode="straight",linecolor="#647584",linewidth=0.16) {#XSEL4_QB:4 (164,-68.45)};
// (164,-68.77) @TEXT("VSS",size=0.98,halign="middle",valign="top");
// &"VDD" @WIRE(mode="straight",linecolor="#647584",linewidth=0.16) {#XSEL4_TB:3 (166,-67.55)};
// (166,-67.23) @TEXT("VDD",size=0.98,halign="middle",valign="bottom");
// &"VSS" @WIRE(mode="straight",linecolor="#647584",linewidth=0.16) {#XSEL4_TB:4 (166,-84.45)};
// (166,-84.77) @TEXT("VSS",size=0.98,halign="middle",valign="top");
// &"VDD" @WIRE(mode="straight",linecolor="#647584",linewidth=0.16) {#XSEL4_D:4 (180,-58.55)};
// (180,-58.23) @TEXT("VDD",size=0.98,halign="middle",valign="bottom");
// &"VSS" @WIRE(mode="straight",linecolor="#647584",linewidth=0.16) {#XSEL4_D:5 (180,-75.45)};
// (180,-75.77) @TEXT("VSS",size=0.98,halign="middle",valign="top");
// &"VDD" @WIRE(mode="straight",linecolor="#647584",linewidth=0.16) {#XSEL4:4 (190,-78.55)};
// (190,-78.23) @TEXT("VDD",size=0.98,halign="middle",valign="bottom");
// &"VSS" @WIRE(mode="straight",linecolor="#647584",linewidth=0.16) {#XSEL4:5 (182,-97.45)};
// (182,-97.77) @TEXT("VSS",size=0.98,halign="middle",valign="top");
// {#XSEL9_QB #XSEL9_TB #XSEL9_D #XSEL9 #XSEL7_QB #XSEL7_TB #XSEL7_D #XSEL7 #XSEL6_QB #XSEL6_TB #XSEL6_D #XSEL6 #XSEL5_QB #XSEL5_TB #XSEL5_D #XSEL5 #XSEL4_QB #XSEL4_TB #XSEL4_D #XSEL4} @GROUP;
// @RECTANGLE(linecolor="#a9b8c5",linewidth=0.16,fill="fillcolor",fillcolor="#f7f9fc") {(-24,-104) (204,-38)} => @LAYER("bottom");
// (-21,-42) @TEXT("Settling window selection",size=1.95,halign="start",textcolor="#223d52");
// (-21,-45.5) @TEXT("The trial bit sets a tap until the next sample.",size=1.26,halign="start",textcolor="#223d52");
// &"ACTIVE" @WIRE(mode="straight",linecolor="#30485d",linewidth=0.16) {#XTIM:1 (-24,50.05)};
// (-24.4,50.05) @TEXT("ACTIVE",size=1.1,halign="end",valign="middle");
// &"SAMPLE" @WIRE(mode="straight",linecolor="#30485d",linewidth=0.16) {#XTIM:2 (-24,53.35)};
// (-24.4,53.35) @TEXT("SAMPLE",size=1.1,halign="end",valign="middle");
// &"SEL9" @WIRE(mode="straight",linecolor="#30485d",linewidth=0.16) {#XTIM:3 (-17,41.75)};
// (-17,41.35) @TEXT("SEL9",size=1.1,halign="middle",valign="top");
// &"SEL7" @WIRE(mode="straight",linecolor="#30485d",linewidth=0.16) {#XTIM:4 (-11,41.75)};
// (-11,41.35) @TEXT("SEL7",size=1.1,halign="middle",valign="top");
// &"SEL6" @WIRE(mode="straight",linecolor="#30485d",linewidth=0.16) {#XTIM:5 (-5,41.75)};
// (-5,41.35) @TEXT("SEL6",size=1.1,halign="middle",valign="top");
// &"SEL5" @WIRE(mode="straight",linecolor="#30485d",linewidth=0.16) {#XTIM:6 (1,41.75)};
// (1,41.35) @TEXT("SEL5",size=1.1,halign="middle",valign="top");
// &"SEL4" @WIRE(mode="straight",linecolor="#30485d",linewidth=0.16) {#XTIM:7 (7,41.75)};
// (7,41.35) @TEXT("SEL4",size=1.1,halign="middle",valign="top");
// &"COMP_P" @WIRE(mode="straight",linecolor="#30485d",linewidth=0.16) {#XTIM:8 (-24,59.95)};
// (-24.4,59.95) @TEXT("COMP_P",size=1.1,halign="end",valign="middle");
// &"COMP_N" @WIRE(mode="straight",linecolor="#30485d",linewidth=0.16) {#XTIM:9 (-24,56.65)};
// (-24.4,56.65) @TEXT("COMP_N",size=1.1,halign="end",valign="middle");
// &"CMP_CLK" @WIRE(mode="straight",linecolor="#30485d",linewidth=0.16) {#XTIM:10 (20,51.7)};
// (20.4,51.7) @TEXT("CMP_CLK",size=1.1,halign="start",valign="middle");
// &"VDD" @WIRE(mode="straight",linecolor="#30485d",linewidth=0.16) {#XTIM:13 (-2,68.25)};
// (-2,68.65) @TEXT("VDD",size=1.1,halign="middle",valign="bottom");
// &"VSS" @WIRE(mode="straight",linecolor="#30485d",linewidth=0.16) {#XTIM:14 (13,41.75)};
// (13,41.35) @TEXT("VSS",size=1.1,halign="middle",valign="top");
// {&"D0" &"D1" &"D2" &"D3" &"D4" &"D5" &"D6" &"D7"} @WIRE(mode="straight",linewidth=0.3) {#XWORD:11 (80,58.3)};
// (80.4,58.3) @TEXT("D[7:0]",size=1.1,halign="start",valign="middle");
// {&"TRIAL6" &"TRIAL5" &"TRIAL4" &"TRIAL3" &"TRIAL2"} @WIRE(mode="straight",linewidth=0.3) {#XWORD:27 (60,43.4)};
// (60,43) @TEXT("TRIAL[2:6]",size=1.1,halign="middle",valign="top");
// &"VDD" @WIRE(mode="straight",linecolor="#30485d",linewidth=0.16) {#XWORD:32 (64,66.6)};
// (64,67) @TEXT("VDD",size=1.1,halign="middle",valign="bottom");
// &"VSS" @WIRE(mode="straight",linecolor="#30485d",linewidth=0.16) {#XWORD:33 (68,43.4)};
// (68,43) @TEXT("VSS",size=1.1,halign="middle",valign="top");
// &"SEL9" @WIRE(mode="straight",linecolor="#30485d",linewidth=0.16) {#XSEL9_QB:1 (-10,-60)};
// (-10.4,-60) @TEXT("SEL9",size=1.1,halign="end",valign="middle");
// &"TRIAL6" @WIRE(mode="straight",linecolor="#30485d",linewidth=0.16) {#XSEL9_TB:1 (-8,-76)};
// (-8.4,-76) @TEXT("TRIAL6",size=1.1,halign="end",valign="middle");
// &"COMMIT" @WIRE(mode="straight",linecolor="#30485d",linewidth=0.16) {#XSEL9:1 (8.5,-86.35)};
// (8.1,-86.35) @TEXT("COMMIT",size=1.1,halign="end",valign="middle");
// &"SAMPLE" @WIRE(mode="straight",linecolor="#30485d",linewidth=0.16) {#XSEL9:3 (8.5,-89.65)};
// (8.1,-89.65) @TEXT("SAMPLE",size=1.1,halign="end",valign="middle");
// &"SEL9" @WIRE(mode="straight",linecolor="#30485d",linewidth=0.16) {#XSEL9:6 (26,-99)};
// (26,-99.4) @TEXT("SEL9",size=1.1,halign="middle",valign="top");
// &"SEL7" @WIRE(mode="straight",linecolor="#30485d",linewidth=0.16) {#XSEL7_QB:1 (31,-60)};
// (30.6,-60) @TEXT("SEL7",size=1.1,halign="end",valign="middle");
// &"TRIAL5" @WIRE(mode="straight",linecolor="#30485d",linewidth=0.16) {#XSEL7_TB:1 (33,-76)};
// (32.6,-76) @TEXT("TRIAL5",size=1.1,halign="end",valign="middle");
// &"COMMIT" @WIRE(mode="straight",linecolor="#30485d",linewidth=0.16) {#XSEL7:1 (49.5,-86.35)};
// (49.1,-86.35) @TEXT("COMMIT",size=1.1,halign="end",valign="middle");
// &"SAMPLE" @WIRE(mode="straight",linecolor="#30485d",linewidth=0.16) {#XSEL7:3 (49.5,-89.65)};
// (49.1,-89.65) @TEXT("SAMPLE",size=1.1,halign="end",valign="middle");
// &"SEL7" @WIRE(mode="straight",linecolor="#30485d",linewidth=0.16) {#XSEL7:6 (67,-99)};
// (67,-99.4) @TEXT("SEL7",size=1.1,halign="middle",valign="top");
// &"SEL6" @WIRE(mode="straight",linecolor="#30485d",linewidth=0.16) {#XSEL6_QB:1 (72,-60)};
// (71.6,-60) @TEXT("SEL6",size=1.1,halign="end",valign="middle");
// &"TRIAL4" @WIRE(mode="straight",linecolor="#30485d",linewidth=0.16) {#XSEL6_TB:1 (74,-76)};
// (73.6,-76) @TEXT("TRIAL4",size=1.1,halign="end",valign="middle");
// &"COMMIT" @WIRE(mode="straight",linecolor="#30485d",linewidth=0.16) {#XSEL6:1 (90.5,-86.35)};
// (90.1,-86.35) @TEXT("COMMIT",size=1.1,halign="end",valign="middle");
// &"SAMPLE" @WIRE(mode="straight",linecolor="#30485d",linewidth=0.16) {#XSEL6:3 (90.5,-89.65)};
// (90.1,-89.65) @TEXT("SAMPLE",size=1.1,halign="end",valign="middle");
// &"SEL6" @WIRE(mode="straight",linecolor="#30485d",linewidth=0.16) {#XSEL6:6 (108,-99)};
// (108,-99.4) @TEXT("SEL6",size=1.1,halign="middle",valign="top");
// &"SEL5" @WIRE(mode="straight",linecolor="#30485d",linewidth=0.16) {#XSEL5_QB:1 (113,-60)};
// (112.6,-60) @TEXT("SEL5",size=1.1,halign="end",valign="middle");
// &"TRIAL3" @WIRE(mode="straight",linecolor="#30485d",linewidth=0.16) {#XSEL5_TB:1 (115,-76)};
// (114.6,-76) @TEXT("TRIAL3",size=1.1,halign="end",valign="middle");
// &"COMMIT" @WIRE(mode="straight",linecolor="#30485d",linewidth=0.16) {#XSEL5:1 (131.5,-86.35)};
// (131.1,-86.35) @TEXT("COMMIT",size=1.1,halign="end",valign="middle");
// &"SAMPLE" @WIRE(mode="straight",linecolor="#30485d",linewidth=0.16) {#XSEL5:3 (131.5,-89.65)};
// (131.1,-89.65) @TEXT("SAMPLE",size=1.1,halign="end",valign="middle");
// &"SEL5" @WIRE(mode="straight",linecolor="#30485d",linewidth=0.16) {#XSEL5:6 (149,-99)};
// (149,-99.4) @TEXT("SEL5",size=1.1,halign="middle",valign="top");
// &"SEL4" @WIRE(mode="straight",linecolor="#30485d",linewidth=0.16) {#XSEL4_QB:1 (154,-60)};
// (153.6,-60) @TEXT("SEL4",size=1.1,halign="end",valign="middle");
// &"TRIAL2" @WIRE(mode="straight",linecolor="#30485d",linewidth=0.16) {#XSEL4_TB:1 (156,-76)};
// (155.6,-76) @TEXT("TRIAL2",size=1.1,halign="end",valign="middle");
// &"COMMIT" @WIRE(mode="straight",linecolor="#30485d",linewidth=0.16) {#XSEL4:1 (172.5,-86.35)};
// (172.1,-86.35) @TEXT("COMMIT",size=1.1,halign="end",valign="middle");
// &"SAMPLE" @WIRE(mode="straight",linecolor="#30485d",linewidth=0.16) {#XSEL4:3 (172.5,-89.65)};
// (172.1,-89.65) @TEXT("SAMPLE",size=1.1,halign="end",valign="middle");
// &"SEL4" @WIRE(mode="straight",linecolor="#30485d",linewidth=0.16) {#XSEL4:6 (190,-99)};
// (190,-99.4) @TEXT("SEL4",size=1.1,halign="middle",valign="top");
// &"CODE0" @WIRE(mode="straight",linecolor="#30485d",linewidth=0.16) {#XDONE:2 (132,66)};
// (132,66.4) @TEXT("CODE0",size=1.1,halign="middle",valign="bottom");
// &"SAMPLE" @WIRE(mode="straight",linecolor="#30485d",linewidth=0.16) {#XDONE:3 (122.5,53.35)};
// (122.1,53.35) @TEXT("SAMPLE",size=1.1,halign="end",valign="middle");
// &"VDD" @WIRE(mode="straight",linecolor="#30485d",linewidth=0.16) {#XDONE:4 (140,66)};
// (140,66.4) @TEXT("VDD",size=1.1,halign="middle",valign="bottom");
// &"VSS" @WIRE(mode="straight",linecolor="#30485d",linewidth=0.16) {#XDONE:5 (132,44)};
// (132,43.6) @TEXT("VSS",size=1.1,halign="middle",valign="top");
// &"ACTIVE" @WIRE(mode="straight",linecolor="#30485d",linewidth=0.16) {#XACTIVE:2 (175,55)};
// (175.4,55) @TEXT("ACTIVE",size=1.1,halign="start",valign="middle");
// &"VDD" @WIRE(mode="straight",linecolor="#30485d",linewidth=0.16) {#XACTIVE:3 (165,65)};
// (165,65.4) @TEXT("VDD",size=1.1,halign="middle",valign="bottom");
// &"VSS" @WIRE(mode="straight",linecolor="#30485d",linewidth=0.16) {#XACTIVE:4 (165,45)};
// (165,44.6) @TEXT("VSS",size=1.1,halign="middle",valign="top");
// &"COMMIT" @WIRE(mode="straight",linecolor="#30485d",linewidth=0.16) {#XBIT0:1 (168.5,-2.35)};
// (168.1,-2.35) @TEXT("COMMIT",size=1.1,halign="end",valign="middle");
// &"SAMPLE" @WIRE(mode="straight",linecolor="#30485d",linewidth=0.16) {#XBIT0:3 (168.5,-5.65)};
// (168.1,-5.65) @TEXT("SAMPLE",size=1.1,halign="end",valign="middle");
// &"VDD" @WIRE(mode="straight",linecolor="#30485d",linewidth=0.16) {#XBIT0:4 (186,7)};
// (186,7.4) @TEXT("VDD",size=1.1,halign="middle",valign="bottom");
// &"VSS" @WIRE(mode="straight",linecolor="#30485d",linewidth=0.16) {#XBIT0:5 (178,-15)};
// (178,-15.4) @TEXT("VSS",size=1.1,halign="middle",valign="top");
// &"COMMIT" @WIRE(mode="straight",linecolor="#30485d",linewidth=0.16) {#XBIT1:1 (142.5,-2.35)};
// (142.1,-2.35) @TEXT("COMMIT",size=1.1,halign="end",valign="middle");
// &"SAMPLE" @WIRE(mode="straight",linecolor="#30485d",linewidth=0.16) {#XBIT1:3 (142.5,-5.65)};
// (142.1,-5.65) @TEXT("SAMPLE",size=1.1,halign="end",valign="middle");
// &"VDD" @WIRE(mode="straight",linecolor="#30485d",linewidth=0.16) {#XBIT1:4 (160,7)};
// (160,7.4) @TEXT("VDD",size=1.1,halign="middle",valign="bottom");
// &"VSS" @WIRE(mode="straight",linecolor="#30485d",linewidth=0.16) {#XBIT1:5 (152,-15)};
// (152,-15.4) @TEXT("VSS",size=1.1,halign="middle",valign="top");
// &"COMMIT" @WIRE(mode="straight",linecolor="#30485d",linewidth=0.16) {#XBIT2:1 (116.5,-2.35)};
// (116.1,-2.35) @TEXT("COMMIT",size=1.1,halign="end",valign="middle");
// &"SAMPLE" @WIRE(mode="straight",linecolor="#30485d",linewidth=0.16) {#XBIT2:3 (116.5,-5.65)};
// (116.1,-5.65) @TEXT("SAMPLE",size=1.1,halign="end",valign="middle");
// &"VDD" @WIRE(mode="straight",linecolor="#30485d",linewidth=0.16) {#XBIT2:4 (134,7)};
// (134,7.4) @TEXT("VDD",size=1.1,halign="middle",valign="bottom");
// &"VSS" @WIRE(mode="straight",linecolor="#30485d",linewidth=0.16) {#XBIT2:5 (126,-15)};
// (126,-15.4) @TEXT("VSS",size=1.1,halign="middle",valign="top");
// &"COMMIT" @WIRE(mode="straight",linecolor="#30485d",linewidth=0.16) {#XBIT3:1 (90.5,-2.35)};
// (90.1,-2.35) @TEXT("COMMIT",size=1.1,halign="end",valign="middle");
// &"SAMPLE" @WIRE(mode="straight",linecolor="#30485d",linewidth=0.16) {#XBIT3:3 (90.5,-5.65)};
// (90.1,-5.65) @TEXT("SAMPLE",size=1.1,halign="end",valign="middle");
// &"VDD" @WIRE(mode="straight",linecolor="#30485d",linewidth=0.16) {#XBIT3:4 (108,7)};
// (108,7.4) @TEXT("VDD",size=1.1,halign="middle",valign="bottom");
// &"VSS" @WIRE(mode="straight",linecolor="#30485d",linewidth=0.16) {#XBIT3:5 (100,-15)};
// (100,-15.4) @TEXT("VSS",size=1.1,halign="middle",valign="top");
// &"COMMIT" @WIRE(mode="straight",linecolor="#30485d",linewidth=0.16) {#XBIT4:1 (64.5,-2.35)};
// (64.1,-2.35) @TEXT("COMMIT",size=1.1,halign="end",valign="middle");
// &"SAMPLE" @WIRE(mode="straight",linecolor="#30485d",linewidth=0.16) {#XBIT4:3 (64.5,-5.65)};
// (64.1,-5.65) @TEXT("SAMPLE",size=1.1,halign="end",valign="middle");
// &"VDD" @WIRE(mode="straight",linecolor="#30485d",linewidth=0.16) {#XBIT4:4 (82,7)};
// (82,7.4) @TEXT("VDD",size=1.1,halign="middle",valign="bottom");
// &"VSS" @WIRE(mode="straight",linecolor="#30485d",linewidth=0.16) {#XBIT4:5 (74,-15)};
// (74,-15.4) @TEXT("VSS",size=1.1,halign="middle",valign="top");
// &"COMMIT" @WIRE(mode="straight",linecolor="#30485d",linewidth=0.16) {#XBIT5:1 (38.5,-2.35)};
// (38.1,-2.35) @TEXT("COMMIT",size=1.1,halign="end",valign="middle");
// &"SAMPLE" @WIRE(mode="straight",linecolor="#30485d",linewidth=0.16) {#XBIT5:3 (38.5,-5.65)};
// (38.1,-5.65) @TEXT("SAMPLE",size=1.1,halign="end",valign="middle");
// &"VDD" @WIRE(mode="straight",linecolor="#30485d",linewidth=0.16) {#XBIT5:4 (56,7)};
// (56,7.4) @TEXT("VDD",size=1.1,halign="middle",valign="bottom");
// &"VSS" @WIRE(mode="straight",linecolor="#30485d",linewidth=0.16) {#XBIT5:5 (48,-15)};
// (48,-15.4) @TEXT("VSS",size=1.1,halign="middle",valign="top");
// &"COMMIT" @WIRE(mode="straight",linecolor="#30485d",linewidth=0.16) {#XBIT6:1 (12.5,-2.35)};
// (12.1,-2.35) @TEXT("COMMIT",size=1.1,halign="end",valign="middle");
// &"SAMPLE" @WIRE(mode="straight",linecolor="#30485d",linewidth=0.16) {#XBIT6:3 (12.5,-5.65)};
// (12.1,-5.65) @TEXT("SAMPLE",size=1.1,halign="end",valign="middle");
// &"VDD" @WIRE(mode="straight",linecolor="#30485d",linewidth=0.16) {#XBIT6:4 (30,7)};
// (30,7.4) @TEXT("VDD",size=1.1,halign="middle",valign="bottom");
// &"VSS" @WIRE(mode="straight",linecolor="#30485d",linewidth=0.16) {#XBIT6:5 (22,-15)};
// (22,-15.4) @TEXT("VSS",size=1.1,halign="middle",valign="top");
// &"VDD" @WIRE(mode="straight",linecolor="#30485d",linewidth=0.16) {#XMSBD:3 (-13,15)};
// (-13,15.4) @TEXT("VDD",size=1.1,halign="middle",valign="bottom");
// &"VSS" @WIRE(mode="straight",linecolor="#30485d",linewidth=0.16) {#XMSBD:4 (-13,-5)};
// (-13,-5.4) @TEXT("VSS",size=1.1,halign="middle",valign="top");
// &"COMMIT" @WIRE(mode="straight",linecolor="#30485d",linewidth=0.16) {#XBIT7:1 (-13.5,-2.35)};
// (-13.9,-2.35) @TEXT("COMMIT",size=1.1,halign="end",valign="middle");
// &"SAMPLE" @WIRE(mode="straight",linecolor="#30485d",linewidth=0.16) {#XBIT7:3 (-13.5,-5.65)};
// (-13.9,-5.65) @TEXT("SAMPLE",size=1.1,halign="end",valign="middle");
// &"VDD" @WIRE(mode="straight",linecolor="#30485d",linewidth=0.16) {#XBIT7:4 (4,7)};
// (4,7.4) @TEXT("VDD",size=1.1,halign="middle",valign="bottom");
// &"VSS" @WIRE(mode="straight",linecolor="#30485d",linewidth=0.16) {#XBIT7:5 (-4,-15)};
// (-4,-15.4) @TEXT("VSS",size=1.1,halign="middle",valign="top");
// &"VDD" @WIRE(mode="straight",linecolor="#30485d",linewidth=0.16) {#XMSBQ:3 (-10,-12)};
// (-10,-11.6) @TEXT("VDD",size=1.1,halign="middle",valign="bottom");
// &"VSS" @WIRE(mode="straight",linecolor="#30485d",linewidth=0.16) {#XMSBQ:4 (-10,-32)};
// (-10,-32.4) @TEXT("VSS",size=1.1,halign="middle",valign="top");
// }
// END SARADC RNL
ends sar8_se_ctrl

subckt sar8_se_acquire REQUEST VDD VSS TRACK
XDEL (REQUEST TAP VDD VSS) DEL200D1BWP12T30P140
XQUAL (REQUEST TAP ACCEPTED VDD VSS) AN2D1BWP12T30P140
XOUT (ACCEPTED TRACK VDD VSS) CKBD1BWP12T30P140
// BEGIN SARADC RNL
// @RNL(author="saradc topology") {
// #XDEL @SET-SYMBOL $S_DEL200D1BWP12T30P140;
// #XDEL @PLACE(0,0) => @ORIENT("R0");
// #XQUAL @SET-SYMBOL $S_AN2D1BWP12T30P140;
// #XQUAL @PLACE(0,-33) => @ORIENT("R0");
// #XOUT @SET-SYMBOL $S_CKBD1BWP12T30P140;
// #XOUT @PLACE(0,-66) => @ORIENT("R0");
// &"REQUEST" @WIRE(mode="straight",linecolor="#30485d",linewidth=0.16) {#XDEL:1 (-13,0) (-13,-31.35) #XQUAL:1};
// &"TAP" @WIRE(mode="straight",linecolor="#30485d",linewidth=0.16) {#XDEL:2 (0,0) (0,-34.65) #XQUAL:2};
// &"ACCEPTED" @WIRE(mode="straight",linecolor="#30485d",linewidth=0.16) {#XQUAL:3 (0,-33) (0,-66) #XOUT:1};
// (-89,30) @TEXT("sar8_se_acquire / source-derived connections",size=1.4,halign="start",textcolor="#223d52");
// &"VDD" @WIRE(mode="straight",linecolor="#30485d",linewidth=0.16) {#XDEL:3 (0,11)};
// (0,11.4) @TEXT("VDD",size=1.1,halign="middle",valign="bottom");
// &"VSS" @WIRE(mode="straight",linecolor="#30485d",linewidth=0.16) {#XDEL:4 (0,-11)};
// (0,-11.4) @TEXT("VSS",size=1.1,halign="middle",valign="top");
// &"VDD" @WIRE(mode="straight",linecolor="#30485d",linewidth=0.16) {#XQUAL:4 (0,-22)};
// (0,-21.6) @TEXT("VDD",size=1.1,halign="middle",valign="bottom");
// &"VSS" @WIRE(mode="straight",linecolor="#30485d",linewidth=0.16) {#XQUAL:5 (0,-44)};
// (0,-44.4) @TEXT("VSS",size=1.1,halign="middle",valign="top");
// &"TRACK" @WIRE(mode="straight",linecolor="#30485d",linewidth=0.16) {#XOUT:2 (16,-66)};
// (16.4,-66) @TEXT("TRACK",size=1.1,halign="start",valign="middle");
// &"VDD" @WIRE(mode="straight",linecolor="#30485d",linewidth=0.16) {#XOUT:3 (0,-55)};
// (0,-54.6) @TEXT("VDD",size=1.1,halign="middle",valign="bottom");
// &"VSS" @WIRE(mode="straight",linecolor="#30485d",linewidth=0.16) {#XOUT:4 (0,-77)};
// (0,-77.4) @TEXT("VSS",size=1.1,halign="middle",valign="top");
// }
// END SARADC RNL
ends sar8_se_acquire
