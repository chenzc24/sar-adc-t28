// Generated from frozen B by scripts/sar8_entry.py build.
// BEGIN SARADC RNL
// @RNL(type="header") { @VERSION("0.3");
// @USE-PACKAGE(name="sar8",version="0.1",path="../../rnl/sar8.rnl");
// @USE-PACKAGE(name="rnl-std-fill") {}; }
// END SARADC RNL
// Electrical subcircuit statements are preserved verbatim.

subckt sar8p_timing ACTIVE CMP_CLK COMP_N COMP_P DATA PHI_U PHI_W SAMPLE \
        VDD VSS
    X017 (PHI_U VDD VSS UN) sar8p_inv
    X016 (PHI_W VDD VSS WN) sar8p_inv
    X015 (CMP_CLK VDD VSS CN) sar8p_inv
    X004 (NR VDD VSS NRB) sar8p_inv
    X000 (SAMPLE VDD VSS SN) sar8p_inv
    X022 (QUIET QUIET_D VDD VSS CLOCK_SET) sar8p_and2
    X020 (Q1 LIVE VDD VSS QUIET) sar8p_and2
    X019 (Q0 UN VDD VSS Q1) sar8p_and2
    X018 (CN WN VDD VSS Q0) sar8p_and2
    X014 (UD SN VDD VSS PHI_U) sar8p_and2
    X013 (PHI_W WRITE_D VDD VSS UD) sar8p_and2
    X010 (WD SN VDD VSS WRITE_REQ) sar8p_and2
    X009 (DEC CMP_CLK VDD VSS WD) sar8p_and2
    X008 (RAW RAW_D VDD VSS DEC) sar8p_and2
    X005 (PR NRB VDD VSS DATA) sar8p_and2
    X001 (SN ACTIVE VDD VSS LIVE) sar8p_and2
    X025 (CLOCK_Q VDD VSS CMP_CLK) sar8p_buf
    X003 (COMP_N VDD VSS NR) sar8p_buf
    X002 (COMP_P VDD VSS PR) sar8p_buf
    X006 (PR NR VDD VSS RAW) sar8p_xor2
    XD_RAW_D (RAW VDD VSS RAW_D) sar8p_delay_valid
    X011 (WRITE_REQ VDD VSS PHI_W) sar8p_clkbuf
    XD_WRITE_D (PHI_W VDD VSS WRITE_D) sar8p_delay_write
    XD_QUIET_D (QUIET VDD VSS QUIET_D) sar8p_delay_quiet
    X023 (SAMPLE PHI_U VDD VSS CLOCK_RESET) sar8p_or2
    XCLOCK (CLOCK_Q CLOCK_RESET CLOCK_SET VDD VSS) sar8p_sr
// BEGIN SARADC RNL
// @RNL(author="saradc topology") {
// (-18,73) @TEXT("Asynchronous completion / write / update / quiet / comparator clock",size=1.5,halign="start",textcolor="#223d52");
// #X002 @SET-SYMBOL $S_sar8p_buf;
// #X002 @PLACE(0,36) => @ORIENT("R0");
// #X003 @SET-SYMBOL $S_sar8p_buf;
// #X003 @PLACE(0,0) => @ORIENT("R0");
// #X004 @SET-SYMBOL $S_sar8p_inv;
// #X004 @PLACE(35,0) => @ORIENT("R0");
// #X005 @SET-SYMBOL $S_sar8p_and2;
// #X005 @PLACE(72,36) => @ORIENT("R0");
// #X006 @SET-SYMBOL $S_sar8p_xor2;
// #X006 @PLACE(110,0) => @ORIENT("R0");
// #XD_RAW_D @SET-SYMBOL $S_sar8p_delay_valid;
// #XD_RAW_D @PLACE(151,-21) => @ORIENT("R0");
// #X008 @SET-SYMBOL $S_sar8p_and2;
// #X008 @PLACE(196,0) => @ORIENT("R0");
// #X009 @SET-SYMBOL $S_sar8p_and2;
// #X009 @PLACE(232,0) => @ORIENT("R0");
// #X010 @SET-SYMBOL $S_sar8p_and2;
// #X010 @PLACE(268,0) => @ORIENT("R0");
// #X011 @SET-SYMBOL $S_sar8p_clkbuf;
// #X011 @PLACE(306,0) => @ORIENT("R0");
// #XD_WRITE_D @SET-SYMBOL $S_sar8p_delay_write;
// #XD_WRITE_D @PLACE(349,-21) => @ORIENT("R0");
// #X013 @SET-SYMBOL $S_sar8p_and2;
// #X013 @PLACE(394,0) => @ORIENT("R0");
// #X014 @SET-SYMBOL $S_sar8p_and2;
// #X014 @PLACE(433,0) => @ORIENT("R0");
// #X000 @SET-SYMBOL $S_sar8p_inv;
// #X000 @PLACE(0,-72) => @ORIENT("R0");
// #X001 @SET-SYMBOL $S_sar8p_and2;
// #X001 @PLACE(36,-72) => @ORIENT("R0");
// #X015 @SET-SYMBOL $S_sar8p_inv;
// #X015 @PLACE(80,-72) => @ORIENT("R0");
// #X016 @SET-SYMBOL $S_sar8p_inv;
// #X016 @PLACE(80,-112) => @ORIENT("R0");
// #X017 @SET-SYMBOL $S_sar8p_inv;
// #X017 @PLACE(121,-112) => @ORIENT("R0");
// #X018 @SET-SYMBOL $S_sar8p_and2;
// #X018 @PLACE(121,-72) => @ORIENT("R0");
// #X019 @SET-SYMBOL $S_sar8p_and2;
// #X019 @PLACE(161,-72) => @ORIENT("R0");
// #X020 @SET-SYMBOL $S_sar8p_and2;
// #X020 @PLACE(201,-72) => @ORIENT("R0");
// #XD_QUIET_D @SET-SYMBOL $S_sar8p_delay_quiet;
// #XD_QUIET_D @PLACE(243,-93) => @ORIENT("R0");
// #X022 @SET-SYMBOL $S_sar8p_and2;
// #X022 @PLACE(288,-72) => @ORIENT("R0");
// #X023 @SET-SYMBOL $S_sar8p_or2;
// #X023 @PLACE(329,-112) => @ORIENT("R0");
// #XCLOCK @SET-SYMBOL $S_sar8p_sr;
// #XCLOCK @PLACE(372,-72) => @ORIENT("R0");
// #X025 @SET-SYMBOL $S_sar8p_buf;
// #X025 @PLACE(417,-72) => @ORIENT("R0");
// &"UN" @WIRE(mode="straight",linecolor="#30485d",linewidth=0.16) {#X017:4 (141,-112) (141,-73.7) #X019:2};
// &"WN" @WIRE(mode="straight",linecolor="#30485d",linewidth=0.16) {#X016:4 (100.5,-112) (100.5,-73.7) #X018:2};
// &"CN" @WIRE(mode="straight",linecolor="#30485d",linewidth=0.16) {#X015:4 (100.5,-72) (100.5,-70.3) #X018:1};
// &"NRB" @WIRE(mode="straight",linecolor="#30485d",linewidth=0.16) {#X004:4 (53.5,0) (53.5,34.3) #X005:2};
// &"QUIET_D" @WIRE(mode="straight",linecolor="#30485d",linewidth=0.16) {#X022:2 (268.5,-73.7) (268.5,-93) #XD_QUIET_D:4};
// &"CLOCK_SET" @WIRE(mode="straight",linecolor="#30485d",linewidth=0.16) {#X022:5 (327,-72) (327,-73.65) #XCLOCK:3};
// &"Q1" @WIRE(mode="straight",linecolor="#30485d",linewidth=0.16) {#X020:1 (181,-70.3) (181,-72) #X019:5};
// &"Q0" @WIRE(mode="straight",linecolor="#30485d",linewidth=0.16) {#X019:1 (141,-70.3) (141,-72) #X018:5};
// &"UD" @WIRE(mode="straight",linecolor="#30485d",linewidth=0.16) {#X014:1 (413.5,1.7) (413.5,0) #X013:5};
// &"WRITE_D" @WIRE(mode="straight",linecolor="#30485d",linewidth=0.16) {#X013:2 (374.5,-1.7) (374.5,-21) #XD_WRITE_D:4};
// &"WD" @WIRE(mode="straight",linecolor="#30485d",linewidth=0.16) {#X010:1 (250,1.7) (250,0) #X009:5};
// &"WRITE_REQ" @WIRE(mode="straight",linecolor="#30485d",linewidth=0.16) {#X010:5 (287,0) (287,0) #X011:1};
// &"DEC" @WIRE(mode="straight",linecolor="#30485d",linewidth=0.16) {#X009:1 (214,1.7) (214,0) #X008:5};
// &"RAW_D" @WIRE(mode="straight",linecolor="#30485d",linewidth=0.16) {#X008:2 (176.5,-1.7) (176.5,-21) #XD_RAW_D:4};
// &"CLOCK_Q" @WIRE(mode="straight",linecolor="#30485d",linewidth=0.16) {#X025:1 (397.5,-72) (397.5,-72) #XCLOCK:1};
// &"CLOCK_RESET" @WIRE(mode="straight",linecolor="#30485d",linewidth=0.16) {#X023:5 (347.5,-112) (347.5,-70.35) #XCLOCK:2};
// (109,49) @TEXT("VALID -> WRITE -> UPDATE",size=1.3,halign="start",textcolor="#223d52");
// (78,-46) @TEXT("QUIET detection -> SET / RESET latch -> CMP_CLK",size=1.3,halign="start",textcolor="#223d52");
// (-18,-140) @TEXT("Named inter-row clocks are the same electrical nets. Expand each RC delay or latch to inspect implementation.",size=1,halign="start",textcolor="#223d52");
// &"PHI_U" @WIRE(mode="straight",linecolor="#30485d",linewidth=0.16) {#X017:1 (111,-112)};
// (110.6,-112) @TEXT("PHI_U",size=1.1,halign="end",valign="middle");
// &"VDD" @WIRE(mode="straight",linecolor="#30485d",linewidth=0.16) {#X017:2 (121,-102)};
// (121,-101.6) @TEXT("VDD",size=1.1,halign="middle",valign="bottom");
// &"VSS" @WIRE(mode="straight",linecolor="#30485d",linewidth=0.16) {#X017:3 (121,-122)};
// (121,-122.4) @TEXT("VSS",size=1.1,halign="middle",valign="top");
// &"PHI_W" @WIRE(mode="straight",linecolor="#30485d",linewidth=0.16) {#X016:1 (70,-112)};
// (69.6,-112) @TEXT("PHI_W",size=1.1,halign="end",valign="middle");
// &"VDD" @WIRE(mode="straight",linecolor="#30485d",linewidth=0.16) {#X016:2 (80,-102)};
// (80,-101.6) @TEXT("VDD",size=1.1,halign="middle",valign="bottom");
// &"VSS" @WIRE(mode="straight",linecolor="#30485d",linewidth=0.16) {#X016:3 (80,-122)};
// (80,-122.4) @TEXT("VSS",size=1.1,halign="middle",valign="top");
// &"CMP_CLK" @WIRE(mode="straight",linecolor="#30485d",linewidth=0.16) {#X015:1 (70,-72)};
// (69.6,-72) @TEXT("CMP_CLK",size=1.1,halign="end",valign="middle");
// &"VDD" @WIRE(mode="straight",linecolor="#30485d",linewidth=0.16) {#X015:2 (80,-62)};
// (80,-61.6) @TEXT("VDD",size=1.1,halign="middle",valign="bottom");
// &"VSS" @WIRE(mode="straight",linecolor="#30485d",linewidth=0.16) {#X015:3 (80,-82)};
// (80,-82.4) @TEXT("VSS",size=1.1,halign="middle",valign="top");
// &"NR" @WIRE(mode="straight",linecolor="#30485d",linewidth=0.16) {#X004:1 (25,0)};
// (24.6,0) @TEXT("NR",size=1.1,halign="end",valign="middle");
// &"VDD" @WIRE(mode="straight",linecolor="#30485d",linewidth=0.16) {#X004:2 (35,10)};
// (35,10.4) @TEXT("VDD",size=1.1,halign="middle",valign="bottom");
// &"VSS" @WIRE(mode="straight",linecolor="#30485d",linewidth=0.16) {#X004:3 (35,-10)};
// (35,-10.4) @TEXT("VSS",size=1.1,halign="middle",valign="top");
// &"SAMPLE" @WIRE(mode="straight",linecolor="#30485d",linewidth=0.16) {#X000:1 (-10,-72)};
// (-10.4,-72) @TEXT("SAMPLE",size=1.1,halign="end",valign="middle");
// &"VDD" @WIRE(mode="straight",linecolor="#30485d",linewidth=0.16) {#X000:2 (0,-62)};
// (0,-61.6) @TEXT("VDD",size=1.1,halign="middle",valign="bottom");
// &"VSS" @WIRE(mode="straight",linecolor="#30485d",linewidth=0.16) {#X000:3 (0,-82)};
// (0,-82.4) @TEXT("VSS",size=1.1,halign="middle",valign="top");
// &"SN" @WIRE(mode="straight",linecolor="#30485d",linewidth=0.16) {#X000:4 (10,-72)};
// (10.4,-72) @TEXT("SN",size=1.1,halign="start",valign="middle");
// &"QUIET" @WIRE(mode="straight",linecolor="#30485d",linewidth=0.16) {#X022:1 (278,-70.3)};
// (277.6,-70.3) @TEXT("QUIET",size=1.1,halign="end",valign="middle");
// &"VDD" @WIRE(mode="straight",linecolor="#30485d",linewidth=0.16) {#X022:3 (288,-62)};
// (288,-61.6) @TEXT("VDD",size=1.1,halign="middle",valign="bottom");
// &"VSS" @WIRE(mode="straight",linecolor="#30485d",linewidth=0.16) {#X022:4 (288,-82)};
// (288,-82.4) @TEXT("VSS",size=1.1,halign="middle",valign="top");
// &"LIVE" @WIRE(mode="straight",linecolor="#30485d",linewidth=0.16) {#X020:2 (191,-73.7)};
// (190.6,-73.7) @TEXT("LIVE",size=1.1,halign="end",valign="middle");
// &"VDD" @WIRE(mode="straight",linecolor="#30485d",linewidth=0.16) {#X020:3 (201,-62)};
// (201,-61.6) @TEXT("VDD",size=1.1,halign="middle",valign="bottom");
// &"VSS" @WIRE(mode="straight",linecolor="#30485d",linewidth=0.16) {#X020:4 (201,-82)};
// (201,-82.4) @TEXT("VSS",size=1.1,halign="middle",valign="top");
// &"QUIET" @WIRE(mode="straight",linecolor="#30485d",linewidth=0.16) {#X020:5 (211,-72)};
// (211.4,-72) @TEXT("QUIET",size=1.1,halign="start",valign="middle");
// &"VDD" @WIRE(mode="straight",linecolor="#30485d",linewidth=0.16) {#X019:3 (161,-62)};
// (161,-61.6) @TEXT("VDD",size=1.1,halign="middle",valign="bottom");
// &"VSS" @WIRE(mode="straight",linecolor="#30485d",linewidth=0.16) {#X019:4 (161,-82)};
// (161,-82.4) @TEXT("VSS",size=1.1,halign="middle",valign="top");
// &"VDD" @WIRE(mode="straight",linecolor="#30485d",linewidth=0.16) {#X018:3 (121,-62)};
// (121,-61.6) @TEXT("VDD",size=1.1,halign="middle",valign="bottom");
// &"VSS" @WIRE(mode="straight",linecolor="#30485d",linewidth=0.16) {#X018:4 (121,-82)};
// (121,-82.4) @TEXT("VSS",size=1.1,halign="middle",valign="top");
// &"SN" @WIRE(mode="straight",linecolor="#30485d",linewidth=0.16) {#X014:2 (423,-1.7)};
// (422.6,-1.7) @TEXT("SN",size=1.1,halign="end",valign="middle");
// &"VDD" @WIRE(mode="straight",linecolor="#30485d",linewidth=0.16) {#X014:3 (433,10)};
// (433,10.4) @TEXT("VDD",size=1.1,halign="middle",valign="bottom");
// &"VSS" @WIRE(mode="straight",linecolor="#30485d",linewidth=0.16) {#X014:4 (433,-10)};
// (433,-10.4) @TEXT("VSS",size=1.1,halign="middle",valign="top");
// &"PHI_U" @WIRE(mode="straight",linecolor="#30485d",linewidth=0.16) {#X014:5 (443,0)};
// (443.4,0) @TEXT("PHI_U",size=1.1,halign="start",valign="middle");
// &"PHI_W" @WIRE(mode="straight",linecolor="#30485d",linewidth=0.16) {#X013:1 (384,1.7)};
// (383.6,1.7) @TEXT("PHI_W",size=1.1,halign="end",valign="middle");
// &"VDD" @WIRE(mode="straight",linecolor="#30485d",linewidth=0.16) {#X013:3 (394,10)};
// (394,10.4) @TEXT("VDD",size=1.1,halign="middle",valign="bottom");
// &"VSS" @WIRE(mode="straight",linecolor="#30485d",linewidth=0.16) {#X013:4 (394,-10)};
// (394,-10.4) @TEXT("VSS",size=1.1,halign="middle",valign="top");
// &"SN" @WIRE(mode="straight",linecolor="#30485d",linewidth=0.16) {#X010:2 (258,-1.7)};
// (257.6,-1.7) @TEXT("SN",size=1.1,halign="end",valign="middle");
// &"VDD" @WIRE(mode="straight",linecolor="#30485d",linewidth=0.16) {#X010:3 (268,10)};
// (268,10.4) @TEXT("VDD",size=1.1,halign="middle",valign="bottom");
// &"VSS" @WIRE(mode="straight",linecolor="#30485d",linewidth=0.16) {#X010:4 (268,-10)};
// (268,-10.4) @TEXT("VSS",size=1.1,halign="middle",valign="top");
// &"CMP_CLK" @WIRE(mode="straight",linecolor="#30485d",linewidth=0.16) {#X009:2 (222,-1.7)};
// (221.6,-1.7) @TEXT("CMP_CLK",size=1.1,halign="end",valign="middle");
// &"VDD" @WIRE(mode="straight",linecolor="#30485d",linewidth=0.16) {#X009:3 (232,10)};
// (232,10.4) @TEXT("VDD",size=1.1,halign="middle",valign="bottom");
// &"VSS" @WIRE(mode="straight",linecolor="#30485d",linewidth=0.16) {#X009:4 (232,-10)};
// (232,-10.4) @TEXT("VSS",size=1.1,halign="middle",valign="top");
// &"RAW" @WIRE(mode="straight",linecolor="#30485d",linewidth=0.16) {#X008:1 (186,1.7)};
// (185.6,1.7) @TEXT("RAW",size=1.1,halign="end",valign="middle");
// &"VDD" @WIRE(mode="straight",linecolor="#30485d",linewidth=0.16) {#X008:3 (196,10)};
// (196,10.4) @TEXT("VDD",size=1.1,halign="middle",valign="bottom");
// &"VSS" @WIRE(mode="straight",linecolor="#30485d",linewidth=0.16) {#X008:4 (196,-10)};
// (196,-10.4) @TEXT("VSS",size=1.1,halign="middle",valign="top");
// &"PR" @WIRE(mode="straight",linecolor="#30485d",linewidth=0.16) {#X005:1 (62,37.7)};
// (61.6,37.7) @TEXT("PR",size=1.1,halign="end",valign="middle");
// &"VDD" @WIRE(mode="straight",linecolor="#30485d",linewidth=0.16) {#X005:3 (72,46)};
// (72,46.4) @TEXT("VDD",size=1.1,halign="middle",valign="bottom");
// &"VSS" @WIRE(mode="straight",linecolor="#30485d",linewidth=0.16) {#X005:4 (72,26)};
// (72,25.6) @TEXT("VSS",size=1.1,halign="middle",valign="top");
// &"DATA" @WIRE(mode="straight",linecolor="#30485d",linewidth=0.16) {#X005:5 (82,36)};
// (82.4,36) @TEXT("DATA",size=1.1,halign="start",valign="middle");
// &"SN" @WIRE(mode="straight",linecolor="#30485d",linewidth=0.16) {#X001:1 (26,-70.3)};
// (25.6,-70.3) @TEXT("SN",size=1.1,halign="end",valign="middle");
// &"ACTIVE" @WIRE(mode="straight",linecolor="#30485d",linewidth=0.16) {#X001:2 (26,-73.7)};
// (25.6,-73.7) @TEXT("ACTIVE",size=1.1,halign="end",valign="middle");
// &"VDD" @WIRE(mode="straight",linecolor="#30485d",linewidth=0.16) {#X001:3 (36,-62)};
// (36,-61.6) @TEXT("VDD",size=1.1,halign="middle",valign="bottom");
// &"VSS" @WIRE(mode="straight",linecolor="#30485d",linewidth=0.16) {#X001:4 (36,-82)};
// (36,-82.4) @TEXT("VSS",size=1.1,halign="middle",valign="top");
// &"LIVE" @WIRE(mode="straight",linecolor="#30485d",linewidth=0.16) {#X001:5 (46,-72)};
// (46.4,-72) @TEXT("LIVE",size=1.1,halign="start",valign="middle");
// &"VDD" @WIRE(mode="straight",linecolor="#30485d",linewidth=0.16) {#X025:2 (417,-62)};
// (417,-61.6) @TEXT("VDD",size=1.1,halign="middle",valign="bottom");
// &"VSS" @WIRE(mode="straight",linecolor="#30485d",linewidth=0.16) {#X025:3 (417,-82)};
// (417,-82.4) @TEXT("VSS",size=1.1,halign="middle",valign="top");
// &"CMP_CLK" @WIRE(mode="straight",linecolor="#30485d",linewidth=0.16) {#X025:4 (427,-72)};
// (427.4,-72) @TEXT("CMP_CLK",size=1.1,halign="start",valign="middle");
// &"COMP_N" @WIRE(mode="straight",linecolor="#30485d",linewidth=0.16) {#X003:1 (-10,0)};
// (-10.4,0) @TEXT("COMP_N",size=1.1,halign="end",valign="middle");
// &"VDD" @WIRE(mode="straight",linecolor="#30485d",linewidth=0.16) {#X003:2 (0,10)};
// (0,10.4) @TEXT("VDD",size=1.1,halign="middle",valign="bottom");
// &"VSS" @WIRE(mode="straight",linecolor="#30485d",linewidth=0.16) {#X003:3 (0,-10)};
// (0,-10.4) @TEXT("VSS",size=1.1,halign="middle",valign="top");
// &"NR" @WIRE(mode="straight",linecolor="#30485d",linewidth=0.16) {#X003:4 (10,0)};
// (10.4,0) @TEXT("NR",size=1.1,halign="start",valign="middle");
// &"COMP_P" @WIRE(mode="straight",linecolor="#30485d",linewidth=0.16) {#X002:1 (-10,36)};
// (-10.4,36) @TEXT("COMP_P",size=1.1,halign="end",valign="middle");
// &"VDD" @WIRE(mode="straight",linecolor="#30485d",linewidth=0.16) {#X002:2 (0,46)};
// (0,46.4) @TEXT("VDD",size=1.1,halign="middle",valign="bottom");
// &"VSS" @WIRE(mode="straight",linecolor="#30485d",linewidth=0.16) {#X002:3 (0,26)};
// (0,25.6) @TEXT("VSS",size=1.1,halign="middle",valign="top");
// &"PR" @WIRE(mode="straight",linecolor="#30485d",linewidth=0.16) {#X002:4 (10,36)};
// (10.4,36) @TEXT("PR",size=1.1,halign="start",valign="middle");
// &"PR" @WIRE(mode="straight",linecolor="#30485d",linewidth=0.16) {#X006:1 (100,1.7)};
// (99.6,1.7) @TEXT("PR",size=1.1,halign="end",valign="middle");
// &"NR" @WIRE(mode="straight",linecolor="#30485d",linewidth=0.16) {#X006:2 (100,-1.7)};
// (99.6,-1.7) @TEXT("NR",size=1.1,halign="end",valign="middle");
// &"VDD" @WIRE(mode="straight",linecolor="#30485d",linewidth=0.16) {#X006:3 (110,10)};
// (110,10.4) @TEXT("VDD",size=1.1,halign="middle",valign="bottom");
// &"VSS" @WIRE(mode="straight",linecolor="#30485d",linewidth=0.16) {#X006:4 (110,-10)};
// (110,-10.4) @TEXT("VSS",size=1.1,halign="middle",valign="top");
// &"RAW" @WIRE(mode="straight",linecolor="#30485d",linewidth=0.16) {#X006:5 (120,0)};
// (120.4,0) @TEXT("RAW",size=1.1,halign="start",valign="middle");
// &"RAW" @WIRE(mode="straight",linecolor="#30485d",linewidth=0.16) {#XD_RAW_D:1 (135,-21)};
// (134.6,-21) @TEXT("RAW",size=1.1,halign="end",valign="middle");
// &"VDD" @WIRE(mode="straight",linecolor="#30485d",linewidth=0.16) {#XD_RAW_D:2 (151,-10)};
// (151,-9.6) @TEXT("VDD",size=1.1,halign="middle",valign="bottom");
// &"VSS" @WIRE(mode="straight",linecolor="#30485d",linewidth=0.16) {#XD_RAW_D:3 (151,-32)};
// (151,-32.4) @TEXT("VSS",size=1.1,halign="middle",valign="top");
// &"VDD" @WIRE(mode="straight",linecolor="#30485d",linewidth=0.16) {#X011:2 (306,10)};
// (306,10.4) @TEXT("VDD",size=1.1,halign="middle",valign="bottom");
// &"VSS" @WIRE(mode="straight",linecolor="#30485d",linewidth=0.16) {#X011:3 (306,-10)};
// (306,-10.4) @TEXT("VSS",size=1.1,halign="middle",valign="top");
// &"PHI_W" @WIRE(mode="straight",linecolor="#30485d",linewidth=0.16) {#X011:4 (316,0)};
// (316.4,0) @TEXT("PHI_W",size=1.1,halign="start",valign="middle");
// &"PHI_W" @WIRE(mode="straight",linecolor="#30485d",linewidth=0.16) {#XD_WRITE_D:1 (333,-21)};
// (332.6,-21) @TEXT("PHI_W",size=1.1,halign="end",valign="middle");
// &"VDD" @WIRE(mode="straight",linecolor="#30485d",linewidth=0.16) {#XD_WRITE_D:2 (349,-10)};
// (349,-9.6) @TEXT("VDD",size=1.1,halign="middle",valign="bottom");
// &"VSS" @WIRE(mode="straight",linecolor="#30485d",linewidth=0.16) {#XD_WRITE_D:3 (349,-32)};
// (349,-32.4) @TEXT("VSS",size=1.1,halign="middle",valign="top");
// &"QUIET" @WIRE(mode="straight",linecolor="#30485d",linewidth=0.16) {#XD_QUIET_D:1 (227,-93)};
// (226.6,-93) @TEXT("QUIET",size=1.1,halign="end",valign="middle");
// &"VDD" @WIRE(mode="straight",linecolor="#30485d",linewidth=0.16) {#XD_QUIET_D:2 (243,-82)};
// (243,-81.6) @TEXT("VDD",size=1.1,halign="middle",valign="bottom");
// &"VSS" @WIRE(mode="straight",linecolor="#30485d",linewidth=0.16) {#XD_QUIET_D:3 (243,-104)};
// (243,-104.4) @TEXT("VSS",size=1.1,halign="middle",valign="top");
// &"SAMPLE" @WIRE(mode="straight",linecolor="#30485d",linewidth=0.16) {#X023:1 (319,-110.3)};
// (318.6,-110.3) @TEXT("SAMPLE",size=1.1,halign="end",valign="middle");
// &"PHI_U" @WIRE(mode="straight",linecolor="#30485d",linewidth=0.16) {#X023:2 (319,-113.7)};
// (318.6,-113.7) @TEXT("PHI_U",size=1.1,halign="end",valign="middle");
// &"VDD" @WIRE(mode="straight",linecolor="#30485d",linewidth=0.16) {#X023:3 (329,-102)};
// (329,-101.6) @TEXT("VDD",size=1.1,halign="middle",valign="bottom");
// &"VSS" @WIRE(mode="straight",linecolor="#30485d",linewidth=0.16) {#X023:4 (329,-122)};
// (329,-122.4) @TEXT("VSS",size=1.1,halign="middle",valign="top");
// &"VDD" @WIRE(mode="straight",linecolor="#30485d",linewidth=0.16) {#XCLOCK:4 (372,-61)};
// (372,-60.6) @TEXT("VDD",size=1.1,halign="middle",valign="bottom");
// &"VSS" @WIRE(mode="straight",linecolor="#30485d",linewidth=0.16) {#XCLOCK:5 (372,-83)};
// (372,-83.4) @TEXT("VSS",size=1.1,halign="middle",valign="top");
// }
// END SARADC RNL
ends sar8p_timing

subckt sar8p_bitseq8 PHI_U SAMPLE T0 T1 T2 T3 T4 T5 T6 T7 VDD VSS
    XF0 (PHI_U T1 T0 SAMPLE VDD VSS) sar8p_dffr
    XF1 (PHI_U T2 T1 SAMPLE VDD VSS) sar8p_dffr
    XF2 (PHI_U T3 T2 SAMPLE VDD VSS) sar8p_dffr
    XF3 (PHI_U T4 T3 SAMPLE VDD VSS) sar8p_dffr
    XF4 (PHI_U T5 T4 SAMPLE VDD VSS) sar8p_dffr
    XF5 (PHI_U T6 T5 SAMPLE VDD VSS) sar8p_dffr
    XF6 (PHI_U T7 T6 SAMPLE VDD VSS) sar8p_dffr
    XF7 (PHI_U VDD NT7 SAMPLE VDD VSS) sar8p_dffr
    X001 (NT7 VDD VSS T7) sar8p_inv
// BEGIN SARADC RNL
// @RNL(author="saradc topology") {
// #XF7 @SET-SYMBOL $S_sar8p_dffr;
// #XF7 @PLACE(0,0) => @ORIENT("R0");
// #XF6 @SET-SYMBOL $S_sar8p_dffr;
// #XF6 @PLACE(43,0) => @ORIENT("R0");
// #XF5 @SET-SYMBOL $S_sar8p_dffr;
// #XF5 @PLACE(86,0) => @ORIENT("R0");
// #XF4 @SET-SYMBOL $S_sar8p_dffr;
// #XF4 @PLACE(129,0) => @ORIENT("R0");
// #XF3 @SET-SYMBOL $S_sar8p_dffr;
// #XF3 @PLACE(172,0) => @ORIENT("R0");
// #XF2 @SET-SYMBOL $S_sar8p_dffr;
// #XF2 @PLACE(215,0) => @ORIENT("R0");
// #XF1 @SET-SYMBOL $S_sar8p_dffr;
// #XF1 @PLACE(258,0) => @ORIENT("R0");
// #XF0 @SET-SYMBOL $S_sar8p_dffr;
// #XF0 @PLACE(301,0) => @ORIENT("R0");
// #X001 @SET-SYMBOL $S_sar8p_inv;
// #X001 @PLACE(22,27) => @ORIENT("R0");
// &"T1" @WIRE(mode="straight",linecolor="#30485d",linewidth=0.16) {#XF0:2 (279.5,0) (279.5,0) #XF1:3};
// &"T2" @WIRE(mode="straight",linecolor="#30485d",linewidth=0.16) {#XF1:2 (236.5,0) (236.5,0) #XF2:3};
// &"T3" @WIRE(mode="straight",linecolor="#30485d",linewidth=0.16) {#XF2:2 (193.5,0) (193.5,0) #XF3:3};
// &"T4" @WIRE(mode="straight",linecolor="#30485d",linewidth=0.16) {#XF3:2 (150.5,0) (150.5,0) #XF4:3};
// &"T5" @WIRE(mode="straight",linecolor="#30485d",linewidth=0.16) {#XF4:2 (107.5,0) (107.5,0) #XF5:3};
// &"T6" @WIRE(mode="straight",linecolor="#30485d",linewidth=0.16) {#XF5:2 (64.5,0) (64.5,0) #XF6:3};
// &"T7" @WIRE(mode="straight",linecolor="#30485d",linewidth=0.16) {#XF6:2 (32.5,0) (32.5,27) #X001:4};
// &"NT7" @WIRE(mode="straight",linecolor="#30485d",linewidth=0.16) {#XF7:3 (11,0) (11,27) #X001:1};
// (-16,50) @TEXT("Token shift / bit 7 -> bit 0 / asynchronous reset",size=1.4,halign="start",textcolor="#223d52");
// &"PHI_U" @WIRE(mode="straight",linecolor="#30485d",linewidth=0.16) {#XF0:1 (291,3.4)};
// (290.6,3.4) @TEXT("PHI_U",size=1.1,halign="end",valign="middle");
// &"T0" @WIRE(mode="straight",linecolor="#30485d",linewidth=0.16) {#XF0:3 (311,0)};
// (311.4,0) @TEXT("T0",size=1.1,halign="start",valign="middle");
// &"SAMPLE" @WIRE(mode="straight",linecolor="#30485d",linewidth=0.16) {#XF0:4 (291,-3.4)};
// (290.6,-3.4) @TEXT("SAMPLE",size=1.1,halign="end",valign="middle");
// &"VDD" @WIRE(mode="straight",linecolor="#30485d",linewidth=0.16) {#XF0:5 (301,10)};
// (301,10.4) @TEXT("VDD",size=1.1,halign="middle",valign="bottom");
// &"VSS" @WIRE(mode="straight",linecolor="#30485d",linewidth=0.16) {#XF0:6 (301,-10)};
// (301,-10.4) @TEXT("VSS",size=1.1,halign="middle",valign="top");
// &"PHI_U" @WIRE(mode="straight",linecolor="#30485d",linewidth=0.16) {#XF1:1 (248,3.4)};
// (247.6,3.4) @TEXT("PHI_U",size=1.1,halign="end",valign="middle");
// &"SAMPLE" @WIRE(mode="straight",linecolor="#30485d",linewidth=0.16) {#XF1:4 (248,-3.4)};
// (247.6,-3.4) @TEXT("SAMPLE",size=1.1,halign="end",valign="middle");
// &"VDD" @WIRE(mode="straight",linecolor="#30485d",linewidth=0.16) {#XF1:5 (258,10)};
// (258,10.4) @TEXT("VDD",size=1.1,halign="middle",valign="bottom");
// &"VSS" @WIRE(mode="straight",linecolor="#30485d",linewidth=0.16) {#XF1:6 (258,-10)};
// (258,-10.4) @TEXT("VSS",size=1.1,halign="middle",valign="top");
// &"PHI_U" @WIRE(mode="straight",linecolor="#30485d",linewidth=0.16) {#XF2:1 (205,3.4)};
// (204.6,3.4) @TEXT("PHI_U",size=1.1,halign="end",valign="middle");
// &"SAMPLE" @WIRE(mode="straight",linecolor="#30485d",linewidth=0.16) {#XF2:4 (205,-3.4)};
// (204.6,-3.4) @TEXT("SAMPLE",size=1.1,halign="end",valign="middle");
// &"VDD" @WIRE(mode="straight",linecolor="#30485d",linewidth=0.16) {#XF2:5 (215,10)};
// (215,10.4) @TEXT("VDD",size=1.1,halign="middle",valign="bottom");
// &"VSS" @WIRE(mode="straight",linecolor="#30485d",linewidth=0.16) {#XF2:6 (215,-10)};
// (215,-10.4) @TEXT("VSS",size=1.1,halign="middle",valign="top");
// &"PHI_U" @WIRE(mode="straight",linecolor="#30485d",linewidth=0.16) {#XF3:1 (162,3.4)};
// (161.6,3.4) @TEXT("PHI_U",size=1.1,halign="end",valign="middle");
// &"SAMPLE" @WIRE(mode="straight",linecolor="#30485d",linewidth=0.16) {#XF3:4 (162,-3.4)};
// (161.6,-3.4) @TEXT("SAMPLE",size=1.1,halign="end",valign="middle");
// &"VDD" @WIRE(mode="straight",linecolor="#30485d",linewidth=0.16) {#XF3:5 (172,10)};
// (172,10.4) @TEXT("VDD",size=1.1,halign="middle",valign="bottom");
// &"VSS" @WIRE(mode="straight",linecolor="#30485d",linewidth=0.16) {#XF3:6 (172,-10)};
// (172,-10.4) @TEXT("VSS",size=1.1,halign="middle",valign="top");
// &"PHI_U" @WIRE(mode="straight",linecolor="#30485d",linewidth=0.16) {#XF4:1 (119,3.4)};
// (118.6,3.4) @TEXT("PHI_U",size=1.1,halign="end",valign="middle");
// &"SAMPLE" @WIRE(mode="straight",linecolor="#30485d",linewidth=0.16) {#XF4:4 (119,-3.4)};
// (118.6,-3.4) @TEXT("SAMPLE",size=1.1,halign="end",valign="middle");
// &"VDD" @WIRE(mode="straight",linecolor="#30485d",linewidth=0.16) {#XF4:5 (129,10)};
// (129,10.4) @TEXT("VDD",size=1.1,halign="middle",valign="bottom");
// &"VSS" @WIRE(mode="straight",linecolor="#30485d",linewidth=0.16) {#XF4:6 (129,-10)};
// (129,-10.4) @TEXT("VSS",size=1.1,halign="middle",valign="top");
// &"PHI_U" @WIRE(mode="straight",linecolor="#30485d",linewidth=0.16) {#XF5:1 (76,3.4)};
// (75.6,3.4) @TEXT("PHI_U",size=1.1,halign="end",valign="middle");
// &"SAMPLE" @WIRE(mode="straight",linecolor="#30485d",linewidth=0.16) {#XF5:4 (76,-3.4)};
// (75.6,-3.4) @TEXT("SAMPLE",size=1.1,halign="end",valign="middle");
// &"VDD" @WIRE(mode="straight",linecolor="#30485d",linewidth=0.16) {#XF5:5 (86,10)};
// (86,10.4) @TEXT("VDD",size=1.1,halign="middle",valign="bottom");
// &"VSS" @WIRE(mode="straight",linecolor="#30485d",linewidth=0.16) {#XF5:6 (86,-10)};
// (86,-10.4) @TEXT("VSS",size=1.1,halign="middle",valign="top");
// &"PHI_U" @WIRE(mode="straight",linecolor="#30485d",linewidth=0.16) {#XF6:1 (33,3.4)};
// (32.6,3.4) @TEXT("PHI_U",size=1.1,halign="end",valign="middle");
// &"SAMPLE" @WIRE(mode="straight",linecolor="#30485d",linewidth=0.16) {#XF6:4 (33,-3.4)};
// (32.6,-3.4) @TEXT("SAMPLE",size=1.1,halign="end",valign="middle");
// &"VDD" @WIRE(mode="straight",linecolor="#30485d",linewidth=0.16) {#XF6:5 (43,10)};
// (43,10.4) @TEXT("VDD",size=1.1,halign="middle",valign="bottom");
// &"VSS" @WIRE(mode="straight",linecolor="#30485d",linewidth=0.16) {#XF6:6 (43,-10)};
// (43,-10.4) @TEXT("VSS",size=1.1,halign="middle",valign="top");
// &"PHI_U" @WIRE(mode="straight",linecolor="#30485d",linewidth=0.16) {#XF7:1 (-10,3.4)};
// (-10.4,3.4) @TEXT("PHI_U",size=1.1,halign="end",valign="middle");
// &"VDD" @WIRE(mode="straight",linecolor="#30485d",linewidth=0.16) {#XF7:2 (-10,0)};
// (-10.4,0) @TEXT("VDD",size=1.1,halign="end",valign="middle");
// &"SAMPLE" @WIRE(mode="straight",linecolor="#30485d",linewidth=0.16) {#XF7:4 (-10,-3.4)};
// (-10.4,-3.4) @TEXT("SAMPLE",size=1.1,halign="end",valign="middle");
// &"VDD" @WIRE(mode="straight",linecolor="#30485d",linewidth=0.16) {#XF7:5 (0,10)};
// (0,10.4) @TEXT("VDD",size=1.1,halign="middle",valign="bottom");
// &"VSS" @WIRE(mode="straight",linecolor="#30485d",linewidth=0.16) {#XF7:6 (0,-10)};
// (0,-10.4) @TEXT("VSS",size=1.1,halign="middle",valign="top");
// &"VDD" @WIRE(mode="straight",linecolor="#30485d",linewidth=0.16) {#X001:2 (22,37)};
// (22,37.4) @TEXT("VDD",size=1.1,halign="middle",valign="bottom");
// &"VSS" @WIRE(mode="straight",linecolor="#30485d",linewidth=0.16) {#X001:3 (22,17)};
// (22,16.6) @TEXT("VSS",size=1.1,halign="middle",valign="top");
// }
// END SARADC RNL
ends sar8p_bitseq8

subckt sar8p_bit CODE D DATA PHI_W SAMPLE TOKEN VDD VSS
    XMUX (D DATA TOKEN VDD VSS NEXT_D) sar8p_mux2
    XSTORE (PHI_W NEXT_D D SAMPLE VDD VSS) sar8p_dffr
    X002 (D TOKEN VDD VSS CODE) sar8p_or2
// BEGIN SARADC RNL
// @RNL(author="saradc topology") {
// #XMUX @SET-SYMBOL $S_sar8p_mux2;
// #XMUX @PLACE(0,0) => @ORIENT("R0");
// #XSTORE @SET-SYMBOL $S_sar8p_dffr;
// #XSTORE @PLACE(43,0) => @ORIENT("R0");
// #X002 @SET-SYMBOL $S_sar8p_or2;
// #X002 @PLACE(84,0) => @ORIENT("R0");
// &"TOKEN" @WIRE(mode="straight",linecolor="#30485d",linewidth=0.16) {#XMUX:3 (35,-3.4) (35,-1.7) #X002:2};
// &"NEXT_D" @WIRE(mode="straight",linecolor="#30485d",linewidth=0.16) {#XMUX:6 (21.5,0) (21.5,0) #XSTORE:2};
// &"D" @WIRE(mode="straight",linecolor="#30485d",linewidth=0.16) {(-12,0) (-12,1.7) (-12,3.4)};
// &"D" @WIRE(mode="straight",linecolor="#30485d",linewidth=0.16) {#XMUX:1 (-12,3.4)};
// $JUNCTION @ATTACH (-12,3.4);
// &"D" @WIRE(mode="straight",linecolor="#30485d",linewidth=0.16) {#XSTORE:3 (-12,0)};
// $JUNCTION @ATTACH (-12,0);
// &"D" @WIRE(mode="straight",linecolor="#30485d",linewidth=0.16) {#X002:1 (-12,1.7)};
// $JUNCTION @ATTACH (-12,1.7);
// (-16,46) @TEXT("sar8p_bit / native standard-cell composition",size=1.3,halign="start",textcolor="#223d52");
// &"DATA" @WIRE(mode="straight",linecolor="#30485d",linewidth=0.16) {#XMUX:2 (-10,0)};
// (-10.4,0) @TEXT("DATA",size=1.1,halign="end",valign="middle");
// &"VDD" @WIRE(mode="straight",linecolor="#30485d",linewidth=0.16) {#XMUX:4 (0,10)};
// (0,10.4) @TEXT("VDD",size=1.1,halign="middle",valign="bottom");
// &"VSS" @WIRE(mode="straight",linecolor="#30485d",linewidth=0.16) {#XMUX:5 (0,-10)};
// (0,-10.4) @TEXT("VSS",size=1.1,halign="middle",valign="top");
// &"PHI_W" @WIRE(mode="straight",linecolor="#30485d",linewidth=0.16) {#XSTORE:1 (33,3.4)};
// (32.6,3.4) @TEXT("PHI_W",size=1.1,halign="end",valign="middle");
// &"SAMPLE" @WIRE(mode="straight",linecolor="#30485d",linewidth=0.16) {#XSTORE:4 (33,-3.4)};
// (32.6,-3.4) @TEXT("SAMPLE",size=1.1,halign="end",valign="middle");
// &"VDD" @WIRE(mode="straight",linecolor="#30485d",linewidth=0.16) {#XSTORE:5 (43,10)};
// (43,10.4) @TEXT("VDD",size=1.1,halign="middle",valign="bottom");
// &"VSS" @WIRE(mode="straight",linecolor="#30485d",linewidth=0.16) {#XSTORE:6 (43,-10)};
// (43,-10.4) @TEXT("VSS",size=1.1,halign="middle",valign="top");
// &"VDD" @WIRE(mode="straight",linecolor="#30485d",linewidth=0.16) {#X002:3 (84,10)};
// (84,10.4) @TEXT("VDD",size=1.1,halign="middle",valign="bottom");
// &"VSS" @WIRE(mode="straight",linecolor="#30485d",linewidth=0.16) {#X002:4 (84,-10)};
// (84,-10.4) @TEXT("VSS",size=1.1,halign="middle",valign="top");
// &"CODE" @WIRE(mode="straight",linecolor="#30485d",linewidth=0.16) {#X002:5 (94,0)};
// (94.4,0) @TEXT("CODE",size=1.1,halign="start",valign="middle");
// }
// END SARADC RNL
ends sar8p_bit

subckt sar_logic_8b_physical CMP_CLK CODE0 CODE1 CODE2 CODE3 CODE4 CODE5 \
        CODE6 CODE7 COMP_N COMP_P D0 D1 D2 D3 D4 D5 D6 D7 PHI_U SAMPLE VDD \
        VSS
    XTIM (ACTIVE CMP_CLK COMP_N COMP_P DATA PHI_U PHI_W SAMPLE VDD VSS) \
        sar8p_timing
    XSEQ (PHI_U SAMPLE T0 T1 T2 T3 T4 T5 T6 T7 VDD VSS) sar8p_bitseq8
    XBIT7 (CODE7 D7 DATA PHI_W SAMPLE T7 VDD VSS) sar8p_bit
    XBIT6 (CODE6 D6 DATA PHI_W SAMPLE T6 VDD VSS) sar8p_bit
    XBIT5 (CODE5 D5 DATA PHI_W SAMPLE T5 VDD VSS) sar8p_bit
    XBIT4 (CODE4 D4 DATA PHI_W SAMPLE T4 VDD VSS) sar8p_bit
    XBIT3 (CODE3 D3 DATA PHI_W SAMPLE T3 VDD VSS) sar8p_bit
    XBIT2 (CODE2 D2 DATA PHI_W SAMPLE T2 VDD VSS) sar8p_bit
    XBIT1 (CODE1 D1 DATA PHI_W SAMPLE T1 VDD VSS) sar8p_bit
    XBIT0 (CODE0 D0 DATA PHI_W SAMPLE T0 VDD VSS) sar8p_bit
    X018 (A01 A23 VDD VSS ACTIVE) sar8p_or2
    X017 (A2 A3 VDD VSS A23) sar8p_or2
    X016 (A0 A1 VDD VSS A01) sar8p_or2
    X015 (T6 T7 VDD VSS A3) sar8p_or2
    X014 (T4 T5 VDD VSS A2) sar8p_or2
    X013 (T2 T3 VDD VSS A1) sar8p_or2
    X012 (T0 T1 VDD VSS A0) sar8p_or2
// BEGIN SARADC RNL
// @RNL(author="saradc topology") {
// (-23,82) @TEXT("8-bit SAR / one token, eight bit stores, asynchronous handshake",size=1.5,halign="start",textcolor="#223d52");
// #XTIM @SET-SYMBOL $S_sar8p_timing;
// #XTIM @PLACE(0,39) => @ORIENT("R0");
// #XSEQ @SET-SYMBOL $S_sar8p_bitseq8;
// #XSEQ @PLACE(0,-17) => @ORIENT("R0");
// #XBIT7 @SET-SYMBOL $S_sar8p_bit;
// #XBIT7 @PLACE(73,0) => @ORIENT("R0");
// #XBIT6 @SET-SYMBOL $S_sar8p_bit;
// #XBIT6 @PLACE(73,-35) => @ORIENT("R0");
// #XBIT5 @SET-SYMBOL $S_sar8p_bit;
// #XBIT5 @PLACE(73,-70) => @ORIENT("R0");
// #XBIT4 @SET-SYMBOL $S_sar8p_bit;
// #XBIT4 @PLACE(73,-105) => @ORIENT("R0");
// #XBIT3 @SET-SYMBOL $S_sar8p_bit;
// #XBIT3 @PLACE(73,-140) => @ORIENT("R0");
// #XBIT2 @SET-SYMBOL $S_sar8p_bit;
// #XBIT2 @PLACE(73,-175) => @ORIENT("R0");
// #XBIT1 @SET-SYMBOL $S_sar8p_bit;
// #XBIT1 @PLACE(73,-210) => @ORIENT("R0");
// #XBIT0 @SET-SYMBOL $S_sar8p_bit;
// #XBIT0 @PLACE(73,-245) => @ORIENT("R0");
// #X012 @SET-SYMBOL $S_sar8p_or2;
// #X012 @PLACE(142,0) => @ORIENT("R0");
// #X013 @SET-SYMBOL $S_sar8p_or2;
// #X013 @PLACE(142,-70) => @ORIENT("R0");
// #X014 @SET-SYMBOL $S_sar8p_or2;
// #X014 @PLACE(142,-140) => @ORIENT("R0");
// #X015 @SET-SYMBOL $S_sar8p_or2;
// #X015 @PLACE(142,-210) => @ORIENT("R0");
// #X016 @SET-SYMBOL $S_sar8p_or2;
// #X016 @PLACE(184,-35) => @ORIENT("R0");
// #X017 @SET-SYMBOL $S_sar8p_or2;
// #X017 @PLACE(184,-175) => @ORIENT("R0");
// #X018 @SET-SYMBOL $S_sar8p_or2;
// #X018 @PLACE(225,-105) => @ORIENT("R0");
// &"A0" @WIRE(mode="straight",linecolor="#30485d",linewidth=0.16) {(163,-33.3) (163,0)};
// &"A0" @WIRE(mode="straight",linecolor="#30485d",linewidth=0.16) {#X016:1 (163,-33.3)};
// $JUNCTION @ATTACH (163,-33.3);
// &"A0" @WIRE(mode="straight",linecolor="#30485d",linewidth=0.16) {#X012:5 (163,0)};
// $JUNCTION @ATTACH (163,0);
// &"A1" @WIRE(mode="straight",linecolor="#30485d",linewidth=0.16) {(163,-70) (163,-36.7)};
// &"A1" @WIRE(mode="straight",linecolor="#30485d",linewidth=0.16) {#X016:2 (163,-36.7)};
// $JUNCTION @ATTACH (163,-36.7);
// &"A1" @WIRE(mode="straight",linecolor="#30485d",linewidth=0.16) {#X013:5 (163,-70)};
// $JUNCTION @ATTACH (163,-70);
// &"A2" @WIRE(mode="straight",linecolor="#30485d",linewidth=0.16) {(163,-173.3) (163,-140)};
// &"A2" @WIRE(mode="straight",linecolor="#30485d",linewidth=0.16) {#X017:1 (163,-173.3)};
// $JUNCTION @ATTACH (163,-173.3);
// &"A2" @WIRE(mode="straight",linecolor="#30485d",linewidth=0.16) {#X014:5 (163,-140)};
// $JUNCTION @ATTACH (163,-140);
// &"A3" @WIRE(mode="straight",linecolor="#30485d",linewidth=0.16) {(163,-210) (163,-176.7)};
// &"A3" @WIRE(mode="straight",linecolor="#30485d",linewidth=0.16) {#X017:2 (163,-176.7)};
// $JUNCTION @ATTACH (163,-176.7);
// &"A3" @WIRE(mode="straight",linecolor="#30485d",linewidth=0.16) {#X015:5 (163,-210)};
// $JUNCTION @ATTACH (163,-210);
// &"A01" @WIRE(mode="straight",linecolor="#30485d",linewidth=0.16) {(204.5,-103.3) (204.5,-35)};
// &"A01" @WIRE(mode="straight",linecolor="#30485d",linewidth=0.16) {#X018:1 (204.5,-103.3)};
// $JUNCTION @ATTACH (204.5,-103.3);
// &"A01" @WIRE(mode="straight",linecolor="#30485d",linewidth=0.16) {#X016:5 (204.5,-35)};
// $JUNCTION @ATTACH (204.5,-35);
// &"A23" @WIRE(mode="straight",linecolor="#30485d",linewidth=0.16) {(204.5,-175) (204.5,-106.7)};
// &"A23" @WIRE(mode="straight",linecolor="#30485d",linewidth=0.16) {#X018:2 (204.5,-106.7)};
// $JUNCTION @ATTACH (204.5,-106.7);
// &"A23" @WIRE(mode="straight",linecolor="#30485d",linewidth=0.16) {#X017:5 (204.5,-175)};
// $JUNCTION @ATTACH (204.5,-175);
// &"ACTIVE" @WIRE(mode="straight",linecolor="#30485d",linewidth=0.16) {(109.5,-105) (109.5,43.95)};
// &"ACTIVE" @WIRE(mode="straight",linecolor="#30485d",linewidth=0.16) {#XTIM:1 (109.5,43.95)};
// $JUNCTION @ATTACH (109.5,43.95);
// &"ACTIVE" @WIRE(mode="straight",linecolor="#30485d",linewidth=0.16) {#X018:5 (109.5,-105)};
// $JUNCTION @ATTACH (109.5,-105);
// &"DATA" @WIRE(mode="straight",linecolor="#30485d",linewidth=0.16) {(33,-240.05) (33,-205.05) (33,-170.05) (33,-135.05) (33,-100.05) (33,-65.05) (33,-30.05) (33,4.95) (33,40.65)};
// &"DATA" @WIRE(mode="straight",linecolor="#30485d",linewidth=0.16) {#XTIM:5 (33,40.65)};
// $JUNCTION @ATTACH (33,40.65);
// &"DATA" @WIRE(mode="straight",linecolor="#30485d",linewidth=0.16) {#XBIT7:3 (33,4.95)};
// $JUNCTION @ATTACH (33,4.95);
// &"DATA" @WIRE(mode="straight",linecolor="#30485d",linewidth=0.16) {#XBIT6:3 (33,-30.05)};
// $JUNCTION @ATTACH (33,-30.05);
// &"DATA" @WIRE(mode="straight",linecolor="#30485d",linewidth=0.16) {#XBIT5:3 (33,-65.05)};
// $JUNCTION @ATTACH (33,-65.05);
// &"DATA" @WIRE(mode="straight",linecolor="#30485d",linewidth=0.16) {#XBIT4:3 (33,-100.05)};
// $JUNCTION @ATTACH (33,-100.05);
// &"DATA" @WIRE(mode="straight",linecolor="#30485d",linewidth=0.16) {#XBIT3:3 (33,-135.05)};
// $JUNCTION @ATTACH (33,-135.05);
// &"DATA" @WIRE(mode="straight",linecolor="#30485d",linewidth=0.16) {#XBIT2:3 (33,-170.05)};
// $JUNCTION @ATTACH (33,-170.05);
// &"DATA" @WIRE(mode="straight",linecolor="#30485d",linewidth=0.16) {#XBIT1:3 (33,-205.05)};
// $JUNCTION @ATTACH (33,-205.05);
// &"DATA" @WIRE(mode="straight",linecolor="#30485d",linewidth=0.16) {#XBIT0:3 (33,-240.05)};
// $JUNCTION @ATTACH (33,-240.05);
// &"PHI_W" @WIRE(mode="straight",linecolor="#94601a",linewidth=0.16) {(38,-243.35) (38,-208.35) (38,-173.35) (38,-138.35) (38,-103.35) (38,-68.35) (38,-33.35) (38,1.65) (38,34.05)};
// &"PHI_W" @WIRE(mode="straight",linecolor="#94601a",linewidth=0.16) {#XTIM:7 (38,34.05)};
// $JUNCTION @ATTACH (38,34.05);
// &"PHI_W" @WIRE(mode="straight",linecolor="#94601a",linewidth=0.16) {#XBIT7:4 (38,1.65)};
// $JUNCTION @ATTACH (38,1.65);
// &"PHI_W" @WIRE(mode="straight",linecolor="#94601a",linewidth=0.16) {#XBIT6:4 (38,-33.35)};
// $JUNCTION @ATTACH (38,-33.35);
// &"PHI_W" @WIRE(mode="straight",linecolor="#94601a",linewidth=0.16) {#XBIT5:4 (38,-68.35)};
// $JUNCTION @ATTACH (38,-68.35);
// &"PHI_W" @WIRE(mode="straight",linecolor="#94601a",linewidth=0.16) {#XBIT4:4 (38,-103.35)};
// $JUNCTION @ATTACH (38,-103.35);
// &"PHI_W" @WIRE(mode="straight",linecolor="#94601a",linewidth=0.16) {#XBIT3:4 (38,-138.35)};
// $JUNCTION @ATTACH (38,-138.35);
// &"PHI_W" @WIRE(mode="straight",linecolor="#94601a",linewidth=0.16) {#XBIT2:4 (38,-173.35)};
// $JUNCTION @ATTACH (38,-173.35);
// &"PHI_W" @WIRE(mode="straight",linecolor="#94601a",linewidth=0.16) {#XBIT1:4 (38,-208.35)};
// $JUNCTION @ATTACH (38,-208.35);
// &"PHI_W" @WIRE(mode="straight",linecolor="#94601a",linewidth=0.16) {#XBIT0:4 (38,-243.35)};
// $JUNCTION @ATTACH (38,-243.35);
// (121,-246) @TEXT("OR reduction -> ACTIVE",size=1.15,halign="start",textcolor="#223d52");
// (-23,-274) @TEXT("T[7:0] selects one bit; CODE is the trial word and D the stored output. SAMPLE resets the controller.",size=0.95,halign="start",textcolor="#223d52");
// &"CMP_CLK" @WIRE(mode="straight",linecolor="#30485d",linewidth=0.16) {#XTIM:2 (16,43.95)};
// (16.4,43.95) @TEXT("CMP_CLK",size=1.1,halign="start",valign="middle");
// &"COMP_N" @WIRE(mode="straight",linecolor="#30485d",linewidth=0.16) {#XTIM:3 (-16,40.65)};
// (-16.4,40.65) @TEXT("COMP_N",size=1.1,halign="end",valign="middle");
// &"COMP_P" @WIRE(mode="straight",linecolor="#30485d",linewidth=0.16) {#XTIM:4 (-16,37.35)};
// (-16.4,37.35) @TEXT("COMP_P",size=1.1,halign="end",valign="middle");
// &"PHI_U" @WIRE(mode="straight",linecolor="#30485d",linewidth=0.16) {#XTIM:6 (16,37.35)};
// (16.4,37.35) @TEXT("PHI_U",size=1.1,halign="start",valign="middle");
// &"SAMPLE" @WIRE(mode="straight",linecolor="#30485d",linewidth=0.16) {#XTIM:8 (-16,34.05)};
// (-16.4,34.05) @TEXT("SAMPLE",size=1.1,halign="end",valign="middle");
// &"VDD" @WIRE(mode="straight",linecolor="#30485d",linewidth=0.16) {#XTIM:9 (0,52.25)};
// (0,52.65) @TEXT("VDD",size=1.1,halign="middle",valign="bottom");
// &"VSS" @WIRE(mode="straight",linecolor="#30485d",linewidth=0.16) {#XTIM:10 (0,25.75)};
// (0,25.35) @TEXT("VSS",size=1.1,halign="middle",valign="top");
// &"PHI_U" @WIRE(mode="straight",linecolor="#30485d",linewidth=0.16) {#XSEQ:1 (-16,-15.35)};
// (-16.4,-15.35) @TEXT("PHI_U",size=1.1,halign="end",valign="middle");
// &"SAMPLE" @WIRE(mode="straight",linecolor="#30485d",linewidth=0.16) {#XSEQ:2 (-16,-18.65)};
// (-16.4,-18.65) @TEXT("SAMPLE",size=1.1,halign="end",valign="middle");
// {&"T0" &"T1" &"T2" &"T3" &"T4" &"T5" &"T6" &"T7"} @WIRE(mode="straight",linewidth=0.3) {#XSEQ:3 (16,-17)};
// (16.4,-17) @TEXT("T[7:0]",size=1.1,halign="start",valign="middle");
// &"VDD" @WIRE(mode="straight",linecolor="#30485d",linewidth=0.16) {#XSEQ:11 (0,-6)};
// (0,-5.6) @TEXT("VDD",size=1.1,halign="middle",valign="bottom");
// &"VSS" @WIRE(mode="straight",linecolor="#30485d",linewidth=0.16) {#XSEQ:12 (0,-28)};
// (0,-28.4) @TEXT("VSS",size=1.1,halign="middle",valign="top");
// &"CODE7" @WIRE(mode="straight",linecolor="#30485d",linewidth=0.16) {#XBIT7:1 (89,1.65)};
// (89.4,1.65) @TEXT("CODE7",size=1.1,halign="start",valign="middle");
// &"D7" @WIRE(mode="straight",linecolor="#30485d",linewidth=0.16) {#XBIT7:2 (89,-1.65)};
// (89.4,-1.65) @TEXT("D7",size=1.1,halign="start",valign="middle");
// &"SAMPLE" @WIRE(mode="straight",linecolor="#30485d",linewidth=0.16) {#XBIT7:5 (57,-1.65)};
// (56.6,-1.65) @TEXT("SAMPLE",size=1.1,halign="end",valign="middle");
// &"T7" @WIRE(mode="straight",linecolor="#30485d",linewidth=0.16) {#XBIT7:6 (57,-4.95)};
// (56.6,-4.95) @TEXT("T7",size=1.1,halign="end",valign="middle");
// &"VDD" @WIRE(mode="straight",linecolor="#30485d",linewidth=0.16) {#XBIT7:7 (73,13.25)};
// (73,13.65) @TEXT("VDD",size=1.1,halign="middle",valign="bottom");
// &"VSS" @WIRE(mode="straight",linecolor="#30485d",linewidth=0.16) {#XBIT7:8 (73,-13.25)};
// (73,-13.65) @TEXT("VSS",size=1.1,halign="middle",valign="top");
// &"CODE6" @WIRE(mode="straight",linecolor="#30485d",linewidth=0.16) {#XBIT6:1 (89,-33.35)};
// (89.4,-33.35) @TEXT("CODE6",size=1.1,halign="start",valign="middle");
// &"D6" @WIRE(mode="straight",linecolor="#30485d",linewidth=0.16) {#XBIT6:2 (89,-36.65)};
// (89.4,-36.65) @TEXT("D6",size=1.1,halign="start",valign="middle");
// &"SAMPLE" @WIRE(mode="straight",linecolor="#30485d",linewidth=0.16) {#XBIT6:5 (57,-36.65)};
// (56.6,-36.65) @TEXT("SAMPLE",size=1.1,halign="end",valign="middle");
// &"T6" @WIRE(mode="straight",linecolor="#30485d",linewidth=0.16) {#XBIT6:6 (57,-39.95)};
// (56.6,-39.95) @TEXT("T6",size=1.1,halign="end",valign="middle");
// &"VDD" @WIRE(mode="straight",linecolor="#30485d",linewidth=0.16) {#XBIT6:7 (73,-21.75)};
// (73,-21.35) @TEXT("VDD",size=1.1,halign="middle",valign="bottom");
// &"VSS" @WIRE(mode="straight",linecolor="#30485d",linewidth=0.16) {#XBIT6:8 (73,-48.25)};
// (73,-48.65) @TEXT("VSS",size=1.1,halign="middle",valign="top");
// &"CODE5" @WIRE(mode="straight",linecolor="#30485d",linewidth=0.16) {#XBIT5:1 (89,-68.35)};
// (89.4,-68.35) @TEXT("CODE5",size=1.1,halign="start",valign="middle");
// &"D5" @WIRE(mode="straight",linecolor="#30485d",linewidth=0.16) {#XBIT5:2 (89,-71.65)};
// (89.4,-71.65) @TEXT("D5",size=1.1,halign="start",valign="middle");
// &"SAMPLE" @WIRE(mode="straight",linecolor="#30485d",linewidth=0.16) {#XBIT5:5 (57,-71.65)};
// (56.6,-71.65) @TEXT("SAMPLE",size=1.1,halign="end",valign="middle");
// &"T5" @WIRE(mode="straight",linecolor="#30485d",linewidth=0.16) {#XBIT5:6 (57,-74.95)};
// (56.6,-74.95) @TEXT("T5",size=1.1,halign="end",valign="middle");
// &"VDD" @WIRE(mode="straight",linecolor="#30485d",linewidth=0.16) {#XBIT5:7 (73,-56.75)};
// (73,-56.35) @TEXT("VDD",size=1.1,halign="middle",valign="bottom");
// &"VSS" @WIRE(mode="straight",linecolor="#30485d",linewidth=0.16) {#XBIT5:8 (73,-83.25)};
// (73,-83.65) @TEXT("VSS",size=1.1,halign="middle",valign="top");
// &"CODE4" @WIRE(mode="straight",linecolor="#30485d",linewidth=0.16) {#XBIT4:1 (89,-103.35)};
// (89.4,-103.35) @TEXT("CODE4",size=1.1,halign="start",valign="middle");
// &"D4" @WIRE(mode="straight",linecolor="#30485d",linewidth=0.16) {#XBIT4:2 (89,-106.65)};
// (89.4,-106.65) @TEXT("D4",size=1.1,halign="start",valign="middle");
// &"SAMPLE" @WIRE(mode="straight",linecolor="#30485d",linewidth=0.16) {#XBIT4:5 (57,-106.65)};
// (56.6,-106.65) @TEXT("SAMPLE",size=1.1,halign="end",valign="middle");
// &"T4" @WIRE(mode="straight",linecolor="#30485d",linewidth=0.16) {#XBIT4:6 (57,-109.95)};
// (56.6,-109.95) @TEXT("T4",size=1.1,halign="end",valign="middle");
// &"VDD" @WIRE(mode="straight",linecolor="#30485d",linewidth=0.16) {#XBIT4:7 (73,-91.75)};
// (73,-91.35) @TEXT("VDD",size=1.1,halign="middle",valign="bottom");
// &"VSS" @WIRE(mode="straight",linecolor="#30485d",linewidth=0.16) {#XBIT4:8 (73,-118.25)};
// (73,-118.65) @TEXT("VSS",size=1.1,halign="middle",valign="top");
// &"CODE3" @WIRE(mode="straight",linecolor="#30485d",linewidth=0.16) {#XBIT3:1 (89,-138.35)};
// (89.4,-138.35) @TEXT("CODE3",size=1.1,halign="start",valign="middle");
// &"D3" @WIRE(mode="straight",linecolor="#30485d",linewidth=0.16) {#XBIT3:2 (89,-141.65)};
// (89.4,-141.65) @TEXT("D3",size=1.1,halign="start",valign="middle");
// &"SAMPLE" @WIRE(mode="straight",linecolor="#30485d",linewidth=0.16) {#XBIT3:5 (57,-141.65)};
// (56.6,-141.65) @TEXT("SAMPLE",size=1.1,halign="end",valign="middle");
// &"T3" @WIRE(mode="straight",linecolor="#30485d",linewidth=0.16) {#XBIT3:6 (57,-144.95)};
// (56.6,-144.95) @TEXT("T3",size=1.1,halign="end",valign="middle");
// &"VDD" @WIRE(mode="straight",linecolor="#30485d",linewidth=0.16) {#XBIT3:7 (73,-126.75)};
// (73,-126.35) @TEXT("VDD",size=1.1,halign="middle",valign="bottom");
// &"VSS" @WIRE(mode="straight",linecolor="#30485d",linewidth=0.16) {#XBIT3:8 (73,-153.25)};
// (73,-153.65) @TEXT("VSS",size=1.1,halign="middle",valign="top");
// &"CODE2" @WIRE(mode="straight",linecolor="#30485d",linewidth=0.16) {#XBIT2:1 (89,-173.35)};
// (89.4,-173.35) @TEXT("CODE2",size=1.1,halign="start",valign="middle");
// &"D2" @WIRE(mode="straight",linecolor="#30485d",linewidth=0.16) {#XBIT2:2 (89,-176.65)};
// (89.4,-176.65) @TEXT("D2",size=1.1,halign="start",valign="middle");
// &"SAMPLE" @WIRE(mode="straight",linecolor="#30485d",linewidth=0.16) {#XBIT2:5 (57,-176.65)};
// (56.6,-176.65) @TEXT("SAMPLE",size=1.1,halign="end",valign="middle");
// &"T2" @WIRE(mode="straight",linecolor="#30485d",linewidth=0.16) {#XBIT2:6 (57,-179.95)};
// (56.6,-179.95) @TEXT("T2",size=1.1,halign="end",valign="middle");
// &"VDD" @WIRE(mode="straight",linecolor="#30485d",linewidth=0.16) {#XBIT2:7 (73,-161.75)};
// (73,-161.35) @TEXT("VDD",size=1.1,halign="middle",valign="bottom");
// &"VSS" @WIRE(mode="straight",linecolor="#30485d",linewidth=0.16) {#XBIT2:8 (73,-188.25)};
// (73,-188.65) @TEXT("VSS",size=1.1,halign="middle",valign="top");
// &"CODE1" @WIRE(mode="straight",linecolor="#30485d",linewidth=0.16) {#XBIT1:1 (89,-208.35)};
// (89.4,-208.35) @TEXT("CODE1",size=1.1,halign="start",valign="middle");
// &"D1" @WIRE(mode="straight",linecolor="#30485d",linewidth=0.16) {#XBIT1:2 (89,-211.65)};
// (89.4,-211.65) @TEXT("D1",size=1.1,halign="start",valign="middle");
// &"SAMPLE" @WIRE(mode="straight",linecolor="#30485d",linewidth=0.16) {#XBIT1:5 (57,-211.65)};
// (56.6,-211.65) @TEXT("SAMPLE",size=1.1,halign="end",valign="middle");
// &"T1" @WIRE(mode="straight",linecolor="#30485d",linewidth=0.16) {#XBIT1:6 (57,-214.95)};
// (56.6,-214.95) @TEXT("T1",size=1.1,halign="end",valign="middle");
// &"VDD" @WIRE(mode="straight",linecolor="#30485d",linewidth=0.16) {#XBIT1:7 (73,-196.75)};
// (73,-196.35) @TEXT("VDD",size=1.1,halign="middle",valign="bottom");
// &"VSS" @WIRE(mode="straight",linecolor="#30485d",linewidth=0.16) {#XBIT1:8 (73,-223.25)};
// (73,-223.65) @TEXT("VSS",size=1.1,halign="middle",valign="top");
// &"CODE0" @WIRE(mode="straight",linecolor="#30485d",linewidth=0.16) {#XBIT0:1 (89,-243.35)};
// (89.4,-243.35) @TEXT("CODE0",size=1.1,halign="start",valign="middle");
// &"D0" @WIRE(mode="straight",linecolor="#30485d",linewidth=0.16) {#XBIT0:2 (89,-246.65)};
// (89.4,-246.65) @TEXT("D0",size=1.1,halign="start",valign="middle");
// &"SAMPLE" @WIRE(mode="straight",linecolor="#30485d",linewidth=0.16) {#XBIT0:5 (57,-246.65)};
// (56.6,-246.65) @TEXT("SAMPLE",size=1.1,halign="end",valign="middle");
// &"T0" @WIRE(mode="straight",linecolor="#30485d",linewidth=0.16) {#XBIT0:6 (57,-249.95)};
// (56.6,-249.95) @TEXT("T0",size=1.1,halign="end",valign="middle");
// &"VDD" @WIRE(mode="straight",linecolor="#30485d",linewidth=0.16) {#XBIT0:7 (73,-231.75)};
// (73,-231.35) @TEXT("VDD",size=1.1,halign="middle",valign="bottom");
// &"VSS" @WIRE(mode="straight",linecolor="#30485d",linewidth=0.16) {#XBIT0:8 (73,-258.25)};
// (73,-258.65) @TEXT("VSS",size=1.1,halign="middle",valign="top");
// &"VDD" @WIRE(mode="straight",linecolor="#30485d",linewidth=0.16) {#X018:3 (225,-95)};
// (225,-94.6) @TEXT("VDD",size=1.1,halign="middle",valign="bottom");
// &"VSS" @WIRE(mode="straight",linecolor="#30485d",linewidth=0.16) {#X018:4 (225,-115)};
// (225,-115.4) @TEXT("VSS",size=1.1,halign="middle",valign="top");
// &"VDD" @WIRE(mode="straight",linecolor="#30485d",linewidth=0.16) {#X017:3 (184,-165)};
// (184,-164.6) @TEXT("VDD",size=1.1,halign="middle",valign="bottom");
// &"VSS" @WIRE(mode="straight",linecolor="#30485d",linewidth=0.16) {#X017:4 (184,-185)};
// (184,-185.4) @TEXT("VSS",size=1.1,halign="middle",valign="top");
// &"VDD" @WIRE(mode="straight",linecolor="#30485d",linewidth=0.16) {#X016:3 (184,-25)};
// (184,-24.6) @TEXT("VDD",size=1.1,halign="middle",valign="bottom");
// &"VSS" @WIRE(mode="straight",linecolor="#30485d",linewidth=0.16) {#X016:4 (184,-45)};
// (184,-45.4) @TEXT("VSS",size=1.1,halign="middle",valign="top");
// &"T6" @WIRE(mode="straight",linecolor="#30485d",linewidth=0.16) {#X015:1 (132,-208.3)};
// (131.6,-208.3) @TEXT("T6",size=1.1,halign="end",valign="middle");
// &"T7" @WIRE(mode="straight",linecolor="#30485d",linewidth=0.16) {#X015:2 (132,-211.7)};
// (131.6,-211.7) @TEXT("T7",size=1.1,halign="end",valign="middle");
// &"VDD" @WIRE(mode="straight",linecolor="#30485d",linewidth=0.16) {#X015:3 (142,-200)};
// (142,-199.6) @TEXT("VDD",size=1.1,halign="middle",valign="bottom");
// &"VSS" @WIRE(mode="straight",linecolor="#30485d",linewidth=0.16) {#X015:4 (142,-220)};
// (142,-220.4) @TEXT("VSS",size=1.1,halign="middle",valign="top");
// &"T4" @WIRE(mode="straight",linecolor="#30485d",linewidth=0.16) {#X014:1 (132,-138.3)};
// (131.6,-138.3) @TEXT("T4",size=1.1,halign="end",valign="middle");
// &"T5" @WIRE(mode="straight",linecolor="#30485d",linewidth=0.16) {#X014:2 (132,-141.7)};
// (131.6,-141.7) @TEXT("T5",size=1.1,halign="end",valign="middle");
// &"VDD" @WIRE(mode="straight",linecolor="#30485d",linewidth=0.16) {#X014:3 (142,-130)};
// (142,-129.6) @TEXT("VDD",size=1.1,halign="middle",valign="bottom");
// &"VSS" @WIRE(mode="straight",linecolor="#30485d",linewidth=0.16) {#X014:4 (142,-150)};
// (142,-150.4) @TEXT("VSS",size=1.1,halign="middle",valign="top");
// &"T2" @WIRE(mode="straight",linecolor="#30485d",linewidth=0.16) {#X013:1 (132,-68.3)};
// (131.6,-68.3) @TEXT("T2",size=1.1,halign="end",valign="middle");
// &"T3" @WIRE(mode="straight",linecolor="#30485d",linewidth=0.16) {#X013:2 (132,-71.7)};
// (131.6,-71.7) @TEXT("T3",size=1.1,halign="end",valign="middle");
// &"VDD" @WIRE(mode="straight",linecolor="#30485d",linewidth=0.16) {#X013:3 (142,-60)};
// (142,-59.6) @TEXT("VDD",size=1.1,halign="middle",valign="bottom");
// &"VSS" @WIRE(mode="straight",linecolor="#30485d",linewidth=0.16) {#X013:4 (142,-80)};
// (142,-80.4) @TEXT("VSS",size=1.1,halign="middle",valign="top");
// &"T0" @WIRE(mode="straight",linecolor="#30485d",linewidth=0.16) {#X012:1 (132,1.7)};
// (131.6,1.7) @TEXT("T0",size=1.1,halign="end",valign="middle");
// &"T1" @WIRE(mode="straight",linecolor="#30485d",linewidth=0.16) {#X012:2 (132,-1.7)};
// (131.6,-1.7) @TEXT("T1",size=1.1,halign="end",valign="middle");
// &"VDD" @WIRE(mode="straight",linecolor="#30485d",linewidth=0.16) {#X012:3 (142,10)};
// (142,10.4) @TEXT("VDD",size=1.1,halign="middle",valign="bottom");
// &"VSS" @WIRE(mode="straight",linecolor="#30485d",linewidth=0.16) {#X012:4 (142,-10)};
// (142,-10.4) @TEXT("VSS",size=1.1,halign="middle",valign="top");
// }
// END SARADC RNL
ends sar_logic_8b_physical

subckt sar8i_ctrl CMP_CLK CODE0 CODE1 CODE2 CODE3 CODE4 CODE5  CODE6 CODE7 COMP_N COMP_P D0 D1 D2 D3 D4 D5 D6 D7 PHI_U SAMPLE VDD  VSS ACTIVE
    XTIM (ACTIVE CMP_CLK COMP_N COMP_P DATA PHI_U PHI_W SAMPLE VDD VSS)  sar8p_timing
    XSEQ (PHI_U SAMPLE T0 T1 T2 T3 T4 T5 T6 T7 VDD VSS) sar8p_bitseq8
    XBIT7 (CODE7 D7 DATA PHI_W SAMPLE T7 VDD VSS) sar8p_bit
    XBIT6 (CODE6 D6 DATA PHI_W SAMPLE T6 VDD VSS) sar8p_bit
    XBIT5 (CODE5 D5 DATA PHI_W SAMPLE T5 VDD VSS) sar8p_bit
    XBIT4 (CODE4 D4 DATA PHI_W SAMPLE T4 VDD VSS) sar8p_bit
    XBIT3 (CODE3 D3 DATA PHI_W SAMPLE T3 VDD VSS) sar8p_bit
    XBIT2 (CODE2 D2 DATA PHI_W SAMPLE T2 VDD VSS) sar8p_bit
    XBIT1 (CODE1 D1 DATA PHI_W SAMPLE T1 VDD VSS) sar8p_bit
    XBIT0 (CODE0 D0 DATA PHI_W SAMPLE T0 VDD VSS) sar8p_bit
    X018 (A01 A23 VDD VSS ACTIVE) sar8p_or2
    X017 (A2 A3 VDD VSS A23) sar8p_or2
    X016 (A0 A1 VDD VSS A01) sar8p_or2
    X015 (T6 T7 VDD VSS A3) sar8p_or2
    X014 (T4 T5 VDD VSS A2) sar8p_or2
    X013 (T2 T3 VDD VSS A1) sar8p_or2
    X012 (T0 T1 VDD VSS A0) sar8p_or2
// BEGIN SARADC RNL
// @RNL(author="saradc topology") {
// (-23,82) @TEXT("8-bit SAR / one token, eight bit stores, asynchronous handshake",size=1.5,halign="start",textcolor="#223d52");
// #XTIM @SET-SYMBOL $S_sar8p_timing;
// #XTIM @PLACE(0,39) => @ORIENT("R0");
// #XSEQ @SET-SYMBOL $S_sar8p_bitseq8;
// #XSEQ @PLACE(0,-17) => @ORIENT("R0");
// #XBIT7 @SET-SYMBOL $S_sar8p_bit;
// #XBIT7 @PLACE(73,0) => @ORIENT("R0");
// #XBIT6 @SET-SYMBOL $S_sar8p_bit;
// #XBIT6 @PLACE(73,-35) => @ORIENT("R0");
// #XBIT5 @SET-SYMBOL $S_sar8p_bit;
// #XBIT5 @PLACE(73,-70) => @ORIENT("R0");
// #XBIT4 @SET-SYMBOL $S_sar8p_bit;
// #XBIT4 @PLACE(73,-105) => @ORIENT("R0");
// #XBIT3 @SET-SYMBOL $S_sar8p_bit;
// #XBIT3 @PLACE(73,-140) => @ORIENT("R0");
// #XBIT2 @SET-SYMBOL $S_sar8p_bit;
// #XBIT2 @PLACE(73,-175) => @ORIENT("R0");
// #XBIT1 @SET-SYMBOL $S_sar8p_bit;
// #XBIT1 @PLACE(73,-210) => @ORIENT("R0");
// #XBIT0 @SET-SYMBOL $S_sar8p_bit;
// #XBIT0 @PLACE(73,-245) => @ORIENT("R0");
// #X012 @SET-SYMBOL $S_sar8p_or2;
// #X012 @PLACE(142,0) => @ORIENT("R0");
// #X013 @SET-SYMBOL $S_sar8p_or2;
// #X013 @PLACE(142,-70) => @ORIENT("R0");
// #X014 @SET-SYMBOL $S_sar8p_or2;
// #X014 @PLACE(142,-140) => @ORIENT("R0");
// #X015 @SET-SYMBOL $S_sar8p_or2;
// #X015 @PLACE(142,-210) => @ORIENT("R0");
// #X016 @SET-SYMBOL $S_sar8p_or2;
// #X016 @PLACE(184,-35) => @ORIENT("R0");
// #X017 @SET-SYMBOL $S_sar8p_or2;
// #X017 @PLACE(184,-175) => @ORIENT("R0");
// #X018 @SET-SYMBOL $S_sar8p_or2;
// #X018 @PLACE(225,-105) => @ORIENT("R0");
// &"A0" @WIRE(mode="straight",linecolor="#30485d",linewidth=0.16) {(163,-33.3) (163,0)};
// &"A0" @WIRE(mode="straight",linecolor="#30485d",linewidth=0.16) {#X016:1 (163,-33.3)};
// $JUNCTION @ATTACH (163,-33.3);
// &"A0" @WIRE(mode="straight",linecolor="#30485d",linewidth=0.16) {#X012:5 (163,0)};
// $JUNCTION @ATTACH (163,0);
// &"A1" @WIRE(mode="straight",linecolor="#30485d",linewidth=0.16) {(163,-70) (163,-36.7)};
// &"A1" @WIRE(mode="straight",linecolor="#30485d",linewidth=0.16) {#X016:2 (163,-36.7)};
// $JUNCTION @ATTACH (163,-36.7);
// &"A1" @WIRE(mode="straight",linecolor="#30485d",linewidth=0.16) {#X013:5 (163,-70)};
// $JUNCTION @ATTACH (163,-70);
// &"A2" @WIRE(mode="straight",linecolor="#30485d",linewidth=0.16) {(163,-173.3) (163,-140)};
// &"A2" @WIRE(mode="straight",linecolor="#30485d",linewidth=0.16) {#X017:1 (163,-173.3)};
// $JUNCTION @ATTACH (163,-173.3);
// &"A2" @WIRE(mode="straight",linecolor="#30485d",linewidth=0.16) {#X014:5 (163,-140)};
// $JUNCTION @ATTACH (163,-140);
// &"A3" @WIRE(mode="straight",linecolor="#30485d",linewidth=0.16) {(163,-210) (163,-176.7)};
// &"A3" @WIRE(mode="straight",linecolor="#30485d",linewidth=0.16) {#X017:2 (163,-176.7)};
// $JUNCTION @ATTACH (163,-176.7);
// &"A3" @WIRE(mode="straight",linecolor="#30485d",linewidth=0.16) {#X015:5 (163,-210)};
// $JUNCTION @ATTACH (163,-210);
// &"A01" @WIRE(mode="straight",linecolor="#30485d",linewidth=0.16) {(204.5,-103.3) (204.5,-35)};
// &"A01" @WIRE(mode="straight",linecolor="#30485d",linewidth=0.16) {#X018:1 (204.5,-103.3)};
// $JUNCTION @ATTACH (204.5,-103.3);
// &"A01" @WIRE(mode="straight",linecolor="#30485d",linewidth=0.16) {#X016:5 (204.5,-35)};
// $JUNCTION @ATTACH (204.5,-35);
// &"A23" @WIRE(mode="straight",linecolor="#30485d",linewidth=0.16) {(204.5,-175) (204.5,-106.7)};
// &"A23" @WIRE(mode="straight",linecolor="#30485d",linewidth=0.16) {#X018:2 (204.5,-106.7)};
// $JUNCTION @ATTACH (204.5,-106.7);
// &"A23" @WIRE(mode="straight",linecolor="#30485d",linewidth=0.16) {#X017:5 (204.5,-175)};
// $JUNCTION @ATTACH (204.5,-175);
// &"ACTIVE" @WIRE(mode="straight",linecolor="#30485d",linewidth=0.16) {(109.5,-105) (109.5,43.95)};
// &"ACTIVE" @WIRE(mode="straight",linecolor="#30485d",linewidth=0.16) {#XTIM:1 (109.5,43.95)};
// $JUNCTION @ATTACH (109.5,43.95);
// &"ACTIVE" @WIRE(mode="straight",linecolor="#30485d",linewidth=0.16) {#X018:5 (109.5,-105)};
// $JUNCTION @ATTACH (109.5,-105);
// &"DATA" @WIRE(mode="straight",linecolor="#30485d",linewidth=0.16) {(33,-240.05) (33,-205.05) (33,-170.05) (33,-135.05) (33,-100.05) (33,-65.05) (33,-30.05) (33,4.95) (33,40.65)};
// &"DATA" @WIRE(mode="straight",linecolor="#30485d",linewidth=0.16) {#XTIM:5 (33,40.65)};
// $JUNCTION @ATTACH (33,40.65);
// &"DATA" @WIRE(mode="straight",linecolor="#30485d",linewidth=0.16) {#XBIT7:3 (33,4.95)};
// $JUNCTION @ATTACH (33,4.95);
// &"DATA" @WIRE(mode="straight",linecolor="#30485d",linewidth=0.16) {#XBIT6:3 (33,-30.05)};
// $JUNCTION @ATTACH (33,-30.05);
// &"DATA" @WIRE(mode="straight",linecolor="#30485d",linewidth=0.16) {#XBIT5:3 (33,-65.05)};
// $JUNCTION @ATTACH (33,-65.05);
// &"DATA" @WIRE(mode="straight",linecolor="#30485d",linewidth=0.16) {#XBIT4:3 (33,-100.05)};
// $JUNCTION @ATTACH (33,-100.05);
// &"DATA" @WIRE(mode="straight",linecolor="#30485d",linewidth=0.16) {#XBIT3:3 (33,-135.05)};
// $JUNCTION @ATTACH (33,-135.05);
// &"DATA" @WIRE(mode="straight",linecolor="#30485d",linewidth=0.16) {#XBIT2:3 (33,-170.05)};
// $JUNCTION @ATTACH (33,-170.05);
// &"DATA" @WIRE(mode="straight",linecolor="#30485d",linewidth=0.16) {#XBIT1:3 (33,-205.05)};
// $JUNCTION @ATTACH (33,-205.05);
// &"DATA" @WIRE(mode="straight",linecolor="#30485d",linewidth=0.16) {#XBIT0:3 (33,-240.05)};
// $JUNCTION @ATTACH (33,-240.05);
// &"PHI_W" @WIRE(mode="straight",linecolor="#94601a",linewidth=0.16) {(38,-243.35) (38,-208.35) (38,-173.35) (38,-138.35) (38,-103.35) (38,-68.35) (38,-33.35) (38,1.65) (38,34.05)};
// &"PHI_W" @WIRE(mode="straight",linecolor="#94601a",linewidth=0.16) {#XTIM:7 (38,34.05)};
// $JUNCTION @ATTACH (38,34.05);
// &"PHI_W" @WIRE(mode="straight",linecolor="#94601a",linewidth=0.16) {#XBIT7:4 (38,1.65)};
// $JUNCTION @ATTACH (38,1.65);
// &"PHI_W" @WIRE(mode="straight",linecolor="#94601a",linewidth=0.16) {#XBIT6:4 (38,-33.35)};
// $JUNCTION @ATTACH (38,-33.35);
// &"PHI_W" @WIRE(mode="straight",linecolor="#94601a",linewidth=0.16) {#XBIT5:4 (38,-68.35)};
// $JUNCTION @ATTACH (38,-68.35);
// &"PHI_W" @WIRE(mode="straight",linecolor="#94601a",linewidth=0.16) {#XBIT4:4 (38,-103.35)};
// $JUNCTION @ATTACH (38,-103.35);
// &"PHI_W" @WIRE(mode="straight",linecolor="#94601a",linewidth=0.16) {#XBIT3:4 (38,-138.35)};
// $JUNCTION @ATTACH (38,-138.35);
// &"PHI_W" @WIRE(mode="straight",linecolor="#94601a",linewidth=0.16) {#XBIT2:4 (38,-173.35)};
// $JUNCTION @ATTACH (38,-173.35);
// &"PHI_W" @WIRE(mode="straight",linecolor="#94601a",linewidth=0.16) {#XBIT1:4 (38,-208.35)};
// $JUNCTION @ATTACH (38,-208.35);
// &"PHI_W" @WIRE(mode="straight",linecolor="#94601a",linewidth=0.16) {#XBIT0:4 (38,-243.35)};
// $JUNCTION @ATTACH (38,-243.35);
// (121,-246) @TEXT("OR reduction -> ACTIVE",size=1.15,halign="start",textcolor="#223d52");
// (-23,-274) @TEXT("T[7:0] selects one bit; CODE is the trial word and D the stored output. SAMPLE resets the controller.",size=0.95,halign="start",textcolor="#223d52");
// &"CMP_CLK" @WIRE(mode="straight",linecolor="#30485d",linewidth=0.16) {#XTIM:2 (16,43.95)};
// (16.4,43.95) @TEXT("CMP_CLK",size=1.1,halign="start",valign="middle");
// &"COMP_N" @WIRE(mode="straight",linecolor="#30485d",linewidth=0.16) {#XTIM:3 (-16,40.65)};
// (-16.4,40.65) @TEXT("COMP_N",size=1.1,halign="end",valign="middle");
// &"COMP_P" @WIRE(mode="straight",linecolor="#30485d",linewidth=0.16) {#XTIM:4 (-16,37.35)};
// (-16.4,37.35) @TEXT("COMP_P",size=1.1,halign="end",valign="middle");
// &"PHI_U" @WIRE(mode="straight",linecolor="#30485d",linewidth=0.16) {#XTIM:6 (16,37.35)};
// (16.4,37.35) @TEXT("PHI_U",size=1.1,halign="start",valign="middle");
// &"SAMPLE" @WIRE(mode="straight",linecolor="#30485d",linewidth=0.16) {#XTIM:8 (-16,34.05)};
// (-16.4,34.05) @TEXT("SAMPLE",size=1.1,halign="end",valign="middle");
// &"VDD" @WIRE(mode="straight",linecolor="#30485d",linewidth=0.16) {#XTIM:9 (0,52.25)};
// (0,52.65) @TEXT("VDD",size=1.1,halign="middle",valign="bottom");
// &"VSS" @WIRE(mode="straight",linecolor="#30485d",linewidth=0.16) {#XTIM:10 (0,25.75)};
// (0,25.35) @TEXT("VSS",size=1.1,halign="middle",valign="top");
// &"PHI_U" @WIRE(mode="straight",linecolor="#30485d",linewidth=0.16) {#XSEQ:1 (-16,-15.35)};
// (-16.4,-15.35) @TEXT("PHI_U",size=1.1,halign="end",valign="middle");
// &"SAMPLE" @WIRE(mode="straight",linecolor="#30485d",linewidth=0.16) {#XSEQ:2 (-16,-18.65)};
// (-16.4,-18.65) @TEXT("SAMPLE",size=1.1,halign="end",valign="middle");
// {&"T0" &"T1" &"T2" &"T3" &"T4" &"T5" &"T6" &"T7"} @WIRE(mode="straight",linewidth=0.3) {#XSEQ:3 (16,-17)};
// (16.4,-17) @TEXT("T[7:0]",size=1.1,halign="start",valign="middle");
// &"VDD" @WIRE(mode="straight",linecolor="#30485d",linewidth=0.16) {#XSEQ:11 (0,-6)};
// (0,-5.6) @TEXT("VDD",size=1.1,halign="middle",valign="bottom");
// &"VSS" @WIRE(mode="straight",linecolor="#30485d",linewidth=0.16) {#XSEQ:12 (0,-28)};
// (0,-28.4) @TEXT("VSS",size=1.1,halign="middle",valign="top");
// &"CODE7" @WIRE(mode="straight",linecolor="#30485d",linewidth=0.16) {#XBIT7:1 (89,1.65)};
// (89.4,1.65) @TEXT("CODE7",size=1.1,halign="start",valign="middle");
// &"D7" @WIRE(mode="straight",linecolor="#30485d",linewidth=0.16) {#XBIT7:2 (89,-1.65)};
// (89.4,-1.65) @TEXT("D7",size=1.1,halign="start",valign="middle");
// &"SAMPLE" @WIRE(mode="straight",linecolor="#30485d",linewidth=0.16) {#XBIT7:5 (57,-1.65)};
// (56.6,-1.65) @TEXT("SAMPLE",size=1.1,halign="end",valign="middle");
// &"T7" @WIRE(mode="straight",linecolor="#30485d",linewidth=0.16) {#XBIT7:6 (57,-4.95)};
// (56.6,-4.95) @TEXT("T7",size=1.1,halign="end",valign="middle");
// &"VDD" @WIRE(mode="straight",linecolor="#30485d",linewidth=0.16) {#XBIT7:7 (73,13.25)};
// (73,13.65) @TEXT("VDD",size=1.1,halign="middle",valign="bottom");
// &"VSS" @WIRE(mode="straight",linecolor="#30485d",linewidth=0.16) {#XBIT7:8 (73,-13.25)};
// (73,-13.65) @TEXT("VSS",size=1.1,halign="middle",valign="top");
// &"CODE6" @WIRE(mode="straight",linecolor="#30485d",linewidth=0.16) {#XBIT6:1 (89,-33.35)};
// (89.4,-33.35) @TEXT("CODE6",size=1.1,halign="start",valign="middle");
// &"D6" @WIRE(mode="straight",linecolor="#30485d",linewidth=0.16) {#XBIT6:2 (89,-36.65)};
// (89.4,-36.65) @TEXT("D6",size=1.1,halign="start",valign="middle");
// &"SAMPLE" @WIRE(mode="straight",linecolor="#30485d",linewidth=0.16) {#XBIT6:5 (57,-36.65)};
// (56.6,-36.65) @TEXT("SAMPLE",size=1.1,halign="end",valign="middle");
// &"T6" @WIRE(mode="straight",linecolor="#30485d",linewidth=0.16) {#XBIT6:6 (57,-39.95)};
// (56.6,-39.95) @TEXT("T6",size=1.1,halign="end",valign="middle");
// &"VDD" @WIRE(mode="straight",linecolor="#30485d",linewidth=0.16) {#XBIT6:7 (73,-21.75)};
// (73,-21.35) @TEXT("VDD",size=1.1,halign="middle",valign="bottom");
// &"VSS" @WIRE(mode="straight",linecolor="#30485d",linewidth=0.16) {#XBIT6:8 (73,-48.25)};
// (73,-48.65) @TEXT("VSS",size=1.1,halign="middle",valign="top");
// &"CODE5" @WIRE(mode="straight",linecolor="#30485d",linewidth=0.16) {#XBIT5:1 (89,-68.35)};
// (89.4,-68.35) @TEXT("CODE5",size=1.1,halign="start",valign="middle");
// &"D5" @WIRE(mode="straight",linecolor="#30485d",linewidth=0.16) {#XBIT5:2 (89,-71.65)};
// (89.4,-71.65) @TEXT("D5",size=1.1,halign="start",valign="middle");
// &"SAMPLE" @WIRE(mode="straight",linecolor="#30485d",linewidth=0.16) {#XBIT5:5 (57,-71.65)};
// (56.6,-71.65) @TEXT("SAMPLE",size=1.1,halign="end",valign="middle");
// &"T5" @WIRE(mode="straight",linecolor="#30485d",linewidth=0.16) {#XBIT5:6 (57,-74.95)};
// (56.6,-74.95) @TEXT("T5",size=1.1,halign="end",valign="middle");
// &"VDD" @WIRE(mode="straight",linecolor="#30485d",linewidth=0.16) {#XBIT5:7 (73,-56.75)};
// (73,-56.35) @TEXT("VDD",size=1.1,halign="middle",valign="bottom");
// &"VSS" @WIRE(mode="straight",linecolor="#30485d",linewidth=0.16) {#XBIT5:8 (73,-83.25)};
// (73,-83.65) @TEXT("VSS",size=1.1,halign="middle",valign="top");
// &"CODE4" @WIRE(mode="straight",linecolor="#30485d",linewidth=0.16) {#XBIT4:1 (89,-103.35)};
// (89.4,-103.35) @TEXT("CODE4",size=1.1,halign="start",valign="middle");
// &"D4" @WIRE(mode="straight",linecolor="#30485d",linewidth=0.16) {#XBIT4:2 (89,-106.65)};
// (89.4,-106.65) @TEXT("D4",size=1.1,halign="start",valign="middle");
// &"SAMPLE" @WIRE(mode="straight",linecolor="#30485d",linewidth=0.16) {#XBIT4:5 (57,-106.65)};
// (56.6,-106.65) @TEXT("SAMPLE",size=1.1,halign="end",valign="middle");
// &"T4" @WIRE(mode="straight",linecolor="#30485d",linewidth=0.16) {#XBIT4:6 (57,-109.95)};
// (56.6,-109.95) @TEXT("T4",size=1.1,halign="end",valign="middle");
// &"VDD" @WIRE(mode="straight",linecolor="#30485d",linewidth=0.16) {#XBIT4:7 (73,-91.75)};
// (73,-91.35) @TEXT("VDD",size=1.1,halign="middle",valign="bottom");
// &"VSS" @WIRE(mode="straight",linecolor="#30485d",linewidth=0.16) {#XBIT4:8 (73,-118.25)};
// (73,-118.65) @TEXT("VSS",size=1.1,halign="middle",valign="top");
// &"CODE3" @WIRE(mode="straight",linecolor="#30485d",linewidth=0.16) {#XBIT3:1 (89,-138.35)};
// (89.4,-138.35) @TEXT("CODE3",size=1.1,halign="start",valign="middle");
// &"D3" @WIRE(mode="straight",linecolor="#30485d",linewidth=0.16) {#XBIT3:2 (89,-141.65)};
// (89.4,-141.65) @TEXT("D3",size=1.1,halign="start",valign="middle");
// &"SAMPLE" @WIRE(mode="straight",linecolor="#30485d",linewidth=0.16) {#XBIT3:5 (57,-141.65)};
// (56.6,-141.65) @TEXT("SAMPLE",size=1.1,halign="end",valign="middle");
// &"T3" @WIRE(mode="straight",linecolor="#30485d",linewidth=0.16) {#XBIT3:6 (57,-144.95)};
// (56.6,-144.95) @TEXT("T3",size=1.1,halign="end",valign="middle");
// &"VDD" @WIRE(mode="straight",linecolor="#30485d",linewidth=0.16) {#XBIT3:7 (73,-126.75)};
// (73,-126.35) @TEXT("VDD",size=1.1,halign="middle",valign="bottom");
// &"VSS" @WIRE(mode="straight",linecolor="#30485d",linewidth=0.16) {#XBIT3:8 (73,-153.25)};
// (73,-153.65) @TEXT("VSS",size=1.1,halign="middle",valign="top");
// &"CODE2" @WIRE(mode="straight",linecolor="#30485d",linewidth=0.16) {#XBIT2:1 (89,-173.35)};
// (89.4,-173.35) @TEXT("CODE2",size=1.1,halign="start",valign="middle");
// &"D2" @WIRE(mode="straight",linecolor="#30485d",linewidth=0.16) {#XBIT2:2 (89,-176.65)};
// (89.4,-176.65) @TEXT("D2",size=1.1,halign="start",valign="middle");
// &"SAMPLE" @WIRE(mode="straight",linecolor="#30485d",linewidth=0.16) {#XBIT2:5 (57,-176.65)};
// (56.6,-176.65) @TEXT("SAMPLE",size=1.1,halign="end",valign="middle");
// &"T2" @WIRE(mode="straight",linecolor="#30485d",linewidth=0.16) {#XBIT2:6 (57,-179.95)};
// (56.6,-179.95) @TEXT("T2",size=1.1,halign="end",valign="middle");
// &"VDD" @WIRE(mode="straight",linecolor="#30485d",linewidth=0.16) {#XBIT2:7 (73,-161.75)};
// (73,-161.35) @TEXT("VDD",size=1.1,halign="middle",valign="bottom");
// &"VSS" @WIRE(mode="straight",linecolor="#30485d",linewidth=0.16) {#XBIT2:8 (73,-188.25)};
// (73,-188.65) @TEXT("VSS",size=1.1,halign="middle",valign="top");
// &"CODE1" @WIRE(mode="straight",linecolor="#30485d",linewidth=0.16) {#XBIT1:1 (89,-208.35)};
// (89.4,-208.35) @TEXT("CODE1",size=1.1,halign="start",valign="middle");
// &"D1" @WIRE(mode="straight",linecolor="#30485d",linewidth=0.16) {#XBIT1:2 (89,-211.65)};
// (89.4,-211.65) @TEXT("D1",size=1.1,halign="start",valign="middle");
// &"SAMPLE" @WIRE(mode="straight",linecolor="#30485d",linewidth=0.16) {#XBIT1:5 (57,-211.65)};
// (56.6,-211.65) @TEXT("SAMPLE",size=1.1,halign="end",valign="middle");
// &"T1" @WIRE(mode="straight",linecolor="#30485d",linewidth=0.16) {#XBIT1:6 (57,-214.95)};
// (56.6,-214.95) @TEXT("T1",size=1.1,halign="end",valign="middle");
// &"VDD" @WIRE(mode="straight",linecolor="#30485d",linewidth=0.16) {#XBIT1:7 (73,-196.75)};
// (73,-196.35) @TEXT("VDD",size=1.1,halign="middle",valign="bottom");
// &"VSS" @WIRE(mode="straight",linecolor="#30485d",linewidth=0.16) {#XBIT1:8 (73,-223.25)};
// (73,-223.65) @TEXT("VSS",size=1.1,halign="middle",valign="top");
// &"CODE0" @WIRE(mode="straight",linecolor="#30485d",linewidth=0.16) {#XBIT0:1 (89,-243.35)};
// (89.4,-243.35) @TEXT("CODE0",size=1.1,halign="start",valign="middle");
// &"D0" @WIRE(mode="straight",linecolor="#30485d",linewidth=0.16) {#XBIT0:2 (89,-246.65)};
// (89.4,-246.65) @TEXT("D0",size=1.1,halign="start",valign="middle");
// &"SAMPLE" @WIRE(mode="straight",linecolor="#30485d",linewidth=0.16) {#XBIT0:5 (57,-246.65)};
// (56.6,-246.65) @TEXT("SAMPLE",size=1.1,halign="end",valign="middle");
// &"T0" @WIRE(mode="straight",linecolor="#30485d",linewidth=0.16) {#XBIT0:6 (57,-249.95)};
// (56.6,-249.95) @TEXT("T0",size=1.1,halign="end",valign="middle");
// &"VDD" @WIRE(mode="straight",linecolor="#30485d",linewidth=0.16) {#XBIT0:7 (73,-231.75)};
// (73,-231.35) @TEXT("VDD",size=1.1,halign="middle",valign="bottom");
// &"VSS" @WIRE(mode="straight",linecolor="#30485d",linewidth=0.16) {#XBIT0:8 (73,-258.25)};
// (73,-258.65) @TEXT("VSS",size=1.1,halign="middle",valign="top");
// &"VDD" @WIRE(mode="straight",linecolor="#30485d",linewidth=0.16) {#X018:3 (225,-95)};
// (225,-94.6) @TEXT("VDD",size=1.1,halign="middle",valign="bottom");
// &"VSS" @WIRE(mode="straight",linecolor="#30485d",linewidth=0.16) {#X018:4 (225,-115)};
// (225,-115.4) @TEXT("VSS",size=1.1,halign="middle",valign="top");
// &"VDD" @WIRE(mode="straight",linecolor="#30485d",linewidth=0.16) {#X017:3 (184,-165)};
// (184,-164.6) @TEXT("VDD",size=1.1,halign="middle",valign="bottom");
// &"VSS" @WIRE(mode="straight",linecolor="#30485d",linewidth=0.16) {#X017:4 (184,-185)};
// (184,-185.4) @TEXT("VSS",size=1.1,halign="middle",valign="top");
// &"VDD" @WIRE(mode="straight",linecolor="#30485d",linewidth=0.16) {#X016:3 (184,-25)};
// (184,-24.6) @TEXT("VDD",size=1.1,halign="middle",valign="bottom");
// &"VSS" @WIRE(mode="straight",linecolor="#30485d",linewidth=0.16) {#X016:4 (184,-45)};
// (184,-45.4) @TEXT("VSS",size=1.1,halign="middle",valign="top");
// &"T6" @WIRE(mode="straight",linecolor="#30485d",linewidth=0.16) {#X015:1 (132,-208.3)};
// (131.6,-208.3) @TEXT("T6",size=1.1,halign="end",valign="middle");
// &"T7" @WIRE(mode="straight",linecolor="#30485d",linewidth=0.16) {#X015:2 (132,-211.7)};
// (131.6,-211.7) @TEXT("T7",size=1.1,halign="end",valign="middle");
// &"VDD" @WIRE(mode="straight",linecolor="#30485d",linewidth=0.16) {#X015:3 (142,-200)};
// (142,-199.6) @TEXT("VDD",size=1.1,halign="middle",valign="bottom");
// &"VSS" @WIRE(mode="straight",linecolor="#30485d",linewidth=0.16) {#X015:4 (142,-220)};
// (142,-220.4) @TEXT("VSS",size=1.1,halign="middle",valign="top");
// &"T4" @WIRE(mode="straight",linecolor="#30485d",linewidth=0.16) {#X014:1 (132,-138.3)};
// (131.6,-138.3) @TEXT("T4",size=1.1,halign="end",valign="middle");
// &"T5" @WIRE(mode="straight",linecolor="#30485d",linewidth=0.16) {#X014:2 (132,-141.7)};
// (131.6,-141.7) @TEXT("T5",size=1.1,halign="end",valign="middle");
// &"VDD" @WIRE(mode="straight",linecolor="#30485d",linewidth=0.16) {#X014:3 (142,-130)};
// (142,-129.6) @TEXT("VDD",size=1.1,halign="middle",valign="bottom");
// &"VSS" @WIRE(mode="straight",linecolor="#30485d",linewidth=0.16) {#X014:4 (142,-150)};
// (142,-150.4) @TEXT("VSS",size=1.1,halign="middle",valign="top");
// &"T2" @WIRE(mode="straight",linecolor="#30485d",linewidth=0.16) {#X013:1 (132,-68.3)};
// (131.6,-68.3) @TEXT("T2",size=1.1,halign="end",valign="middle");
// &"T3" @WIRE(mode="straight",linecolor="#30485d",linewidth=0.16) {#X013:2 (132,-71.7)};
// (131.6,-71.7) @TEXT("T3",size=1.1,halign="end",valign="middle");
// &"VDD" @WIRE(mode="straight",linecolor="#30485d",linewidth=0.16) {#X013:3 (142,-60)};
// (142,-59.6) @TEXT("VDD",size=1.1,halign="middle",valign="bottom");
// &"VSS" @WIRE(mode="straight",linecolor="#30485d",linewidth=0.16) {#X013:4 (142,-80)};
// (142,-80.4) @TEXT("VSS",size=1.1,halign="middle",valign="top");
// &"T0" @WIRE(mode="straight",linecolor="#30485d",linewidth=0.16) {#X012:1 (132,1.7)};
// (131.6,1.7) @TEXT("T0",size=1.1,halign="end",valign="middle");
// &"T1" @WIRE(mode="straight",linecolor="#30485d",linewidth=0.16) {#X012:2 (132,-1.7)};
// (131.6,-1.7) @TEXT("T1",size=1.1,halign="end",valign="middle");
// &"VDD" @WIRE(mode="straight",linecolor="#30485d",linewidth=0.16) {#X012:3 (142,10)};
// (142,10.4) @TEXT("VDD",size=1.1,halign="middle",valign="bottom");
// &"VSS" @WIRE(mode="straight",linecolor="#30485d",linewidth=0.16) {#X012:4 (142,-10)};
// (142,-10.4) @TEXT("VSS",size=1.1,halign="middle",valign="top");
// }
// END SARADC RNL
ends sar8i_ctrl
