// Standard-cell delay paths with input-qualified clear taps.

subckt sar8p_delay_valid A VDD VSS Y
XD1 (A D1 VDD VSS) DEL200D1BWP12T30P140
XQUAL1 (A D1 VDD VSS Y) sar8p_and2
ends sar8p_delay_valid

subckt sar8p_delay_write A VDD VSS Y
XD1 (A D1 VDD VSS) DEL250D1BWP12T30P140
XD2 (D1 D2 VDD VSS) DEL250D1BWP12T30P140
XQUAL2 (A D2 VDD VSS Q2) sar8p_and2
XD3 (Q2 D3 VDD VSS) DEL075D1BWP12T30P140
XQUAL3 (A D3 VDD VSS Y) sar8p_and2
ends sar8p_delay_write

subckt sar8p_delay_quiet A VDD VSS Y
XD1 (A D1 VDD VSS) DEL250D1BWP12T30P140
XD2 (D1 D2 VDD VSS) DEL250D1BWP12T30P140
XQUAL2 (A D2 VDD VSS Q2) sar8p_and2
XD3 (Q2 D3 VDD VSS) DEL250D1BWP12T30P140
XD4 (D3 D4 VDD VSS) DEL250D1BWP12T30P140
XQUAL4 (A D4 VDD VSS Q4) sar8p_and2
XD5 (Q4 D5 VDD VSS) DEL250D1BWP12T30P140
XD6 (D5 D6 VDD VSS) DEL250D1BWP12T30P140
XQUAL6 (A D6 VDD VSS Q6) sar8p_and2
XD7 (Q6 D7 VDD VSS) DEL250D1BWP12T30P140
XD8 (D7 D8 VDD VSS) DEL250D1BWP12T30P140
XQUAL8 (A D8 VDD VSS Q8) sar8p_and2
XD9 (Q8 D9 VDD VSS) DEL250D1BWP12T30P140
XQUAL9 (A D9 VDD VSS Y) sar8p_and2
ends sar8p_delay_quiet

subckt sar8p_delay_capture A VDD VSS Y
XD1 (A D1 VDD VSS) DEL250D1BWP12T30P140
XD2 (D1 D2 VDD VSS) DEL250D1BWP12T30P140
XQUAL2 (A D2 VDD VSS Q2) sar8p_and2
XD3 (Q2 D3 VDD VSS) DEL250D1BWP12T30P140
XD4 (D3 D4 VDD VSS) DEL250D1BWP12T30P140
XQUAL4 (A D4 VDD VSS Q4) sar8p_and2
XD5 (Q4 D5 VDD VSS) DEL250D1BWP12T30P140
XD6 (D5 D6 VDD VSS) DEL050D1BWP12T30P140
XQUAL6 (A D6 VDD VSS Y) sar8p_and2
ends sar8p_delay_capture

subckt sar8p_delay_bbm A VDD VSS Y
XD1 (A D1 VDD VSS) DEL200D1BWP12T30P140
XQUAL1 (A D1 VDD VSS Y) sar8p_and2
ends sar8p_delay_bbm

subckt sar8r_delay A VDD VSS Y
XD1 (A D1 VDD VSS) DEL250D1BWP12T30P140
XD2 (D1 D2 VDD VSS) DEL250D1BWP12T30P140
XQUAL2 (A D2 VDD VSS Q2) sar8p_and2
XD3 (Q2 D3 VDD VSS) DEL250D1BWP12T30P140
XD4 (D3 D4 VDD VSS) DEL250D1BWP12T30P140
XQUAL4 (A D4 VDD VSS Q4) sar8p_and2
XD5 (Q4 D5 VDD VSS) DEL250D1BWP12T30P140
XD6 (D5 D6 VDD VSS) DEL250D1BWP12T30P140
XQUAL6 (A D6 VDD VSS Q6) sar8p_and2
XD7 (Q6 D7 VDD VSS) DEL250D1BWP12T30P140
XD8 (D7 D8 VDD VSS) DEL250D1BWP12T30P140
XQUAL8 (A D8 VDD VSS Q8) sar8p_and2
XD9 (Q8 D9 VDD VSS) DEL250D1BWP12T30P140
XD10 (D9 D10 VDD VSS) DEL250D1BWP12T30P140
XQUAL10 (A D10 VDD VSS Y) sar8p_and2
ends sar8r_delay

subckt sar8r_edge A VDD VSS Y
    XD (A VDD VSS AD) sar8r_delay
    XA (A AD VDD VSS QUAL) sar8p_and2
    XB (QUAL VDD VSS Y) sar8p_clkbuf
ends sar8r_edge

subckt sar8s_step A VDD VSS Y
XD1 (A D1 VDD VSS) DEL250D1BWP12T30P140
XD2 (D1 D2 VDD VSS) DEL250D1BWP12T30P140
XQUAL2 (A D2 VDD VSS Q2) sar8p_and2
XD3 (Q2 D3 VDD VSS) DEL250D1BWP12T30P140
XD4 (D3 D4 VDD VSS) DEL075D1BWP12T30P140
XQUAL4 (A D4 VDD VSS Y) sar8p_and2
ends sar8s_step

subckt sar8i_guard A VDD VSS Y
XD1 (A D1 VDD VSS) DEL250D1BWP12T30P140
XD2 (D1 D2 VDD VSS) DEL250D1BWP12T30P140
XQUAL2 (A D2 VDD VSS Q2) sar8p_and2
XD3 (Q2 D3 VDD VSS) DEL250D1BWP12T30P140
XD4 (D3 D4 VDD VSS) DEL250D1BWP12T30P140
XQUAL4 (A D4 VDD VSS Q4) sar8p_and2
XD5 (Q4 D5 VDD VSS) DEL250D1BWP12T30P140
XD6 (D5 D6 VDD VSS) DEL250D1BWP12T30P140
XQUAL6 (A D6 VDD VSS Q6) sar8p_and2
XD7 (Q6 D7 VDD VSS) DEL250D1BWP12T30P140
XD8 (D7 D8 VDD VSS) DEL250D1BWP12T30P140
XQUAL8 (A D8 VDD VSS Q8) sar8p_and2
XD9 (Q8 D9 VDD VSS) DEL250D1BWP12T30P140
XD10 (D9 D10 VDD VSS) DEL250D1BWP12T30P140
XQUAL10 (A D10 VDD VSS Q10) sar8p_and2
XD11 (Q10 D11 VDD VSS) DEL250D1BWP12T30P140
XD12 (D11 D12 VDD VSS) DEL250D1BWP12T30P140
XQUAL12 (A D12 VDD VSS Q12) sar8p_and2
XD13 (Q12 D13 VDD VSS) DEL250D1BWP12T30P140
XD14 (D13 D14 VDD VSS) DEL250D1BWP12T30P140
XQUAL14 (A D14 VDD VSS Q14) sar8p_and2
XD15 (Q14 D15 VDD VSS) DEL250D1BWP12T30P140
XD16 (D15 D16 VDD VSS) DEL250D1BWP12T30P140
XQUAL16 (A D16 VDD VSS Q16) sar8p_and2
XD17 (Q16 D17 VDD VSS) DEL250D1BWP12T30P140
XD18 (D17 D18 VDD VSS) DEL250D1BWP12T30P140
XQUAL18 (A D18 VDD VSS Q18) sar8p_and2
XD19 (Q18 D19 VDD VSS) DEL250D1BWP12T30P140
XD20 (D19 D20 VDD VSS) DEL250D1BWP12T30P140
XQUAL20 (A D20 VDD VSS Q20) sar8p_and2
XD21 (Q20 D21 VDD VSS) DEL250D1BWP12T30P140
XD22 (D21 D22 VDD VSS) DEL250D1BWP12T30P140
XQUAL22 (A D22 VDD VSS Q22) sar8p_and2
XD23 (Q22 D23 VDD VSS) DEL250D1BWP12T30P140
XD24 (D23 D24 VDD VSS) DEL250D1BWP12T30P140
XQUAL24 (A D24 VDD VSS Q24) sar8p_and2
XD25 (Q24 D25 VDD VSS) DEL250D1BWP12T30P140
XD26 (D25 D26 VDD VSS) DEL250D1BWP12T30P140
XQUAL26 (A D26 VDD VSS Q26) sar8p_and2
XD27 (Q26 D27 VDD VSS) DEL250D1BWP12T30P140
XD28 (D27 D28 VDD VSS) DEL250D1BWP12T30P140
XQUAL28 (A D28 VDD VSS Q28) sar8p_and2
XD29 (Q28 D29 VDD VSS) DEL250D1BWP12T30P140
XQUAL29 (A D29 VDD VSS Y) sar8p_and2
ends sar8i_guard
