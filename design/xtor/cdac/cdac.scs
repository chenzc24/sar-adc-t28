// Single-edge CDAC with a shared NMOS/PMOS select per bit and side.
// BEGIN SARADC RNL
// @RNL(type="header") { @VERSION("0.3");
// @USE-PACKAGE(name="sar8",version="0.1",path="../../rnl/sar8.rnl");
// @USE-PACKAGE(name="rnl-std-fill") {}; }
// END SARADC RNL
// Switch device parameters and capacitor weights come from the frozen B source.

subckt sar8j_r1_sw_b0 BOT SEL VDD VREFN VREFP VSS
    MP_HIGH (BOT SEL VREFP VDD) pch_mac l=90n w=175.00n multi=3 nf=1 \
        sd=100n ad=1.3125e-14 as=1.3125e-14 pd=500n ps=500n nrd=1.633331 \
        nrs=1.633331 sa=75.0n sb=75.0n sa1=75.0n sa2=75.0n sa3=75.0n \
        sa4=75.0n sb1=75.0n sb2=75.0n sb3=75.0n spa=100n spa1=100n \
        spa2=100n spa3=100n sap=91.9776n sapb=114.444n spba=115.715n \
        spba1=117.043n dfm_flag=0 spmt=1.11111e+15 spomt=0 \
        spomt1=1.11111e+60 spmb=1.11111e+15 spomb=0 spomb1=1.11111e+60
    MN_LOW (BOT SEL VREFN VSS) nch_mac l=90n w=150.0n multi=3 nf=1 sd=100n \
        ad=1.125e-14 as=1.125e-14 pd=450.0n ps=450.0n nrd=2.702751 \
        nrs=2.702751 sa=75.0n sb=75.0n sa1=75.0n sa2=75.0n sa3=75.0n \
        sa4=75.0n sb1=75.0n sb2=75.0n sb3=75.0n spa=100n spa1=100n \
        spa2=100n spa3=100n sap=91.9776n sapb=114.444n spba=115.715n \
        spba1=117.043n dfm_flag=0 spmt=1.11111e+15 spomt=0 \
        spomt1=1.11111e+60 spmb=1.11111e+15 spomb=0 spomb1=1.11111e+60
// BEGIN SARADC RNL
// @RNL(author="saradc topology") {
// #MP_HIGH @SET-SYMBOL $PMOS_4TERM;
// #MP_HIGH @PLACE(0,20) => @ORIENT("R0");
// #MP_HIGH @TEXT("MP_HIGH",key="name",size=1.3,halign="start") => @PLACE(3,23);
// #MP_HIGH @TEXT("l=90n w=175.00n multi=3",key="value",size=0.9,halign="start") => @PLACE(3,16);
// #MP_HIGH @TEXT("",key="model");
// #MN_LOW @SET-SYMBOL $NMOS_4TERM;
// #MN_LOW @PLACE(0,-10) => @ORIENT("R0");
// #MN_LOW @TEXT("MN_LOW",key="name",size=1.3,halign="start") => @PLACE(3,-7);
// #MN_LOW @TEXT("l=90n w=150.0n multi=3",key="value",size=0.9,halign="start") => @PLACE(3,-14);
// #MN_LOW @TEXT("",key="model");
// &"BOT" @WIRE(mode="straight",linecolor="#226e85",linewidth=0.16) {#MP_HIGH:1 (0,5)};
// $JUNCTION @ATTACH (0,5);
// &"BOT" @WIRE(mode="straight",linecolor="#226e85",linewidth=0.16) {#MN_LOW:1 (0,5)};
// $JUNCTION @ATTACH (0,5);
// &"SEL" @WIRE(mode="straight",linecolor="#30485d",linewidth=0.16) {(-12,-10) (-12,20)};
// &"SEL" @WIRE(mode="straight",linecolor="#30485d",linewidth=0.16) {#MP_HIGH:2 (-12,20)};
// $JUNCTION @ATTACH (-12,20);
// &"SEL" @WIRE(mode="straight",linecolor="#30485d",linewidth=0.16) {#MN_LOW:2 (-12,-10)};
// $JUNCTION @ATTACH (-12,-10);
// (-20,48) @TEXT("sar8j_r1_sw_b0 / real reference switches",size=1.3,halign="start",textcolor="#223d52");
// &"VREFP" @WIRE(mode="straight",linecolor="#30485d",linewidth=0.16) {#MP_HIGH:3 (0,25)};
// (0,25.4) @TEXT("VREFP",size=1.1,halign="middle",valign="bottom");
// &"VDD" @WIRE(mode="straight",linecolor="#30485d",linewidth=0.16) {#MP_HIGH:4 (4,20)};
// (4.4,20) @TEXT("VDD",size=1.1,halign="start",valign="middle");
// &"VREFN" @WIRE(mode="straight",linecolor="#30485d",linewidth=0.16) {#MN_LOW:3 (0,-15)};
// (0,-15.4) @TEXT("VREFN",size=1.1,halign="middle",valign="top");
// &"VSS" @WIRE(mode="straight",linecolor="#30485d",linewidth=0.16) {#MN_LOW:4 (4,-10)};
// (4.4,-10) @TEXT("VSS",size=1.1,halign="start",valign="middle");
// }
// END SARADC RNL
ends sar8j_r1_sw_b0

subckt sar8j_r1_sw_b1 BOT SEL VDD VREFN VREFP VSS
    MP_HIGH (BOT SEL VREFP VDD) pch_mac l=90n w=175.00n multi=6 nf=1 \
        sd=100n ad=1.3125e-14 as=1.3125e-14 pd=500n ps=500n nrd=1.633331 \
        nrs=1.633331 sa=75.0n sb=75.0n sa1=75.0n sa2=75.0n sa3=75.0n \
        sa4=75.0n sb1=75.0n sb2=75.0n sb3=75.0n spa=100n spa1=100n \
        spa2=100n spa3=100n sap=91.9776n sapb=114.444n spba=115.715n \
        spba1=117.043n dfm_flag=0 spmt=1.11111e+15 spomt=0 \
        spomt1=1.11111e+60 spmb=1.11111e+15 spomb=0 spomb1=1.11111e+60
    MN_LOW (BOT SEL VREFN VSS) nch_mac l=90n w=150.0n multi=6 nf=1 sd=100n \
        ad=1.125e-14 as=1.125e-14 pd=450.0n ps=450.0n nrd=2.702751 \
        nrs=2.702751 sa=75.0n sb=75.0n sa1=75.0n sa2=75.0n sa3=75.0n \
        sa4=75.0n sb1=75.0n sb2=75.0n sb3=75.0n spa=100n spa1=100n \
        spa2=100n spa3=100n sap=91.9776n sapb=114.444n spba=115.715n \
        spba1=117.043n dfm_flag=0 spmt=1.11111e+15 spomt=0 \
        spomt1=1.11111e+60 spmb=1.11111e+15 spomb=0 spomb1=1.11111e+60
// BEGIN SARADC RNL
// @RNL(author="saradc topology") {
// #MP_HIGH @SET-SYMBOL $PMOS_4TERM;
// #MP_HIGH @PLACE(0,20) => @ORIENT("R0");
// #MP_HIGH @TEXT("MP_HIGH",key="name",size=1.3,halign="start") => @PLACE(3,23);
// #MP_HIGH @TEXT("l=90n w=175.00n multi=6",key="value",size=0.9,halign="start") => @PLACE(3,16);
// #MP_HIGH @TEXT("",key="model");
// #MN_LOW @SET-SYMBOL $NMOS_4TERM;
// #MN_LOW @PLACE(0,-10) => @ORIENT("R0");
// #MN_LOW @TEXT("MN_LOW",key="name",size=1.3,halign="start") => @PLACE(3,-7);
// #MN_LOW @TEXT("l=90n w=150.0n multi=6",key="value",size=0.9,halign="start") => @PLACE(3,-14);
// #MN_LOW @TEXT("",key="model");
// &"BOT" @WIRE(mode="straight",linecolor="#226e85",linewidth=0.16) {#MP_HIGH:1 (0,5)};
// $JUNCTION @ATTACH (0,5);
// &"BOT" @WIRE(mode="straight",linecolor="#226e85",linewidth=0.16) {#MN_LOW:1 (0,5)};
// $JUNCTION @ATTACH (0,5);
// &"SEL" @WIRE(mode="straight",linecolor="#30485d",linewidth=0.16) {(-12,-10) (-12,20)};
// &"SEL" @WIRE(mode="straight",linecolor="#30485d",linewidth=0.16) {#MP_HIGH:2 (-12,20)};
// $JUNCTION @ATTACH (-12,20);
// &"SEL" @WIRE(mode="straight",linecolor="#30485d",linewidth=0.16) {#MN_LOW:2 (-12,-10)};
// $JUNCTION @ATTACH (-12,-10);
// (-20,48) @TEXT("sar8j_r1_sw_b1 / real reference switches",size=1.3,halign="start",textcolor="#223d52");
// &"VREFP" @WIRE(mode="straight",linecolor="#30485d",linewidth=0.16) {#MP_HIGH:3 (0,25)};
// (0,25.4) @TEXT("VREFP",size=1.1,halign="middle",valign="bottom");
// &"VDD" @WIRE(mode="straight",linecolor="#30485d",linewidth=0.16) {#MP_HIGH:4 (4,20)};
// (4.4,20) @TEXT("VDD",size=1.1,halign="start",valign="middle");
// &"VREFN" @WIRE(mode="straight",linecolor="#30485d",linewidth=0.16) {#MN_LOW:3 (0,-15)};
// (0,-15.4) @TEXT("VREFN",size=1.1,halign="middle",valign="top");
// &"VSS" @WIRE(mode="straight",linecolor="#30485d",linewidth=0.16) {#MN_LOW:4 (4,-10)};
// (4.4,-10) @TEXT("VSS",size=1.1,halign="start",valign="middle");
// }
// END SARADC RNL
ends sar8j_r1_sw_b1

subckt sar8j_r1_sw_b2 BOT SEL VDD VREFN VREFP VSS
    MP_HIGH (BOT SEL VREFP VDD) pch_mac l=90n w=175.00n multi=12 nf=1 \
        sd=100n ad=1.3125e-14 as=1.3125e-14 pd=500n ps=500n nrd=1.633331 \
        nrs=1.633331 sa=75.0n sb=75.0n sa1=75.0n sa2=75.0n sa3=75.0n \
        sa4=75.0n sb1=75.0n sb2=75.0n sb3=75.0n spa=100n spa1=100n \
        spa2=100n spa3=100n sap=91.9776n sapb=114.444n spba=115.715n \
        spba1=117.043n dfm_flag=0 spmt=1.11111e+15 spomt=0 \
        spomt1=1.11111e+60 spmb=1.11111e+15 spomb=0 spomb1=1.11111e+60
    MN_LOW (BOT SEL VREFN VSS) nch_mac l=90n w=150.0n multi=12 nf=1 sd=100n \
        ad=1.125e-14 as=1.125e-14 pd=450.0n ps=450.0n nrd=2.702751 \
        nrs=2.702751 sa=75.0n sb=75.0n sa1=75.0n sa2=75.0n sa3=75.0n \
        sa4=75.0n sb1=75.0n sb2=75.0n sb3=75.0n spa=100n spa1=100n \
        spa2=100n spa3=100n sap=91.9776n sapb=114.444n spba=115.715n \
        spba1=117.043n dfm_flag=0 spmt=1.11111e+15 spomt=0 \
        spomt1=1.11111e+60 spmb=1.11111e+15 spomb=0 spomb1=1.11111e+60
// BEGIN SARADC RNL
// @RNL(author="saradc topology") {
// #MP_HIGH @SET-SYMBOL $PMOS_4TERM;
// #MP_HIGH @PLACE(0,20) => @ORIENT("R0");
// #MP_HIGH @TEXT("MP_HIGH",key="name",size=1.3,halign="start") => @PLACE(3,23);
// #MP_HIGH @TEXT("l=90n w=175.00n multi=12",key="value",size=0.9,halign="start") => @PLACE(3,16);
// #MP_HIGH @TEXT("",key="model");
// #MN_LOW @SET-SYMBOL $NMOS_4TERM;
// #MN_LOW @PLACE(0,-10) => @ORIENT("R0");
// #MN_LOW @TEXT("MN_LOW",key="name",size=1.3,halign="start") => @PLACE(3,-7);
// #MN_LOW @TEXT("l=90n w=150.0n multi=12",key="value",size=0.9,halign="start") => @PLACE(3,-14);
// #MN_LOW @TEXT("",key="model");
// &"BOT" @WIRE(mode="straight",linecolor="#226e85",linewidth=0.16) {#MP_HIGH:1 (0,5)};
// $JUNCTION @ATTACH (0,5);
// &"BOT" @WIRE(mode="straight",linecolor="#226e85",linewidth=0.16) {#MN_LOW:1 (0,5)};
// $JUNCTION @ATTACH (0,5);
// &"SEL" @WIRE(mode="straight",linecolor="#30485d",linewidth=0.16) {(-12,-10) (-12,20)};
// &"SEL" @WIRE(mode="straight",linecolor="#30485d",linewidth=0.16) {#MP_HIGH:2 (-12,20)};
// $JUNCTION @ATTACH (-12,20);
// &"SEL" @WIRE(mode="straight",linecolor="#30485d",linewidth=0.16) {#MN_LOW:2 (-12,-10)};
// $JUNCTION @ATTACH (-12,-10);
// (-20,48) @TEXT("sar8j_r1_sw_b2 / real reference switches",size=1.3,halign="start",textcolor="#223d52");
// &"VREFP" @WIRE(mode="straight",linecolor="#30485d",linewidth=0.16) {#MP_HIGH:3 (0,25)};
// (0,25.4) @TEXT("VREFP",size=1.1,halign="middle",valign="bottom");
// &"VDD" @WIRE(mode="straight",linecolor="#30485d",linewidth=0.16) {#MP_HIGH:4 (4,20)};
// (4.4,20) @TEXT("VDD",size=1.1,halign="start",valign="middle");
// &"VREFN" @WIRE(mode="straight",linecolor="#30485d",linewidth=0.16) {#MN_LOW:3 (0,-15)};
// (0,-15.4) @TEXT("VREFN",size=1.1,halign="middle",valign="top");
// &"VSS" @WIRE(mode="straight",linecolor="#30485d",linewidth=0.16) {#MN_LOW:4 (4,-10)};
// (4.4,-10) @TEXT("VSS",size=1.1,halign="start",valign="middle");
// }
// END SARADC RNL
ends sar8j_r1_sw_b2

subckt sar8j_r1_sw_b3 BOT SEL VDD VREFN VREFP VSS
    MP_HIGH (BOT SEL VREFP VDD) pch_mac l=90n w=175.00n multi=24 nf=1 \
        sd=100n ad=1.3125e-14 as=1.3125e-14 pd=500n ps=500n nrd=1.633331 \
        nrs=1.633331 sa=75.0n sb=75.0n sa1=75.0n sa2=75.0n sa3=75.0n \
        sa4=75.0n sb1=75.0n sb2=75.0n sb3=75.0n spa=100n spa1=100n \
        spa2=100n spa3=100n sap=91.9776n sapb=114.444n spba=115.715n \
        spba1=117.043n dfm_flag=0 spmt=1.11111e+15 spomt=0 \
        spomt1=1.11111e+60 spmb=1.11111e+15 spomb=0 spomb1=1.11111e+60
    MN_LOW (BOT SEL VREFN VSS) nch_mac l=90n w=150.0n multi=24 nf=1 sd=100n \
        ad=1.125e-14 as=1.125e-14 pd=450.0n ps=450.0n nrd=2.702751 \
        nrs=2.702751 sa=75.0n sb=75.0n sa1=75.0n sa2=75.0n sa3=75.0n \
        sa4=75.0n sb1=75.0n sb2=75.0n sb3=75.0n spa=100n spa1=100n \
        spa2=100n spa3=100n sap=91.9776n sapb=114.444n spba=115.715n \
        spba1=117.043n dfm_flag=0 spmt=1.11111e+15 spomt=0 \
        spomt1=1.11111e+60 spmb=1.11111e+15 spomb=0 spomb1=1.11111e+60
// BEGIN SARADC RNL
// @RNL(author="saradc topology") {
// #MP_HIGH @SET-SYMBOL $PMOS_4TERM;
// #MP_HIGH @PLACE(0,20) => @ORIENT("R0");
// #MP_HIGH @TEXT("MP_HIGH",key="name",size=1.3,halign="start") => @PLACE(3,23);
// #MP_HIGH @TEXT("l=90n w=175.00n multi=24",key="value",size=0.9,halign="start") => @PLACE(3,16);
// #MP_HIGH @TEXT("",key="model");
// #MN_LOW @SET-SYMBOL $NMOS_4TERM;
// #MN_LOW @PLACE(0,-10) => @ORIENT("R0");
// #MN_LOW @TEXT("MN_LOW",key="name",size=1.3,halign="start") => @PLACE(3,-7);
// #MN_LOW @TEXT("l=90n w=150.0n multi=24",key="value",size=0.9,halign="start") => @PLACE(3,-14);
// #MN_LOW @TEXT("",key="model");
// &"BOT" @WIRE(mode="straight",linecolor="#226e85",linewidth=0.16) {#MP_HIGH:1 (0,5)};
// $JUNCTION @ATTACH (0,5);
// &"BOT" @WIRE(mode="straight",linecolor="#226e85",linewidth=0.16) {#MN_LOW:1 (0,5)};
// $JUNCTION @ATTACH (0,5);
// &"SEL" @WIRE(mode="straight",linecolor="#30485d",linewidth=0.16) {(-12,-10) (-12,20)};
// &"SEL" @WIRE(mode="straight",linecolor="#30485d",linewidth=0.16) {#MP_HIGH:2 (-12,20)};
// $JUNCTION @ATTACH (-12,20);
// &"SEL" @WIRE(mode="straight",linecolor="#30485d",linewidth=0.16) {#MN_LOW:2 (-12,-10)};
// $JUNCTION @ATTACH (-12,-10);
// (-20,48) @TEXT("sar8j_r1_sw_b3 / real reference switches",size=1.3,halign="start",textcolor="#223d52");
// &"VREFP" @WIRE(mode="straight",linecolor="#30485d",linewidth=0.16) {#MP_HIGH:3 (0,25)};
// (0,25.4) @TEXT("VREFP",size=1.1,halign="middle",valign="bottom");
// &"VDD" @WIRE(mode="straight",linecolor="#30485d",linewidth=0.16) {#MP_HIGH:4 (4,20)};
// (4.4,20) @TEXT("VDD",size=1.1,halign="start",valign="middle");
// &"VREFN" @WIRE(mode="straight",linecolor="#30485d",linewidth=0.16) {#MN_LOW:3 (0,-15)};
// (0,-15.4) @TEXT("VREFN",size=1.1,halign="middle",valign="top");
// &"VSS" @WIRE(mode="straight",linecolor="#30485d",linewidth=0.16) {#MN_LOW:4 (4,-10)};
// (4.4,-10) @TEXT("VSS",size=1.1,halign="start",valign="middle");
// }
// END SARADC RNL
ends sar8j_r1_sw_b3

subckt sar8j_r1_sw_b4 BOT SEL VDD VREFN VREFP VSS
    MP_HIGH (BOT SEL VREFP VDD) pch_mac l=90n w=175.00n multi=48 nf=1 \
        sd=100n ad=1.3125e-14 as=1.3125e-14 pd=500n ps=500n nrd=1.633331 \
        nrs=1.633331 sa=75.0n sb=75.0n sa1=75.0n sa2=75.0n sa3=75.0n \
        sa4=75.0n sb1=75.0n sb2=75.0n sb3=75.0n spa=100n spa1=100n \
        spa2=100n spa3=100n sap=91.9776n sapb=114.444n spba=115.715n \
        spba1=117.043n dfm_flag=0 spmt=1.11111e+15 spomt=0 \
        spomt1=1.11111e+60 spmb=1.11111e+15 spomb=0 spomb1=1.11111e+60
    MN_LOW (BOT SEL VREFN VSS) nch_mac l=90n w=150.0n multi=48 nf=1 sd=100n \
        ad=1.125e-14 as=1.125e-14 pd=450.0n ps=450.0n nrd=2.702751 \
        nrs=2.702751 sa=75.0n sb=75.0n sa1=75.0n sa2=75.0n sa3=75.0n \
        sa4=75.0n sb1=75.0n sb2=75.0n sb3=75.0n spa=100n spa1=100n \
        spa2=100n spa3=100n sap=91.9776n sapb=114.444n spba=115.715n \
        spba1=117.043n dfm_flag=0 spmt=1.11111e+15 spomt=0 \
        spomt1=1.11111e+60 spmb=1.11111e+15 spomb=0 spomb1=1.11111e+60
// BEGIN SARADC RNL
// @RNL(author="saradc topology") {
// #MP_HIGH @SET-SYMBOL $PMOS_4TERM;
// #MP_HIGH @PLACE(0,20) => @ORIENT("R0");
// #MP_HIGH @TEXT("MP_HIGH",key="name",size=1.3,halign="start") => @PLACE(3,23);
// #MP_HIGH @TEXT("l=90n w=175.00n multi=48",key="value",size=0.9,halign="start") => @PLACE(3,16);
// #MP_HIGH @TEXT("",key="model");
// #MN_LOW @SET-SYMBOL $NMOS_4TERM;
// #MN_LOW @PLACE(0,-10) => @ORIENT("R0");
// #MN_LOW @TEXT("MN_LOW",key="name",size=1.3,halign="start") => @PLACE(3,-7);
// #MN_LOW @TEXT("l=90n w=150.0n multi=48",key="value",size=0.9,halign="start") => @PLACE(3,-14);
// #MN_LOW @TEXT("",key="model");
// &"BOT" @WIRE(mode="straight",linecolor="#226e85",linewidth=0.16) {#MP_HIGH:1 (0,5)};
// $JUNCTION @ATTACH (0,5);
// &"BOT" @WIRE(mode="straight",linecolor="#226e85",linewidth=0.16) {#MN_LOW:1 (0,5)};
// $JUNCTION @ATTACH (0,5);
// &"SEL" @WIRE(mode="straight",linecolor="#30485d",linewidth=0.16) {(-12,-10) (-12,20)};
// &"SEL" @WIRE(mode="straight",linecolor="#30485d",linewidth=0.16) {#MP_HIGH:2 (-12,20)};
// $JUNCTION @ATTACH (-12,20);
// &"SEL" @WIRE(mode="straight",linecolor="#30485d",linewidth=0.16) {#MN_LOW:2 (-12,-10)};
// $JUNCTION @ATTACH (-12,-10);
// (-20,48) @TEXT("sar8j_r1_sw_b4 / real reference switches",size=1.3,halign="start",textcolor="#223d52");
// &"VREFP" @WIRE(mode="straight",linecolor="#30485d",linewidth=0.16) {#MP_HIGH:3 (0,25)};
// (0,25.4) @TEXT("VREFP",size=1.1,halign="middle",valign="bottom");
// &"VDD" @WIRE(mode="straight",linecolor="#30485d",linewidth=0.16) {#MP_HIGH:4 (4,20)};
// (4.4,20) @TEXT("VDD",size=1.1,halign="start",valign="middle");
// &"VREFN" @WIRE(mode="straight",linecolor="#30485d",linewidth=0.16) {#MN_LOW:3 (0,-15)};
// (0,-15.4) @TEXT("VREFN",size=1.1,halign="middle",valign="top");
// &"VSS" @WIRE(mode="straight",linecolor="#30485d",linewidth=0.16) {#MN_LOW:4 (4,-10)};
// (4.4,-10) @TEXT("VSS",size=1.1,halign="start",valign="middle");
// }
// END SARADC RNL
ends sar8j_r1_sw_b4

subckt sar8j_r1_sw_b5 BOT SEL VDD VREFN VREFP VSS
    MP_HIGH (BOT SEL VREFP VDD) pch_mac l=90n w=175.00n multi=96 nf=1 \
        sd=100n ad=1.3125e-14 as=1.3125e-14 pd=500n ps=500n nrd=1.633331 \
        nrs=1.633331 sa=75.0n sb=75.0n sa1=75.0n sa2=75.0n sa3=75.0n \
        sa4=75.0n sb1=75.0n sb2=75.0n sb3=75.0n spa=100n spa1=100n \
        spa2=100n spa3=100n sap=91.9776n sapb=114.444n spba=115.715n \
        spba1=117.043n dfm_flag=0 spmt=1.11111e+15 spomt=0 \
        spomt1=1.11111e+60 spmb=1.11111e+15 spomb=0 spomb1=1.11111e+60
    MN_LOW (BOT SEL VREFN VSS) nch_mac l=90n w=150.0n multi=96 nf=1 sd=100n \
        ad=1.125e-14 as=1.125e-14 pd=450.0n ps=450.0n nrd=2.702751 \
        nrs=2.702751 sa=75.0n sb=75.0n sa1=75.0n sa2=75.0n sa3=75.0n \
        sa4=75.0n sb1=75.0n sb2=75.0n sb3=75.0n spa=100n spa1=100n \
        spa2=100n spa3=100n sap=91.9776n sapb=114.444n spba=115.715n \
        spba1=117.043n dfm_flag=0 spmt=1.11111e+15 spomt=0 \
        spomt1=1.11111e+60 spmb=1.11111e+15 spomb=0 spomb1=1.11111e+60
// BEGIN SARADC RNL
// @RNL(author="saradc topology") {
// #MP_HIGH @SET-SYMBOL $PMOS_4TERM;
// #MP_HIGH @PLACE(0,20) => @ORIENT("R0");
// #MP_HIGH @TEXT("MP_HIGH",key="name",size=1.3,halign="start") => @PLACE(3,23);
// #MP_HIGH @TEXT("l=90n w=175.00n multi=96",key="value",size=0.9,halign="start") => @PLACE(3,16);
// #MP_HIGH @TEXT("",key="model");
// #MN_LOW @SET-SYMBOL $NMOS_4TERM;
// #MN_LOW @PLACE(0,-10) => @ORIENT("R0");
// #MN_LOW @TEXT("MN_LOW",key="name",size=1.3,halign="start") => @PLACE(3,-7);
// #MN_LOW @TEXT("l=90n w=150.0n multi=96",key="value",size=0.9,halign="start") => @PLACE(3,-14);
// #MN_LOW @TEXT("",key="model");
// &"BOT" @WIRE(mode="straight",linecolor="#226e85",linewidth=0.16) {#MP_HIGH:1 (0,5)};
// $JUNCTION @ATTACH (0,5);
// &"BOT" @WIRE(mode="straight",linecolor="#226e85",linewidth=0.16) {#MN_LOW:1 (0,5)};
// $JUNCTION @ATTACH (0,5);
// &"SEL" @WIRE(mode="straight",linecolor="#30485d",linewidth=0.16) {(-12,-10) (-12,20)};
// &"SEL" @WIRE(mode="straight",linecolor="#30485d",linewidth=0.16) {#MP_HIGH:2 (-12,20)};
// $JUNCTION @ATTACH (-12,20);
// &"SEL" @WIRE(mode="straight",linecolor="#30485d",linewidth=0.16) {#MN_LOW:2 (-12,-10)};
// $JUNCTION @ATTACH (-12,-10);
// (-20,48) @TEXT("sar8j_r1_sw_b5 / real reference switches",size=1.3,halign="start",textcolor="#223d52");
// &"VREFP" @WIRE(mode="straight",linecolor="#30485d",linewidth=0.16) {#MP_HIGH:3 (0,25)};
// (0,25.4) @TEXT("VREFP",size=1.1,halign="middle",valign="bottom");
// &"VDD" @WIRE(mode="straight",linecolor="#30485d",linewidth=0.16) {#MP_HIGH:4 (4,20)};
// (4.4,20) @TEXT("VDD",size=1.1,halign="start",valign="middle");
// &"VREFN" @WIRE(mode="straight",linecolor="#30485d",linewidth=0.16) {#MN_LOW:3 (0,-15)};
// (0,-15.4) @TEXT("VREFN",size=1.1,halign="middle",valign="top");
// &"VSS" @WIRE(mode="straight",linecolor="#30485d",linewidth=0.16) {#MN_LOW:4 (4,-10)};
// (4.4,-10) @TEXT("VSS",size=1.1,halign="start",valign="middle");
// }
// END SARADC RNL
ends sar8j_r1_sw_b5

subckt sar8j_r1_sw_b6 BOT SEL VDD VREFN VREFP VSS
    MP_HIGH (BOT SEL VREFP VDD) pch_mac l=90n w=175.00n multi=192 nf=1 \
        sd=100n ad=1.3125e-14 as=1.3125e-14 pd=500n ps=500n nrd=1.633331 \
        nrs=1.633331 sa=75.0n sb=75.0n sa1=75.0n sa2=75.0n sa3=75.0n \
        sa4=75.0n sb1=75.0n sb2=75.0n sb3=75.0n spa=100n spa1=100n \
        spa2=100n spa3=100n sap=91.9776n sapb=114.444n spba=115.715n \
        spba1=117.043n dfm_flag=0 spmt=1.11111e+15 spomt=0 \
        spomt1=1.11111e+60 spmb=1.11111e+15 spomb=0 spomb1=1.11111e+60
    MN_LOW (BOT SEL VREFN VSS) nch_mac l=90n w=150.0n multi=192 nf=1 \
        sd=100n ad=1.125e-14 as=1.125e-14 pd=450.0n ps=450.0n nrd=2.702751 \
        nrs=2.702751 sa=75.0n sb=75.0n sa1=75.0n sa2=75.0n sa3=75.0n \
        sa4=75.0n sb1=75.0n sb2=75.0n sb3=75.0n spa=100n spa1=100n \
        spa2=100n spa3=100n sap=91.9776n sapb=114.444n spba=115.715n \
        spba1=117.043n dfm_flag=0 spmt=1.11111e+15 spomt=0 \
        spomt1=1.11111e+60 spmb=1.11111e+15 spomb=0 spomb1=1.11111e+60
// BEGIN SARADC RNL
// @RNL(author="saradc topology") {
// #MP_HIGH @SET-SYMBOL $PMOS_4TERM;
// #MP_HIGH @PLACE(0,20) => @ORIENT("R0");
// #MP_HIGH @TEXT("MP_HIGH",key="name",size=1.3,halign="start") => @PLACE(3,23);
// #MP_HIGH @TEXT("l=90n w=175.00n multi=192",key="value",size=0.9,halign="start") => @PLACE(3,16);
// #MP_HIGH @TEXT("",key="model");
// #MN_LOW @SET-SYMBOL $NMOS_4TERM;
// #MN_LOW @PLACE(0,-10) => @ORIENT("R0");
// #MN_LOW @TEXT("MN_LOW",key="name",size=1.3,halign="start") => @PLACE(3,-7);
// #MN_LOW @TEXT("l=90n w=150.0n multi=192",key="value",size=0.9,halign="start") => @PLACE(3,-14);
// #MN_LOW @TEXT("",key="model");
// &"BOT" @WIRE(mode="straight",linecolor="#226e85",linewidth=0.16) {#MP_HIGH:1 (0,5)};
// $JUNCTION @ATTACH (0,5);
// &"BOT" @WIRE(mode="straight",linecolor="#226e85",linewidth=0.16) {#MN_LOW:1 (0,5)};
// $JUNCTION @ATTACH (0,5);
// &"SEL" @WIRE(mode="straight",linecolor="#30485d",linewidth=0.16) {(-12,-10) (-12,20)};
// &"SEL" @WIRE(mode="straight",linecolor="#30485d",linewidth=0.16) {#MP_HIGH:2 (-12,20)};
// $JUNCTION @ATTACH (-12,20);
// &"SEL" @WIRE(mode="straight",linecolor="#30485d",linewidth=0.16) {#MN_LOW:2 (-12,-10)};
// $JUNCTION @ATTACH (-12,-10);
// (-20,48) @TEXT("sar8j_r1_sw_b6 / real reference switches",size=1.3,halign="start",textcolor="#223d52");
// &"VREFP" @WIRE(mode="straight",linecolor="#30485d",linewidth=0.16) {#MP_HIGH:3 (0,25)};
// (0,25.4) @TEXT("VREFP",size=1.1,halign="middle",valign="bottom");
// &"VDD" @WIRE(mode="straight",linecolor="#30485d",linewidth=0.16) {#MP_HIGH:4 (4,20)};
// (4.4,20) @TEXT("VDD",size=1.1,halign="start",valign="middle");
// &"VREFN" @WIRE(mode="straight",linecolor="#30485d",linewidth=0.16) {#MN_LOW:3 (0,-15)};
// (0,-15.4) @TEXT("VREFN",size=1.1,halign="middle",valign="top");
// &"VSS" @WIRE(mode="straight",linecolor="#30485d",linewidth=0.16) {#MN_LOW:4 (4,-10)};
// (4.4,-10) @TEXT("VSS",size=1.1,halign="start",valign="middle");
// }
// END SARADC RNL
ends sar8j_r1_sw_b6

subckt sar8j_r1_sw_b7 BOT SEL VDD VREFN VREFP VSS
    MP_HIGH (BOT SEL VREFP VDD) pch_mac l=90n w=175.00n multi=384 nf=1 \
        sd=100n ad=1.3125e-14 as=1.3125e-14 pd=500n ps=500n nrd=1.633331 \
        nrs=1.633331 sa=75.0n sb=75.0n sa1=75.0n sa2=75.0n sa3=75.0n \
        sa4=75.0n sb1=75.0n sb2=75.0n sb3=75.0n spa=100n spa1=100n \
        spa2=100n spa3=100n sap=91.9776n sapb=114.444n spba=115.715n \
        spba1=117.043n dfm_flag=0 spmt=1.11111e+15 spomt=0 \
        spomt1=1.11111e+60 spmb=1.11111e+15 spomb=0 spomb1=1.11111e+60
    MN_LOW (BOT SEL VREFN VSS) nch_mac l=90n w=150.0n multi=384 nf=1 \
        sd=100n ad=1.125e-14 as=1.125e-14 pd=450.0n ps=450.0n nrd=2.702751 \
        nrs=2.702751 sa=75.0n sb=75.0n sa1=75.0n sa2=75.0n sa3=75.0n \
        sa4=75.0n sb1=75.0n sb2=75.0n sb3=75.0n spa=100n spa1=100n \
        spa2=100n spa3=100n sap=91.9776n sapb=114.444n spba=115.715n \
        spba1=117.043n dfm_flag=0 spmt=1.11111e+15 spomt=0 \
        spomt1=1.11111e+60 spmb=1.11111e+15 spomb=0 spomb1=1.11111e+60
// BEGIN SARADC RNL
// @RNL(author="saradc topology") {
// #MP_HIGH @SET-SYMBOL $PMOS_4TERM;
// #MP_HIGH @PLACE(0,20) => @ORIENT("R0");
// #MP_HIGH @TEXT("MP_HIGH",key="name",size=1.3,halign="start") => @PLACE(3,23);
// #MP_HIGH @TEXT("l=90n w=175.00n multi=384",key="value",size=0.9,halign="start") => @PLACE(3,16);
// #MP_HIGH @TEXT("",key="model");
// #MN_LOW @SET-SYMBOL $NMOS_4TERM;
// #MN_LOW @PLACE(0,-10) => @ORIENT("R0");
// #MN_LOW @TEXT("MN_LOW",key="name",size=1.3,halign="start") => @PLACE(3,-7);
// #MN_LOW @TEXT("l=90n w=150.0n multi=384",key="value",size=0.9,halign="start") => @PLACE(3,-14);
// #MN_LOW @TEXT("",key="model");
// &"BOT" @WIRE(mode="straight",linecolor="#226e85",linewidth=0.16) {#MP_HIGH:1 (0,5)};
// $JUNCTION @ATTACH (0,5);
// &"BOT" @WIRE(mode="straight",linecolor="#226e85",linewidth=0.16) {#MN_LOW:1 (0,5)};
// $JUNCTION @ATTACH (0,5);
// &"SEL" @WIRE(mode="straight",linecolor="#30485d",linewidth=0.16) {(-12,-10) (-12,20)};
// &"SEL" @WIRE(mode="straight",linecolor="#30485d",linewidth=0.16) {#MP_HIGH:2 (-12,20)};
// $JUNCTION @ATTACH (-12,20);
// &"SEL" @WIRE(mode="straight",linecolor="#30485d",linewidth=0.16) {#MN_LOW:2 (-12,-10)};
// $JUNCTION @ATTACH (-12,-10);
// (-20,48) @TEXT("sar8j_r1_sw_b7 / real reference switches",size=1.3,halign="start",textcolor="#223d52");
// &"VREFP" @WIRE(mode="straight",linecolor="#30485d",linewidth=0.16) {#MP_HIGH:3 (0,25)};
// (0,25.4) @TEXT("VREFP",size=1.1,halign="middle",valign="bottom");
// &"VDD" @WIRE(mode="straight",linecolor="#30485d",linewidth=0.16) {#MP_HIGH:4 (4,20)};
// (4.4,20) @TEXT("VDD",size=1.1,halign="start",valign="middle");
// &"VREFN" @WIRE(mode="straight",linecolor="#30485d",linewidth=0.16) {#MN_LOW:3 (0,-15)};
// (0,-15.4) @TEXT("VREFN",size=1.1,halign="middle",valign="top");
// &"VSS" @WIRE(mode="straight",linecolor="#30485d",linewidth=0.16) {#MN_LOW:4 (4,-10)};
// (4.4,-10) @TEXT("VSS",size=1.1,halign="start",valign="middle");
// }
// END SARADC RNL
ends sar8j_r1_sw_b7

subckt sar8j_r1_cdac REFSEL_N0 REFSEL_N1 REFSEL_N2 REFSEL_N3 REFSEL_N4 REFSEL_N5 REFSEL_N6 REFSEL_N7 \
    REFSEL_P0 REFSEL_P1 REFSEL_P2 REFSEL_P3 REFSEL_P4 REFSEL_P5 REFSEL_P6 REFSEL_P7 \
    TOPN TOPP VDD VREFN VREFP VSS
    CMOMN8 (TOPN VREFN) cfmom_2t nr=8 lr=2u w=50n s=50n stm=1 spm=3 \
        multi=1 mismatchflag=1
    CMOMN7 (TOPN BN7) cfmom_2t nr=8 lr=2u w=50n s=50n stm=1 spm=3 \
        multi=128 mismatchflag=1
    CMOMN6 (TOPN BN6) cfmom_2t nr=8 lr=2u w=50n s=50n stm=1 spm=3 multi=64 \
        mismatchflag=1
    CMOMN5 (TOPN BN5) cfmom_2t nr=8 lr=2u w=50n s=50n stm=1 spm=3 multi=32 \
        mismatchflag=1
    CMOMN4 (TOPN BN4) cfmom_2t nr=8 lr=2u w=50n s=50n stm=1 spm=3 multi=16 \
        mismatchflag=1
    CMOMN3 (TOPN BN3) cfmom_2t nr=8 lr=2u w=50n s=50n stm=1 spm=3 multi=8 \
        mismatchflag=1
    CMOMN2 (TOPN BN2) cfmom_2t nr=8 lr=2u w=50n s=50n stm=1 spm=3 multi=4 \
        mismatchflag=1
    CMOMN1 (TOPN BN1) cfmom_2t nr=8 lr=2u w=50n s=50n stm=1 spm=3 multi=2 \
        mismatchflag=1
    CMOMN0 (TOPN BN0) cfmom_2t nr=8 lr=2u w=50n s=50n stm=1 spm=3 multi=1 \
        mismatchflag=1
    CMOMP8 (TOPP VREFP) cfmom_2t nr=8 lr=2u w=50n s=50n stm=1 spm=3 \
        multi=1 mismatchflag=1
    CMOMP7 (TOPP BP7) cfmom_2t nr=8 lr=2u w=50n s=50n stm=1 spm=3 \
        multi=128 mismatchflag=1
    CMOMP6 (TOPP BP6) cfmom_2t nr=8 lr=2u w=50n s=50n stm=1 spm=3 multi=64 \
        mismatchflag=1
    CMOMP5 (TOPP BP5) cfmom_2t nr=8 lr=2u w=50n s=50n stm=1 spm=3 multi=32 \
        mismatchflag=1
    CMOMP4 (TOPP BP4) cfmom_2t nr=8 lr=2u w=50n s=50n stm=1 spm=3 multi=16 \
        mismatchflag=1
    CMOMP3 (TOPP BP3) cfmom_2t nr=8 lr=2u w=50n s=50n stm=1 spm=3 multi=8 \
        mismatchflag=1
    CMOMP2 (TOPP BP2) cfmom_2t nr=8 lr=2u w=50n s=50n stm=1 spm=3 multi=4 \
        mismatchflag=1
    CMOMP1 (TOPP BP1) cfmom_2t nr=8 lr=2u w=50n s=50n stm=1 spm=3 multi=2 \
        mismatchflag=1
    CMOMP0 (TOPP BP0) cfmom_2t nr=8 lr=2u w=50n s=50n stm=1 spm=3 multi=1 \
        mismatchflag=1
    XSN0 (BN0 REFSEL_N0 VDD VREFN VREFP VSS) sar8j_r1_sw_b0
    XSP0 (BP0 REFSEL_P0 VDD VREFN VREFP VSS) sar8j_r1_sw_b0
    XSN1 (BN1 REFSEL_N1 VDD VREFN VREFP VSS) sar8j_r1_sw_b1
    XSP1 (BP1 REFSEL_P1 VDD VREFN VREFP VSS) sar8j_r1_sw_b1
    XSN2 (BN2 REFSEL_N2 VDD VREFN VREFP VSS) sar8j_r1_sw_b2
    XSP2 (BP2 REFSEL_P2 VDD VREFN VREFP VSS) sar8j_r1_sw_b2
    XSN3 (BN3 REFSEL_N3 VDD VREFN VREFP VSS) sar8j_r1_sw_b3
    XSP3 (BP3 REFSEL_P3 VDD VREFN VREFP VSS) sar8j_r1_sw_b3
    XSN4 (BN4 REFSEL_N4 VDD VREFN VREFP VSS) sar8j_r1_sw_b4
    XSP4 (BP4 REFSEL_P4 VDD VREFN VREFP VSS) sar8j_r1_sw_b4
    XSN5 (BN5 REFSEL_N5 VDD VREFN VREFP VSS) sar8j_r1_sw_b5
    XSP5 (BP5 REFSEL_P5 VDD VREFN VREFP VSS) sar8j_r1_sw_b5
    XSN6 (BN6 REFSEL_N6 VDD VREFN VREFP VSS) sar8j_r1_sw_b6
    XSP6 (BP6 REFSEL_P6 VDD VREFN VREFP VSS) sar8j_r1_sw_b6
    XSN7 (BN7 REFSEL_N7 VDD VREFN VREFP VSS) sar8j_r1_sw_b7
    XSP7 (BP7 REFSEL_P7 VDD VREFN VREFP VSS) sar8j_r1_sw_b7
// BEGIN SARADC RNL
// @RNL(author="saradc topology") {
// (-15,68) @TEXT("Differential MOM CDAC  /  binary weights and unit dummy",size=1.65,halign="start",textcolor="#223d52");
// #CMOMN0 @SET-SYMBOL $CAPACITOR;
// #CMOMN0 @PLACE(0,34) => @ORIENT("R0");
// #CMOMN0 @TEXT("CMOMN0",key="name",size=1.3,halign="start") => @PLACE(3,37);
// #CMOMN0 @TEXT("nr=8 lr=2u w=50n multi=1",key="value",size=0.9,halign="start") => @PLACE(3,30);
// #CMOMN0 @TEXT("",key="model");
// #XSN0 @SET-SYMBOL $S_sar8j_r1_sw_b0;
// #XSN0 @PLACE(0,12) => @ORIENT("R0");
// &"BN0" @WIRE(mode="straight",linecolor="#30485d",linewidth=0.16) {#CMOMN0:2 (0,32) (0,24) #XSN0:1};
// #CMOMN1 @SET-SYMBOL $CAPACITOR;
// #CMOMN1 @PLACE(38,34) => @ORIENT("R0");
// #CMOMN1 @TEXT("CMOMN1",key="name",size=1.3,halign="start") => @PLACE(41,37);
// #CMOMN1 @TEXT("nr=8 lr=2u w=50n multi=2",key="value",size=0.9,halign="start") => @PLACE(41,30);
// #CMOMN1 @TEXT("",key="model");
// #XSN1 @SET-SYMBOL $S_sar8j_r1_sw_b1;
// #XSN1 @PLACE(38,12) => @ORIENT("R0");
// &"BN1" @WIRE(mode="straight",linecolor="#30485d",linewidth=0.16) {#CMOMN1:2 (38,32) (38,24) #XSN1:1};
// #CMOMN2 @SET-SYMBOL $CAPACITOR;
// #CMOMN2 @PLACE(76,34) => @ORIENT("R0");
// #CMOMN2 @TEXT("CMOMN2",key="name",size=1.3,halign="start") => @PLACE(79,37);
// #CMOMN2 @TEXT("nr=8 lr=2u w=50n multi=4",key="value",size=0.9,halign="start") => @PLACE(79,30);
// #CMOMN2 @TEXT("",key="model");
// #XSN2 @SET-SYMBOL $S_sar8j_r1_sw_b2;
// #XSN2 @PLACE(76,12) => @ORIENT("R0");
// &"BN2" @WIRE(mode="straight",linecolor="#30485d",linewidth=0.16) {#CMOMN2:2 (76,32) (76,24) #XSN2:1};
// #CMOMN3 @SET-SYMBOL $CAPACITOR;
// #CMOMN3 @PLACE(114,34) => @ORIENT("R0");
// #CMOMN3 @TEXT("CMOMN3",key="name",size=1.3,halign="start") => @PLACE(117,37);
// #CMOMN3 @TEXT("nr=8 lr=2u w=50n multi=8",key="value",size=0.9,halign="start") => @PLACE(117,30);
// #CMOMN3 @TEXT("",key="model");
// #XSN3 @SET-SYMBOL $S_sar8j_r1_sw_b3;
// #XSN3 @PLACE(114,12) => @ORIENT("R0");
// &"BN3" @WIRE(mode="straight",linecolor="#30485d",linewidth=0.16) {#CMOMN3:2 (114,32) (114,24) #XSN3:1};
// #CMOMN4 @SET-SYMBOL $CAPACITOR;
// #CMOMN4 @PLACE(152,34) => @ORIENT("R0");
// #CMOMN4 @TEXT("CMOMN4",key="name",size=1.3,halign="start") => @PLACE(155,37);
// #CMOMN4 @TEXT("nr=8 lr=2u w=50n multi=16",key="value",size=0.9,halign="start") => @PLACE(155,30);
// #CMOMN4 @TEXT("",key="model");
// #XSN4 @SET-SYMBOL $S_sar8j_r1_sw_b4;
// #XSN4 @PLACE(152,12) => @ORIENT("R0");
// &"BN4" @WIRE(mode="straight",linecolor="#30485d",linewidth=0.16) {#CMOMN4:2 (152,32) (152,24) #XSN4:1};
// #CMOMN5 @SET-SYMBOL $CAPACITOR;
// #CMOMN5 @PLACE(190,34) => @ORIENT("R0");
// #CMOMN5 @TEXT("CMOMN5",key="name",size=1.3,halign="start") => @PLACE(193,37);
// #CMOMN5 @TEXT("nr=8 lr=2u w=50n multi=32",key="value",size=0.9,halign="start") => @PLACE(193,30);
// #CMOMN5 @TEXT("",key="model");
// #XSN5 @SET-SYMBOL $S_sar8j_r1_sw_b5;
// #XSN5 @PLACE(190,12) => @ORIENT("R0");
// &"BN5" @WIRE(mode="straight",linecolor="#30485d",linewidth=0.16) {#CMOMN5:2 (190,32) (190,24) #XSN5:1};
// #CMOMN6 @SET-SYMBOL $CAPACITOR;
// #CMOMN6 @PLACE(228,34) => @ORIENT("R0");
// #CMOMN6 @TEXT("CMOMN6",key="name",size=1.3,halign="start") => @PLACE(231,37);
// #CMOMN6 @TEXT("nr=8 lr=2u w=50n multi=64",key="value",size=0.9,halign="start") => @PLACE(231,30);
// #CMOMN6 @TEXT("",key="model");
// #XSN6 @SET-SYMBOL $S_sar8j_r1_sw_b6;
// #XSN6 @PLACE(228,12) => @ORIENT("R0");
// &"BN6" @WIRE(mode="straight",linecolor="#30485d",linewidth=0.16) {#CMOMN6:2 (228,32) (228,24) #XSN6:1};
// #CMOMN7 @SET-SYMBOL $CAPACITOR;
// #CMOMN7 @PLACE(266,34) => @ORIENT("R0");
// #CMOMN7 @TEXT("CMOMN7",key="name",size=1.3,halign="start") => @PLACE(269,37);
// #CMOMN7 @TEXT("nr=8 lr=2u w=50n multi=128",key="value",size=0.9,halign="start") => @PLACE(269,30);
// #CMOMN7 @TEXT("",key="model");
// #XSN7 @SET-SYMBOL $S_sar8j_r1_sw_b7;
// #XSN7 @PLACE(266,12) => @ORIENT("R0");
// &"BN7" @WIRE(mode="straight",linecolor="#30485d",linewidth=0.16) {#CMOMN7:2 (266,32) (266,24) #XSN7:1};
// #CMOMN8 @SET-SYMBOL $CAPACITOR;
// #CMOMN8 @PLACE(304,34) => @ORIENT("R0");
// #CMOMN8 @TEXT("CMOMN8",key="name",size=1.3,halign="start") => @PLACE(307,37);
// #CMOMN8 @TEXT("nr=8 lr=2u w=50n multi=1",key="value",size=0.9,halign="start") => @PLACE(307,30);
// #CMOMN8 @TEXT("",key="model");
// &"TOPN" @WIRE(mode="straight",linecolor="#226e85",linewidth=0.16) {(0,46) (38,46) (76,46) (114,46) (152,46) (190,46) (228,46) (266,46) (304,46)};
// &"TOPN" @WIRE(mode="straight",linecolor="#226e85",linewidth=0.16) {#CMOMN0:1 (0,46)};
// $JUNCTION @ATTACH (0,46);
// &"TOPN" @WIRE(mode="straight",linecolor="#226e85",linewidth=0.16) {#CMOMN1:1 (38,46)};
// $JUNCTION @ATTACH (38,46);
// &"TOPN" @WIRE(mode="straight",linecolor="#226e85",linewidth=0.16) {#CMOMN2:1 (76,46)};
// $JUNCTION @ATTACH (76,46);
// &"TOPN" @WIRE(mode="straight",linecolor="#226e85",linewidth=0.16) {#CMOMN3:1 (114,46)};
// $JUNCTION @ATTACH (114,46);
// &"TOPN" @WIRE(mode="straight",linecolor="#226e85",linewidth=0.16) {#CMOMN4:1 (152,46)};
// $JUNCTION @ATTACH (152,46);
// &"TOPN" @WIRE(mode="straight",linecolor="#226e85",linewidth=0.16) {#CMOMN5:1 (190,46)};
// $JUNCTION @ATTACH (190,46);
// &"TOPN" @WIRE(mode="straight",linecolor="#226e85",linewidth=0.16) {#CMOMN6:1 (228,46)};
// $JUNCTION @ATTACH (228,46);
// &"TOPN" @WIRE(mode="straight",linecolor="#226e85",linewidth=0.16) {#CMOMN7:1 (266,46)};
// $JUNCTION @ATTACH (266,46);
// &"TOPN" @WIRE(mode="straight",linecolor="#226e85",linewidth=0.16) {#CMOMN8:1 (304,46)};
// $JUNCTION @ATTACH (304,46);
// (-15,54) @TEXT("TOPN / negative bank",size=1.2,halign="start",textcolor="#223d52");
// (289,16) @TEXT("Dummy -> VREFN",size=1,halign="start",textcolor="#223d52");
// #CMOMP0 @SET-SYMBOL $CAPACITOR;
// #CMOMP0 @PLACE(0,-32) => @ORIENT("R0");
// #CMOMP0 @TEXT("CMOMP0",key="name",size=1.3,halign="start") => @PLACE(3,-29);
// #CMOMP0 @TEXT("nr=8 lr=2u w=50n multi=1",key="value",size=0.9,halign="start") => @PLACE(3,-36);
// #CMOMP0 @TEXT("",key="model");
// #XSP0 @SET-SYMBOL $S_sar8j_r1_sw_b0;
// #XSP0 @PLACE(0,-54) => @ORIENT("R0");
// &"BP0" @WIRE(mode="straight",linecolor="#30485d",linewidth=0.16) {#CMOMP0:2 (0,-34) (0,-42) #XSP0:1};
// #CMOMP1 @SET-SYMBOL $CAPACITOR;
// #CMOMP1 @PLACE(38,-32) => @ORIENT("R0");
// #CMOMP1 @TEXT("CMOMP1",key="name",size=1.3,halign="start") => @PLACE(41,-29);
// #CMOMP1 @TEXT("nr=8 lr=2u w=50n multi=2",key="value",size=0.9,halign="start") => @PLACE(41,-36);
// #CMOMP1 @TEXT("",key="model");
// #XSP1 @SET-SYMBOL $S_sar8j_r1_sw_b1;
// #XSP1 @PLACE(38,-54) => @ORIENT("R0");
// &"BP1" @WIRE(mode="straight",linecolor="#30485d",linewidth=0.16) {#CMOMP1:2 (38,-34) (38,-42) #XSP1:1};
// #CMOMP2 @SET-SYMBOL $CAPACITOR;
// #CMOMP2 @PLACE(76,-32) => @ORIENT("R0");
// #CMOMP2 @TEXT("CMOMP2",key="name",size=1.3,halign="start") => @PLACE(79,-29);
// #CMOMP2 @TEXT("nr=8 lr=2u w=50n multi=4",key="value",size=0.9,halign="start") => @PLACE(79,-36);
// #CMOMP2 @TEXT("",key="model");
// #XSP2 @SET-SYMBOL $S_sar8j_r1_sw_b2;
// #XSP2 @PLACE(76,-54) => @ORIENT("R0");
// &"BP2" @WIRE(mode="straight",linecolor="#30485d",linewidth=0.16) {#CMOMP2:2 (76,-34) (76,-42) #XSP2:1};
// #CMOMP3 @SET-SYMBOL $CAPACITOR;
// #CMOMP3 @PLACE(114,-32) => @ORIENT("R0");
// #CMOMP3 @TEXT("CMOMP3",key="name",size=1.3,halign="start") => @PLACE(117,-29);
// #CMOMP3 @TEXT("nr=8 lr=2u w=50n multi=8",key="value",size=0.9,halign="start") => @PLACE(117,-36);
// #CMOMP3 @TEXT("",key="model");
// #XSP3 @SET-SYMBOL $S_sar8j_r1_sw_b3;
// #XSP3 @PLACE(114,-54) => @ORIENT("R0");
// &"BP3" @WIRE(mode="straight",linecolor="#30485d",linewidth=0.16) {#CMOMP3:2 (114,-34) (114,-42) #XSP3:1};
// #CMOMP4 @SET-SYMBOL $CAPACITOR;
// #CMOMP4 @PLACE(152,-32) => @ORIENT("R0");
// #CMOMP4 @TEXT("CMOMP4",key="name",size=1.3,halign="start") => @PLACE(155,-29);
// #CMOMP4 @TEXT("nr=8 lr=2u w=50n multi=16",key="value",size=0.9,halign="start") => @PLACE(155,-36);
// #CMOMP4 @TEXT("",key="model");
// #XSP4 @SET-SYMBOL $S_sar8j_r1_sw_b4;
// #XSP4 @PLACE(152,-54) => @ORIENT("R0");
// &"BP4" @WIRE(mode="straight",linecolor="#30485d",linewidth=0.16) {#CMOMP4:2 (152,-34) (152,-42) #XSP4:1};
// #CMOMP5 @SET-SYMBOL $CAPACITOR;
// #CMOMP5 @PLACE(190,-32) => @ORIENT("R0");
// #CMOMP5 @TEXT("CMOMP5",key="name",size=1.3,halign="start") => @PLACE(193,-29);
// #CMOMP5 @TEXT("nr=8 lr=2u w=50n multi=32",key="value",size=0.9,halign="start") => @PLACE(193,-36);
// #CMOMP5 @TEXT("",key="model");
// #XSP5 @SET-SYMBOL $S_sar8j_r1_sw_b5;
// #XSP5 @PLACE(190,-54) => @ORIENT("R0");
// &"BP5" @WIRE(mode="straight",linecolor="#30485d",linewidth=0.16) {#CMOMP5:2 (190,-34) (190,-42) #XSP5:1};
// #CMOMP6 @SET-SYMBOL $CAPACITOR;
// #CMOMP6 @PLACE(228,-32) => @ORIENT("R0");
// #CMOMP6 @TEXT("CMOMP6",key="name",size=1.3,halign="start") => @PLACE(231,-29);
// #CMOMP6 @TEXT("nr=8 lr=2u w=50n multi=64",key="value",size=0.9,halign="start") => @PLACE(231,-36);
// #CMOMP6 @TEXT("",key="model");
// #XSP6 @SET-SYMBOL $S_sar8j_r1_sw_b6;
// #XSP6 @PLACE(228,-54) => @ORIENT("R0");
// &"BP6" @WIRE(mode="straight",linecolor="#30485d",linewidth=0.16) {#CMOMP6:2 (228,-34) (228,-42) #XSP6:1};
// #CMOMP7 @SET-SYMBOL $CAPACITOR;
// #CMOMP7 @PLACE(266,-32) => @ORIENT("R0");
// #CMOMP7 @TEXT("CMOMP7",key="name",size=1.3,halign="start") => @PLACE(269,-29);
// #CMOMP7 @TEXT("nr=8 lr=2u w=50n multi=128",key="value",size=0.9,halign="start") => @PLACE(269,-36);
// #CMOMP7 @TEXT("",key="model");
// #XSP7 @SET-SYMBOL $S_sar8j_r1_sw_b7;
// #XSP7 @PLACE(266,-54) => @ORIENT("R0");
// &"BP7" @WIRE(mode="straight",linecolor="#30485d",linewidth=0.16) {#CMOMP7:2 (266,-34) (266,-42) #XSP7:1};
// #CMOMP8 @SET-SYMBOL $CAPACITOR;
// #CMOMP8 @PLACE(304,-32) => @ORIENT("R0");
// #CMOMP8 @TEXT("CMOMP8",key="name",size=1.3,halign="start") => @PLACE(307,-29);
// #CMOMP8 @TEXT("nr=8 lr=2u w=50n multi=1",key="value",size=0.9,halign="start") => @PLACE(307,-36);
// #CMOMP8 @TEXT("",key="model");
// &"TOPP" @WIRE(mode="straight",linecolor="#226e85",linewidth=0.16) {(0,-20) (38,-20) (76,-20) (114,-20) (152,-20) (190,-20) (228,-20) (266,-20) (304,-20)};
// &"TOPP" @WIRE(mode="straight",linecolor="#226e85",linewidth=0.16) {#CMOMP0:1 (0,-20)};
// $JUNCTION @ATTACH (0,-20);
// &"TOPP" @WIRE(mode="straight",linecolor="#226e85",linewidth=0.16) {#CMOMP1:1 (38,-20)};
// $JUNCTION @ATTACH (38,-20);
// &"TOPP" @WIRE(mode="straight",linecolor="#226e85",linewidth=0.16) {#CMOMP2:1 (76,-20)};
// $JUNCTION @ATTACH (76,-20);
// &"TOPP" @WIRE(mode="straight",linecolor="#226e85",linewidth=0.16) {#CMOMP3:1 (114,-20)};
// $JUNCTION @ATTACH (114,-20);
// &"TOPP" @WIRE(mode="straight",linecolor="#226e85",linewidth=0.16) {#CMOMP4:1 (152,-20)};
// $JUNCTION @ATTACH (152,-20);
// &"TOPP" @WIRE(mode="straight",linecolor="#226e85",linewidth=0.16) {#CMOMP5:1 (190,-20)};
// $JUNCTION @ATTACH (190,-20);
// &"TOPP" @WIRE(mode="straight",linecolor="#226e85",linewidth=0.16) {#CMOMP6:1 (228,-20)};
// $JUNCTION @ATTACH (228,-20);
// &"TOPP" @WIRE(mode="straight",linecolor="#226e85",linewidth=0.16) {#CMOMP7:1 (266,-20)};
// $JUNCTION @ATTACH (266,-20);
// &"TOPP" @WIRE(mode="straight",linecolor="#226e85",linewidth=0.16) {#CMOMP8:1 (304,-20)};
// $JUNCTION @ATTACH (304,-20);
// (-15,-12) @TEXT("TOPP / positive bank",size=1.2,halign="start",textcolor="#223d52");
// (289,-50) @TEXT("Dummy -> VREFP",size=1,halign="start",textcolor="#223d52");
// &"VREFN" @WIRE(mode="straight",linecolor="#30485d",linewidth=0.16) {#CMOMN8:2 (304,29)};
// (304,28.6) @TEXT("VREFN",size=1.1,halign="middle",valign="top");
// &"VREFP" @WIRE(mode="straight",linecolor="#30485d",linewidth=0.16) {#CMOMP8:2 (304,-37)};
// (304,-37.4) @TEXT("VREFP",size=1.1,halign="middle",valign="top");
// &"REFSEL_N0" @WIRE(mode="straight",linecolor="#30485d",linewidth=0.16) {#XSN0:2 (0,-3)};
// (0,-3.4) @TEXT("REFSEL_N0",size=1.1,halign="middle",valign="top");
// &"VDD" @WIRE(mode="straight",linecolor="#30485d",linewidth=0.16) {#XSN0:3 (14,16)};
// (14.4,16) @TEXT("VDD",size=1.1,halign="start",valign="middle");
// &"VREFN" @WIRE(mode="straight",linecolor="#30485d",linewidth=0.16) {#XSN0:4 (-14,8)};
// (-14.4,8) @TEXT("VREFN",size=1.1,halign="end",valign="middle");
// &"VREFP" @WIRE(mode="straight",linecolor="#30485d",linewidth=0.16) {#XSN0:5 (-14,16)};
// (-14.4,16) @TEXT("VREFP",size=1.1,halign="end",valign="middle");
// &"VSS" @WIRE(mode="straight",linecolor="#30485d",linewidth=0.16) {#XSN0:6 (14,8)};
// (14.4,8) @TEXT("VSS",size=1.1,halign="start",valign="middle");
// &"REFSEL_P0" @WIRE(mode="straight",linecolor="#30485d",linewidth=0.16) {#XSP0:2 (0,-69)};
// (0,-69.4) @TEXT("REFSEL_P0",size=1.1,halign="middle",valign="top");
// &"VDD" @WIRE(mode="straight",linecolor="#30485d",linewidth=0.16) {#XSP0:3 (14,-50)};
// (14.4,-50) @TEXT("VDD",size=1.1,halign="start",valign="middle");
// &"VREFN" @WIRE(mode="straight",linecolor="#30485d",linewidth=0.16) {#XSP0:4 (-14,-58)};
// (-14.4,-58) @TEXT("VREFN",size=1.1,halign="end",valign="middle");
// &"VREFP" @WIRE(mode="straight",linecolor="#30485d",linewidth=0.16) {#XSP0:5 (-14,-50)};
// (-14.4,-50) @TEXT("VREFP",size=1.1,halign="end",valign="middle");
// &"VSS" @WIRE(mode="straight",linecolor="#30485d",linewidth=0.16) {#XSP0:6 (14,-58)};
// (14.4,-58) @TEXT("VSS",size=1.1,halign="start",valign="middle");
// &"REFSEL_N1" @WIRE(mode="straight",linecolor="#30485d",linewidth=0.16) {#XSN1:2 (38,-3)};
// (38,-3.4) @TEXT("REFSEL_N1",size=1.1,halign="middle",valign="top");
// &"VDD" @WIRE(mode="straight",linecolor="#30485d",linewidth=0.16) {#XSN1:3 (52,16)};
// (52.4,16) @TEXT("VDD",size=1.1,halign="start",valign="middle");
// &"VREFN" @WIRE(mode="straight",linecolor="#30485d",linewidth=0.16) {#XSN1:4 (24,8)};
// (23.6,8) @TEXT("VREFN",size=1.1,halign="end",valign="middle");
// &"VREFP" @WIRE(mode="straight",linecolor="#30485d",linewidth=0.16) {#XSN1:5 (24,16)};
// (23.6,16) @TEXT("VREFP",size=1.1,halign="end",valign="middle");
// &"VSS" @WIRE(mode="straight",linecolor="#30485d",linewidth=0.16) {#XSN1:6 (52,8)};
// (52.4,8) @TEXT("VSS",size=1.1,halign="start",valign="middle");
// &"REFSEL_P1" @WIRE(mode="straight",linecolor="#30485d",linewidth=0.16) {#XSP1:2 (38,-69)};
// (38,-69.4) @TEXT("REFSEL_P1",size=1.1,halign="middle",valign="top");
// &"VDD" @WIRE(mode="straight",linecolor="#30485d",linewidth=0.16) {#XSP1:3 (52,-50)};
// (52.4,-50) @TEXT("VDD",size=1.1,halign="start",valign="middle");
// &"VREFN" @WIRE(mode="straight",linecolor="#30485d",linewidth=0.16) {#XSP1:4 (24,-58)};
// (23.6,-58) @TEXT("VREFN",size=1.1,halign="end",valign="middle");
// &"VREFP" @WIRE(mode="straight",linecolor="#30485d",linewidth=0.16) {#XSP1:5 (24,-50)};
// (23.6,-50) @TEXT("VREFP",size=1.1,halign="end",valign="middle");
// &"VSS" @WIRE(mode="straight",linecolor="#30485d",linewidth=0.16) {#XSP1:6 (52,-58)};
// (52.4,-58) @TEXT("VSS",size=1.1,halign="start",valign="middle");
// &"REFSEL_N2" @WIRE(mode="straight",linecolor="#30485d",linewidth=0.16) {#XSN2:2 (76,-3)};
// (76,-3.4) @TEXT("REFSEL_N2",size=1.1,halign="middle",valign="top");
// &"VDD" @WIRE(mode="straight",linecolor="#30485d",linewidth=0.16) {#XSN2:3 (90,16)};
// (90.4,16) @TEXT("VDD",size=1.1,halign="start",valign="middle");
// &"VREFN" @WIRE(mode="straight",linecolor="#30485d",linewidth=0.16) {#XSN2:4 (62,8)};
// (61.6,8) @TEXT("VREFN",size=1.1,halign="end",valign="middle");
// &"VREFP" @WIRE(mode="straight",linecolor="#30485d",linewidth=0.16) {#XSN2:5 (62,16)};
// (61.6,16) @TEXT("VREFP",size=1.1,halign="end",valign="middle");
// &"VSS" @WIRE(mode="straight",linecolor="#30485d",linewidth=0.16) {#XSN2:6 (90,8)};
// (90.4,8) @TEXT("VSS",size=1.1,halign="start",valign="middle");
// &"REFSEL_P2" @WIRE(mode="straight",linecolor="#30485d",linewidth=0.16) {#XSP2:2 (76,-69)};
// (76,-69.4) @TEXT("REFSEL_P2",size=1.1,halign="middle",valign="top");
// &"VDD" @WIRE(mode="straight",linecolor="#30485d",linewidth=0.16) {#XSP2:3 (90,-50)};
// (90.4,-50) @TEXT("VDD",size=1.1,halign="start",valign="middle");
// &"VREFN" @WIRE(mode="straight",linecolor="#30485d",linewidth=0.16) {#XSP2:4 (62,-58)};
// (61.6,-58) @TEXT("VREFN",size=1.1,halign="end",valign="middle");
// &"VREFP" @WIRE(mode="straight",linecolor="#30485d",linewidth=0.16) {#XSP2:5 (62,-50)};
// (61.6,-50) @TEXT("VREFP",size=1.1,halign="end",valign="middle");
// &"VSS" @WIRE(mode="straight",linecolor="#30485d",linewidth=0.16) {#XSP2:6 (90,-58)};
// (90.4,-58) @TEXT("VSS",size=1.1,halign="start",valign="middle");
// &"REFSEL_N3" @WIRE(mode="straight",linecolor="#30485d",linewidth=0.16) {#XSN3:2 (114,-3)};
// (114,-3.4) @TEXT("REFSEL_N3",size=1.1,halign="middle",valign="top");
// &"VDD" @WIRE(mode="straight",linecolor="#30485d",linewidth=0.16) {#XSN3:3 (128,16)};
// (128.4,16) @TEXT("VDD",size=1.1,halign="start",valign="middle");
// &"VREFN" @WIRE(mode="straight",linecolor="#30485d",linewidth=0.16) {#XSN3:4 (100,8)};
// (99.6,8) @TEXT("VREFN",size=1.1,halign="end",valign="middle");
// &"VREFP" @WIRE(mode="straight",linecolor="#30485d",linewidth=0.16) {#XSN3:5 (100,16)};
// (99.6,16) @TEXT("VREFP",size=1.1,halign="end",valign="middle");
// &"VSS" @WIRE(mode="straight",linecolor="#30485d",linewidth=0.16) {#XSN3:6 (128,8)};
// (128.4,8) @TEXT("VSS",size=1.1,halign="start",valign="middle");
// &"REFSEL_P3" @WIRE(mode="straight",linecolor="#30485d",linewidth=0.16) {#XSP3:2 (114,-69)};
// (114,-69.4) @TEXT("REFSEL_P3",size=1.1,halign="middle",valign="top");
// &"VDD" @WIRE(mode="straight",linecolor="#30485d",linewidth=0.16) {#XSP3:3 (128,-50)};
// (128.4,-50) @TEXT("VDD",size=1.1,halign="start",valign="middle");
// &"VREFN" @WIRE(mode="straight",linecolor="#30485d",linewidth=0.16) {#XSP3:4 (100,-58)};
// (99.6,-58) @TEXT("VREFN",size=1.1,halign="end",valign="middle");
// &"VREFP" @WIRE(mode="straight",linecolor="#30485d",linewidth=0.16) {#XSP3:5 (100,-50)};
// (99.6,-50) @TEXT("VREFP",size=1.1,halign="end",valign="middle");
// &"VSS" @WIRE(mode="straight",linecolor="#30485d",linewidth=0.16) {#XSP3:6 (128,-58)};
// (128.4,-58) @TEXT("VSS",size=1.1,halign="start",valign="middle");
// &"REFSEL_N4" @WIRE(mode="straight",linecolor="#30485d",linewidth=0.16) {#XSN4:2 (152,-3)};
// (152,-3.4) @TEXT("REFSEL_N4",size=1.1,halign="middle",valign="top");
// &"VDD" @WIRE(mode="straight",linecolor="#30485d",linewidth=0.16) {#XSN4:3 (166,16)};
// (166.4,16) @TEXT("VDD",size=1.1,halign="start",valign="middle");
// &"VREFN" @WIRE(mode="straight",linecolor="#30485d",linewidth=0.16) {#XSN4:4 (138,8)};
// (137.6,8) @TEXT("VREFN",size=1.1,halign="end",valign="middle");
// &"VREFP" @WIRE(mode="straight",linecolor="#30485d",linewidth=0.16) {#XSN4:5 (138,16)};
// (137.6,16) @TEXT("VREFP",size=1.1,halign="end",valign="middle");
// &"VSS" @WIRE(mode="straight",linecolor="#30485d",linewidth=0.16) {#XSN4:6 (166,8)};
// (166.4,8) @TEXT("VSS",size=1.1,halign="start",valign="middle");
// &"REFSEL_P4" @WIRE(mode="straight",linecolor="#30485d",linewidth=0.16) {#XSP4:2 (152,-69)};
// (152,-69.4) @TEXT("REFSEL_P4",size=1.1,halign="middle",valign="top");
// &"VDD" @WIRE(mode="straight",linecolor="#30485d",linewidth=0.16) {#XSP4:3 (166,-50)};
// (166.4,-50) @TEXT("VDD",size=1.1,halign="start",valign="middle");
// &"VREFN" @WIRE(mode="straight",linecolor="#30485d",linewidth=0.16) {#XSP4:4 (138,-58)};
// (137.6,-58) @TEXT("VREFN",size=1.1,halign="end",valign="middle");
// &"VREFP" @WIRE(mode="straight",linecolor="#30485d",linewidth=0.16) {#XSP4:5 (138,-50)};
// (137.6,-50) @TEXT("VREFP",size=1.1,halign="end",valign="middle");
// &"VSS" @WIRE(mode="straight",linecolor="#30485d",linewidth=0.16) {#XSP4:6 (166,-58)};
// (166.4,-58) @TEXT("VSS",size=1.1,halign="start",valign="middle");
// &"REFSEL_N5" @WIRE(mode="straight",linecolor="#30485d",linewidth=0.16) {#XSN5:2 (190,-3)};
// (190,-3.4) @TEXT("REFSEL_N5",size=1.1,halign="middle",valign="top");
// &"VDD" @WIRE(mode="straight",linecolor="#30485d",linewidth=0.16) {#XSN5:3 (204,16)};
// (204.4,16) @TEXT("VDD",size=1.1,halign="start",valign="middle");
// &"VREFN" @WIRE(mode="straight",linecolor="#30485d",linewidth=0.16) {#XSN5:4 (176,8)};
// (175.6,8) @TEXT("VREFN",size=1.1,halign="end",valign="middle");
// &"VREFP" @WIRE(mode="straight",linecolor="#30485d",linewidth=0.16) {#XSN5:5 (176,16)};
// (175.6,16) @TEXT("VREFP",size=1.1,halign="end",valign="middle");
// &"VSS" @WIRE(mode="straight",linecolor="#30485d",linewidth=0.16) {#XSN5:6 (204,8)};
// (204.4,8) @TEXT("VSS",size=1.1,halign="start",valign="middle");
// &"REFSEL_P5" @WIRE(mode="straight",linecolor="#30485d",linewidth=0.16) {#XSP5:2 (190,-69)};
// (190,-69.4) @TEXT("REFSEL_P5",size=1.1,halign="middle",valign="top");
// &"VDD" @WIRE(mode="straight",linecolor="#30485d",linewidth=0.16) {#XSP5:3 (204,-50)};
// (204.4,-50) @TEXT("VDD",size=1.1,halign="start",valign="middle");
// &"VREFN" @WIRE(mode="straight",linecolor="#30485d",linewidth=0.16) {#XSP5:4 (176,-58)};
// (175.6,-58) @TEXT("VREFN",size=1.1,halign="end",valign="middle");
// &"VREFP" @WIRE(mode="straight",linecolor="#30485d",linewidth=0.16) {#XSP5:5 (176,-50)};
// (175.6,-50) @TEXT("VREFP",size=1.1,halign="end",valign="middle");
// &"VSS" @WIRE(mode="straight",linecolor="#30485d",linewidth=0.16) {#XSP5:6 (204,-58)};
// (204.4,-58) @TEXT("VSS",size=1.1,halign="start",valign="middle");
// &"REFSEL_N6" @WIRE(mode="straight",linecolor="#30485d",linewidth=0.16) {#XSN6:2 (228,-3)};
// (228,-3.4) @TEXT("REFSEL_N6",size=1.1,halign="middle",valign="top");
// &"VDD" @WIRE(mode="straight",linecolor="#30485d",linewidth=0.16) {#XSN6:3 (242,16)};
// (242.4,16) @TEXT("VDD",size=1.1,halign="start",valign="middle");
// &"VREFN" @WIRE(mode="straight",linecolor="#30485d",linewidth=0.16) {#XSN6:4 (214,8)};
// (213.6,8) @TEXT("VREFN",size=1.1,halign="end",valign="middle");
// &"VREFP" @WIRE(mode="straight",linecolor="#30485d",linewidth=0.16) {#XSN6:5 (214,16)};
// (213.6,16) @TEXT("VREFP",size=1.1,halign="end",valign="middle");
// &"VSS" @WIRE(mode="straight",linecolor="#30485d",linewidth=0.16) {#XSN6:6 (242,8)};
// (242.4,8) @TEXT("VSS",size=1.1,halign="start",valign="middle");
// &"REFSEL_P6" @WIRE(mode="straight",linecolor="#30485d",linewidth=0.16) {#XSP6:2 (228,-69)};
// (228,-69.4) @TEXT("REFSEL_P6",size=1.1,halign="middle",valign="top");
// &"VDD" @WIRE(mode="straight",linecolor="#30485d",linewidth=0.16) {#XSP6:3 (242,-50)};
// (242.4,-50) @TEXT("VDD",size=1.1,halign="start",valign="middle");
// &"VREFN" @WIRE(mode="straight",linecolor="#30485d",linewidth=0.16) {#XSP6:4 (214,-58)};
// (213.6,-58) @TEXT("VREFN",size=1.1,halign="end",valign="middle");
// &"VREFP" @WIRE(mode="straight",linecolor="#30485d",linewidth=0.16) {#XSP6:5 (214,-50)};
// (213.6,-50) @TEXT("VREFP",size=1.1,halign="end",valign="middle");
// &"VSS" @WIRE(mode="straight",linecolor="#30485d",linewidth=0.16) {#XSP6:6 (242,-58)};
// (242.4,-58) @TEXT("VSS",size=1.1,halign="start",valign="middle");
// &"REFSEL_N7" @WIRE(mode="straight",linecolor="#30485d",linewidth=0.16) {#XSN7:2 (266,-3)};
// (266,-3.4) @TEXT("REFSEL_N7",size=1.1,halign="middle",valign="top");
// &"VDD" @WIRE(mode="straight",linecolor="#30485d",linewidth=0.16) {#XSN7:3 (280,16)};
// (280.4,16) @TEXT("VDD",size=1.1,halign="start",valign="middle");
// &"VREFN" @WIRE(mode="straight",linecolor="#30485d",linewidth=0.16) {#XSN7:4 (252,8)};
// (251.6,8) @TEXT("VREFN",size=1.1,halign="end",valign="middle");
// &"VREFP" @WIRE(mode="straight",linecolor="#30485d",linewidth=0.16) {#XSN7:5 (252,16)};
// (251.6,16) @TEXT("VREFP",size=1.1,halign="end",valign="middle");
// &"VSS" @WIRE(mode="straight",linecolor="#30485d",linewidth=0.16) {#XSN7:6 (280,8)};
// (280.4,8) @TEXT("VSS",size=1.1,halign="start",valign="middle");
// &"REFSEL_P7" @WIRE(mode="straight",linecolor="#30485d",linewidth=0.16) {#XSP7:2 (266,-69)};
// (266,-69.4) @TEXT("REFSEL_P7",size=1.1,halign="middle",valign="top");
// &"VDD" @WIRE(mode="straight",linecolor="#30485d",linewidth=0.16) {#XSP7:3 (280,-50)};
// (280.4,-50) @TEXT("VDD",size=1.1,halign="start",valign="middle");
// &"VREFN" @WIRE(mode="straight",linecolor="#30485d",linewidth=0.16) {#XSP7:4 (252,-58)};
// (251.6,-58) @TEXT("VREFN",size=1.1,halign="end",valign="middle");
// &"VREFP" @WIRE(mode="straight",linecolor="#30485d",linewidth=0.16) {#XSP7:5 (252,-50)};
// (251.6,-50) @TEXT("VREFP",size=1.1,halign="end",valign="middle");
// &"VSS" @WIRE(mode="straight",linecolor="#30485d",linewidth=0.16) {#XSP7:6 (280,-58)};
// (280.4,-58) @TEXT("VSS",size=1.1,halign="start",valign="middle");
// }
// END SARADC RNL
ends sar8j_r1_cdac
