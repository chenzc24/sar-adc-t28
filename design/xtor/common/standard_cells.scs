// Generated from frozen B by scripts/sar8_entry.py build.
// BEGIN SARADC RNL
// @RNL(type="header") { @VERSION("0.3");
// @USE-PACKAGE(name="sar8",version="0.1",path="../../rnl/sar8.rnl");
// @USE-PACKAGE(name="rnl-std-fill") {}; }
// END SARADC RNL
// Electrical subcircuit statements are preserved verbatim.

subckt sar8p_inv A VDD VSS Y
    XLIB (A Y VDD VSS) INVD1BWP12T30P140
// BEGIN SARADC RNL
// @RNL(author="saradc topology") {
// #XLIB @SET-SYMBOL $S_INVD1BWP12T30P140;
// #XLIB @PLACE(0,0) => @ORIENT("R0");
// (-16,46) @TEXT("sar8p_inv / native standard-cell composition",size=1.3,halign="start",textcolor="#223d52");
// &"A" @WIRE(mode="straight",linecolor="#30485d",linewidth=0.16) {#XLIB:1 (-10,0)};
// (-10.4,0) @TEXT("A",size=1.1,halign="end",valign="middle");
// &"Y" @WIRE(mode="straight",linecolor="#30485d",linewidth=0.16) {#XLIB:2 (10,0)};
// (10.4,0) @TEXT("Y",size=1.1,halign="start",valign="middle");
// &"VDD" @WIRE(mode="straight",linecolor="#30485d",linewidth=0.16) {#XLIB:3 (0,10)};
// (0,10.4) @TEXT("VDD",size=1.1,halign="middle",valign="bottom");
// &"VSS" @WIRE(mode="straight",linecolor="#30485d",linewidth=0.16) {#XLIB:4 (0,-10)};
// (0,-10.4) @TEXT("VSS",size=1.1,halign="middle",valign="top");
// }
// END SARADC RNL
ends sar8p_inv

subckt sar8p_clkbuf A VDD VSS Y
    X000 (A VDD VSS AB) sar8p_inv
    XFINAL (AB VDD VSS Y) sar8p_inv
// BEGIN SARADC RNL
// @RNL(author="saradc topology") {
// #X000 @SET-SYMBOL $S_sar8p_inv;
// #X000 @PLACE(0,0) => @ORIENT("R0");
// #XFINAL @SET-SYMBOL $S_sar8p_inv;
// #XFINAL @PLACE(34,0) => @ORIENT("R0");
// &"AB" @WIRE(mode="straight",linecolor="#30485d",linewidth=0.16) {#X000:4 (17,0) (17,0) #XFINAL:1};
// (-16,46) @TEXT("sar8p_clkbuf / native standard-cell composition",size=1.3,halign="start",textcolor="#223d52");
// &"A" @WIRE(mode="straight",linecolor="#30485d",linewidth=0.16) {#X000:1 (-10,0)};
// (-10.4,0) @TEXT("A",size=1.1,halign="end",valign="middle");
// &"VDD" @WIRE(mode="straight",linecolor="#30485d",linewidth=0.16) {#X000:2 (0,10)};
// (0,10.4) @TEXT("VDD",size=1.1,halign="middle",valign="bottom");
// &"VSS" @WIRE(mode="straight",linecolor="#30485d",linewidth=0.16) {#X000:3 (0,-10)};
// (0,-10.4) @TEXT("VSS",size=1.1,halign="middle",valign="top");
// &"VDD" @WIRE(mode="straight",linecolor="#30485d",linewidth=0.16) {#XFINAL:2 (34,10)};
// (34,10.4) @TEXT("VDD",size=1.1,halign="middle",valign="bottom");
// &"VSS" @WIRE(mode="straight",linecolor="#30485d",linewidth=0.16) {#XFINAL:3 (34,-10)};
// (34,-10.4) @TEXT("VSS",size=1.1,halign="middle",valign="top");
// &"Y" @WIRE(mode="straight",linecolor="#30485d",linewidth=0.16) {#XFINAL:4 (44,0)};
// (44.4,0) @TEXT("Y",size=1.1,halign="start",valign="middle");
// }
// END SARADC RNL
ends sar8p_clkbuf

subckt sar8p_nand2 A B VDD VSS Y
    XLIB (A B Y VDD VSS) ND2D1BWP12T30P140
// BEGIN SARADC RNL
// @RNL(author="saradc topology") {
// #XLIB @SET-SYMBOL $S_ND2D1BWP12T30P140;
// #XLIB @PLACE(0,0) => @ORIENT("R0");
// (-16,46) @TEXT("sar8p_nand2 / native standard-cell composition",size=1.3,halign="start",textcolor="#223d52");
// &"A" @WIRE(mode="straight",linecolor="#30485d",linewidth=0.16) {#XLIB:1 (-10,1.7)};
// (-10.4,1.7) @TEXT("A",size=1.1,halign="end",valign="middle");
// &"B" @WIRE(mode="straight",linecolor="#30485d",linewidth=0.16) {#XLIB:2 (-10,-1.7)};
// (-10.4,-1.7) @TEXT("B",size=1.1,halign="end",valign="middle");
// &"Y" @WIRE(mode="straight",linecolor="#30485d",linewidth=0.16) {#XLIB:3 (10,0)};
// (10.4,0) @TEXT("Y",size=1.1,halign="start",valign="middle");
// &"VDD" @WIRE(mode="straight",linecolor="#30485d",linewidth=0.16) {#XLIB:4 (0,10)};
// (0,10.4) @TEXT("VDD",size=1.1,halign="middle",valign="bottom");
// &"VSS" @WIRE(mode="straight",linecolor="#30485d",linewidth=0.16) {#XLIB:5 (0,-10)};
// (0,-10.4) @TEXT("VSS",size=1.1,halign="middle",valign="top");
// }
// END SARADC RNL
ends sar8p_nand2

subckt sar8p_and2 A B VDD VSS Y
    X000 (A B VDD VSS N) sar8p_nand2
    X001 (N VDD VSS Y) sar8p_inv
// BEGIN SARADC RNL
// @RNL(author="saradc topology") {
// #X000 @SET-SYMBOL $S_sar8p_nand2;
// #X000 @PLACE(0,0) => @ORIENT("R0");
// #X001 @SET-SYMBOL $S_sar8p_inv;
// #X001 @PLACE(34,0) => @ORIENT("R0");
// &"N" @WIRE(mode="straight",linecolor="#30485d",linewidth=0.16) {#X000:5 (17,0) (17,0) #X001:1};
// (-16,46) @TEXT("sar8p_and2 / native standard-cell composition",size=1.3,halign="start",textcolor="#223d52");
// &"A" @WIRE(mode="straight",linecolor="#30485d",linewidth=0.16) {#X000:1 (-10,1.7)};
// (-10.4,1.7) @TEXT("A",size=1.1,halign="end",valign="middle");
// &"B" @WIRE(mode="straight",linecolor="#30485d",linewidth=0.16) {#X000:2 (-10,-1.7)};
// (-10.4,-1.7) @TEXT("B",size=1.1,halign="end",valign="middle");
// &"VDD" @WIRE(mode="straight",linecolor="#30485d",linewidth=0.16) {#X000:3 (0,10)};
// (0,10.4) @TEXT("VDD",size=1.1,halign="middle",valign="bottom");
// &"VSS" @WIRE(mode="straight",linecolor="#30485d",linewidth=0.16) {#X000:4 (0,-10)};
// (0,-10.4) @TEXT("VSS",size=1.1,halign="middle",valign="top");
// &"VDD" @WIRE(mode="straight",linecolor="#30485d",linewidth=0.16) {#X001:2 (34,10)};
// (34,10.4) @TEXT("VDD",size=1.1,halign="middle",valign="bottom");
// &"VSS" @WIRE(mode="straight",linecolor="#30485d",linewidth=0.16) {#X001:3 (34,-10)};
// (34,-10.4) @TEXT("VSS",size=1.1,halign="middle",valign="top");
// &"Y" @WIRE(mode="straight",linecolor="#30485d",linewidth=0.16) {#X001:4 (44,0)};
// (44.4,0) @TEXT("Y",size=1.1,halign="start",valign="middle");
// }
// END SARADC RNL
ends sar8p_and2

subckt sar8p_buf A VDD VSS Y
    X001 (N VDD VSS Y) sar8p_inv
    X000 (A VDD VSS N) sar8p_inv
// BEGIN SARADC RNL
// @RNL(author="saradc topology") {
// #X000 @SET-SYMBOL $S_sar8p_inv;
// #X000 @PLACE(0,0) => @ORIENT("R0");
// #X001 @SET-SYMBOL $S_sar8p_inv;
// #X001 @PLACE(34,0) => @ORIENT("R0");
// &"N" @WIRE(mode="straight",linecolor="#30485d",linewidth=0.16) {#X001:1 (17,0) (17,0) #X000:4};
// (-16,46) @TEXT("sar8p_buf / native standard-cell composition",size=1.3,halign="start",textcolor="#223d52");
// &"VDD" @WIRE(mode="straight",linecolor="#30485d",linewidth=0.16) {#X001:2 (34,10)};
// (34,10.4) @TEXT("VDD",size=1.1,halign="middle",valign="bottom");
// &"VSS" @WIRE(mode="straight",linecolor="#30485d",linewidth=0.16) {#X001:3 (34,-10)};
// (34,-10.4) @TEXT("VSS",size=1.1,halign="middle",valign="top");
// &"Y" @WIRE(mode="straight",linecolor="#30485d",linewidth=0.16) {#X001:4 (44,0)};
// (44.4,0) @TEXT("Y",size=1.1,halign="start",valign="middle");
// &"A" @WIRE(mode="straight",linecolor="#30485d",linewidth=0.16) {#X000:1 (-10,0)};
// (-10.4,0) @TEXT("A",size=1.1,halign="end",valign="middle");
// &"VDD" @WIRE(mode="straight",linecolor="#30485d",linewidth=0.16) {#X000:2 (0,10)};
// (0,10.4) @TEXT("VDD",size=1.1,halign="middle",valign="bottom");
// &"VSS" @WIRE(mode="straight",linecolor="#30485d",linewidth=0.16) {#X000:3 (0,-10)};
// (0,-10.4) @TEXT("VSS",size=1.1,halign="middle",valign="top");
// }
// END SARADC RNL
ends sar8p_buf

subckt sar8p_xor2 A B VDD VSS Y
    X003 (NA NB VDD VSS Y) sar8p_nand2
    X002 (B N VDD VSS NB) sar8p_nand2
    X001 (A N VDD VSS NA) sar8p_nand2
    X000 (A B VDD VSS N) sar8p_nand2
// BEGIN SARADC RNL
// @RNL(author="saradc topology") {
// #X000 @SET-SYMBOL $S_sar8p_nand2;
// #X000 @PLACE(0,0) => @ORIENT("R0");
// #X001 @SET-SYMBOL $S_sar8p_nand2;
// #X001 @PLACE(40,20) => @ORIENT("R0");
// #X002 @SET-SYMBOL $S_sar8p_nand2;
// #X002 @PLACE(40,-20) => @ORIENT("R0");
// #X003 @SET-SYMBOL $S_sar8p_nand2;
// #X003 @PLACE(80,0) => @ORIENT("R0");
// &"NA" @WIRE(mode="straight",linecolor="#30485d",linewidth=0.16) {#X003:1 (60,1.7) (60,20) #X001:5};
// &"NB" @WIRE(mode="straight",linecolor="#30485d",linewidth=0.16) {#X003:2 (60,-1.7) (60,-20) #X002:5};
// &"B" @WIRE(mode="straight",linecolor="#30485d",linewidth=0.16) {#X002:1 (13,-18.3) (13,-1.7) #X000:2};
// &"A" @WIRE(mode="straight",linecolor="#30485d",linewidth=0.16) {#X001:1 (13,21.7) (13,1.7) #X000:1};
// &"N" @WIRE(mode="straight",linecolor="#30485d",linewidth=0.16) {(2,-21.7) (2,0) (2,18.3)};
// &"N" @WIRE(mode="straight",linecolor="#30485d",linewidth=0.16) {#X002:2 (2,-21.7)};
// $JUNCTION @ATTACH (2,-21.7);
// &"N" @WIRE(mode="straight",linecolor="#30485d",linewidth=0.16) {#X001:2 (2,18.3)};
// $JUNCTION @ATTACH (2,18.3);
// &"N" @WIRE(mode="straight",linecolor="#30485d",linewidth=0.16) {#X000:5 (2,0)};
// $JUNCTION @ATTACH (2,0);
// (-16,46) @TEXT("sar8p_xor2 / native standard-cell composition",size=1.3,halign="start",textcolor="#223d52");
// &"VDD" @WIRE(mode="straight",linecolor="#30485d",linewidth=0.16) {#X003:3 (80,10)};
// (80,10.4) @TEXT("VDD",size=1.1,halign="middle",valign="bottom");
// &"VSS" @WIRE(mode="straight",linecolor="#30485d",linewidth=0.16) {#X003:4 (80,-10)};
// (80,-10.4) @TEXT("VSS",size=1.1,halign="middle",valign="top");
// &"Y" @WIRE(mode="straight",linecolor="#30485d",linewidth=0.16) {#X003:5 (90,0)};
// (90.4,0) @TEXT("Y",size=1.1,halign="start",valign="middle");
// &"VDD" @WIRE(mode="straight",linecolor="#30485d",linewidth=0.16) {#X002:3 (40,-10)};
// (40,-9.6) @TEXT("VDD",size=1.1,halign="middle",valign="bottom");
// &"VSS" @WIRE(mode="straight",linecolor="#30485d",linewidth=0.16) {#X002:4 (40,-30)};
// (40,-30.4) @TEXT("VSS",size=1.1,halign="middle",valign="top");
// &"VDD" @WIRE(mode="straight",linecolor="#30485d",linewidth=0.16) {#X001:3 (40,30)};
// (40,30.4) @TEXT("VDD",size=1.1,halign="middle",valign="bottom");
// &"VSS" @WIRE(mode="straight",linecolor="#30485d",linewidth=0.16) {#X001:4 (40,10)};
// (40,9.6) @TEXT("VSS",size=1.1,halign="middle",valign="top");
// &"VDD" @WIRE(mode="straight",linecolor="#30485d",linewidth=0.16) {#X000:3 (0,10)};
// (0,10.4) @TEXT("VDD",size=1.1,halign="middle",valign="bottom");
// &"VSS" @WIRE(mode="straight",linecolor="#30485d",linewidth=0.16) {#X000:4 (0,-10)};
// (0,-10.4) @TEXT("VSS",size=1.1,halign="middle",valign="top");
// }
// END SARADC RNL
ends sar8p_xor2

subckt sar8p_or2 A B VDD VSS Y
    X001 (B VDD VSS BB) sar8p_inv
    X000 (A VDD VSS AB) sar8p_inv
    X002 (AB BB VDD VSS Y) sar8p_nand2
// BEGIN SARADC RNL
// @RNL(author="saradc topology") {
// #X000 @SET-SYMBOL $S_sar8p_inv;
// #X000 @PLACE(0,16) => @ORIENT("R0");
// #X001 @SET-SYMBOL $S_sar8p_inv;
// #X001 @PLACE(0,-16) => @ORIENT("R0");
// #X002 @SET-SYMBOL $S_sar8p_nand2;
// #X002 @PLACE(40,0) => @ORIENT("R0");
// &"BB" @WIRE(mode="straight",linecolor="#30485d",linewidth=0.16) {#X001:4 (20,-16) (20,-1.7) #X002:2};
// &"AB" @WIRE(mode="straight",linecolor="#30485d",linewidth=0.16) {#X000:4 (20,16) (20,1.7) #X002:1};
// (-16,46) @TEXT("sar8p_or2 / native standard-cell composition",size=1.3,halign="start",textcolor="#223d52");
// &"B" @WIRE(mode="straight",linecolor="#30485d",linewidth=0.16) {#X001:1 (-10,-16)};
// (-10.4,-16) @TEXT("B",size=1.1,halign="end",valign="middle");
// &"VDD" @WIRE(mode="straight",linecolor="#30485d",linewidth=0.16) {#X001:2 (0,-6)};
// (0,-5.6) @TEXT("VDD",size=1.1,halign="middle",valign="bottom");
// &"VSS" @WIRE(mode="straight",linecolor="#30485d",linewidth=0.16) {#X001:3 (0,-26)};
// (0,-26.4) @TEXT("VSS",size=1.1,halign="middle",valign="top");
// &"A" @WIRE(mode="straight",linecolor="#30485d",linewidth=0.16) {#X000:1 (-10,16)};
// (-10.4,16) @TEXT("A",size=1.1,halign="end",valign="middle");
// &"VDD" @WIRE(mode="straight",linecolor="#30485d",linewidth=0.16) {#X000:2 (0,26)};
// (0,26.4) @TEXT("VDD",size=1.1,halign="middle",valign="bottom");
// &"VSS" @WIRE(mode="straight",linecolor="#30485d",linewidth=0.16) {#X000:3 (0,6)};
// (0,5.6) @TEXT("VSS",size=1.1,halign="middle",valign="top");
// &"VDD" @WIRE(mode="straight",linecolor="#30485d",linewidth=0.16) {#X002:3 (40,10)};
// (40,10.4) @TEXT("VDD",size=1.1,halign="middle",valign="bottom");
// &"VSS" @WIRE(mode="straight",linecolor="#30485d",linewidth=0.16) {#X002:4 (40,-10)};
// (40,-10.4) @TEXT("VSS",size=1.1,halign="middle",valign="top");
// &"Y" @WIRE(mode="straight",linecolor="#30485d",linewidth=0.16) {#X002:5 (50,0)};
// (50.4,0) @TEXT("Y",size=1.1,halign="start",valign="middle");
// }
// END SARADC RNL
ends sar8p_or2

subckt sar8p_sr Q R S VDD VSS
    X000 (R VDD VSS RB) sar8p_inv
    X003 (RB Q VDD VSS QB) sar8p_nand2
    X002 (SN QB VDD VSS Q) sar8p_nand2
    X001 (S RB VDD VSS SN) sar8p_nand2
    CQB (QB VSS) cfmom_2t nr=8 lr=2.5u w=50n s=50n stm=1 spm=3 multi=1 \
        mismatchflag=1
// BEGIN SARADC RNL
// @RNL(author="saradc topology") {
// #X000 @SET-SYMBOL $S_sar8p_inv;
// #X000 @PLACE(0,-24) => @ORIENT("R0");
// #X001 @SET-SYMBOL $S_sar8p_nand2;
// #X001 @PLACE(38,20) => @ORIENT("R0");
// #X002 @SET-SYMBOL $S_sar8p_nand2;
// #X002 @PLACE(76,20) => @ORIENT("R0");
// #X003 @SET-SYMBOL $S_sar8p_nand2;
// #X003 @PLACE(76,-24) => @ORIENT("R0");
// #CQB @SET-SYMBOL $CAPACITOR;
// #CQB @PLACE(108,-37) => @ORIENT("R0");
// #CQB @TEXT("CQB",key="name",size=1.3,halign="start") => @PLACE(111,-34);
// #CQB @TEXT("nr=8 lr=2.5u w=50n multi=1",key="value",size=0.9,halign="start") => @PLACE(111,-41);
// #CQB @TEXT("",key="model");
// &"Q" @WIRE(mode="straight",linecolor="#30485d",linewidth=0.16) {#X003:2 (76,-25.7) (76,20) #X002:5};
// &"SN" @WIRE(mode="straight",linecolor="#30485d",linewidth=0.16) {#X002:1 (57,21.7) (57,20) #X001:5};
// &"RB" @WIRE(mode="straight",linecolor="#30485d",linewidth=0.16) {(2,-24) (2,-22.3) (2,18.3)};
// &"RB" @WIRE(mode="straight",linecolor="#30485d",linewidth=0.16) {#X000:4 (2,-24)};
// $JUNCTION @ATTACH (2,-24);
// &"RB" @WIRE(mode="straight",linecolor="#30485d",linewidth=0.16) {#X003:1 (2,-22.3)};
// $JUNCTION @ATTACH (2,-22.3);
// &"RB" @WIRE(mode="straight",linecolor="#30485d",linewidth=0.16) {#X001:2 (2,18.3)};
// $JUNCTION @ATTACH (2,18.3);
// &"QB" @WIRE(mode="straight",linecolor="#30485d",linewidth=0.16) {(64,-35) (64,-24) (64,18.3)};
// &"QB" @WIRE(mode="straight",linecolor="#30485d",linewidth=0.16) {#X003:5 (64,-24)};
// $JUNCTION @ATTACH (64,-24);
// &"QB" @WIRE(mode="straight",linecolor="#30485d",linewidth=0.16) {#X002:2 (64,18.3)};
// $JUNCTION @ATTACH (64,18.3);
// &"QB" @WIRE(mode="straight",linecolor="#30485d",linewidth=0.16) {#CQB:1 (64,-35)};
// $JUNCTION @ATTACH (64,-35);
// (-16,46) @TEXT("sar8p_sr / native standard-cell composition",size=1.3,halign="start",textcolor="#223d52");
// &"R" @WIRE(mode="straight",linecolor="#30485d",linewidth=0.16) {#X000:1 (-10,-24)};
// (-10.4,-24) @TEXT("R",size=1.1,halign="end",valign="middle");
// &"VDD" @WIRE(mode="straight",linecolor="#30485d",linewidth=0.16) {#X000:2 (0,-14)};
// (0,-13.6) @TEXT("VDD",size=1.1,halign="middle",valign="bottom");
// &"VSS" @WIRE(mode="straight",linecolor="#30485d",linewidth=0.16) {#X000:3 (0,-34)};
// (0,-34.4) @TEXT("VSS",size=1.1,halign="middle",valign="top");
// &"VDD" @WIRE(mode="straight",linecolor="#30485d",linewidth=0.16) {#X003:3 (76,-14)};
// (76,-13.6) @TEXT("VDD",size=1.1,halign="middle",valign="bottom");
// &"VSS" @WIRE(mode="straight",linecolor="#30485d",linewidth=0.16) {#X003:4 (76,-34)};
// (76,-34.4) @TEXT("VSS",size=1.1,halign="middle",valign="top");
// &"VDD" @WIRE(mode="straight",linecolor="#30485d",linewidth=0.16) {#X002:3 (76,30)};
// (76,30.4) @TEXT("VDD",size=1.1,halign="middle",valign="bottom");
// &"VSS" @WIRE(mode="straight",linecolor="#30485d",linewidth=0.16) {#X002:4 (76,10)};
// (76,9.6) @TEXT("VSS",size=1.1,halign="middle",valign="top");
// &"S" @WIRE(mode="straight",linecolor="#30485d",linewidth=0.16) {#X001:1 (28,21.7)};
// (27.6,21.7) @TEXT("S",size=1.1,halign="end",valign="middle");
// &"VDD" @WIRE(mode="straight",linecolor="#30485d",linewidth=0.16) {#X001:3 (38,30)};
// (38,30.4) @TEXT("VDD",size=1.1,halign="middle",valign="bottom");
// &"VSS" @WIRE(mode="straight",linecolor="#30485d",linewidth=0.16) {#X001:4 (38,10)};
// (38,9.6) @TEXT("VSS",size=1.1,halign="middle",valign="top");
// &"VSS" @WIRE(mode="straight",linecolor="#30485d",linewidth=0.16) {#CQB:2 (108,-42)};
// (108,-42.4) @TEXT("VSS",size=1.1,halign="middle",valign="top");
// }
// END SARADC RNL
ends sar8p_sr

subckt sar8p_dffr CK D Q RST VDD VSS
    XRESET (RST RN VDD VSS) INVD1BWP12T30P140
    XFF (D CK RN Q VDD VSS) DFCNQD1BWP12T30P140
// BEGIN SARADC RNL
// @RNL(author="saradc topology") {
// #XRESET @SET-SYMBOL $S_INVD1BWP12T30P140;
// #XRESET @PLACE(0,-20) => @ORIENT("R0");
// #XFF @SET-SYMBOL $S_DFCNQD1BWP12T30P140;
// #XFF @PLACE(43,0) => @ORIENT("R0");
// &"RN" @WIRE(mode="straight",linecolor="#30485d",linewidth=0.16) {#XRESET:2 (21.5,-20) (21.5,-3.4) #XFF:3};
// (-16,46) @TEXT("sar8p_dffr / native standard-cell composition",size=1.3,halign="start",textcolor="#223d52");
// &"RST" @WIRE(mode="straight",linecolor="#30485d",linewidth=0.16) {#XRESET:1 (-10,-20)};
// (-10.4,-20) @TEXT("RST",size=1.1,halign="end",valign="middle");
// &"VDD" @WIRE(mode="straight",linecolor="#30485d",linewidth=0.16) {#XRESET:3 (0,-10)};
// (0,-9.6) @TEXT("VDD",size=1.1,halign="middle",valign="bottom");
// &"VSS" @WIRE(mode="straight",linecolor="#30485d",linewidth=0.16) {#XRESET:4 (0,-30)};
// (0,-30.4) @TEXT("VSS",size=1.1,halign="middle",valign="top");
// &"D" @WIRE(mode="straight",linecolor="#30485d",linewidth=0.16) {#XFF:1 (33,3.4)};
// (32.6,3.4) @TEXT("D",size=1.1,halign="end",valign="middle");
// &"CK" @WIRE(mode="straight",linecolor="#30485d",linewidth=0.16) {#XFF:2 (33,0)};
// (32.6,0) @TEXT("CK",size=1.1,halign="end",valign="middle");
// &"Q" @WIRE(mode="straight",linecolor="#30485d",linewidth=0.16) {#XFF:4 (53,0)};
// (53.4,0) @TEXT("Q",size=1.1,halign="start",valign="middle");
// &"VDD" @WIRE(mode="straight",linecolor="#30485d",linewidth=0.16) {#XFF:5 (43,10)};
// (43,10.4) @TEXT("VDD",size=1.1,halign="middle",valign="bottom");
// &"VSS" @WIRE(mode="straight",linecolor="#30485d",linewidth=0.16) {#XFF:6 (43,-10)};
// (43,-10.4) @TEXT("VSS",size=1.1,halign="middle",valign="top");
// }
// END SARADC RNL
ends sar8p_dffr

subckt sar8p_mux2 D0 D1 SEL VDD VSS Y
    X000 (SEL VDD VSS SB) sar8p_inv
    X003 (N0 N1 VDD VSS Y) sar8p_nand2
    X002 (D1 SEL VDD VSS N1) sar8p_nand2
    X001 (D0 SB VDD VSS N0) sar8p_nand2
// BEGIN SARADC RNL
// @RNL(author="saradc topology") {
// #X000 @SET-SYMBOL $S_sar8p_inv;
// #X000 @PLACE(0,-26) => @ORIENT("R0");
// #X001 @SET-SYMBOL $S_sar8p_nand2;
// #X001 @PLACE(42,15) => @ORIENT("R0");
// #X002 @SET-SYMBOL $S_sar8p_nand2;
// #X002 @PLACE(42,-15) => @ORIENT("R0");
// #X003 @SET-SYMBOL $S_sar8p_nand2;
// #X003 @PLACE(84,0) => @ORIENT("R0");
// &"SEL" @WIRE(mode="straight",linecolor="#30485d",linewidth=0.16) {#X000:1 (14,-26) (14,-16.7) #X002:2};
// &"SB" @WIRE(mode="straight",linecolor="#30485d",linewidth=0.16) {#X000:4 (21,-26) (21,13.3) #X001:2};
// &"N0" @WIRE(mode="straight",linecolor="#30485d",linewidth=0.16) {#X003:1 (63,1.7) (63,15) #X001:5};
// &"N1" @WIRE(mode="straight",linecolor="#30485d",linewidth=0.16) {#X003:2 (63,-1.7) (63,-15) #X002:5};
// (-16,46) @TEXT("sar8p_mux2 / native standard-cell composition",size=1.3,halign="start",textcolor="#223d52");
// &"VDD" @WIRE(mode="straight",linecolor="#30485d",linewidth=0.16) {#X000:2 (0,-16)};
// (0,-15.6) @TEXT("VDD",size=1.1,halign="middle",valign="bottom");
// &"VSS" @WIRE(mode="straight",linecolor="#30485d",linewidth=0.16) {#X000:3 (0,-36)};
// (0,-36.4) @TEXT("VSS",size=1.1,halign="middle",valign="top");
// &"VDD" @WIRE(mode="straight",linecolor="#30485d",linewidth=0.16) {#X003:3 (84,10)};
// (84,10.4) @TEXT("VDD",size=1.1,halign="middle",valign="bottom");
// &"VSS" @WIRE(mode="straight",linecolor="#30485d",linewidth=0.16) {#X003:4 (84,-10)};
// (84,-10.4) @TEXT("VSS",size=1.1,halign="middle",valign="top");
// &"Y" @WIRE(mode="straight",linecolor="#30485d",linewidth=0.16) {#X003:5 (94,0)};
// (94.4,0) @TEXT("Y",size=1.1,halign="start",valign="middle");
// &"D1" @WIRE(mode="straight",linecolor="#30485d",linewidth=0.16) {#X002:1 (32,-13.3)};
// (31.6,-13.3) @TEXT("D1",size=1.1,halign="end",valign="middle");
// &"VDD" @WIRE(mode="straight",linecolor="#30485d",linewidth=0.16) {#X002:3 (42,-5)};
// (42,-4.6) @TEXT("VDD",size=1.1,halign="middle",valign="bottom");
// &"VSS" @WIRE(mode="straight",linecolor="#30485d",linewidth=0.16) {#X002:4 (42,-25)};
// (42,-25.4) @TEXT("VSS",size=1.1,halign="middle",valign="top");
// &"D0" @WIRE(mode="straight",linecolor="#30485d",linewidth=0.16) {#X001:1 (32,16.7)};
// (31.6,16.7) @TEXT("D0",size=1.1,halign="end",valign="middle");
// &"VDD" @WIRE(mode="straight",linecolor="#30485d",linewidth=0.16) {#X001:3 (42,25)};
// (42,25.4) @TEXT("VDD",size=1.1,halign="middle",valign="bottom");
// &"VSS" @WIRE(mode="straight",linecolor="#30485d",linewidth=0.16) {#X001:4 (42,5)};
// (42,4.6) @TEXT("VSS",size=1.1,halign="middle",valign="top");
// }
// END SARADC RNL
ends sar8p_mux2
