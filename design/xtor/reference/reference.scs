// Generated from frozen B by scripts/sar8_entry.py build.
// BEGIN SARADC RNL
// @RNL(type="header") { @VERSION("0.3");
// @USE-PACKAGE(name="sar8",version="0.1",path="../../rnl/sar8.rnl");
// @USE-PACKAGE(name="rnl-std-fill") {}; }
// END SARADC RNL
// Electrical subcircuit statements are preserved verbatim.

subckt sar8p_nonoverlap CODE H L VDD VSS
    X000 (CODE VDD VSS CB) sar8p_inv
    XD_LD (CB VDD VSS LD) sar8p_delay_bbm
    XD_HD (CODE VDD VSS HD) sar8p_delay_bbm
    X004 (CB LD VDD VSS L) sar8p_and2
    X002 (CODE HD VDD VSS H) sar8p_and2
// BEGIN SARADC RNL
// @RNL(author="saradc topology") {
// #X000 @SET-SYMBOL $S_sar8p_inv;
// #X000 @PLACE(0,18) => @ORIENT("R0");
// #XD_LD @SET-SYMBOL $S_sar8p_delay_bbm;
// #XD_LD @PLACE(36,18) => @ORIENT("R0");
// #XD_HD @SET-SYMBOL $S_sar8p_delay_bbm;
// #XD_HD @PLACE(36,-18) => @ORIENT("R0");
// #X004 @SET-SYMBOL $S_sar8p_and2;
// #X004 @PLACE(76,18) => @ORIENT("R0");
// #X002 @SET-SYMBOL $S_sar8p_and2;
// #X002 @PLACE(76,-18) => @ORIENT("R0");
// &"LD" @WIRE(mode="straight",linecolor="#30485d",linewidth=0.16) {#XD_LD:4 (59,18) (59,16.3) #X004:2};
// &"HD" @WIRE(mode="straight",linecolor="#30485d",linewidth=0.16) {#XD_HD:4 (59,-18) (59,-19.7) #X002:2};
// &"CODE" @WIRE(mode="straight",linecolor="#30485d",linewidth=0.16) {(-12,-18) (-12,-16.3) (-12,18)};
// &"CODE" @WIRE(mode="straight",linecolor="#30485d",linewidth=0.16) {#X000:1 (-12,18)};
// $JUNCTION @ATTACH (-12,18);
// &"CODE" @WIRE(mode="straight",linecolor="#30485d",linewidth=0.16) {#XD_HD:1 (-12,-18)};
// $JUNCTION @ATTACH (-12,-18);
// &"CODE" @WIRE(mode="straight",linecolor="#30485d",linewidth=0.16) {#X002:1 (-12,-16.3)};
// $JUNCTION @ATTACH (-12,-16.3);
// &"CB" @WIRE(mode="straight",linecolor="#30485d",linewidth=0.16) {(2,18) (2,19.7)};
// &"CB" @WIRE(mode="straight",linecolor="#30485d",linewidth=0.16) {#X000:4 (2,18)};
// $JUNCTION @ATTACH (2,18);
// &"CB" @WIRE(mode="straight",linecolor="#30485d",linewidth=0.16) {#XD_LD:1 (2,18)};
// $JUNCTION @ATTACH (2,18);
// &"CB" @WIRE(mode="straight",linecolor="#30485d",linewidth=0.16) {#X004:1 (2,19.7)};
// $JUNCTION @ATTACH (2,19.7);
// (-16,46) @TEXT("sar8p_nonoverlap / native standard-cell composition",size=1.3,halign="start",textcolor="#223d52");
// &"VDD" @WIRE(mode="straight",linecolor="#30485d",linewidth=0.16) {#X000:2 (0,28)};
// (0,28.4) @TEXT("VDD",size=1.1,halign="middle",valign="bottom");
// &"VSS" @WIRE(mode="straight",linecolor="#30485d",linewidth=0.16) {#X000:3 (0,8)};
// (0,7.6) @TEXT("VSS",size=1.1,halign="middle",valign="top");
// &"VDD" @WIRE(mode="straight",linecolor="#30485d",linewidth=0.16) {#XD_LD:2 (36,29)};
// (36,29.4) @TEXT("VDD",size=1.1,halign="middle",valign="bottom");
// &"VSS" @WIRE(mode="straight",linecolor="#30485d",linewidth=0.16) {#XD_LD:3 (36,7)};
// (36,6.6) @TEXT("VSS",size=1.1,halign="middle",valign="top");
// &"VDD" @WIRE(mode="straight",linecolor="#30485d",linewidth=0.16) {#XD_HD:2 (36,-7)};
// (36,-6.6) @TEXT("VDD",size=1.1,halign="middle",valign="bottom");
// &"VSS" @WIRE(mode="straight",linecolor="#30485d",linewidth=0.16) {#XD_HD:3 (36,-29)};
// (36,-29.4) @TEXT("VSS",size=1.1,halign="middle",valign="top");
// &"VDD" @WIRE(mode="straight",linecolor="#30485d",linewidth=0.16) {#X004:3 (76,28)};
// (76,28.4) @TEXT("VDD",size=1.1,halign="middle",valign="bottom");
// &"VSS" @WIRE(mode="straight",linecolor="#30485d",linewidth=0.16) {#X004:4 (76,8)};
// (76,7.6) @TEXT("VSS",size=1.1,halign="middle",valign="top");
// &"L" @WIRE(mode="straight",linecolor="#30485d",linewidth=0.16) {#X004:5 (86,18)};
// (86.4,18) @TEXT("L",size=1.1,halign="start",valign="middle");
// &"VDD" @WIRE(mode="straight",linecolor="#30485d",linewidth=0.16) {#X002:3 (76,-8)};
// (76,-7.6) @TEXT("VDD",size=1.1,halign="middle",valign="bottom");
// &"VSS" @WIRE(mode="straight",linecolor="#30485d",linewidth=0.16) {#X002:4 (76,-28)};
// (76,-28.4) @TEXT("VSS",size=1.1,halign="middle",valign="top");
// &"H" @WIRE(mode="straight",linecolor="#30485d",linewidth=0.16) {#X002:5 (86,-18)};
// (86.4,-18) @TEXT("H",size=1.1,halign="start",valign="middle");
// }
// END SARADC RNL
ends sar8p_nonoverlap

subckt sar8p_refdrv_b0 GNN GNP GPN GPP H L VDD VSS
    XSTD_GNNCN (GNNB GNNDRV VDD VSS) INVD1BWP12T30P140
    XSTD_GNNBN (GNNA GNNB VDD VSS) INVD1BWP12T30P140
    XSTD_GNNAN (GNNPRE GNNA VDD VSS) INVD1BWP12T30P140
    XSTD_GNPCN (GNPB GNPDRV VDD VSS) INVD1BWP12T30P140
    XSTD_GNPBN (GNPA GNPB VDD VSS) INVD1BWP12T30P140
    XSTD_GNPAN (H GNPA VDD VSS) INVD1BWP12T30P140
    XSTD_GPNCN (GPNB GPNDRV VDD VSS) INVD1BWP12T30P140
    XSTD_GPNBN (GPNA GPNB VDD VSS) INVD1BWP12T30P140
    XSTD_GPNAN (GPNPRE GPNA VDD VSS) INVD1BWP12T30P140
    XSTD_GPPCN (GPPB GPPDRV VDD VSS) INVD1BWP12T30P140
    XSTD_GPPBN (GPPA GPPB VDD VSS) INVD1BWP12T30P140
    XSTD_GPPAN (L GPPA VDD VSS) INVD1BWP12T30P140
//Series configuration of RGNN1
RGNN1  (GNNRG RGNN1_1__dmy0 ) rupolym l=17.13u w=1u m=1 multi=(1)
RGNN1_2__dmy0  (RGNN1_1__dmy0 RGNN1_2__dmy0 ) rupolym l=17.13u w=1u m=1 \
        multi=(1)
RGNN1_3__dmy0  (RGNN1_2__dmy0 RGNN1_3__dmy0 ) rupolym l=17.13u w=1u m=1 \
        multi=(1)
RGNN1_4__dmy0  (RGNN1_3__dmy0 RGNN1_4__dmy0 ) rupolym l=17.13u w=1u m=1 \
        multi=(1)
RGNN1_5__dmy0  (RGNN1_4__dmy0 GNN ) rupolym l=17.13u w=1u m=1 multi=(1)
//End of RGNN1

//Series configuration of RGNN0
RGNN0  (GNNDRV RGNN0_1__dmy0 ) rupolym l=17.13u w=1u m=1 multi=(1)
RGNN0_2__dmy0  (RGNN0_1__dmy0 RGNN0_2__dmy0 ) rupolym l=17.13u w=1u m=1 \
        multi=(1)
RGNN0_3__dmy0  (RGNN0_2__dmy0 RGNN0_3__dmy0 ) rupolym l=17.13u w=1u m=1 \
        multi=(1)
RGNN0_4__dmy0  (RGNN0_3__dmy0 RGNN0_4__dmy0 ) rupolym l=17.13u w=1u m=1 \
        multi=(1)
RGNN0_5__dmy0  (RGNN0_4__dmy0 GNNRG ) rupolym l=17.13u w=1u m=1 multi=(1)
//End of RGNN0

//Series configuration of RGNP1
RGNP1  (GNPRG RGNP1_1__dmy0 ) rupolym l=17.13u w=1u m=1 multi=(1)
RGNP1_2__dmy0  (RGNP1_1__dmy0 RGNP1_2__dmy0 ) rupolym l=17.13u w=1u m=1 \
        multi=(1)
RGNP1_3__dmy0  (RGNP1_2__dmy0 RGNP1_3__dmy0 ) rupolym l=17.13u w=1u m=1 \
        multi=(1)
RGNP1_4__dmy0  (RGNP1_3__dmy0 RGNP1_4__dmy0 ) rupolym l=17.13u w=1u m=1 \
        multi=(1)
RGNP1_5__dmy0  (RGNP1_4__dmy0 GNP ) rupolym l=17.13u w=1u m=1 multi=(1)
//End of RGNP1

//Series configuration of RGNP0
RGNP0  (GNPDRV RGNP0_1__dmy0 ) rupolym l=17.13u w=1u m=1 multi=(1)
RGNP0_2__dmy0  (RGNP0_1__dmy0 RGNP0_2__dmy0 ) rupolym l=17.13u w=1u m=1 \
        multi=(1)
RGNP0_3__dmy0  (RGNP0_2__dmy0 RGNP0_3__dmy0 ) rupolym l=17.13u w=1u m=1 \
        multi=(1)
RGNP0_4__dmy0  (RGNP0_3__dmy0 RGNP0_4__dmy0 ) rupolym l=17.13u w=1u m=1 \
        multi=(1)
RGNP0_5__dmy0  (RGNP0_4__dmy0 GNPRG ) rupolym l=17.13u w=1u m=1 multi=(1)
//End of RGNP0

//Series configuration of RGPN1
RGPN1  (GPNRG RGPN1_1__dmy0 ) rupolym l=17.13u w=1u m=1 multi=(1)
RGPN1_2__dmy0  (RGPN1_1__dmy0 RGPN1_2__dmy0 ) rupolym l=17.13u w=1u m=1 \
        multi=(1)
RGPN1_3__dmy0  (RGPN1_2__dmy0 RGPN1_3__dmy0 ) rupolym l=17.13u w=1u m=1 \
        multi=(1)
RGPN1_4__dmy0  (RGPN1_3__dmy0 RGPN1_4__dmy0 ) rupolym l=17.13u w=1u m=1 \
        multi=(1)
RGPN1_5__dmy0  (RGPN1_4__dmy0 GPN ) rupolym l=17.13u w=1u m=1 multi=(1)
//End of RGPN1

//Series configuration of RGPN0
RGPN0  (GPNDRV RGPN0_1__dmy0 ) rupolym l=17.13u w=1u m=1 multi=(1)
RGPN0_2__dmy0  (RGPN0_1__dmy0 RGPN0_2__dmy0 ) rupolym l=17.13u w=1u m=1 \
        multi=(1)
RGPN0_3__dmy0  (RGPN0_2__dmy0 RGPN0_3__dmy0 ) rupolym l=17.13u w=1u m=1 \
        multi=(1)
RGPN0_4__dmy0  (RGPN0_3__dmy0 RGPN0_4__dmy0 ) rupolym l=17.13u w=1u m=1 \
        multi=(1)
RGPN0_5__dmy0  (RGPN0_4__dmy0 GPNRG ) rupolym l=17.13u w=1u m=1 multi=(1)
//End of RGPN0

//Series configuration of RGPP1
RGPP1  (GPPRG RGPP1_1__dmy0 ) rupolym l=17.13u w=1u m=1 multi=(1)
RGPP1_2__dmy0  (RGPP1_1__dmy0 RGPP1_2__dmy0 ) rupolym l=17.13u w=1u m=1 \
        multi=(1)
RGPP1_3__dmy0  (RGPP1_2__dmy0 RGPP1_3__dmy0 ) rupolym l=17.13u w=1u m=1 \
        multi=(1)
RGPP1_4__dmy0  (RGPP1_3__dmy0 RGPP1_4__dmy0 ) rupolym l=17.13u w=1u m=1 \
        multi=(1)
RGPP1_5__dmy0  (RGPP1_4__dmy0 GPP ) rupolym l=17.13u w=1u m=1 multi=(1)
//End of RGPP1

//Series configuration of RGPP0
RGPP0  (GPPDRV RGPP0_1__dmy0 ) rupolym l=17.13u w=1u m=1 multi=(1)
RGPP0_2__dmy0  (RGPP0_1__dmy0 RGPP0_2__dmy0 ) rupolym l=17.13u w=1u m=1 \
        multi=(1)
RGPP0_3__dmy0  (RGPP0_2__dmy0 RGPP0_3__dmy0 ) rupolym l=17.13u w=1u m=1 \
        multi=(1)
RGPP0_4__dmy0  (RGPP0_3__dmy0 RGPP0_4__dmy0 ) rupolym l=17.13u w=1u m=1 \
        multi=(1)
RGPP0_5__dmy0  (RGPP0_4__dmy0 GPPRG ) rupolym l=17.13u w=1u m=1 multi=(1)
//End of RGPP0

    X025 (L VDD VSS GNNPRE) sar8p_inv
    X008 (H VDD VSS GPNPRE) sar8p_inv
// BEGIN SARADC RNL
// @RNL(author="saradc topology") {
// (-28,27) @TEXT("sar8p_refdrv_b0 / four physical gate-driver chains",size=1.5,halign="start",textcolor="#223d52");
// #X025 @SET-SYMBOL $S_sar8p_inv;
// #X025 @PLACE(-17,0) => @ORIENT("R0");
// #XSTD_GNNAN @SET-SYMBOL $S_INVD1BWP12T30P140;
// #XSTD_GNNAN @PLACE(18,0) => @ORIENT("R0");
// #XSTD_GNNBN @SET-SYMBOL $S_INVD1BWP12T30P140;
// #XSTD_GNNBN @PLACE(47,0) => @ORIENT("R0");
// #XSTD_GNNCN @SET-SYMBOL $S_INVD1BWP12T30P140;
// #XSTD_GNNCN @PLACE(76,0) => @ORIENT("R0");
// #RGNN0 @SET-SYMBOL $RESISTOR;
// #RGNN0 @PLACE(110,0) => @ORIENT("R90");
// #RGNN0 @TEXT("RGNN0",key="name",size=1.3,halign="start") => @PLACE(113,3);
// #RGNN0 @TEXT("l=17.13u w=1u multi=(1)",key="value",size=0.9,halign="start") => @PLACE(113,-4);
// #RGNN0 @TEXT("",key="model");
// #RGNN0_2__dmy0 @SET-SYMBOL $RESISTOR;
// #RGNN0_2__dmy0 @PLACE(135,0) => @ORIENT("R90");
// #RGNN0_2__dmy0 @TEXT("RGNN0_2__dmy0",key="name",size=1.3,halign="start") => @PLACE(138,3);
// #RGNN0_2__dmy0 @TEXT("l=17.13u w=1u multi=(1)",key="value",size=0.9,halign="start") => @PLACE(138,-4);
// #RGNN0_2__dmy0 @TEXT("",key="model");
// #RGNN0_3__dmy0 @SET-SYMBOL $RESISTOR;
// #RGNN0_3__dmy0 @PLACE(160,0) => @ORIENT("R90");
// #RGNN0_3__dmy0 @TEXT("RGNN0_3__dmy0",key="name",size=1.3,halign="start") => @PLACE(163,3);
// #RGNN0_3__dmy0 @TEXT("l=17.13u w=1u multi=(1)",key="value",size=0.9,halign="start") => @PLACE(163,-4);
// #RGNN0_3__dmy0 @TEXT("",key="model");
// #RGNN0_4__dmy0 @SET-SYMBOL $RESISTOR;
// #RGNN0_4__dmy0 @PLACE(185,0) => @ORIENT("R90");
// #RGNN0_4__dmy0 @TEXT("RGNN0_4__dmy0",key="name",size=1.3,halign="start") => @PLACE(188,3);
// #RGNN0_4__dmy0 @TEXT("l=17.13u w=1u multi=(1)",key="value",size=0.9,halign="start") => @PLACE(188,-4);
// #RGNN0_4__dmy0 @TEXT("",key="model");
// #RGNN0_5__dmy0 @SET-SYMBOL $RESISTOR;
// #RGNN0_5__dmy0 @PLACE(210,0) => @ORIENT("R90");
// #RGNN0_5__dmy0 @TEXT("RGNN0_5__dmy0",key="name",size=1.3,halign="start") => @PLACE(213,3);
// #RGNN0_5__dmy0 @TEXT("l=17.13u w=1u multi=(1)",key="value",size=0.9,halign="start") => @PLACE(213,-4);
// #RGNN0_5__dmy0 @TEXT("",key="model");
// #RGNN1 @SET-SYMBOL $RESISTOR;
// #RGNN1 @PLACE(235,0) => @ORIENT("R90");
// #RGNN1 @TEXT("RGNN1",key="name",size=1.3,halign="start") => @PLACE(238,3);
// #RGNN1 @TEXT("l=17.13u w=1u multi=(1)",key="value",size=0.9,halign="start") => @PLACE(238,-4);
// #RGNN1 @TEXT("",key="model");
// #RGNN1_2__dmy0 @SET-SYMBOL $RESISTOR;
// #RGNN1_2__dmy0 @PLACE(260,0) => @ORIENT("R90");
// #RGNN1_2__dmy0 @TEXT("RGNN1_2__dmy0",key="name",size=1.3,halign="start") => @PLACE(263,3);
// #RGNN1_2__dmy0 @TEXT("l=17.13u w=1u multi=(1)",key="value",size=0.9,halign="start") => @PLACE(263,-4);
// #RGNN1_2__dmy0 @TEXT("",key="model");
// #RGNN1_3__dmy0 @SET-SYMBOL $RESISTOR;
// #RGNN1_3__dmy0 @PLACE(285,0) => @ORIENT("R90");
// #RGNN1_3__dmy0 @TEXT("RGNN1_3__dmy0",key="name",size=1.3,halign="start") => @PLACE(288,3);
// #RGNN1_3__dmy0 @TEXT("l=17.13u w=1u multi=(1)",key="value",size=0.9,halign="start") => @PLACE(288,-4);
// #RGNN1_3__dmy0 @TEXT("",key="model");
// #RGNN1_4__dmy0 @SET-SYMBOL $RESISTOR;
// #RGNN1_4__dmy0 @PLACE(310,0) => @ORIENT("R90");
// #RGNN1_4__dmy0 @TEXT("RGNN1_4__dmy0",key="name",size=1.3,halign="start") => @PLACE(313,3);
// #RGNN1_4__dmy0 @TEXT("l=17.13u w=1u multi=(1)",key="value",size=0.9,halign="start") => @PLACE(313,-4);
// #RGNN1_4__dmy0 @TEXT("",key="model");
// #RGNN1_5__dmy0 @SET-SYMBOL $RESISTOR;
// #RGNN1_5__dmy0 @PLACE(335,0) => @ORIENT("R90");
// #RGNN1_5__dmy0 @TEXT("RGNN1_5__dmy0",key="name",size=1.3,halign="start") => @PLACE(338,3);
// #RGNN1_5__dmy0 @TEXT("l=17.13u w=1u multi=(1)",key="value",size=0.9,halign="start") => @PLACE(338,-4);
// #RGNN1_5__dmy0 @TEXT("",key="model");
// (104,15) @TEXT("GNN / 10 series poly sections",size=0.95,halign="start",textcolor="#223d52");
// #XSTD_GNPAN @SET-SYMBOL $S_INVD1BWP12T30P140;
// #XSTD_GNPAN @PLACE(18,-38) => @ORIENT("R0");
// #XSTD_GNPBN @SET-SYMBOL $S_INVD1BWP12T30P140;
// #XSTD_GNPBN @PLACE(47,-38) => @ORIENT("R0");
// #XSTD_GNPCN @SET-SYMBOL $S_INVD1BWP12T30P140;
// #XSTD_GNPCN @PLACE(76,-38) => @ORIENT("R0");
// #RGNP0 @SET-SYMBOL $RESISTOR;
// #RGNP0 @PLACE(110,-38) => @ORIENT("R90");
// #RGNP0 @TEXT("RGNP0",key="name",size=1.3,halign="start") => @PLACE(113,-35);
// #RGNP0 @TEXT("l=17.13u w=1u multi=(1)",key="value",size=0.9,halign="start") => @PLACE(113,-42);
// #RGNP0 @TEXT("",key="model");
// #RGNP0_2__dmy0 @SET-SYMBOL $RESISTOR;
// #RGNP0_2__dmy0 @PLACE(135,-38) => @ORIENT("R90");
// #RGNP0_2__dmy0 @TEXT("RGNP0_2__dmy0",key="name",size=1.3,halign="start") => @PLACE(138,-35);
// #RGNP0_2__dmy0 @TEXT("l=17.13u w=1u multi=(1)",key="value",size=0.9,halign="start") => @PLACE(138,-42);
// #RGNP0_2__dmy0 @TEXT("",key="model");
// #RGNP0_3__dmy0 @SET-SYMBOL $RESISTOR;
// #RGNP0_3__dmy0 @PLACE(160,-38) => @ORIENT("R90");
// #RGNP0_3__dmy0 @TEXT("RGNP0_3__dmy0",key="name",size=1.3,halign="start") => @PLACE(163,-35);
// #RGNP0_3__dmy0 @TEXT("l=17.13u w=1u multi=(1)",key="value",size=0.9,halign="start") => @PLACE(163,-42);
// #RGNP0_3__dmy0 @TEXT("",key="model");
// #RGNP0_4__dmy0 @SET-SYMBOL $RESISTOR;
// #RGNP0_4__dmy0 @PLACE(185,-38) => @ORIENT("R90");
// #RGNP0_4__dmy0 @TEXT("RGNP0_4__dmy0",key="name",size=1.3,halign="start") => @PLACE(188,-35);
// #RGNP0_4__dmy0 @TEXT("l=17.13u w=1u multi=(1)",key="value",size=0.9,halign="start") => @PLACE(188,-42);
// #RGNP0_4__dmy0 @TEXT("",key="model");
// #RGNP0_5__dmy0 @SET-SYMBOL $RESISTOR;
// #RGNP0_5__dmy0 @PLACE(210,-38) => @ORIENT("R90");
// #RGNP0_5__dmy0 @TEXT("RGNP0_5__dmy0",key="name",size=1.3,halign="start") => @PLACE(213,-35);
// #RGNP0_5__dmy0 @TEXT("l=17.13u w=1u multi=(1)",key="value",size=0.9,halign="start") => @PLACE(213,-42);
// #RGNP0_5__dmy0 @TEXT("",key="model");
// #RGNP1 @SET-SYMBOL $RESISTOR;
// #RGNP1 @PLACE(235,-38) => @ORIENT("R90");
// #RGNP1 @TEXT("RGNP1",key="name",size=1.3,halign="start") => @PLACE(238,-35);
// #RGNP1 @TEXT("l=17.13u w=1u multi=(1)",key="value",size=0.9,halign="start") => @PLACE(238,-42);
// #RGNP1 @TEXT("",key="model");
// #RGNP1_2__dmy0 @SET-SYMBOL $RESISTOR;
// #RGNP1_2__dmy0 @PLACE(260,-38) => @ORIENT("R90");
// #RGNP1_2__dmy0 @TEXT("RGNP1_2__dmy0",key="name",size=1.3,halign="start") => @PLACE(263,-35);
// #RGNP1_2__dmy0 @TEXT("l=17.13u w=1u multi=(1)",key="value",size=0.9,halign="start") => @PLACE(263,-42);
// #RGNP1_2__dmy0 @TEXT("",key="model");
// #RGNP1_3__dmy0 @SET-SYMBOL $RESISTOR;
// #RGNP1_3__dmy0 @PLACE(285,-38) => @ORIENT("R90");
// #RGNP1_3__dmy0 @TEXT("RGNP1_3__dmy0",key="name",size=1.3,halign="start") => @PLACE(288,-35);
// #RGNP1_3__dmy0 @TEXT("l=17.13u w=1u multi=(1)",key="value",size=0.9,halign="start") => @PLACE(288,-42);
// #RGNP1_3__dmy0 @TEXT("",key="model");
// #RGNP1_4__dmy0 @SET-SYMBOL $RESISTOR;
// #RGNP1_4__dmy0 @PLACE(310,-38) => @ORIENT("R90");
// #RGNP1_4__dmy0 @TEXT("RGNP1_4__dmy0",key="name",size=1.3,halign="start") => @PLACE(313,-35);
// #RGNP1_4__dmy0 @TEXT("l=17.13u w=1u multi=(1)",key="value",size=0.9,halign="start") => @PLACE(313,-42);
// #RGNP1_4__dmy0 @TEXT("",key="model");
// #RGNP1_5__dmy0 @SET-SYMBOL $RESISTOR;
// #RGNP1_5__dmy0 @PLACE(335,-38) => @ORIENT("R90");
// #RGNP1_5__dmy0 @TEXT("RGNP1_5__dmy0",key="name",size=1.3,halign="start") => @PLACE(338,-35);
// #RGNP1_5__dmy0 @TEXT("l=17.13u w=1u multi=(1)",key="value",size=0.9,halign="start") => @PLACE(338,-42);
// #RGNP1_5__dmy0 @TEXT("",key="model");
// (104,-23) @TEXT("GNP / 10 series poly sections",size=0.95,halign="start",textcolor="#223d52");
// #X008 @SET-SYMBOL $S_sar8p_inv;
// #X008 @PLACE(-17,-76) => @ORIENT("R0");
// #XSTD_GPNAN @SET-SYMBOL $S_INVD1BWP12T30P140;
// #XSTD_GPNAN @PLACE(18,-76) => @ORIENT("R0");
// #XSTD_GPNBN @SET-SYMBOL $S_INVD1BWP12T30P140;
// #XSTD_GPNBN @PLACE(47,-76) => @ORIENT("R0");
// #XSTD_GPNCN @SET-SYMBOL $S_INVD1BWP12T30P140;
// #XSTD_GPNCN @PLACE(76,-76) => @ORIENT("R0");
// #RGPN0 @SET-SYMBOL $RESISTOR;
// #RGPN0 @PLACE(110,-76) => @ORIENT("R90");
// #RGPN0 @TEXT("RGPN0",key="name",size=1.3,halign="start") => @PLACE(113,-73);
// #RGPN0 @TEXT("l=17.13u w=1u multi=(1)",key="value",size=0.9,halign="start") => @PLACE(113,-80);
// #RGPN0 @TEXT("",key="model");
// #RGPN0_2__dmy0 @SET-SYMBOL $RESISTOR;
// #RGPN0_2__dmy0 @PLACE(135,-76) => @ORIENT("R90");
// #RGPN0_2__dmy0 @TEXT("RGPN0_2__dmy0",key="name",size=1.3,halign="start") => @PLACE(138,-73);
// #RGPN0_2__dmy0 @TEXT("l=17.13u w=1u multi=(1)",key="value",size=0.9,halign="start") => @PLACE(138,-80);
// #RGPN0_2__dmy0 @TEXT("",key="model");
// #RGPN0_3__dmy0 @SET-SYMBOL $RESISTOR;
// #RGPN0_3__dmy0 @PLACE(160,-76) => @ORIENT("R90");
// #RGPN0_3__dmy0 @TEXT("RGPN0_3__dmy0",key="name",size=1.3,halign="start") => @PLACE(163,-73);
// #RGPN0_3__dmy0 @TEXT("l=17.13u w=1u multi=(1)",key="value",size=0.9,halign="start") => @PLACE(163,-80);
// #RGPN0_3__dmy0 @TEXT("",key="model");
// #RGPN0_4__dmy0 @SET-SYMBOL $RESISTOR;
// #RGPN0_4__dmy0 @PLACE(185,-76) => @ORIENT("R90");
// #RGPN0_4__dmy0 @TEXT("RGPN0_4__dmy0",key="name",size=1.3,halign="start") => @PLACE(188,-73);
// #RGPN0_4__dmy0 @TEXT("l=17.13u w=1u multi=(1)",key="value",size=0.9,halign="start") => @PLACE(188,-80);
// #RGPN0_4__dmy0 @TEXT("",key="model");
// #RGPN0_5__dmy0 @SET-SYMBOL $RESISTOR;
// #RGPN0_5__dmy0 @PLACE(210,-76) => @ORIENT("R90");
// #RGPN0_5__dmy0 @TEXT("RGPN0_5__dmy0",key="name",size=1.3,halign="start") => @PLACE(213,-73);
// #RGPN0_5__dmy0 @TEXT("l=17.13u w=1u multi=(1)",key="value",size=0.9,halign="start") => @PLACE(213,-80);
// #RGPN0_5__dmy0 @TEXT("",key="model");
// #RGPN1 @SET-SYMBOL $RESISTOR;
// #RGPN1 @PLACE(235,-76) => @ORIENT("R90");
// #RGPN1 @TEXT("RGPN1",key="name",size=1.3,halign="start") => @PLACE(238,-73);
// #RGPN1 @TEXT("l=17.13u w=1u multi=(1)",key="value",size=0.9,halign="start") => @PLACE(238,-80);
// #RGPN1 @TEXT("",key="model");
// #RGPN1_2__dmy0 @SET-SYMBOL $RESISTOR;
// #RGPN1_2__dmy0 @PLACE(260,-76) => @ORIENT("R90");
// #RGPN1_2__dmy0 @TEXT("RGPN1_2__dmy0",key="name",size=1.3,halign="start") => @PLACE(263,-73);
// #RGPN1_2__dmy0 @TEXT("l=17.13u w=1u multi=(1)",key="value",size=0.9,halign="start") => @PLACE(263,-80);
// #RGPN1_2__dmy0 @TEXT("",key="model");
// #RGPN1_3__dmy0 @SET-SYMBOL $RESISTOR;
// #RGPN1_3__dmy0 @PLACE(285,-76) => @ORIENT("R90");
// #RGPN1_3__dmy0 @TEXT("RGPN1_3__dmy0",key="name",size=1.3,halign="start") => @PLACE(288,-73);
// #RGPN1_3__dmy0 @TEXT("l=17.13u w=1u multi=(1)",key="value",size=0.9,halign="start") => @PLACE(288,-80);
// #RGPN1_3__dmy0 @TEXT("",key="model");
// #RGPN1_4__dmy0 @SET-SYMBOL $RESISTOR;
// #RGPN1_4__dmy0 @PLACE(310,-76) => @ORIENT("R90");
// #RGPN1_4__dmy0 @TEXT("RGPN1_4__dmy0",key="name",size=1.3,halign="start") => @PLACE(313,-73);
// #RGPN1_4__dmy0 @TEXT("l=17.13u w=1u multi=(1)",key="value",size=0.9,halign="start") => @PLACE(313,-80);
// #RGPN1_4__dmy0 @TEXT("",key="model");
// #RGPN1_5__dmy0 @SET-SYMBOL $RESISTOR;
// #RGPN1_5__dmy0 @PLACE(335,-76) => @ORIENT("R90");
// #RGPN1_5__dmy0 @TEXT("RGPN1_5__dmy0",key="name",size=1.3,halign="start") => @PLACE(338,-73);
// #RGPN1_5__dmy0 @TEXT("l=17.13u w=1u multi=(1)",key="value",size=0.9,halign="start") => @PLACE(338,-80);
// #RGPN1_5__dmy0 @TEXT("",key="model");
// (104,-61) @TEXT("GPN / 10 series poly sections",size=0.95,halign="start",textcolor="#223d52");
// #XSTD_GPPAN @SET-SYMBOL $S_INVD1BWP12T30P140;
// #XSTD_GPPAN @PLACE(18,-114) => @ORIENT("R0");
// #XSTD_GPPBN @SET-SYMBOL $S_INVD1BWP12T30P140;
// #XSTD_GPPBN @PLACE(47,-114) => @ORIENT("R0");
// #XSTD_GPPCN @SET-SYMBOL $S_INVD1BWP12T30P140;
// #XSTD_GPPCN @PLACE(76,-114) => @ORIENT("R0");
// #RGPP0 @SET-SYMBOL $RESISTOR;
// #RGPP0 @PLACE(110,-114) => @ORIENT("R90");
// #RGPP0 @TEXT("RGPP0",key="name",size=1.3,halign="start") => @PLACE(113,-111);
// #RGPP0 @TEXT("l=17.13u w=1u multi=(1)",key="value",size=0.9,halign="start") => @PLACE(113,-118);
// #RGPP0 @TEXT("",key="model");
// #RGPP0_2__dmy0 @SET-SYMBOL $RESISTOR;
// #RGPP0_2__dmy0 @PLACE(135,-114) => @ORIENT("R90");
// #RGPP0_2__dmy0 @TEXT("RGPP0_2__dmy0",key="name",size=1.3,halign="start") => @PLACE(138,-111);
// #RGPP0_2__dmy0 @TEXT("l=17.13u w=1u multi=(1)",key="value",size=0.9,halign="start") => @PLACE(138,-118);
// #RGPP0_2__dmy0 @TEXT("",key="model");
// #RGPP0_3__dmy0 @SET-SYMBOL $RESISTOR;
// #RGPP0_3__dmy0 @PLACE(160,-114) => @ORIENT("R90");
// #RGPP0_3__dmy0 @TEXT("RGPP0_3__dmy0",key="name",size=1.3,halign="start") => @PLACE(163,-111);
// #RGPP0_3__dmy0 @TEXT("l=17.13u w=1u multi=(1)",key="value",size=0.9,halign="start") => @PLACE(163,-118);
// #RGPP0_3__dmy0 @TEXT("",key="model");
// #RGPP0_4__dmy0 @SET-SYMBOL $RESISTOR;
// #RGPP0_4__dmy0 @PLACE(185,-114) => @ORIENT("R90");
// #RGPP0_4__dmy0 @TEXT("RGPP0_4__dmy0",key="name",size=1.3,halign="start") => @PLACE(188,-111);
// #RGPP0_4__dmy0 @TEXT("l=17.13u w=1u multi=(1)",key="value",size=0.9,halign="start") => @PLACE(188,-118);
// #RGPP0_4__dmy0 @TEXT("",key="model");
// #RGPP0_5__dmy0 @SET-SYMBOL $RESISTOR;
// #RGPP0_5__dmy0 @PLACE(210,-114) => @ORIENT("R90");
// #RGPP0_5__dmy0 @TEXT("RGPP0_5__dmy0",key="name",size=1.3,halign="start") => @PLACE(213,-111);
// #RGPP0_5__dmy0 @TEXT("l=17.13u w=1u multi=(1)",key="value",size=0.9,halign="start") => @PLACE(213,-118);
// #RGPP0_5__dmy0 @TEXT("",key="model");
// #RGPP1 @SET-SYMBOL $RESISTOR;
// #RGPP1 @PLACE(235,-114) => @ORIENT("R90");
// #RGPP1 @TEXT("RGPP1",key="name",size=1.3,halign="start") => @PLACE(238,-111);
// #RGPP1 @TEXT("l=17.13u w=1u multi=(1)",key="value",size=0.9,halign="start") => @PLACE(238,-118);
// #RGPP1 @TEXT("",key="model");
// #RGPP1_2__dmy0 @SET-SYMBOL $RESISTOR;
// #RGPP1_2__dmy0 @PLACE(260,-114) => @ORIENT("R90");
// #RGPP1_2__dmy0 @TEXT("RGPP1_2__dmy0",key="name",size=1.3,halign="start") => @PLACE(263,-111);
// #RGPP1_2__dmy0 @TEXT("l=17.13u w=1u multi=(1)",key="value",size=0.9,halign="start") => @PLACE(263,-118);
// #RGPP1_2__dmy0 @TEXT("",key="model");
// #RGPP1_3__dmy0 @SET-SYMBOL $RESISTOR;
// #RGPP1_3__dmy0 @PLACE(285,-114) => @ORIENT("R90");
// #RGPP1_3__dmy0 @TEXT("RGPP1_3__dmy0",key="name",size=1.3,halign="start") => @PLACE(288,-111);
// #RGPP1_3__dmy0 @TEXT("l=17.13u w=1u multi=(1)",key="value",size=0.9,halign="start") => @PLACE(288,-118);
// #RGPP1_3__dmy0 @TEXT("",key="model");
// #RGPP1_4__dmy0 @SET-SYMBOL $RESISTOR;
// #RGPP1_4__dmy0 @PLACE(310,-114) => @ORIENT("R90");
// #RGPP1_4__dmy0 @TEXT("RGPP1_4__dmy0",key="name",size=1.3,halign="start") => @PLACE(313,-111);
// #RGPP1_4__dmy0 @TEXT("l=17.13u w=1u multi=(1)",key="value",size=0.9,halign="start") => @PLACE(313,-118);
// #RGPP1_4__dmy0 @TEXT("",key="model");
// #RGPP1_5__dmy0 @SET-SYMBOL $RESISTOR;
// #RGPP1_5__dmy0 @PLACE(335,-114) => @ORIENT("R90");
// #RGPP1_5__dmy0 @TEXT("RGPP1_5__dmy0",key="name",size=1.3,halign="start") => @PLACE(338,-111);
// #RGPP1_5__dmy0 @TEXT("l=17.13u w=1u multi=(1)",key="value",size=0.9,halign="start") => @PLACE(338,-118);
// #RGPP1_5__dmy0 @TEXT("",key="model");
// (104,-99) @TEXT("GPP / 10 series poly sections",size=0.95,halign="start",textcolor="#223d52");
// &"GNNB" @WIRE(mode="straight",linecolor="#30485d",linewidth=0.16) {#XSTD_GNNCN:1 (61.5,0) (61.5,0) #XSTD_GNNBN:2};
// &"GNNDRV" @WIRE(mode="straight",linecolor="#30485d",linewidth=0.16) {#XSTD_GNNCN:2 (95.5,0) (95.5,0) #RGNN0:1};
// &"GNNA" @WIRE(mode="straight",linecolor="#30485d",linewidth=0.16) {#XSTD_GNNBN:1 (32.5,0) (32.5,0) #XSTD_GNNAN:2};
// &"GNNPRE" @WIRE(mode="straight",linecolor="#30485d",linewidth=0.16) {#XSTD_GNNAN:1 (0.5,0) (0.5,0) #X025:4};
// &"GNPB" @WIRE(mode="straight",linecolor="#30485d",linewidth=0.16) {#XSTD_GNPCN:1 (61.5,-38) (61.5,-38) #XSTD_GNPBN:2};
// &"GNPDRV" @WIRE(mode="straight",linecolor="#30485d",linewidth=0.16) {#XSTD_GNPCN:2 (95.5,-38) (95.5,-38) #RGNP0:1};
// &"GNPA" @WIRE(mode="straight",linecolor="#30485d",linewidth=0.16) {#XSTD_GNPBN:1 (32.5,-38) (32.5,-38) #XSTD_GNPAN:2};
// &"H" @WIRE(mode="straight",linecolor="#30485d",linewidth=0.16) {#XSTD_GNPAN:1 (-6.5,-38) (-6.5,-76) #X008:1};
// &"GPNB" @WIRE(mode="straight",linecolor="#30485d",linewidth=0.16) {#XSTD_GPNCN:1 (61.5,-76) (61.5,-76) #XSTD_GPNBN:2};
// &"GPNDRV" @WIRE(mode="straight",linecolor="#30485d",linewidth=0.16) {#XSTD_GPNCN:2 (95.5,-76) (95.5,-76) #RGPN0:1};
// &"GPNA" @WIRE(mode="straight",linecolor="#30485d",linewidth=0.16) {#XSTD_GPNBN:1 (32.5,-76) (32.5,-76) #XSTD_GPNAN:2};
// &"GPNPRE" @WIRE(mode="straight",linecolor="#30485d",linewidth=0.16) {#XSTD_GPNAN:1 (0.5,-76) (0.5,-76) #X008:4};
// &"GPPB" @WIRE(mode="straight",linecolor="#30485d",linewidth=0.16) {#XSTD_GPPCN:1 (61.5,-114) (61.5,-114) #XSTD_GPPBN:2};
// &"GPPDRV" @WIRE(mode="straight",linecolor="#30485d",linewidth=0.16) {#XSTD_GPPCN:2 (95.5,-114) (95.5,-114) #RGPP0:1};
// &"GPPA" @WIRE(mode="straight",linecolor="#30485d",linewidth=0.16) {#XSTD_GPPBN:1 (32.5,-114) (32.5,-114) #XSTD_GPPAN:2};
// &"GNNRG" @WIRE(mode="straight",linecolor="#30485d",linewidth=0.16) {#RGNN1:1 (222.5,0) (222.5,0) #RGNN0_5__dmy0:2};
// &"RGNN1_1__dmy0" @WIRE(mode="straight",linecolor="#30485d",linewidth=0.16) {#RGNN1:2 (247.5,0) (247.5,0) #RGNN1_2__dmy0:1};
// &"RGNN1_2__dmy0" @WIRE(mode="straight",linecolor="#30485d",linewidth=0.16) {#RGNN1_2__dmy0:2 (272.5,0) (272.5,0) #RGNN1_3__dmy0:1};
// &"RGNN1_3__dmy0" @WIRE(mode="straight",linecolor="#30485d",linewidth=0.16) {#RGNN1_3__dmy0:2 (297.5,0) (297.5,0) #RGNN1_4__dmy0:1};
// &"RGNN1_4__dmy0" @WIRE(mode="straight",linecolor="#30485d",linewidth=0.16) {#RGNN1_4__dmy0:2 (322.5,0) (322.5,0) #RGNN1_5__dmy0:1};
// &"RGNN0_1__dmy0" @WIRE(mode="straight",linecolor="#30485d",linewidth=0.16) {#RGNN0:2 (122.5,0) (122.5,0) #RGNN0_2__dmy0:1};
// &"RGNN0_2__dmy0" @WIRE(mode="straight",linecolor="#30485d",linewidth=0.16) {#RGNN0_2__dmy0:2 (147.5,0) (147.5,0) #RGNN0_3__dmy0:1};
// &"RGNN0_3__dmy0" @WIRE(mode="straight",linecolor="#30485d",linewidth=0.16) {#RGNN0_3__dmy0:2 (172.5,0) (172.5,0) #RGNN0_4__dmy0:1};
// &"RGNN0_4__dmy0" @WIRE(mode="straight",linecolor="#30485d",linewidth=0.16) {#RGNN0_4__dmy0:2 (197.5,0) (197.5,0) #RGNN0_5__dmy0:1};
// &"GNPRG" @WIRE(mode="straight",linecolor="#30485d",linewidth=0.16) {#RGNP1:1 (222.5,-38) (222.5,-38) #RGNP0_5__dmy0:2};
// &"RGNP1_1__dmy0" @WIRE(mode="straight",linecolor="#30485d",linewidth=0.16) {#RGNP1:2 (247.5,-38) (247.5,-38) #RGNP1_2__dmy0:1};
// &"RGNP1_2__dmy0" @WIRE(mode="straight",linecolor="#30485d",linewidth=0.16) {#RGNP1_2__dmy0:2 (272.5,-38) (272.5,-38) #RGNP1_3__dmy0:1};
// &"RGNP1_3__dmy0" @WIRE(mode="straight",linecolor="#30485d",linewidth=0.16) {#RGNP1_3__dmy0:2 (297.5,-38) (297.5,-38) #RGNP1_4__dmy0:1};
// &"RGNP1_4__dmy0" @WIRE(mode="straight",linecolor="#30485d",linewidth=0.16) {#RGNP1_4__dmy0:2 (322.5,-38) (322.5,-38) #RGNP1_5__dmy0:1};
// &"RGNP0_1__dmy0" @WIRE(mode="straight",linecolor="#30485d",linewidth=0.16) {#RGNP0:2 (122.5,-38) (122.5,-38) #RGNP0_2__dmy0:1};
// &"RGNP0_2__dmy0" @WIRE(mode="straight",linecolor="#30485d",linewidth=0.16) {#RGNP0_2__dmy0:2 (147.5,-38) (147.5,-38) #RGNP0_3__dmy0:1};
// &"RGNP0_3__dmy0" @WIRE(mode="straight",linecolor="#30485d",linewidth=0.16) {#RGNP0_3__dmy0:2 (172.5,-38) (172.5,-38) #RGNP0_4__dmy0:1};
// &"RGNP0_4__dmy0" @WIRE(mode="straight",linecolor="#30485d",linewidth=0.16) {#RGNP0_4__dmy0:2 (197.5,-38) (197.5,-38) #RGNP0_5__dmy0:1};
// &"GPNRG" @WIRE(mode="straight",linecolor="#30485d",linewidth=0.16) {#RGPN1:1 (222.5,-76) (222.5,-76) #RGPN0_5__dmy0:2};
// &"RGPN1_1__dmy0" @WIRE(mode="straight",linecolor="#30485d",linewidth=0.16) {#RGPN1:2 (247.5,-76) (247.5,-76) #RGPN1_2__dmy0:1};
// &"RGPN1_2__dmy0" @WIRE(mode="straight",linecolor="#30485d",linewidth=0.16) {#RGPN1_2__dmy0:2 (272.5,-76) (272.5,-76) #RGPN1_3__dmy0:1};
// &"RGPN1_3__dmy0" @WIRE(mode="straight",linecolor="#30485d",linewidth=0.16) {#RGPN1_3__dmy0:2 (297.5,-76) (297.5,-76) #RGPN1_4__dmy0:1};
// &"RGPN1_4__dmy0" @WIRE(mode="straight",linecolor="#30485d",linewidth=0.16) {#RGPN1_4__dmy0:2 (322.5,-76) (322.5,-76) #RGPN1_5__dmy0:1};
// &"RGPN0_1__dmy0" @WIRE(mode="straight",linecolor="#30485d",linewidth=0.16) {#RGPN0:2 (122.5,-76) (122.5,-76) #RGPN0_2__dmy0:1};
// &"RGPN0_2__dmy0" @WIRE(mode="straight",linecolor="#30485d",linewidth=0.16) {#RGPN0_2__dmy0:2 (147.5,-76) (147.5,-76) #RGPN0_3__dmy0:1};
// &"RGPN0_3__dmy0" @WIRE(mode="straight",linecolor="#30485d",linewidth=0.16) {#RGPN0_3__dmy0:2 (172.5,-76) (172.5,-76) #RGPN0_4__dmy0:1};
// &"RGPN0_4__dmy0" @WIRE(mode="straight",linecolor="#30485d",linewidth=0.16) {#RGPN0_4__dmy0:2 (197.5,-76) (197.5,-76) #RGPN0_5__dmy0:1};
// &"GPPRG" @WIRE(mode="straight",linecolor="#30485d",linewidth=0.16) {#RGPP1:1 (222.5,-114) (222.5,-114) #RGPP0_5__dmy0:2};
// &"RGPP1_1__dmy0" @WIRE(mode="straight",linecolor="#30485d",linewidth=0.16) {#RGPP1:2 (247.5,-114) (247.5,-114) #RGPP1_2__dmy0:1};
// &"RGPP1_2__dmy0" @WIRE(mode="straight",linecolor="#30485d",linewidth=0.16) {#RGPP1_2__dmy0:2 (272.5,-114) (272.5,-114) #RGPP1_3__dmy0:1};
// &"RGPP1_3__dmy0" @WIRE(mode="straight",linecolor="#30485d",linewidth=0.16) {#RGPP1_3__dmy0:2 (297.5,-114) (297.5,-114) #RGPP1_4__dmy0:1};
// &"RGPP1_4__dmy0" @WIRE(mode="straight",linecolor="#30485d",linewidth=0.16) {#RGPP1_4__dmy0:2 (322.5,-114) (322.5,-114) #RGPP1_5__dmy0:1};
// &"RGPP0_1__dmy0" @WIRE(mode="straight",linecolor="#30485d",linewidth=0.16) {#RGPP0:2 (122.5,-114) (122.5,-114) #RGPP0_2__dmy0:1};
// &"RGPP0_2__dmy0" @WIRE(mode="straight",linecolor="#30485d",linewidth=0.16) {#RGPP0_2__dmy0:2 (147.5,-114) (147.5,-114) #RGPP0_3__dmy0:1};
// &"RGPP0_3__dmy0" @WIRE(mode="straight",linecolor="#30485d",linewidth=0.16) {#RGPP0_3__dmy0:2 (172.5,-114) (172.5,-114) #RGPP0_4__dmy0:1};
// &"RGPP0_4__dmy0" @WIRE(mode="straight",linecolor="#30485d",linewidth=0.16) {#RGPP0_4__dmy0:2 (197.5,-114) (197.5,-114) #RGPP0_5__dmy0:1};
// (-28,-148) @TEXT("GP and GN chains keep their source polarity, device sizing and series R; no zero-delay abstraction.",size=1,halign="start",textcolor="#223d52");
// &"VDD" @WIRE(mode="straight",linecolor="#30485d",linewidth=0.16) {#XSTD_GNNCN:3 (76,10)};
// (76,10.4) @TEXT("VDD",size=1.1,halign="middle",valign="bottom");
// &"VSS" @WIRE(mode="straight",linecolor="#30485d",linewidth=0.16) {#XSTD_GNNCN:4 (76,-10)};
// (76,-10.4) @TEXT("VSS",size=1.1,halign="middle",valign="top");
// &"VDD" @WIRE(mode="straight",linecolor="#30485d",linewidth=0.16) {#XSTD_GNNBN:3 (47,10)};
// (47,10.4) @TEXT("VDD",size=1.1,halign="middle",valign="bottom");
// &"VSS" @WIRE(mode="straight",linecolor="#30485d",linewidth=0.16) {#XSTD_GNNBN:4 (47,-10)};
// (47,-10.4) @TEXT("VSS",size=1.1,halign="middle",valign="top");
// &"VDD" @WIRE(mode="straight",linecolor="#30485d",linewidth=0.16) {#XSTD_GNNAN:3 (18,10)};
// (18,10.4) @TEXT("VDD",size=1.1,halign="middle",valign="bottom");
// &"VSS" @WIRE(mode="straight",linecolor="#30485d",linewidth=0.16) {#XSTD_GNNAN:4 (18,-10)};
// (18,-10.4) @TEXT("VSS",size=1.1,halign="middle",valign="top");
// &"VDD" @WIRE(mode="straight",linecolor="#30485d",linewidth=0.16) {#XSTD_GNPCN:3 (76,-28)};
// (76,-27.6) @TEXT("VDD",size=1.1,halign="middle",valign="bottom");
// &"VSS" @WIRE(mode="straight",linecolor="#30485d",linewidth=0.16) {#XSTD_GNPCN:4 (76,-48)};
// (76,-48.4) @TEXT("VSS",size=1.1,halign="middle",valign="top");
// &"VDD" @WIRE(mode="straight",linecolor="#30485d",linewidth=0.16) {#XSTD_GNPBN:3 (47,-28)};
// (47,-27.6) @TEXT("VDD",size=1.1,halign="middle",valign="bottom");
// &"VSS" @WIRE(mode="straight",linecolor="#30485d",linewidth=0.16) {#XSTD_GNPBN:4 (47,-48)};
// (47,-48.4) @TEXT("VSS",size=1.1,halign="middle",valign="top");
// &"VDD" @WIRE(mode="straight",linecolor="#30485d",linewidth=0.16) {#XSTD_GNPAN:3 (18,-28)};
// (18,-27.6) @TEXT("VDD",size=1.1,halign="middle",valign="bottom");
// &"VSS" @WIRE(mode="straight",linecolor="#30485d",linewidth=0.16) {#XSTD_GNPAN:4 (18,-48)};
// (18,-48.4) @TEXT("VSS",size=1.1,halign="middle",valign="top");
// &"VDD" @WIRE(mode="straight",linecolor="#30485d",linewidth=0.16) {#XSTD_GPNCN:3 (76,-66)};
// (76,-65.6) @TEXT("VDD",size=1.1,halign="middle",valign="bottom");
// &"VSS" @WIRE(mode="straight",linecolor="#30485d",linewidth=0.16) {#XSTD_GPNCN:4 (76,-86)};
// (76,-86.4) @TEXT("VSS",size=1.1,halign="middle",valign="top");
// &"VDD" @WIRE(mode="straight",linecolor="#30485d",linewidth=0.16) {#XSTD_GPNBN:3 (47,-66)};
// (47,-65.6) @TEXT("VDD",size=1.1,halign="middle",valign="bottom");
// &"VSS" @WIRE(mode="straight",linecolor="#30485d",linewidth=0.16) {#XSTD_GPNBN:4 (47,-86)};
// (47,-86.4) @TEXT("VSS",size=1.1,halign="middle",valign="top");
// &"VDD" @WIRE(mode="straight",linecolor="#30485d",linewidth=0.16) {#XSTD_GPNAN:3 (18,-66)};
// (18,-65.6) @TEXT("VDD",size=1.1,halign="middle",valign="bottom");
// &"VSS" @WIRE(mode="straight",linecolor="#30485d",linewidth=0.16) {#XSTD_GPNAN:4 (18,-86)};
// (18,-86.4) @TEXT("VSS",size=1.1,halign="middle",valign="top");
// &"VDD" @WIRE(mode="straight",linecolor="#30485d",linewidth=0.16) {#XSTD_GPPCN:3 (76,-104)};
// (76,-103.6) @TEXT("VDD",size=1.1,halign="middle",valign="bottom");
// &"VSS" @WIRE(mode="straight",linecolor="#30485d",linewidth=0.16) {#XSTD_GPPCN:4 (76,-124)};
// (76,-124.4) @TEXT("VSS",size=1.1,halign="middle",valign="top");
// &"VDD" @WIRE(mode="straight",linecolor="#30485d",linewidth=0.16) {#XSTD_GPPBN:3 (47,-104)};
// (47,-103.6) @TEXT("VDD",size=1.1,halign="middle",valign="bottom");
// &"VSS" @WIRE(mode="straight",linecolor="#30485d",linewidth=0.16) {#XSTD_GPPBN:4 (47,-124)};
// (47,-124.4) @TEXT("VSS",size=1.1,halign="middle",valign="top");
// &"L" @WIRE(mode="straight",linecolor="#30485d",linewidth=0.16) {#XSTD_GPPAN:1 (8,-114)};
// (7.6,-114) @TEXT("L",size=1.1,halign="end",valign="middle");
// &"VDD" @WIRE(mode="straight",linecolor="#30485d",linewidth=0.16) {#XSTD_GPPAN:3 (18,-104)};
// (18,-103.6) @TEXT("VDD",size=1.1,halign="middle",valign="bottom");
// &"VSS" @WIRE(mode="straight",linecolor="#30485d",linewidth=0.16) {#XSTD_GPPAN:4 (18,-124)};
// (18,-124.4) @TEXT("VSS",size=1.1,halign="middle",valign="top");
// &"GNN" @WIRE(mode="straight",linecolor="#30485d",linewidth=0.16) {#RGNN1_5__dmy0:2 (340,0)};
// (340.4,0) @TEXT("GNN",size=1.1,halign="start",valign="middle");
// &"GNP" @WIRE(mode="straight",linecolor="#30485d",linewidth=0.16) {#RGNP1_5__dmy0:2 (340,-38)};
// (340.4,-38) @TEXT("GNP",size=1.1,halign="start",valign="middle");
// &"GPN" @WIRE(mode="straight",linecolor="#30485d",linewidth=0.16) {#RGPN1_5__dmy0:2 (340,-76)};
// (340.4,-76) @TEXT("GPN",size=1.1,halign="start",valign="middle");
// &"GPP" @WIRE(mode="straight",linecolor="#30485d",linewidth=0.16) {#RGPP1_5__dmy0:2 (340,-114)};
// (340.4,-114) @TEXT("GPP",size=1.1,halign="start",valign="middle");
// &"L" @WIRE(mode="straight",linecolor="#30485d",linewidth=0.16) {#X025:1 (-27,0)};
// (-27.4,0) @TEXT("L",size=1.1,halign="end",valign="middle");
// &"VDD" @WIRE(mode="straight",linecolor="#30485d",linewidth=0.16) {#X025:2 (-17,10)};
// (-17,10.4) @TEXT("VDD",size=1.1,halign="middle",valign="bottom");
// &"VSS" @WIRE(mode="straight",linecolor="#30485d",linewidth=0.16) {#X025:3 (-17,-10)};
// (-17,-10.4) @TEXT("VSS",size=1.1,halign="middle",valign="top");
// &"VDD" @WIRE(mode="straight",linecolor="#30485d",linewidth=0.16) {#X008:2 (-17,-66)};
// (-17,-65.6) @TEXT("VDD",size=1.1,halign="middle",valign="bottom");
// &"VSS" @WIRE(mode="straight",linecolor="#30485d",linewidth=0.16) {#X008:3 (-17,-86)};
// (-17,-86.4) @TEXT("VSS",size=1.1,halign="middle",valign="top");
// }
// END SARADC RNL
ends sar8p_refdrv_b0

subckt sar8p_refdrv_b1 GNN GNP GPN GPP H L VDD VSS
    XSTD_GNNCN (GNNB GNNDRV VDD VSS) INVD1BWP12T30P140
    XSTD_GNNBN (GNNA GNNB VDD VSS) INVD1BWP12T30P140
    XSTD_GNNAN (GNNPRE GNNA VDD VSS) INVD1BWP12T30P140
    XSTD_GNPCN (GNPB GNPDRV VDD VSS) INVD1BWP12T30P140
    XSTD_GNPBN (GNPA GNPB VDD VSS) INVD1BWP12T30P140
    XSTD_GNPAN (H GNPA VDD VSS) INVD1BWP12T30P140
    XSTD_GPNCN (GPNB GPNDRV VDD VSS) INVD1BWP12T30P140
    XSTD_GPNBN (GPNA GPNB VDD VSS) INVD1BWP12T30P140
    XSTD_GPNAN (GPNPRE GPNA VDD VSS) INVD1BWP12T30P140
    XSTD_GPPCN (GPPB GPPDRV VDD VSS) INVD1BWP12T30P140
    XSTD_GPPBN (GPPA GPPB VDD VSS) INVD1BWP12T30P140
    XSTD_GPPAN (L GPPA VDD VSS) INVD1BWP12T30P140
//Series configuration of RGNN1
RGNN1  (GNNRG RGNN1_1__dmy0 ) rupolym l=17.13u w=1u m=2 multi=(1)
RGNN1_2__dmy0  (RGNN1_1__dmy0 RGNN1_2__dmy0 ) rupolym l=17.13u w=1u m=2 \
        multi=(1)
RGNN1_3__dmy0  (RGNN1_2__dmy0 RGNN1_3__dmy0 ) rupolym l=17.13u w=1u m=2 \
        multi=(1)
RGNN1_4__dmy0  (RGNN1_3__dmy0 RGNN1_4__dmy0 ) rupolym l=17.13u w=1u m=2 \
        multi=(1)
RGNN1_5__dmy0  (RGNN1_4__dmy0 GNN ) rupolym l=17.13u w=1u m=2 multi=(1)
//End of RGNN1

//Series configuration of RGNN0
RGNN0  (GNNDRV RGNN0_1__dmy0 ) rupolym l=17.13u w=1u m=2 multi=(1)
RGNN0_2__dmy0  (RGNN0_1__dmy0 RGNN0_2__dmy0 ) rupolym l=17.13u w=1u m=2 \
        multi=(1)
RGNN0_3__dmy0  (RGNN0_2__dmy0 RGNN0_3__dmy0 ) rupolym l=17.13u w=1u m=2 \
        multi=(1)
RGNN0_4__dmy0  (RGNN0_3__dmy0 RGNN0_4__dmy0 ) rupolym l=17.13u w=1u m=2 \
        multi=(1)
RGNN0_5__dmy0  (RGNN0_4__dmy0 GNNRG ) rupolym l=17.13u w=1u m=2 multi=(1)
//End of RGNN0

//Series configuration of RGNP1
RGNP1  (GNPRG RGNP1_1__dmy0 ) rupolym l=17.13u w=1u m=2 multi=(1)
RGNP1_2__dmy0  (RGNP1_1__dmy0 RGNP1_2__dmy0 ) rupolym l=17.13u w=1u m=2 \
        multi=(1)
RGNP1_3__dmy0  (RGNP1_2__dmy0 RGNP1_3__dmy0 ) rupolym l=17.13u w=1u m=2 \
        multi=(1)
RGNP1_4__dmy0  (RGNP1_3__dmy0 RGNP1_4__dmy0 ) rupolym l=17.13u w=1u m=2 \
        multi=(1)
RGNP1_5__dmy0  (RGNP1_4__dmy0 GNP ) rupolym l=17.13u w=1u m=2 multi=(1)
//End of RGNP1

//Series configuration of RGNP0
RGNP0  (GNPDRV RGNP0_1__dmy0 ) rupolym l=17.13u w=1u m=2 multi=(1)
RGNP0_2__dmy0  (RGNP0_1__dmy0 RGNP0_2__dmy0 ) rupolym l=17.13u w=1u m=2 \
        multi=(1)
RGNP0_3__dmy0  (RGNP0_2__dmy0 RGNP0_3__dmy0 ) rupolym l=17.13u w=1u m=2 \
        multi=(1)
RGNP0_4__dmy0  (RGNP0_3__dmy0 RGNP0_4__dmy0 ) rupolym l=17.13u w=1u m=2 \
        multi=(1)
RGNP0_5__dmy0  (RGNP0_4__dmy0 GNPRG ) rupolym l=17.13u w=1u m=2 multi=(1)
//End of RGNP0

//Series configuration of RGPN1
RGPN1  (GPNRG RGPN1_1__dmy0 ) rupolym l=17.13u w=1u m=2 multi=(1)
RGPN1_2__dmy0  (RGPN1_1__dmy0 RGPN1_2__dmy0 ) rupolym l=17.13u w=1u m=2 \
        multi=(1)
RGPN1_3__dmy0  (RGPN1_2__dmy0 RGPN1_3__dmy0 ) rupolym l=17.13u w=1u m=2 \
        multi=(1)
RGPN1_4__dmy0  (RGPN1_3__dmy0 RGPN1_4__dmy0 ) rupolym l=17.13u w=1u m=2 \
        multi=(1)
RGPN1_5__dmy0  (RGPN1_4__dmy0 GPN ) rupolym l=17.13u w=1u m=2 multi=(1)
//End of RGPN1

//Series configuration of RGPN0
RGPN0  (GPNDRV RGPN0_1__dmy0 ) rupolym l=17.13u w=1u m=2 multi=(1)
RGPN0_2__dmy0  (RGPN0_1__dmy0 RGPN0_2__dmy0 ) rupolym l=17.13u w=1u m=2 \
        multi=(1)
RGPN0_3__dmy0  (RGPN0_2__dmy0 RGPN0_3__dmy0 ) rupolym l=17.13u w=1u m=2 \
        multi=(1)
RGPN0_4__dmy0  (RGPN0_3__dmy0 RGPN0_4__dmy0 ) rupolym l=17.13u w=1u m=2 \
        multi=(1)
RGPN0_5__dmy0  (RGPN0_4__dmy0 GPNRG ) rupolym l=17.13u w=1u m=2 multi=(1)
//End of RGPN0

//Series configuration of RGPP1
RGPP1  (GPPRG RGPP1_1__dmy0 ) rupolym l=17.13u w=1u m=2 multi=(1)
RGPP1_2__dmy0  (RGPP1_1__dmy0 RGPP1_2__dmy0 ) rupolym l=17.13u w=1u m=2 \
        multi=(1)
RGPP1_3__dmy0  (RGPP1_2__dmy0 RGPP1_3__dmy0 ) rupolym l=17.13u w=1u m=2 \
        multi=(1)
RGPP1_4__dmy0  (RGPP1_3__dmy0 RGPP1_4__dmy0 ) rupolym l=17.13u w=1u m=2 \
        multi=(1)
RGPP1_5__dmy0  (RGPP1_4__dmy0 GPP ) rupolym l=17.13u w=1u m=2 multi=(1)
//End of RGPP1

//Series configuration of RGPP0
RGPP0  (GPPDRV RGPP0_1__dmy0 ) rupolym l=17.13u w=1u m=2 multi=(1)
RGPP0_2__dmy0  (RGPP0_1__dmy0 RGPP0_2__dmy0 ) rupolym l=17.13u w=1u m=2 \
        multi=(1)
RGPP0_3__dmy0  (RGPP0_2__dmy0 RGPP0_3__dmy0 ) rupolym l=17.13u w=1u m=2 \
        multi=(1)
RGPP0_4__dmy0  (RGPP0_3__dmy0 RGPP0_4__dmy0 ) rupolym l=17.13u w=1u m=2 \
        multi=(1)
RGPP0_5__dmy0  (RGPP0_4__dmy0 GPPRG ) rupolym l=17.13u w=1u m=2 multi=(1)
//End of RGPP0

    X025 (L VDD VSS GNNPRE) sar8p_inv
    X008 (H VDD VSS GPNPRE) sar8p_inv
// BEGIN SARADC RNL
// @RNL(author="saradc topology") {
// (-28,27) @TEXT("sar8p_refdrv_b1 / four physical gate-driver chains",size=1.5,halign="start",textcolor="#223d52");
// #X025 @SET-SYMBOL $S_sar8p_inv;
// #X025 @PLACE(-17,0) => @ORIENT("R0");
// #XSTD_GNNAN @SET-SYMBOL $S_INVD1BWP12T30P140;
// #XSTD_GNNAN @PLACE(18,0) => @ORIENT("R0");
// #XSTD_GNNBN @SET-SYMBOL $S_INVD1BWP12T30P140;
// #XSTD_GNNBN @PLACE(47,0) => @ORIENT("R0");
// #XSTD_GNNCN @SET-SYMBOL $S_INVD1BWP12T30P140;
// #XSTD_GNNCN @PLACE(76,0) => @ORIENT("R0");
// #RGNN0 @SET-SYMBOL $RESISTOR;
// #RGNN0 @PLACE(110,0) => @ORIENT("R90");
// #RGNN0 @TEXT("RGNN0",key="name",size=1.3,halign="start") => @PLACE(113,3);
// #RGNN0 @TEXT("l=17.13u w=1u multi=(1)",key="value",size=0.9,halign="start") => @PLACE(113,-4);
// #RGNN0 @TEXT("",key="model");
// #RGNN0_2__dmy0 @SET-SYMBOL $RESISTOR;
// #RGNN0_2__dmy0 @PLACE(135,0) => @ORIENT("R90");
// #RGNN0_2__dmy0 @TEXT("RGNN0_2__dmy0",key="name",size=1.3,halign="start") => @PLACE(138,3);
// #RGNN0_2__dmy0 @TEXT("l=17.13u w=1u multi=(1)",key="value",size=0.9,halign="start") => @PLACE(138,-4);
// #RGNN0_2__dmy0 @TEXT("",key="model");
// #RGNN0_3__dmy0 @SET-SYMBOL $RESISTOR;
// #RGNN0_3__dmy0 @PLACE(160,0) => @ORIENT("R90");
// #RGNN0_3__dmy0 @TEXT("RGNN0_3__dmy0",key="name",size=1.3,halign="start") => @PLACE(163,3);
// #RGNN0_3__dmy0 @TEXT("l=17.13u w=1u multi=(1)",key="value",size=0.9,halign="start") => @PLACE(163,-4);
// #RGNN0_3__dmy0 @TEXT("",key="model");
// #RGNN0_4__dmy0 @SET-SYMBOL $RESISTOR;
// #RGNN0_4__dmy0 @PLACE(185,0) => @ORIENT("R90");
// #RGNN0_4__dmy0 @TEXT("RGNN0_4__dmy0",key="name",size=1.3,halign="start") => @PLACE(188,3);
// #RGNN0_4__dmy0 @TEXT("l=17.13u w=1u multi=(1)",key="value",size=0.9,halign="start") => @PLACE(188,-4);
// #RGNN0_4__dmy0 @TEXT("",key="model");
// #RGNN0_5__dmy0 @SET-SYMBOL $RESISTOR;
// #RGNN0_5__dmy0 @PLACE(210,0) => @ORIENT("R90");
// #RGNN0_5__dmy0 @TEXT("RGNN0_5__dmy0",key="name",size=1.3,halign="start") => @PLACE(213,3);
// #RGNN0_5__dmy0 @TEXT("l=17.13u w=1u multi=(1)",key="value",size=0.9,halign="start") => @PLACE(213,-4);
// #RGNN0_5__dmy0 @TEXT("",key="model");
// #RGNN1 @SET-SYMBOL $RESISTOR;
// #RGNN1 @PLACE(235,0) => @ORIENT("R90");
// #RGNN1 @TEXT("RGNN1",key="name",size=1.3,halign="start") => @PLACE(238,3);
// #RGNN1 @TEXT("l=17.13u w=1u multi=(1)",key="value",size=0.9,halign="start") => @PLACE(238,-4);
// #RGNN1 @TEXT("",key="model");
// #RGNN1_2__dmy0 @SET-SYMBOL $RESISTOR;
// #RGNN1_2__dmy0 @PLACE(260,0) => @ORIENT("R90");
// #RGNN1_2__dmy0 @TEXT("RGNN1_2__dmy0",key="name",size=1.3,halign="start") => @PLACE(263,3);
// #RGNN1_2__dmy0 @TEXT("l=17.13u w=1u multi=(1)",key="value",size=0.9,halign="start") => @PLACE(263,-4);
// #RGNN1_2__dmy0 @TEXT("",key="model");
// #RGNN1_3__dmy0 @SET-SYMBOL $RESISTOR;
// #RGNN1_3__dmy0 @PLACE(285,0) => @ORIENT("R90");
// #RGNN1_3__dmy0 @TEXT("RGNN1_3__dmy0",key="name",size=1.3,halign="start") => @PLACE(288,3);
// #RGNN1_3__dmy0 @TEXT("l=17.13u w=1u multi=(1)",key="value",size=0.9,halign="start") => @PLACE(288,-4);
// #RGNN1_3__dmy0 @TEXT("",key="model");
// #RGNN1_4__dmy0 @SET-SYMBOL $RESISTOR;
// #RGNN1_4__dmy0 @PLACE(310,0) => @ORIENT("R90");
// #RGNN1_4__dmy0 @TEXT("RGNN1_4__dmy0",key="name",size=1.3,halign="start") => @PLACE(313,3);
// #RGNN1_4__dmy0 @TEXT("l=17.13u w=1u multi=(1)",key="value",size=0.9,halign="start") => @PLACE(313,-4);
// #RGNN1_4__dmy0 @TEXT("",key="model");
// #RGNN1_5__dmy0 @SET-SYMBOL $RESISTOR;
// #RGNN1_5__dmy0 @PLACE(335,0) => @ORIENT("R90");
// #RGNN1_5__dmy0 @TEXT("RGNN1_5__dmy0",key="name",size=1.3,halign="start") => @PLACE(338,3);
// #RGNN1_5__dmy0 @TEXT("l=17.13u w=1u multi=(1)",key="value",size=0.9,halign="start") => @PLACE(338,-4);
// #RGNN1_5__dmy0 @TEXT("",key="model");
// (104,15) @TEXT("GNN / 10 series poly sections",size=0.95,halign="start",textcolor="#223d52");
// #XSTD_GNPAN @SET-SYMBOL $S_INVD1BWP12T30P140;
// #XSTD_GNPAN @PLACE(18,-38) => @ORIENT("R0");
// #XSTD_GNPBN @SET-SYMBOL $S_INVD1BWP12T30P140;
// #XSTD_GNPBN @PLACE(47,-38) => @ORIENT("R0");
// #XSTD_GNPCN @SET-SYMBOL $S_INVD1BWP12T30P140;
// #XSTD_GNPCN @PLACE(76,-38) => @ORIENT("R0");
// #RGNP0 @SET-SYMBOL $RESISTOR;
// #RGNP0 @PLACE(110,-38) => @ORIENT("R90");
// #RGNP0 @TEXT("RGNP0",key="name",size=1.3,halign="start") => @PLACE(113,-35);
// #RGNP0 @TEXT("l=17.13u w=1u multi=(1)",key="value",size=0.9,halign="start") => @PLACE(113,-42);
// #RGNP0 @TEXT("",key="model");
// #RGNP0_2__dmy0 @SET-SYMBOL $RESISTOR;
// #RGNP0_2__dmy0 @PLACE(135,-38) => @ORIENT("R90");
// #RGNP0_2__dmy0 @TEXT("RGNP0_2__dmy0",key="name",size=1.3,halign="start") => @PLACE(138,-35);
// #RGNP0_2__dmy0 @TEXT("l=17.13u w=1u multi=(1)",key="value",size=0.9,halign="start") => @PLACE(138,-42);
// #RGNP0_2__dmy0 @TEXT("",key="model");
// #RGNP0_3__dmy0 @SET-SYMBOL $RESISTOR;
// #RGNP0_3__dmy0 @PLACE(160,-38) => @ORIENT("R90");
// #RGNP0_3__dmy0 @TEXT("RGNP0_3__dmy0",key="name",size=1.3,halign="start") => @PLACE(163,-35);
// #RGNP0_3__dmy0 @TEXT("l=17.13u w=1u multi=(1)",key="value",size=0.9,halign="start") => @PLACE(163,-42);
// #RGNP0_3__dmy0 @TEXT("",key="model");
// #RGNP0_4__dmy0 @SET-SYMBOL $RESISTOR;
// #RGNP0_4__dmy0 @PLACE(185,-38) => @ORIENT("R90");
// #RGNP0_4__dmy0 @TEXT("RGNP0_4__dmy0",key="name",size=1.3,halign="start") => @PLACE(188,-35);
// #RGNP0_4__dmy0 @TEXT("l=17.13u w=1u multi=(1)",key="value",size=0.9,halign="start") => @PLACE(188,-42);
// #RGNP0_4__dmy0 @TEXT("",key="model");
// #RGNP0_5__dmy0 @SET-SYMBOL $RESISTOR;
// #RGNP0_5__dmy0 @PLACE(210,-38) => @ORIENT("R90");
// #RGNP0_5__dmy0 @TEXT("RGNP0_5__dmy0",key="name",size=1.3,halign="start") => @PLACE(213,-35);
// #RGNP0_5__dmy0 @TEXT("l=17.13u w=1u multi=(1)",key="value",size=0.9,halign="start") => @PLACE(213,-42);
// #RGNP0_5__dmy0 @TEXT("",key="model");
// #RGNP1 @SET-SYMBOL $RESISTOR;
// #RGNP1 @PLACE(235,-38) => @ORIENT("R90");
// #RGNP1 @TEXT("RGNP1",key="name",size=1.3,halign="start") => @PLACE(238,-35);
// #RGNP1 @TEXT("l=17.13u w=1u multi=(1)",key="value",size=0.9,halign="start") => @PLACE(238,-42);
// #RGNP1 @TEXT("",key="model");
// #RGNP1_2__dmy0 @SET-SYMBOL $RESISTOR;
// #RGNP1_2__dmy0 @PLACE(260,-38) => @ORIENT("R90");
// #RGNP1_2__dmy0 @TEXT("RGNP1_2__dmy0",key="name",size=1.3,halign="start") => @PLACE(263,-35);
// #RGNP1_2__dmy0 @TEXT("l=17.13u w=1u multi=(1)",key="value",size=0.9,halign="start") => @PLACE(263,-42);
// #RGNP1_2__dmy0 @TEXT("",key="model");
// #RGNP1_3__dmy0 @SET-SYMBOL $RESISTOR;
// #RGNP1_3__dmy0 @PLACE(285,-38) => @ORIENT("R90");
// #RGNP1_3__dmy0 @TEXT("RGNP1_3__dmy0",key="name",size=1.3,halign="start") => @PLACE(288,-35);
// #RGNP1_3__dmy0 @TEXT("l=17.13u w=1u multi=(1)",key="value",size=0.9,halign="start") => @PLACE(288,-42);
// #RGNP1_3__dmy0 @TEXT("",key="model");
// #RGNP1_4__dmy0 @SET-SYMBOL $RESISTOR;
// #RGNP1_4__dmy0 @PLACE(310,-38) => @ORIENT("R90");
// #RGNP1_4__dmy0 @TEXT("RGNP1_4__dmy0",key="name",size=1.3,halign="start") => @PLACE(313,-35);
// #RGNP1_4__dmy0 @TEXT("l=17.13u w=1u multi=(1)",key="value",size=0.9,halign="start") => @PLACE(313,-42);
// #RGNP1_4__dmy0 @TEXT("",key="model");
// #RGNP1_5__dmy0 @SET-SYMBOL $RESISTOR;
// #RGNP1_5__dmy0 @PLACE(335,-38) => @ORIENT("R90");
// #RGNP1_5__dmy0 @TEXT("RGNP1_5__dmy0",key="name",size=1.3,halign="start") => @PLACE(338,-35);
// #RGNP1_5__dmy0 @TEXT("l=17.13u w=1u multi=(1)",key="value",size=0.9,halign="start") => @PLACE(338,-42);
// #RGNP1_5__dmy0 @TEXT("",key="model");
// (104,-23) @TEXT("GNP / 10 series poly sections",size=0.95,halign="start",textcolor="#223d52");
// #X008 @SET-SYMBOL $S_sar8p_inv;
// #X008 @PLACE(-17,-76) => @ORIENT("R0");
// #XSTD_GPNAN @SET-SYMBOL $S_INVD1BWP12T30P140;
// #XSTD_GPNAN @PLACE(18,-76) => @ORIENT("R0");
// #XSTD_GPNBN @SET-SYMBOL $S_INVD1BWP12T30P140;
// #XSTD_GPNBN @PLACE(47,-76) => @ORIENT("R0");
// #XSTD_GPNCN @SET-SYMBOL $S_INVD1BWP12T30P140;
// #XSTD_GPNCN @PLACE(76,-76) => @ORIENT("R0");
// #RGPN0 @SET-SYMBOL $RESISTOR;
// #RGPN0 @PLACE(110,-76) => @ORIENT("R90");
// #RGPN0 @TEXT("RGPN0",key="name",size=1.3,halign="start") => @PLACE(113,-73);
// #RGPN0 @TEXT("l=17.13u w=1u multi=(1)",key="value",size=0.9,halign="start") => @PLACE(113,-80);
// #RGPN0 @TEXT("",key="model");
// #RGPN0_2__dmy0 @SET-SYMBOL $RESISTOR;
// #RGPN0_2__dmy0 @PLACE(135,-76) => @ORIENT("R90");
// #RGPN0_2__dmy0 @TEXT("RGPN0_2__dmy0",key="name",size=1.3,halign="start") => @PLACE(138,-73);
// #RGPN0_2__dmy0 @TEXT("l=17.13u w=1u multi=(1)",key="value",size=0.9,halign="start") => @PLACE(138,-80);
// #RGPN0_2__dmy0 @TEXT("",key="model");
// #RGPN0_3__dmy0 @SET-SYMBOL $RESISTOR;
// #RGPN0_3__dmy0 @PLACE(160,-76) => @ORIENT("R90");
// #RGPN0_3__dmy0 @TEXT("RGPN0_3__dmy0",key="name",size=1.3,halign="start") => @PLACE(163,-73);
// #RGPN0_3__dmy0 @TEXT("l=17.13u w=1u multi=(1)",key="value",size=0.9,halign="start") => @PLACE(163,-80);
// #RGPN0_3__dmy0 @TEXT("",key="model");
// #RGPN0_4__dmy0 @SET-SYMBOL $RESISTOR;
// #RGPN0_4__dmy0 @PLACE(185,-76) => @ORIENT("R90");
// #RGPN0_4__dmy0 @TEXT("RGPN0_4__dmy0",key="name",size=1.3,halign="start") => @PLACE(188,-73);
// #RGPN0_4__dmy0 @TEXT("l=17.13u w=1u multi=(1)",key="value",size=0.9,halign="start") => @PLACE(188,-80);
// #RGPN0_4__dmy0 @TEXT("",key="model");
// #RGPN0_5__dmy0 @SET-SYMBOL $RESISTOR;
// #RGPN0_5__dmy0 @PLACE(210,-76) => @ORIENT("R90");
// #RGPN0_5__dmy0 @TEXT("RGPN0_5__dmy0",key="name",size=1.3,halign="start") => @PLACE(213,-73);
// #RGPN0_5__dmy0 @TEXT("l=17.13u w=1u multi=(1)",key="value",size=0.9,halign="start") => @PLACE(213,-80);
// #RGPN0_5__dmy0 @TEXT("",key="model");
// #RGPN1 @SET-SYMBOL $RESISTOR;
// #RGPN1 @PLACE(235,-76) => @ORIENT("R90");
// #RGPN1 @TEXT("RGPN1",key="name",size=1.3,halign="start") => @PLACE(238,-73);
// #RGPN1 @TEXT("l=17.13u w=1u multi=(1)",key="value",size=0.9,halign="start") => @PLACE(238,-80);
// #RGPN1 @TEXT("",key="model");
// #RGPN1_2__dmy0 @SET-SYMBOL $RESISTOR;
// #RGPN1_2__dmy0 @PLACE(260,-76) => @ORIENT("R90");
// #RGPN1_2__dmy0 @TEXT("RGPN1_2__dmy0",key="name",size=1.3,halign="start") => @PLACE(263,-73);
// #RGPN1_2__dmy0 @TEXT("l=17.13u w=1u multi=(1)",key="value",size=0.9,halign="start") => @PLACE(263,-80);
// #RGPN1_2__dmy0 @TEXT("",key="model");
// #RGPN1_3__dmy0 @SET-SYMBOL $RESISTOR;
// #RGPN1_3__dmy0 @PLACE(285,-76) => @ORIENT("R90");
// #RGPN1_3__dmy0 @TEXT("RGPN1_3__dmy0",key="name",size=1.3,halign="start") => @PLACE(288,-73);
// #RGPN1_3__dmy0 @TEXT("l=17.13u w=1u multi=(1)",key="value",size=0.9,halign="start") => @PLACE(288,-80);
// #RGPN1_3__dmy0 @TEXT("",key="model");
// #RGPN1_4__dmy0 @SET-SYMBOL $RESISTOR;
// #RGPN1_4__dmy0 @PLACE(310,-76) => @ORIENT("R90");
// #RGPN1_4__dmy0 @TEXT("RGPN1_4__dmy0",key="name",size=1.3,halign="start") => @PLACE(313,-73);
// #RGPN1_4__dmy0 @TEXT("l=17.13u w=1u multi=(1)",key="value",size=0.9,halign="start") => @PLACE(313,-80);
// #RGPN1_4__dmy0 @TEXT("",key="model");
// #RGPN1_5__dmy0 @SET-SYMBOL $RESISTOR;
// #RGPN1_5__dmy0 @PLACE(335,-76) => @ORIENT("R90");
// #RGPN1_5__dmy0 @TEXT("RGPN1_5__dmy0",key="name",size=1.3,halign="start") => @PLACE(338,-73);
// #RGPN1_5__dmy0 @TEXT("l=17.13u w=1u multi=(1)",key="value",size=0.9,halign="start") => @PLACE(338,-80);
// #RGPN1_5__dmy0 @TEXT("",key="model");
// (104,-61) @TEXT("GPN / 10 series poly sections",size=0.95,halign="start",textcolor="#223d52");
// #XSTD_GPPAN @SET-SYMBOL $S_INVD1BWP12T30P140;
// #XSTD_GPPAN @PLACE(18,-114) => @ORIENT("R0");
// #XSTD_GPPBN @SET-SYMBOL $S_INVD1BWP12T30P140;
// #XSTD_GPPBN @PLACE(47,-114) => @ORIENT("R0");
// #XSTD_GPPCN @SET-SYMBOL $S_INVD1BWP12T30P140;
// #XSTD_GPPCN @PLACE(76,-114) => @ORIENT("R0");
// #RGPP0 @SET-SYMBOL $RESISTOR;
// #RGPP0 @PLACE(110,-114) => @ORIENT("R90");
// #RGPP0 @TEXT("RGPP0",key="name",size=1.3,halign="start") => @PLACE(113,-111);
// #RGPP0 @TEXT("l=17.13u w=1u multi=(1)",key="value",size=0.9,halign="start") => @PLACE(113,-118);
// #RGPP0 @TEXT("",key="model");
// #RGPP0_2__dmy0 @SET-SYMBOL $RESISTOR;
// #RGPP0_2__dmy0 @PLACE(135,-114) => @ORIENT("R90");
// #RGPP0_2__dmy0 @TEXT("RGPP0_2__dmy0",key="name",size=1.3,halign="start") => @PLACE(138,-111);
// #RGPP0_2__dmy0 @TEXT("l=17.13u w=1u multi=(1)",key="value",size=0.9,halign="start") => @PLACE(138,-118);
// #RGPP0_2__dmy0 @TEXT("",key="model");
// #RGPP0_3__dmy0 @SET-SYMBOL $RESISTOR;
// #RGPP0_3__dmy0 @PLACE(160,-114) => @ORIENT("R90");
// #RGPP0_3__dmy0 @TEXT("RGPP0_3__dmy0",key="name",size=1.3,halign="start") => @PLACE(163,-111);
// #RGPP0_3__dmy0 @TEXT("l=17.13u w=1u multi=(1)",key="value",size=0.9,halign="start") => @PLACE(163,-118);
// #RGPP0_3__dmy0 @TEXT("",key="model");
// #RGPP0_4__dmy0 @SET-SYMBOL $RESISTOR;
// #RGPP0_4__dmy0 @PLACE(185,-114) => @ORIENT("R90");
// #RGPP0_4__dmy0 @TEXT("RGPP0_4__dmy0",key="name",size=1.3,halign="start") => @PLACE(188,-111);
// #RGPP0_4__dmy0 @TEXT("l=17.13u w=1u multi=(1)",key="value",size=0.9,halign="start") => @PLACE(188,-118);
// #RGPP0_4__dmy0 @TEXT("",key="model");
// #RGPP0_5__dmy0 @SET-SYMBOL $RESISTOR;
// #RGPP0_5__dmy0 @PLACE(210,-114) => @ORIENT("R90");
// #RGPP0_5__dmy0 @TEXT("RGPP0_5__dmy0",key="name",size=1.3,halign="start") => @PLACE(213,-111);
// #RGPP0_5__dmy0 @TEXT("l=17.13u w=1u multi=(1)",key="value",size=0.9,halign="start") => @PLACE(213,-118);
// #RGPP0_5__dmy0 @TEXT("",key="model");
// #RGPP1 @SET-SYMBOL $RESISTOR;
// #RGPP1 @PLACE(235,-114) => @ORIENT("R90");
// #RGPP1 @TEXT("RGPP1",key="name",size=1.3,halign="start") => @PLACE(238,-111);
// #RGPP1 @TEXT("l=17.13u w=1u multi=(1)",key="value",size=0.9,halign="start") => @PLACE(238,-118);
// #RGPP1 @TEXT("",key="model");
// #RGPP1_2__dmy0 @SET-SYMBOL $RESISTOR;
// #RGPP1_2__dmy0 @PLACE(260,-114) => @ORIENT("R90");
// #RGPP1_2__dmy0 @TEXT("RGPP1_2__dmy0",key="name",size=1.3,halign="start") => @PLACE(263,-111);
// #RGPP1_2__dmy0 @TEXT("l=17.13u w=1u multi=(1)",key="value",size=0.9,halign="start") => @PLACE(263,-118);
// #RGPP1_2__dmy0 @TEXT("",key="model");
// #RGPP1_3__dmy0 @SET-SYMBOL $RESISTOR;
// #RGPP1_3__dmy0 @PLACE(285,-114) => @ORIENT("R90");
// #RGPP1_3__dmy0 @TEXT("RGPP1_3__dmy0",key="name",size=1.3,halign="start") => @PLACE(288,-111);
// #RGPP1_3__dmy0 @TEXT("l=17.13u w=1u multi=(1)",key="value",size=0.9,halign="start") => @PLACE(288,-118);
// #RGPP1_3__dmy0 @TEXT("",key="model");
// #RGPP1_4__dmy0 @SET-SYMBOL $RESISTOR;
// #RGPP1_4__dmy0 @PLACE(310,-114) => @ORIENT("R90");
// #RGPP1_4__dmy0 @TEXT("RGPP1_4__dmy0",key="name",size=1.3,halign="start") => @PLACE(313,-111);
// #RGPP1_4__dmy0 @TEXT("l=17.13u w=1u multi=(1)",key="value",size=0.9,halign="start") => @PLACE(313,-118);
// #RGPP1_4__dmy0 @TEXT("",key="model");
// #RGPP1_5__dmy0 @SET-SYMBOL $RESISTOR;
// #RGPP1_5__dmy0 @PLACE(335,-114) => @ORIENT("R90");
// #RGPP1_5__dmy0 @TEXT("RGPP1_5__dmy0",key="name",size=1.3,halign="start") => @PLACE(338,-111);
// #RGPP1_5__dmy0 @TEXT("l=17.13u w=1u multi=(1)",key="value",size=0.9,halign="start") => @PLACE(338,-118);
// #RGPP1_5__dmy0 @TEXT("",key="model");
// (104,-99) @TEXT("GPP / 10 series poly sections",size=0.95,halign="start",textcolor="#223d52");
// &"GNNB" @WIRE(mode="straight",linecolor="#30485d",linewidth=0.16) {#XSTD_GNNCN:1 (61.5,0) (61.5,0) #XSTD_GNNBN:2};
// &"GNNDRV" @WIRE(mode="straight",linecolor="#30485d",linewidth=0.16) {#XSTD_GNNCN:2 (95.5,0) (95.5,0) #RGNN0:1};
// &"GNNA" @WIRE(mode="straight",linecolor="#30485d",linewidth=0.16) {#XSTD_GNNBN:1 (32.5,0) (32.5,0) #XSTD_GNNAN:2};
// &"GNNPRE" @WIRE(mode="straight",linecolor="#30485d",linewidth=0.16) {#XSTD_GNNAN:1 (0.5,0) (0.5,0) #X025:4};
// &"GNPB" @WIRE(mode="straight",linecolor="#30485d",linewidth=0.16) {#XSTD_GNPCN:1 (61.5,-38) (61.5,-38) #XSTD_GNPBN:2};
// &"GNPDRV" @WIRE(mode="straight",linecolor="#30485d",linewidth=0.16) {#XSTD_GNPCN:2 (95.5,-38) (95.5,-38) #RGNP0:1};
// &"GNPA" @WIRE(mode="straight",linecolor="#30485d",linewidth=0.16) {#XSTD_GNPBN:1 (32.5,-38) (32.5,-38) #XSTD_GNPAN:2};
// &"H" @WIRE(mode="straight",linecolor="#30485d",linewidth=0.16) {#XSTD_GNPAN:1 (-6.5,-38) (-6.5,-76) #X008:1};
// &"GPNB" @WIRE(mode="straight",linecolor="#30485d",linewidth=0.16) {#XSTD_GPNCN:1 (61.5,-76) (61.5,-76) #XSTD_GPNBN:2};
// &"GPNDRV" @WIRE(mode="straight",linecolor="#30485d",linewidth=0.16) {#XSTD_GPNCN:2 (95.5,-76) (95.5,-76) #RGPN0:1};
// &"GPNA" @WIRE(mode="straight",linecolor="#30485d",linewidth=0.16) {#XSTD_GPNBN:1 (32.5,-76) (32.5,-76) #XSTD_GPNAN:2};
// &"GPNPRE" @WIRE(mode="straight",linecolor="#30485d",linewidth=0.16) {#XSTD_GPNAN:1 (0.5,-76) (0.5,-76) #X008:4};
// &"GPPB" @WIRE(mode="straight",linecolor="#30485d",linewidth=0.16) {#XSTD_GPPCN:1 (61.5,-114) (61.5,-114) #XSTD_GPPBN:2};
// &"GPPDRV" @WIRE(mode="straight",linecolor="#30485d",linewidth=0.16) {#XSTD_GPPCN:2 (95.5,-114) (95.5,-114) #RGPP0:1};
// &"GPPA" @WIRE(mode="straight",linecolor="#30485d",linewidth=0.16) {#XSTD_GPPBN:1 (32.5,-114) (32.5,-114) #XSTD_GPPAN:2};
// &"GNNRG" @WIRE(mode="straight",linecolor="#30485d",linewidth=0.16) {#RGNN1:1 (222.5,0) (222.5,0) #RGNN0_5__dmy0:2};
// &"RGNN1_1__dmy0" @WIRE(mode="straight",linecolor="#30485d",linewidth=0.16) {#RGNN1:2 (247.5,0) (247.5,0) #RGNN1_2__dmy0:1};
// &"RGNN1_2__dmy0" @WIRE(mode="straight",linecolor="#30485d",linewidth=0.16) {#RGNN1_2__dmy0:2 (272.5,0) (272.5,0) #RGNN1_3__dmy0:1};
// &"RGNN1_3__dmy0" @WIRE(mode="straight",linecolor="#30485d",linewidth=0.16) {#RGNN1_3__dmy0:2 (297.5,0) (297.5,0) #RGNN1_4__dmy0:1};
// &"RGNN1_4__dmy0" @WIRE(mode="straight",linecolor="#30485d",linewidth=0.16) {#RGNN1_4__dmy0:2 (322.5,0) (322.5,0) #RGNN1_5__dmy0:1};
// &"RGNN0_1__dmy0" @WIRE(mode="straight",linecolor="#30485d",linewidth=0.16) {#RGNN0:2 (122.5,0) (122.5,0) #RGNN0_2__dmy0:1};
// &"RGNN0_2__dmy0" @WIRE(mode="straight",linecolor="#30485d",linewidth=0.16) {#RGNN0_2__dmy0:2 (147.5,0) (147.5,0) #RGNN0_3__dmy0:1};
// &"RGNN0_3__dmy0" @WIRE(mode="straight",linecolor="#30485d",linewidth=0.16) {#RGNN0_3__dmy0:2 (172.5,0) (172.5,0) #RGNN0_4__dmy0:1};
// &"RGNN0_4__dmy0" @WIRE(mode="straight",linecolor="#30485d",linewidth=0.16) {#RGNN0_4__dmy0:2 (197.5,0) (197.5,0) #RGNN0_5__dmy0:1};
// &"GNPRG" @WIRE(mode="straight",linecolor="#30485d",linewidth=0.16) {#RGNP1:1 (222.5,-38) (222.5,-38) #RGNP0_5__dmy0:2};
// &"RGNP1_1__dmy0" @WIRE(mode="straight",linecolor="#30485d",linewidth=0.16) {#RGNP1:2 (247.5,-38) (247.5,-38) #RGNP1_2__dmy0:1};
// &"RGNP1_2__dmy0" @WIRE(mode="straight",linecolor="#30485d",linewidth=0.16) {#RGNP1_2__dmy0:2 (272.5,-38) (272.5,-38) #RGNP1_3__dmy0:1};
// &"RGNP1_3__dmy0" @WIRE(mode="straight",linecolor="#30485d",linewidth=0.16) {#RGNP1_3__dmy0:2 (297.5,-38) (297.5,-38) #RGNP1_4__dmy0:1};
// &"RGNP1_4__dmy0" @WIRE(mode="straight",linecolor="#30485d",linewidth=0.16) {#RGNP1_4__dmy0:2 (322.5,-38) (322.5,-38) #RGNP1_5__dmy0:1};
// &"RGNP0_1__dmy0" @WIRE(mode="straight",linecolor="#30485d",linewidth=0.16) {#RGNP0:2 (122.5,-38) (122.5,-38) #RGNP0_2__dmy0:1};
// &"RGNP0_2__dmy0" @WIRE(mode="straight",linecolor="#30485d",linewidth=0.16) {#RGNP0_2__dmy0:2 (147.5,-38) (147.5,-38) #RGNP0_3__dmy0:1};
// &"RGNP0_3__dmy0" @WIRE(mode="straight",linecolor="#30485d",linewidth=0.16) {#RGNP0_3__dmy0:2 (172.5,-38) (172.5,-38) #RGNP0_4__dmy0:1};
// &"RGNP0_4__dmy0" @WIRE(mode="straight",linecolor="#30485d",linewidth=0.16) {#RGNP0_4__dmy0:2 (197.5,-38) (197.5,-38) #RGNP0_5__dmy0:1};
// &"GPNRG" @WIRE(mode="straight",linecolor="#30485d",linewidth=0.16) {#RGPN1:1 (222.5,-76) (222.5,-76) #RGPN0_5__dmy0:2};
// &"RGPN1_1__dmy0" @WIRE(mode="straight",linecolor="#30485d",linewidth=0.16) {#RGPN1:2 (247.5,-76) (247.5,-76) #RGPN1_2__dmy0:1};
// &"RGPN1_2__dmy0" @WIRE(mode="straight",linecolor="#30485d",linewidth=0.16) {#RGPN1_2__dmy0:2 (272.5,-76) (272.5,-76) #RGPN1_3__dmy0:1};
// &"RGPN1_3__dmy0" @WIRE(mode="straight",linecolor="#30485d",linewidth=0.16) {#RGPN1_3__dmy0:2 (297.5,-76) (297.5,-76) #RGPN1_4__dmy0:1};
// &"RGPN1_4__dmy0" @WIRE(mode="straight",linecolor="#30485d",linewidth=0.16) {#RGPN1_4__dmy0:2 (322.5,-76) (322.5,-76) #RGPN1_5__dmy0:1};
// &"RGPN0_1__dmy0" @WIRE(mode="straight",linecolor="#30485d",linewidth=0.16) {#RGPN0:2 (122.5,-76) (122.5,-76) #RGPN0_2__dmy0:1};
// &"RGPN0_2__dmy0" @WIRE(mode="straight",linecolor="#30485d",linewidth=0.16) {#RGPN0_2__dmy0:2 (147.5,-76) (147.5,-76) #RGPN0_3__dmy0:1};
// &"RGPN0_3__dmy0" @WIRE(mode="straight",linecolor="#30485d",linewidth=0.16) {#RGPN0_3__dmy0:2 (172.5,-76) (172.5,-76) #RGPN0_4__dmy0:1};
// &"RGPN0_4__dmy0" @WIRE(mode="straight",linecolor="#30485d",linewidth=0.16) {#RGPN0_4__dmy0:2 (197.5,-76) (197.5,-76) #RGPN0_5__dmy0:1};
// &"GPPRG" @WIRE(mode="straight",linecolor="#30485d",linewidth=0.16) {#RGPP1:1 (222.5,-114) (222.5,-114) #RGPP0_5__dmy0:2};
// &"RGPP1_1__dmy0" @WIRE(mode="straight",linecolor="#30485d",linewidth=0.16) {#RGPP1:2 (247.5,-114) (247.5,-114) #RGPP1_2__dmy0:1};
// &"RGPP1_2__dmy0" @WIRE(mode="straight",linecolor="#30485d",linewidth=0.16) {#RGPP1_2__dmy0:2 (272.5,-114) (272.5,-114) #RGPP1_3__dmy0:1};
// &"RGPP1_3__dmy0" @WIRE(mode="straight",linecolor="#30485d",linewidth=0.16) {#RGPP1_3__dmy0:2 (297.5,-114) (297.5,-114) #RGPP1_4__dmy0:1};
// &"RGPP1_4__dmy0" @WIRE(mode="straight",linecolor="#30485d",linewidth=0.16) {#RGPP1_4__dmy0:2 (322.5,-114) (322.5,-114) #RGPP1_5__dmy0:1};
// &"RGPP0_1__dmy0" @WIRE(mode="straight",linecolor="#30485d",linewidth=0.16) {#RGPP0:2 (122.5,-114) (122.5,-114) #RGPP0_2__dmy0:1};
// &"RGPP0_2__dmy0" @WIRE(mode="straight",linecolor="#30485d",linewidth=0.16) {#RGPP0_2__dmy0:2 (147.5,-114) (147.5,-114) #RGPP0_3__dmy0:1};
// &"RGPP0_3__dmy0" @WIRE(mode="straight",linecolor="#30485d",linewidth=0.16) {#RGPP0_3__dmy0:2 (172.5,-114) (172.5,-114) #RGPP0_4__dmy0:1};
// &"RGPP0_4__dmy0" @WIRE(mode="straight",linecolor="#30485d",linewidth=0.16) {#RGPP0_4__dmy0:2 (197.5,-114) (197.5,-114) #RGPP0_5__dmy0:1};
// (-28,-148) @TEXT("GP and GN chains keep their source polarity, device sizing and series R; no zero-delay abstraction.",size=1,halign="start",textcolor="#223d52");
// &"VDD" @WIRE(mode="straight",linecolor="#30485d",linewidth=0.16) {#XSTD_GNNCN:3 (76,10)};
// (76,10.4) @TEXT("VDD",size=1.1,halign="middle",valign="bottom");
// &"VSS" @WIRE(mode="straight",linecolor="#30485d",linewidth=0.16) {#XSTD_GNNCN:4 (76,-10)};
// (76,-10.4) @TEXT("VSS",size=1.1,halign="middle",valign="top");
// &"VDD" @WIRE(mode="straight",linecolor="#30485d",linewidth=0.16) {#XSTD_GNNBN:3 (47,10)};
// (47,10.4) @TEXT("VDD",size=1.1,halign="middle",valign="bottom");
// &"VSS" @WIRE(mode="straight",linecolor="#30485d",linewidth=0.16) {#XSTD_GNNBN:4 (47,-10)};
// (47,-10.4) @TEXT("VSS",size=1.1,halign="middle",valign="top");
// &"VDD" @WIRE(mode="straight",linecolor="#30485d",linewidth=0.16) {#XSTD_GNNAN:3 (18,10)};
// (18,10.4) @TEXT("VDD",size=1.1,halign="middle",valign="bottom");
// &"VSS" @WIRE(mode="straight",linecolor="#30485d",linewidth=0.16) {#XSTD_GNNAN:4 (18,-10)};
// (18,-10.4) @TEXT("VSS",size=1.1,halign="middle",valign="top");
// &"VDD" @WIRE(mode="straight",linecolor="#30485d",linewidth=0.16) {#XSTD_GNPCN:3 (76,-28)};
// (76,-27.6) @TEXT("VDD",size=1.1,halign="middle",valign="bottom");
// &"VSS" @WIRE(mode="straight",linecolor="#30485d",linewidth=0.16) {#XSTD_GNPCN:4 (76,-48)};
// (76,-48.4) @TEXT("VSS",size=1.1,halign="middle",valign="top");
// &"VDD" @WIRE(mode="straight",linecolor="#30485d",linewidth=0.16) {#XSTD_GNPBN:3 (47,-28)};
// (47,-27.6) @TEXT("VDD",size=1.1,halign="middle",valign="bottom");
// &"VSS" @WIRE(mode="straight",linecolor="#30485d",linewidth=0.16) {#XSTD_GNPBN:4 (47,-48)};
// (47,-48.4) @TEXT("VSS",size=1.1,halign="middle",valign="top");
// &"VDD" @WIRE(mode="straight",linecolor="#30485d",linewidth=0.16) {#XSTD_GNPAN:3 (18,-28)};
// (18,-27.6) @TEXT("VDD",size=1.1,halign="middle",valign="bottom");
// &"VSS" @WIRE(mode="straight",linecolor="#30485d",linewidth=0.16) {#XSTD_GNPAN:4 (18,-48)};
// (18,-48.4) @TEXT("VSS",size=1.1,halign="middle",valign="top");
// &"VDD" @WIRE(mode="straight",linecolor="#30485d",linewidth=0.16) {#XSTD_GPNCN:3 (76,-66)};
// (76,-65.6) @TEXT("VDD",size=1.1,halign="middle",valign="bottom");
// &"VSS" @WIRE(mode="straight",linecolor="#30485d",linewidth=0.16) {#XSTD_GPNCN:4 (76,-86)};
// (76,-86.4) @TEXT("VSS",size=1.1,halign="middle",valign="top");
// &"VDD" @WIRE(mode="straight",linecolor="#30485d",linewidth=0.16) {#XSTD_GPNBN:3 (47,-66)};
// (47,-65.6) @TEXT("VDD",size=1.1,halign="middle",valign="bottom");
// &"VSS" @WIRE(mode="straight",linecolor="#30485d",linewidth=0.16) {#XSTD_GPNBN:4 (47,-86)};
// (47,-86.4) @TEXT("VSS",size=1.1,halign="middle",valign="top");
// &"VDD" @WIRE(mode="straight",linecolor="#30485d",linewidth=0.16) {#XSTD_GPNAN:3 (18,-66)};
// (18,-65.6) @TEXT("VDD",size=1.1,halign="middle",valign="bottom");
// &"VSS" @WIRE(mode="straight",linecolor="#30485d",linewidth=0.16) {#XSTD_GPNAN:4 (18,-86)};
// (18,-86.4) @TEXT("VSS",size=1.1,halign="middle",valign="top");
// &"VDD" @WIRE(mode="straight",linecolor="#30485d",linewidth=0.16) {#XSTD_GPPCN:3 (76,-104)};
// (76,-103.6) @TEXT("VDD",size=1.1,halign="middle",valign="bottom");
// &"VSS" @WIRE(mode="straight",linecolor="#30485d",linewidth=0.16) {#XSTD_GPPCN:4 (76,-124)};
// (76,-124.4) @TEXT("VSS",size=1.1,halign="middle",valign="top");
// &"VDD" @WIRE(mode="straight",linecolor="#30485d",linewidth=0.16) {#XSTD_GPPBN:3 (47,-104)};
// (47,-103.6) @TEXT("VDD",size=1.1,halign="middle",valign="bottom");
// &"VSS" @WIRE(mode="straight",linecolor="#30485d",linewidth=0.16) {#XSTD_GPPBN:4 (47,-124)};
// (47,-124.4) @TEXT("VSS",size=1.1,halign="middle",valign="top");
// &"L" @WIRE(mode="straight",linecolor="#30485d",linewidth=0.16) {#XSTD_GPPAN:1 (8,-114)};
// (7.6,-114) @TEXT("L",size=1.1,halign="end",valign="middle");
// &"VDD" @WIRE(mode="straight",linecolor="#30485d",linewidth=0.16) {#XSTD_GPPAN:3 (18,-104)};
// (18,-103.6) @TEXT("VDD",size=1.1,halign="middle",valign="bottom");
// &"VSS" @WIRE(mode="straight",linecolor="#30485d",linewidth=0.16) {#XSTD_GPPAN:4 (18,-124)};
// (18,-124.4) @TEXT("VSS",size=1.1,halign="middle",valign="top");
// &"GNN" @WIRE(mode="straight",linecolor="#30485d",linewidth=0.16) {#RGNN1_5__dmy0:2 (340,0)};
// (340.4,0) @TEXT("GNN",size=1.1,halign="start",valign="middle");
// &"GNP" @WIRE(mode="straight",linecolor="#30485d",linewidth=0.16) {#RGNP1_5__dmy0:2 (340,-38)};
// (340.4,-38) @TEXT("GNP",size=1.1,halign="start",valign="middle");
// &"GPN" @WIRE(mode="straight",linecolor="#30485d",linewidth=0.16) {#RGPN1_5__dmy0:2 (340,-76)};
// (340.4,-76) @TEXT("GPN",size=1.1,halign="start",valign="middle");
// &"GPP" @WIRE(mode="straight",linecolor="#30485d",linewidth=0.16) {#RGPP1_5__dmy0:2 (340,-114)};
// (340.4,-114) @TEXT("GPP",size=1.1,halign="start",valign="middle");
// &"L" @WIRE(mode="straight",linecolor="#30485d",linewidth=0.16) {#X025:1 (-27,0)};
// (-27.4,0) @TEXT("L",size=1.1,halign="end",valign="middle");
// &"VDD" @WIRE(mode="straight",linecolor="#30485d",linewidth=0.16) {#X025:2 (-17,10)};
// (-17,10.4) @TEXT("VDD",size=1.1,halign="middle",valign="bottom");
// &"VSS" @WIRE(mode="straight",linecolor="#30485d",linewidth=0.16) {#X025:3 (-17,-10)};
// (-17,-10.4) @TEXT("VSS",size=1.1,halign="middle",valign="top");
// &"VDD" @WIRE(mode="straight",linecolor="#30485d",linewidth=0.16) {#X008:2 (-17,-66)};
// (-17,-65.6) @TEXT("VDD",size=1.1,halign="middle",valign="bottom");
// &"VSS" @WIRE(mode="straight",linecolor="#30485d",linewidth=0.16) {#X008:3 (-17,-86)};
// (-17,-86.4) @TEXT("VSS",size=1.1,halign="middle",valign="top");
// }
// END SARADC RNL
ends sar8p_refdrv_b1

subckt sar8p_refdrv_b2 GNN GNP GPN GPP H L VDD VSS
    XSTD_GNNCN (GNNB GNNDRV VDD VSS) INVD1BWP12T30P140
    XSTD_GNNBN (GNNA GNNB VDD VSS) INVD1BWP12T30P140
    XSTD_GNNAN (GNNPRE GNNA VDD VSS) INVD1BWP12T30P140
    XSTD_GNPCN (GNPB GNPDRV VDD VSS) INVD1BWP12T30P140
    XSTD_GNPBN (GNPA GNPB VDD VSS) INVD1BWP12T30P140
    XSTD_GNPAN (H GNPA VDD VSS) INVD1BWP12T30P140
    XSTD_GPNCN (GPNB GPNDRV VDD VSS) INVD1BWP12T30P140
    XSTD_GPNBN (GPNA GPNB VDD VSS) INVD1BWP12T30P140
    XSTD_GPNAN (GPNPRE GPNA VDD VSS) INVD1BWP12T30P140
    XSTD_GPPCN (GPPB GPPDRV VDD VSS) INVD1BWP12T30P140
    XSTD_GPPBN (GPPA GPPB VDD VSS) INVD1BWP12T30P140
    XSTD_GPPAN (L GPPA VDD VSS) INVD1BWP12T30P140
//Series configuration of RGNN1
RGNN1  (GNNRG RGNN1_1__dmy0 ) rupolym l=17.13u w=1u m=4 multi=(1)
RGNN1_2__dmy0  (RGNN1_1__dmy0 RGNN1_2__dmy0 ) rupolym l=17.13u w=1u m=4 \
        multi=(1)
RGNN1_3__dmy0  (RGNN1_2__dmy0 RGNN1_3__dmy0 ) rupolym l=17.13u w=1u m=4 \
        multi=(1)
RGNN1_4__dmy0  (RGNN1_3__dmy0 RGNN1_4__dmy0 ) rupolym l=17.13u w=1u m=4 \
        multi=(1)
RGNN1_5__dmy0  (RGNN1_4__dmy0 GNN ) rupolym l=17.13u w=1u m=4 multi=(1)
//End of RGNN1

//Series configuration of RGNN0
RGNN0  (GNNDRV RGNN0_1__dmy0 ) rupolym l=17.13u w=1u m=4 multi=(1)
RGNN0_2__dmy0  (RGNN0_1__dmy0 RGNN0_2__dmy0 ) rupolym l=17.13u w=1u m=4 \
        multi=(1)
RGNN0_3__dmy0  (RGNN0_2__dmy0 RGNN0_3__dmy0 ) rupolym l=17.13u w=1u m=4 \
        multi=(1)
RGNN0_4__dmy0  (RGNN0_3__dmy0 RGNN0_4__dmy0 ) rupolym l=17.13u w=1u m=4 \
        multi=(1)
RGNN0_5__dmy0  (RGNN0_4__dmy0 GNNRG ) rupolym l=17.13u w=1u m=4 multi=(1)
//End of RGNN0

//Series configuration of RGNP1
RGNP1  (GNPRG RGNP1_1__dmy0 ) rupolym l=17.13u w=1u m=4 multi=(1)
RGNP1_2__dmy0  (RGNP1_1__dmy0 RGNP1_2__dmy0 ) rupolym l=17.13u w=1u m=4 \
        multi=(1)
RGNP1_3__dmy0  (RGNP1_2__dmy0 RGNP1_3__dmy0 ) rupolym l=17.13u w=1u m=4 \
        multi=(1)
RGNP1_4__dmy0  (RGNP1_3__dmy0 RGNP1_4__dmy0 ) rupolym l=17.13u w=1u m=4 \
        multi=(1)
RGNP1_5__dmy0  (RGNP1_4__dmy0 GNP ) rupolym l=17.13u w=1u m=4 multi=(1)
//End of RGNP1

//Series configuration of RGNP0
RGNP0  (GNPDRV RGNP0_1__dmy0 ) rupolym l=17.13u w=1u m=4 multi=(1)
RGNP0_2__dmy0  (RGNP0_1__dmy0 RGNP0_2__dmy0 ) rupolym l=17.13u w=1u m=4 \
        multi=(1)
RGNP0_3__dmy0  (RGNP0_2__dmy0 RGNP0_3__dmy0 ) rupolym l=17.13u w=1u m=4 \
        multi=(1)
RGNP0_4__dmy0  (RGNP0_3__dmy0 RGNP0_4__dmy0 ) rupolym l=17.13u w=1u m=4 \
        multi=(1)
RGNP0_5__dmy0  (RGNP0_4__dmy0 GNPRG ) rupolym l=17.13u w=1u m=4 multi=(1)
//End of RGNP0

//Series configuration of RGPN1
RGPN1  (GPNRG RGPN1_1__dmy0 ) rupolym l=17.13u w=1u m=4 multi=(1)
RGPN1_2__dmy0  (RGPN1_1__dmy0 RGPN1_2__dmy0 ) rupolym l=17.13u w=1u m=4 \
        multi=(1)
RGPN1_3__dmy0  (RGPN1_2__dmy0 RGPN1_3__dmy0 ) rupolym l=17.13u w=1u m=4 \
        multi=(1)
RGPN1_4__dmy0  (RGPN1_3__dmy0 RGPN1_4__dmy0 ) rupolym l=17.13u w=1u m=4 \
        multi=(1)
RGPN1_5__dmy0  (RGPN1_4__dmy0 GPN ) rupolym l=17.13u w=1u m=4 multi=(1)
//End of RGPN1

//Series configuration of RGPN0
RGPN0  (GPNDRV RGPN0_1__dmy0 ) rupolym l=17.13u w=1u m=4 multi=(1)
RGPN0_2__dmy0  (RGPN0_1__dmy0 RGPN0_2__dmy0 ) rupolym l=17.13u w=1u m=4 \
        multi=(1)
RGPN0_3__dmy0  (RGPN0_2__dmy0 RGPN0_3__dmy0 ) rupolym l=17.13u w=1u m=4 \
        multi=(1)
RGPN0_4__dmy0  (RGPN0_3__dmy0 RGPN0_4__dmy0 ) rupolym l=17.13u w=1u m=4 \
        multi=(1)
RGPN0_5__dmy0  (RGPN0_4__dmy0 GPNRG ) rupolym l=17.13u w=1u m=4 multi=(1)
//End of RGPN0

//Series configuration of RGPP1
RGPP1  (GPPRG RGPP1_1__dmy0 ) rupolym l=17.13u w=1u m=4 multi=(1)
RGPP1_2__dmy0  (RGPP1_1__dmy0 RGPP1_2__dmy0 ) rupolym l=17.13u w=1u m=4 \
        multi=(1)
RGPP1_3__dmy0  (RGPP1_2__dmy0 RGPP1_3__dmy0 ) rupolym l=17.13u w=1u m=4 \
        multi=(1)
RGPP1_4__dmy0  (RGPP1_3__dmy0 RGPP1_4__dmy0 ) rupolym l=17.13u w=1u m=4 \
        multi=(1)
RGPP1_5__dmy0  (RGPP1_4__dmy0 GPP ) rupolym l=17.13u w=1u m=4 multi=(1)
//End of RGPP1

//Series configuration of RGPP0
RGPP0  (GPPDRV RGPP0_1__dmy0 ) rupolym l=17.13u w=1u m=4 multi=(1)
RGPP0_2__dmy0  (RGPP0_1__dmy0 RGPP0_2__dmy0 ) rupolym l=17.13u w=1u m=4 \
        multi=(1)
RGPP0_3__dmy0  (RGPP0_2__dmy0 RGPP0_3__dmy0 ) rupolym l=17.13u w=1u m=4 \
        multi=(1)
RGPP0_4__dmy0  (RGPP0_3__dmy0 RGPP0_4__dmy0 ) rupolym l=17.13u w=1u m=4 \
        multi=(1)
RGPP0_5__dmy0  (RGPP0_4__dmy0 GPPRG ) rupolym l=17.13u w=1u m=4 multi=(1)
//End of RGPP0

    X025 (L VDD VSS GNNPRE) sar8p_inv
    X008 (H VDD VSS GPNPRE) sar8p_inv
// BEGIN SARADC RNL
// @RNL(author="saradc topology") {
// (-28,27) @TEXT("sar8p_refdrv_b2 / four physical gate-driver chains",size=1.5,halign="start",textcolor="#223d52");
// #X025 @SET-SYMBOL $S_sar8p_inv;
// #X025 @PLACE(-17,0) => @ORIENT("R0");
// #XSTD_GNNAN @SET-SYMBOL $S_INVD1BWP12T30P140;
// #XSTD_GNNAN @PLACE(18,0) => @ORIENT("R0");
// #XSTD_GNNBN @SET-SYMBOL $S_INVD1BWP12T30P140;
// #XSTD_GNNBN @PLACE(47,0) => @ORIENT("R0");
// #XSTD_GNNCN @SET-SYMBOL $S_INVD1BWP12T30P140;
// #XSTD_GNNCN @PLACE(76,0) => @ORIENT("R0");
// #RGNN0 @SET-SYMBOL $RESISTOR;
// #RGNN0 @PLACE(110,0) => @ORIENT("R90");
// #RGNN0 @TEXT("RGNN0",key="name",size=1.3,halign="start") => @PLACE(113,3);
// #RGNN0 @TEXT("l=17.13u w=1u multi=(1)",key="value",size=0.9,halign="start") => @PLACE(113,-4);
// #RGNN0 @TEXT("",key="model");
// #RGNN0_2__dmy0 @SET-SYMBOL $RESISTOR;
// #RGNN0_2__dmy0 @PLACE(135,0) => @ORIENT("R90");
// #RGNN0_2__dmy0 @TEXT("RGNN0_2__dmy0",key="name",size=1.3,halign="start") => @PLACE(138,3);
// #RGNN0_2__dmy0 @TEXT("l=17.13u w=1u multi=(1)",key="value",size=0.9,halign="start") => @PLACE(138,-4);
// #RGNN0_2__dmy0 @TEXT("",key="model");
// #RGNN0_3__dmy0 @SET-SYMBOL $RESISTOR;
// #RGNN0_3__dmy0 @PLACE(160,0) => @ORIENT("R90");
// #RGNN0_3__dmy0 @TEXT("RGNN0_3__dmy0",key="name",size=1.3,halign="start") => @PLACE(163,3);
// #RGNN0_3__dmy0 @TEXT("l=17.13u w=1u multi=(1)",key="value",size=0.9,halign="start") => @PLACE(163,-4);
// #RGNN0_3__dmy0 @TEXT("",key="model");
// #RGNN0_4__dmy0 @SET-SYMBOL $RESISTOR;
// #RGNN0_4__dmy0 @PLACE(185,0) => @ORIENT("R90");
// #RGNN0_4__dmy0 @TEXT("RGNN0_4__dmy0",key="name",size=1.3,halign="start") => @PLACE(188,3);
// #RGNN0_4__dmy0 @TEXT("l=17.13u w=1u multi=(1)",key="value",size=0.9,halign="start") => @PLACE(188,-4);
// #RGNN0_4__dmy0 @TEXT("",key="model");
// #RGNN0_5__dmy0 @SET-SYMBOL $RESISTOR;
// #RGNN0_5__dmy0 @PLACE(210,0) => @ORIENT("R90");
// #RGNN0_5__dmy0 @TEXT("RGNN0_5__dmy0",key="name",size=1.3,halign="start") => @PLACE(213,3);
// #RGNN0_5__dmy0 @TEXT("l=17.13u w=1u multi=(1)",key="value",size=0.9,halign="start") => @PLACE(213,-4);
// #RGNN0_5__dmy0 @TEXT("",key="model");
// #RGNN1 @SET-SYMBOL $RESISTOR;
// #RGNN1 @PLACE(235,0) => @ORIENT("R90");
// #RGNN1 @TEXT("RGNN1",key="name",size=1.3,halign="start") => @PLACE(238,3);
// #RGNN1 @TEXT("l=17.13u w=1u multi=(1)",key="value",size=0.9,halign="start") => @PLACE(238,-4);
// #RGNN1 @TEXT("",key="model");
// #RGNN1_2__dmy0 @SET-SYMBOL $RESISTOR;
// #RGNN1_2__dmy0 @PLACE(260,0) => @ORIENT("R90");
// #RGNN1_2__dmy0 @TEXT("RGNN1_2__dmy0",key="name",size=1.3,halign="start") => @PLACE(263,3);
// #RGNN1_2__dmy0 @TEXT("l=17.13u w=1u multi=(1)",key="value",size=0.9,halign="start") => @PLACE(263,-4);
// #RGNN1_2__dmy0 @TEXT("",key="model");
// #RGNN1_3__dmy0 @SET-SYMBOL $RESISTOR;
// #RGNN1_3__dmy0 @PLACE(285,0) => @ORIENT("R90");
// #RGNN1_3__dmy0 @TEXT("RGNN1_3__dmy0",key="name",size=1.3,halign="start") => @PLACE(288,3);
// #RGNN1_3__dmy0 @TEXT("l=17.13u w=1u multi=(1)",key="value",size=0.9,halign="start") => @PLACE(288,-4);
// #RGNN1_3__dmy0 @TEXT("",key="model");
// #RGNN1_4__dmy0 @SET-SYMBOL $RESISTOR;
// #RGNN1_4__dmy0 @PLACE(310,0) => @ORIENT("R90");
// #RGNN1_4__dmy0 @TEXT("RGNN1_4__dmy0",key="name",size=1.3,halign="start") => @PLACE(313,3);
// #RGNN1_4__dmy0 @TEXT("l=17.13u w=1u multi=(1)",key="value",size=0.9,halign="start") => @PLACE(313,-4);
// #RGNN1_4__dmy0 @TEXT("",key="model");
// #RGNN1_5__dmy0 @SET-SYMBOL $RESISTOR;
// #RGNN1_5__dmy0 @PLACE(335,0) => @ORIENT("R90");
// #RGNN1_5__dmy0 @TEXT("RGNN1_5__dmy0",key="name",size=1.3,halign="start") => @PLACE(338,3);
// #RGNN1_5__dmy0 @TEXT("l=17.13u w=1u multi=(1)",key="value",size=0.9,halign="start") => @PLACE(338,-4);
// #RGNN1_5__dmy0 @TEXT("",key="model");
// (104,15) @TEXT("GNN / 10 series poly sections",size=0.95,halign="start",textcolor="#223d52");
// #XSTD_GNPAN @SET-SYMBOL $S_INVD1BWP12T30P140;
// #XSTD_GNPAN @PLACE(18,-38) => @ORIENT("R0");
// #XSTD_GNPBN @SET-SYMBOL $S_INVD1BWP12T30P140;
// #XSTD_GNPBN @PLACE(47,-38) => @ORIENT("R0");
// #XSTD_GNPCN @SET-SYMBOL $S_INVD1BWP12T30P140;
// #XSTD_GNPCN @PLACE(76,-38) => @ORIENT("R0");
// #RGNP0 @SET-SYMBOL $RESISTOR;
// #RGNP0 @PLACE(110,-38) => @ORIENT("R90");
// #RGNP0 @TEXT("RGNP0",key="name",size=1.3,halign="start") => @PLACE(113,-35);
// #RGNP0 @TEXT("l=17.13u w=1u multi=(1)",key="value",size=0.9,halign="start") => @PLACE(113,-42);
// #RGNP0 @TEXT("",key="model");
// #RGNP0_2__dmy0 @SET-SYMBOL $RESISTOR;
// #RGNP0_2__dmy0 @PLACE(135,-38) => @ORIENT("R90");
// #RGNP0_2__dmy0 @TEXT("RGNP0_2__dmy0",key="name",size=1.3,halign="start") => @PLACE(138,-35);
// #RGNP0_2__dmy0 @TEXT("l=17.13u w=1u multi=(1)",key="value",size=0.9,halign="start") => @PLACE(138,-42);
// #RGNP0_2__dmy0 @TEXT("",key="model");
// #RGNP0_3__dmy0 @SET-SYMBOL $RESISTOR;
// #RGNP0_3__dmy0 @PLACE(160,-38) => @ORIENT("R90");
// #RGNP0_3__dmy0 @TEXT("RGNP0_3__dmy0",key="name",size=1.3,halign="start") => @PLACE(163,-35);
// #RGNP0_3__dmy0 @TEXT("l=17.13u w=1u multi=(1)",key="value",size=0.9,halign="start") => @PLACE(163,-42);
// #RGNP0_3__dmy0 @TEXT("",key="model");
// #RGNP0_4__dmy0 @SET-SYMBOL $RESISTOR;
// #RGNP0_4__dmy0 @PLACE(185,-38) => @ORIENT("R90");
// #RGNP0_4__dmy0 @TEXT("RGNP0_4__dmy0",key="name",size=1.3,halign="start") => @PLACE(188,-35);
// #RGNP0_4__dmy0 @TEXT("l=17.13u w=1u multi=(1)",key="value",size=0.9,halign="start") => @PLACE(188,-42);
// #RGNP0_4__dmy0 @TEXT("",key="model");
// #RGNP0_5__dmy0 @SET-SYMBOL $RESISTOR;
// #RGNP0_5__dmy0 @PLACE(210,-38) => @ORIENT("R90");
// #RGNP0_5__dmy0 @TEXT("RGNP0_5__dmy0",key="name",size=1.3,halign="start") => @PLACE(213,-35);
// #RGNP0_5__dmy0 @TEXT("l=17.13u w=1u multi=(1)",key="value",size=0.9,halign="start") => @PLACE(213,-42);
// #RGNP0_5__dmy0 @TEXT("",key="model");
// #RGNP1 @SET-SYMBOL $RESISTOR;
// #RGNP1 @PLACE(235,-38) => @ORIENT("R90");
// #RGNP1 @TEXT("RGNP1",key="name",size=1.3,halign="start") => @PLACE(238,-35);
// #RGNP1 @TEXT("l=17.13u w=1u multi=(1)",key="value",size=0.9,halign="start") => @PLACE(238,-42);
// #RGNP1 @TEXT("",key="model");
// #RGNP1_2__dmy0 @SET-SYMBOL $RESISTOR;
// #RGNP1_2__dmy0 @PLACE(260,-38) => @ORIENT("R90");
// #RGNP1_2__dmy0 @TEXT("RGNP1_2__dmy0",key="name",size=1.3,halign="start") => @PLACE(263,-35);
// #RGNP1_2__dmy0 @TEXT("l=17.13u w=1u multi=(1)",key="value",size=0.9,halign="start") => @PLACE(263,-42);
// #RGNP1_2__dmy0 @TEXT("",key="model");
// #RGNP1_3__dmy0 @SET-SYMBOL $RESISTOR;
// #RGNP1_3__dmy0 @PLACE(285,-38) => @ORIENT("R90");
// #RGNP1_3__dmy0 @TEXT("RGNP1_3__dmy0",key="name",size=1.3,halign="start") => @PLACE(288,-35);
// #RGNP1_3__dmy0 @TEXT("l=17.13u w=1u multi=(1)",key="value",size=0.9,halign="start") => @PLACE(288,-42);
// #RGNP1_3__dmy0 @TEXT("",key="model");
// #RGNP1_4__dmy0 @SET-SYMBOL $RESISTOR;
// #RGNP1_4__dmy0 @PLACE(310,-38) => @ORIENT("R90");
// #RGNP1_4__dmy0 @TEXT("RGNP1_4__dmy0",key="name",size=1.3,halign="start") => @PLACE(313,-35);
// #RGNP1_4__dmy0 @TEXT("l=17.13u w=1u multi=(1)",key="value",size=0.9,halign="start") => @PLACE(313,-42);
// #RGNP1_4__dmy0 @TEXT("",key="model");
// #RGNP1_5__dmy0 @SET-SYMBOL $RESISTOR;
// #RGNP1_5__dmy0 @PLACE(335,-38) => @ORIENT("R90");
// #RGNP1_5__dmy0 @TEXT("RGNP1_5__dmy0",key="name",size=1.3,halign="start") => @PLACE(338,-35);
// #RGNP1_5__dmy0 @TEXT("l=17.13u w=1u multi=(1)",key="value",size=0.9,halign="start") => @PLACE(338,-42);
// #RGNP1_5__dmy0 @TEXT("",key="model");
// (104,-23) @TEXT("GNP / 10 series poly sections",size=0.95,halign="start",textcolor="#223d52");
// #X008 @SET-SYMBOL $S_sar8p_inv;
// #X008 @PLACE(-17,-76) => @ORIENT("R0");
// #XSTD_GPNAN @SET-SYMBOL $S_INVD1BWP12T30P140;
// #XSTD_GPNAN @PLACE(18,-76) => @ORIENT("R0");
// #XSTD_GPNBN @SET-SYMBOL $S_INVD1BWP12T30P140;
// #XSTD_GPNBN @PLACE(47,-76) => @ORIENT("R0");
// #XSTD_GPNCN @SET-SYMBOL $S_INVD1BWP12T30P140;
// #XSTD_GPNCN @PLACE(76,-76) => @ORIENT("R0");
// #RGPN0 @SET-SYMBOL $RESISTOR;
// #RGPN0 @PLACE(110,-76) => @ORIENT("R90");
// #RGPN0 @TEXT("RGPN0",key="name",size=1.3,halign="start") => @PLACE(113,-73);
// #RGPN0 @TEXT("l=17.13u w=1u multi=(1)",key="value",size=0.9,halign="start") => @PLACE(113,-80);
// #RGPN0 @TEXT("",key="model");
// #RGPN0_2__dmy0 @SET-SYMBOL $RESISTOR;
// #RGPN0_2__dmy0 @PLACE(135,-76) => @ORIENT("R90");
// #RGPN0_2__dmy0 @TEXT("RGPN0_2__dmy0",key="name",size=1.3,halign="start") => @PLACE(138,-73);
// #RGPN0_2__dmy0 @TEXT("l=17.13u w=1u multi=(1)",key="value",size=0.9,halign="start") => @PLACE(138,-80);
// #RGPN0_2__dmy0 @TEXT("",key="model");
// #RGPN0_3__dmy0 @SET-SYMBOL $RESISTOR;
// #RGPN0_3__dmy0 @PLACE(160,-76) => @ORIENT("R90");
// #RGPN0_3__dmy0 @TEXT("RGPN0_3__dmy0",key="name",size=1.3,halign="start") => @PLACE(163,-73);
// #RGPN0_3__dmy0 @TEXT("l=17.13u w=1u multi=(1)",key="value",size=0.9,halign="start") => @PLACE(163,-80);
// #RGPN0_3__dmy0 @TEXT("",key="model");
// #RGPN0_4__dmy0 @SET-SYMBOL $RESISTOR;
// #RGPN0_4__dmy0 @PLACE(185,-76) => @ORIENT("R90");
// #RGPN0_4__dmy0 @TEXT("RGPN0_4__dmy0",key="name",size=1.3,halign="start") => @PLACE(188,-73);
// #RGPN0_4__dmy0 @TEXT("l=17.13u w=1u multi=(1)",key="value",size=0.9,halign="start") => @PLACE(188,-80);
// #RGPN0_4__dmy0 @TEXT("",key="model");
// #RGPN0_5__dmy0 @SET-SYMBOL $RESISTOR;
// #RGPN0_5__dmy0 @PLACE(210,-76) => @ORIENT("R90");
// #RGPN0_5__dmy0 @TEXT("RGPN0_5__dmy0",key="name",size=1.3,halign="start") => @PLACE(213,-73);
// #RGPN0_5__dmy0 @TEXT("l=17.13u w=1u multi=(1)",key="value",size=0.9,halign="start") => @PLACE(213,-80);
// #RGPN0_5__dmy0 @TEXT("",key="model");
// #RGPN1 @SET-SYMBOL $RESISTOR;
// #RGPN1 @PLACE(235,-76) => @ORIENT("R90");
// #RGPN1 @TEXT("RGPN1",key="name",size=1.3,halign="start") => @PLACE(238,-73);
// #RGPN1 @TEXT("l=17.13u w=1u multi=(1)",key="value",size=0.9,halign="start") => @PLACE(238,-80);
// #RGPN1 @TEXT("",key="model");
// #RGPN1_2__dmy0 @SET-SYMBOL $RESISTOR;
// #RGPN1_2__dmy0 @PLACE(260,-76) => @ORIENT("R90");
// #RGPN1_2__dmy0 @TEXT("RGPN1_2__dmy0",key="name",size=1.3,halign="start") => @PLACE(263,-73);
// #RGPN1_2__dmy0 @TEXT("l=17.13u w=1u multi=(1)",key="value",size=0.9,halign="start") => @PLACE(263,-80);
// #RGPN1_2__dmy0 @TEXT("",key="model");
// #RGPN1_3__dmy0 @SET-SYMBOL $RESISTOR;
// #RGPN1_3__dmy0 @PLACE(285,-76) => @ORIENT("R90");
// #RGPN1_3__dmy0 @TEXT("RGPN1_3__dmy0",key="name",size=1.3,halign="start") => @PLACE(288,-73);
// #RGPN1_3__dmy0 @TEXT("l=17.13u w=1u multi=(1)",key="value",size=0.9,halign="start") => @PLACE(288,-80);
// #RGPN1_3__dmy0 @TEXT("",key="model");
// #RGPN1_4__dmy0 @SET-SYMBOL $RESISTOR;
// #RGPN1_4__dmy0 @PLACE(310,-76) => @ORIENT("R90");
// #RGPN1_4__dmy0 @TEXT("RGPN1_4__dmy0",key="name",size=1.3,halign="start") => @PLACE(313,-73);
// #RGPN1_4__dmy0 @TEXT("l=17.13u w=1u multi=(1)",key="value",size=0.9,halign="start") => @PLACE(313,-80);
// #RGPN1_4__dmy0 @TEXT("",key="model");
// #RGPN1_5__dmy0 @SET-SYMBOL $RESISTOR;
// #RGPN1_5__dmy0 @PLACE(335,-76) => @ORIENT("R90");
// #RGPN1_5__dmy0 @TEXT("RGPN1_5__dmy0",key="name",size=1.3,halign="start") => @PLACE(338,-73);
// #RGPN1_5__dmy0 @TEXT("l=17.13u w=1u multi=(1)",key="value",size=0.9,halign="start") => @PLACE(338,-80);
// #RGPN1_5__dmy0 @TEXT("",key="model");
// (104,-61) @TEXT("GPN / 10 series poly sections",size=0.95,halign="start",textcolor="#223d52");
// #XSTD_GPPAN @SET-SYMBOL $S_INVD1BWP12T30P140;
// #XSTD_GPPAN @PLACE(18,-114) => @ORIENT("R0");
// #XSTD_GPPBN @SET-SYMBOL $S_INVD1BWP12T30P140;
// #XSTD_GPPBN @PLACE(47,-114) => @ORIENT("R0");
// #XSTD_GPPCN @SET-SYMBOL $S_INVD1BWP12T30P140;
// #XSTD_GPPCN @PLACE(76,-114) => @ORIENT("R0");
// #RGPP0 @SET-SYMBOL $RESISTOR;
// #RGPP0 @PLACE(110,-114) => @ORIENT("R90");
// #RGPP0 @TEXT("RGPP0",key="name",size=1.3,halign="start") => @PLACE(113,-111);
// #RGPP0 @TEXT("l=17.13u w=1u multi=(1)",key="value",size=0.9,halign="start") => @PLACE(113,-118);
// #RGPP0 @TEXT("",key="model");
// #RGPP0_2__dmy0 @SET-SYMBOL $RESISTOR;
// #RGPP0_2__dmy0 @PLACE(135,-114) => @ORIENT("R90");
// #RGPP0_2__dmy0 @TEXT("RGPP0_2__dmy0",key="name",size=1.3,halign="start") => @PLACE(138,-111);
// #RGPP0_2__dmy0 @TEXT("l=17.13u w=1u multi=(1)",key="value",size=0.9,halign="start") => @PLACE(138,-118);
// #RGPP0_2__dmy0 @TEXT("",key="model");
// #RGPP0_3__dmy0 @SET-SYMBOL $RESISTOR;
// #RGPP0_3__dmy0 @PLACE(160,-114) => @ORIENT("R90");
// #RGPP0_3__dmy0 @TEXT("RGPP0_3__dmy0",key="name",size=1.3,halign="start") => @PLACE(163,-111);
// #RGPP0_3__dmy0 @TEXT("l=17.13u w=1u multi=(1)",key="value",size=0.9,halign="start") => @PLACE(163,-118);
// #RGPP0_3__dmy0 @TEXT("",key="model");
// #RGPP0_4__dmy0 @SET-SYMBOL $RESISTOR;
// #RGPP0_4__dmy0 @PLACE(185,-114) => @ORIENT("R90");
// #RGPP0_4__dmy0 @TEXT("RGPP0_4__dmy0",key="name",size=1.3,halign="start") => @PLACE(188,-111);
// #RGPP0_4__dmy0 @TEXT("l=17.13u w=1u multi=(1)",key="value",size=0.9,halign="start") => @PLACE(188,-118);
// #RGPP0_4__dmy0 @TEXT("",key="model");
// #RGPP0_5__dmy0 @SET-SYMBOL $RESISTOR;
// #RGPP0_5__dmy0 @PLACE(210,-114) => @ORIENT("R90");
// #RGPP0_5__dmy0 @TEXT("RGPP0_5__dmy0",key="name",size=1.3,halign="start") => @PLACE(213,-111);
// #RGPP0_5__dmy0 @TEXT("l=17.13u w=1u multi=(1)",key="value",size=0.9,halign="start") => @PLACE(213,-118);
// #RGPP0_5__dmy0 @TEXT("",key="model");
// #RGPP1 @SET-SYMBOL $RESISTOR;
// #RGPP1 @PLACE(235,-114) => @ORIENT("R90");
// #RGPP1 @TEXT("RGPP1",key="name",size=1.3,halign="start") => @PLACE(238,-111);
// #RGPP1 @TEXT("l=17.13u w=1u multi=(1)",key="value",size=0.9,halign="start") => @PLACE(238,-118);
// #RGPP1 @TEXT("",key="model");
// #RGPP1_2__dmy0 @SET-SYMBOL $RESISTOR;
// #RGPP1_2__dmy0 @PLACE(260,-114) => @ORIENT("R90");
// #RGPP1_2__dmy0 @TEXT("RGPP1_2__dmy0",key="name",size=1.3,halign="start") => @PLACE(263,-111);
// #RGPP1_2__dmy0 @TEXT("l=17.13u w=1u multi=(1)",key="value",size=0.9,halign="start") => @PLACE(263,-118);
// #RGPP1_2__dmy0 @TEXT("",key="model");
// #RGPP1_3__dmy0 @SET-SYMBOL $RESISTOR;
// #RGPP1_3__dmy0 @PLACE(285,-114) => @ORIENT("R90");
// #RGPP1_3__dmy0 @TEXT("RGPP1_3__dmy0",key="name",size=1.3,halign="start") => @PLACE(288,-111);
// #RGPP1_3__dmy0 @TEXT("l=17.13u w=1u multi=(1)",key="value",size=0.9,halign="start") => @PLACE(288,-118);
// #RGPP1_3__dmy0 @TEXT("",key="model");
// #RGPP1_4__dmy0 @SET-SYMBOL $RESISTOR;
// #RGPP1_4__dmy0 @PLACE(310,-114) => @ORIENT("R90");
// #RGPP1_4__dmy0 @TEXT("RGPP1_4__dmy0",key="name",size=1.3,halign="start") => @PLACE(313,-111);
// #RGPP1_4__dmy0 @TEXT("l=17.13u w=1u multi=(1)",key="value",size=0.9,halign="start") => @PLACE(313,-118);
// #RGPP1_4__dmy0 @TEXT("",key="model");
// #RGPP1_5__dmy0 @SET-SYMBOL $RESISTOR;
// #RGPP1_5__dmy0 @PLACE(335,-114) => @ORIENT("R90");
// #RGPP1_5__dmy0 @TEXT("RGPP1_5__dmy0",key="name",size=1.3,halign="start") => @PLACE(338,-111);
// #RGPP1_5__dmy0 @TEXT("l=17.13u w=1u multi=(1)",key="value",size=0.9,halign="start") => @PLACE(338,-118);
// #RGPP1_5__dmy0 @TEXT("",key="model");
// (104,-99) @TEXT("GPP / 10 series poly sections",size=0.95,halign="start",textcolor="#223d52");
// &"GNNB" @WIRE(mode="straight",linecolor="#30485d",linewidth=0.16) {#XSTD_GNNCN:1 (61.5,0) (61.5,0) #XSTD_GNNBN:2};
// &"GNNDRV" @WIRE(mode="straight",linecolor="#30485d",linewidth=0.16) {#XSTD_GNNCN:2 (95.5,0) (95.5,0) #RGNN0:1};
// &"GNNA" @WIRE(mode="straight",linecolor="#30485d",linewidth=0.16) {#XSTD_GNNBN:1 (32.5,0) (32.5,0) #XSTD_GNNAN:2};
// &"GNNPRE" @WIRE(mode="straight",linecolor="#30485d",linewidth=0.16) {#XSTD_GNNAN:1 (0.5,0) (0.5,0) #X025:4};
// &"GNPB" @WIRE(mode="straight",linecolor="#30485d",linewidth=0.16) {#XSTD_GNPCN:1 (61.5,-38) (61.5,-38) #XSTD_GNPBN:2};
// &"GNPDRV" @WIRE(mode="straight",linecolor="#30485d",linewidth=0.16) {#XSTD_GNPCN:2 (95.5,-38) (95.5,-38) #RGNP0:1};
// &"GNPA" @WIRE(mode="straight",linecolor="#30485d",linewidth=0.16) {#XSTD_GNPBN:1 (32.5,-38) (32.5,-38) #XSTD_GNPAN:2};
// &"H" @WIRE(mode="straight",linecolor="#30485d",linewidth=0.16) {#XSTD_GNPAN:1 (-6.5,-38) (-6.5,-76) #X008:1};
// &"GPNB" @WIRE(mode="straight",linecolor="#30485d",linewidth=0.16) {#XSTD_GPNCN:1 (61.5,-76) (61.5,-76) #XSTD_GPNBN:2};
// &"GPNDRV" @WIRE(mode="straight",linecolor="#30485d",linewidth=0.16) {#XSTD_GPNCN:2 (95.5,-76) (95.5,-76) #RGPN0:1};
// &"GPNA" @WIRE(mode="straight",linecolor="#30485d",linewidth=0.16) {#XSTD_GPNBN:1 (32.5,-76) (32.5,-76) #XSTD_GPNAN:2};
// &"GPNPRE" @WIRE(mode="straight",linecolor="#30485d",linewidth=0.16) {#XSTD_GPNAN:1 (0.5,-76) (0.5,-76) #X008:4};
// &"GPPB" @WIRE(mode="straight",linecolor="#30485d",linewidth=0.16) {#XSTD_GPPCN:1 (61.5,-114) (61.5,-114) #XSTD_GPPBN:2};
// &"GPPDRV" @WIRE(mode="straight",linecolor="#30485d",linewidth=0.16) {#XSTD_GPPCN:2 (95.5,-114) (95.5,-114) #RGPP0:1};
// &"GPPA" @WIRE(mode="straight",linecolor="#30485d",linewidth=0.16) {#XSTD_GPPBN:1 (32.5,-114) (32.5,-114) #XSTD_GPPAN:2};
// &"GNNRG" @WIRE(mode="straight",linecolor="#30485d",linewidth=0.16) {#RGNN1:1 (222.5,0) (222.5,0) #RGNN0_5__dmy0:2};
// &"RGNN1_1__dmy0" @WIRE(mode="straight",linecolor="#30485d",linewidth=0.16) {#RGNN1:2 (247.5,0) (247.5,0) #RGNN1_2__dmy0:1};
// &"RGNN1_2__dmy0" @WIRE(mode="straight",linecolor="#30485d",linewidth=0.16) {#RGNN1_2__dmy0:2 (272.5,0) (272.5,0) #RGNN1_3__dmy0:1};
// &"RGNN1_3__dmy0" @WIRE(mode="straight",linecolor="#30485d",linewidth=0.16) {#RGNN1_3__dmy0:2 (297.5,0) (297.5,0) #RGNN1_4__dmy0:1};
// &"RGNN1_4__dmy0" @WIRE(mode="straight",linecolor="#30485d",linewidth=0.16) {#RGNN1_4__dmy0:2 (322.5,0) (322.5,0) #RGNN1_5__dmy0:1};
// &"RGNN0_1__dmy0" @WIRE(mode="straight",linecolor="#30485d",linewidth=0.16) {#RGNN0:2 (122.5,0) (122.5,0) #RGNN0_2__dmy0:1};
// &"RGNN0_2__dmy0" @WIRE(mode="straight",linecolor="#30485d",linewidth=0.16) {#RGNN0_2__dmy0:2 (147.5,0) (147.5,0) #RGNN0_3__dmy0:1};
// &"RGNN0_3__dmy0" @WIRE(mode="straight",linecolor="#30485d",linewidth=0.16) {#RGNN0_3__dmy0:2 (172.5,0) (172.5,0) #RGNN0_4__dmy0:1};
// &"RGNN0_4__dmy0" @WIRE(mode="straight",linecolor="#30485d",linewidth=0.16) {#RGNN0_4__dmy0:2 (197.5,0) (197.5,0) #RGNN0_5__dmy0:1};
// &"GNPRG" @WIRE(mode="straight",linecolor="#30485d",linewidth=0.16) {#RGNP1:1 (222.5,-38) (222.5,-38) #RGNP0_5__dmy0:2};
// &"RGNP1_1__dmy0" @WIRE(mode="straight",linecolor="#30485d",linewidth=0.16) {#RGNP1:2 (247.5,-38) (247.5,-38) #RGNP1_2__dmy0:1};
// &"RGNP1_2__dmy0" @WIRE(mode="straight",linecolor="#30485d",linewidth=0.16) {#RGNP1_2__dmy0:2 (272.5,-38) (272.5,-38) #RGNP1_3__dmy0:1};
// &"RGNP1_3__dmy0" @WIRE(mode="straight",linecolor="#30485d",linewidth=0.16) {#RGNP1_3__dmy0:2 (297.5,-38) (297.5,-38) #RGNP1_4__dmy0:1};
// &"RGNP1_4__dmy0" @WIRE(mode="straight",linecolor="#30485d",linewidth=0.16) {#RGNP1_4__dmy0:2 (322.5,-38) (322.5,-38) #RGNP1_5__dmy0:1};
// &"RGNP0_1__dmy0" @WIRE(mode="straight",linecolor="#30485d",linewidth=0.16) {#RGNP0:2 (122.5,-38) (122.5,-38) #RGNP0_2__dmy0:1};
// &"RGNP0_2__dmy0" @WIRE(mode="straight",linecolor="#30485d",linewidth=0.16) {#RGNP0_2__dmy0:2 (147.5,-38) (147.5,-38) #RGNP0_3__dmy0:1};
// &"RGNP0_3__dmy0" @WIRE(mode="straight",linecolor="#30485d",linewidth=0.16) {#RGNP0_3__dmy0:2 (172.5,-38) (172.5,-38) #RGNP0_4__dmy0:1};
// &"RGNP0_4__dmy0" @WIRE(mode="straight",linecolor="#30485d",linewidth=0.16) {#RGNP0_4__dmy0:2 (197.5,-38) (197.5,-38) #RGNP0_5__dmy0:1};
// &"GPNRG" @WIRE(mode="straight",linecolor="#30485d",linewidth=0.16) {#RGPN1:1 (222.5,-76) (222.5,-76) #RGPN0_5__dmy0:2};
// &"RGPN1_1__dmy0" @WIRE(mode="straight",linecolor="#30485d",linewidth=0.16) {#RGPN1:2 (247.5,-76) (247.5,-76) #RGPN1_2__dmy0:1};
// &"RGPN1_2__dmy0" @WIRE(mode="straight",linecolor="#30485d",linewidth=0.16) {#RGPN1_2__dmy0:2 (272.5,-76) (272.5,-76) #RGPN1_3__dmy0:1};
// &"RGPN1_3__dmy0" @WIRE(mode="straight",linecolor="#30485d",linewidth=0.16) {#RGPN1_3__dmy0:2 (297.5,-76) (297.5,-76) #RGPN1_4__dmy0:1};
// &"RGPN1_4__dmy0" @WIRE(mode="straight",linecolor="#30485d",linewidth=0.16) {#RGPN1_4__dmy0:2 (322.5,-76) (322.5,-76) #RGPN1_5__dmy0:1};
// &"RGPN0_1__dmy0" @WIRE(mode="straight",linecolor="#30485d",linewidth=0.16) {#RGPN0:2 (122.5,-76) (122.5,-76) #RGPN0_2__dmy0:1};
// &"RGPN0_2__dmy0" @WIRE(mode="straight",linecolor="#30485d",linewidth=0.16) {#RGPN0_2__dmy0:2 (147.5,-76) (147.5,-76) #RGPN0_3__dmy0:1};
// &"RGPN0_3__dmy0" @WIRE(mode="straight",linecolor="#30485d",linewidth=0.16) {#RGPN0_3__dmy0:2 (172.5,-76) (172.5,-76) #RGPN0_4__dmy0:1};
// &"RGPN0_4__dmy0" @WIRE(mode="straight",linecolor="#30485d",linewidth=0.16) {#RGPN0_4__dmy0:2 (197.5,-76) (197.5,-76) #RGPN0_5__dmy0:1};
// &"GPPRG" @WIRE(mode="straight",linecolor="#30485d",linewidth=0.16) {#RGPP1:1 (222.5,-114) (222.5,-114) #RGPP0_5__dmy0:2};
// &"RGPP1_1__dmy0" @WIRE(mode="straight",linecolor="#30485d",linewidth=0.16) {#RGPP1:2 (247.5,-114) (247.5,-114) #RGPP1_2__dmy0:1};
// &"RGPP1_2__dmy0" @WIRE(mode="straight",linecolor="#30485d",linewidth=0.16) {#RGPP1_2__dmy0:2 (272.5,-114) (272.5,-114) #RGPP1_3__dmy0:1};
// &"RGPP1_3__dmy0" @WIRE(mode="straight",linecolor="#30485d",linewidth=0.16) {#RGPP1_3__dmy0:2 (297.5,-114) (297.5,-114) #RGPP1_4__dmy0:1};
// &"RGPP1_4__dmy0" @WIRE(mode="straight",linecolor="#30485d",linewidth=0.16) {#RGPP1_4__dmy0:2 (322.5,-114) (322.5,-114) #RGPP1_5__dmy0:1};
// &"RGPP0_1__dmy0" @WIRE(mode="straight",linecolor="#30485d",linewidth=0.16) {#RGPP0:2 (122.5,-114) (122.5,-114) #RGPP0_2__dmy0:1};
// &"RGPP0_2__dmy0" @WIRE(mode="straight",linecolor="#30485d",linewidth=0.16) {#RGPP0_2__dmy0:2 (147.5,-114) (147.5,-114) #RGPP0_3__dmy0:1};
// &"RGPP0_3__dmy0" @WIRE(mode="straight",linecolor="#30485d",linewidth=0.16) {#RGPP0_3__dmy0:2 (172.5,-114) (172.5,-114) #RGPP0_4__dmy0:1};
// &"RGPP0_4__dmy0" @WIRE(mode="straight",linecolor="#30485d",linewidth=0.16) {#RGPP0_4__dmy0:2 (197.5,-114) (197.5,-114) #RGPP0_5__dmy0:1};
// (-28,-148) @TEXT("GP and GN chains keep their source polarity, device sizing and series R; no zero-delay abstraction.",size=1,halign="start",textcolor="#223d52");
// &"VDD" @WIRE(mode="straight",linecolor="#30485d",linewidth=0.16) {#XSTD_GNNCN:3 (76,10)};
// (76,10.4) @TEXT("VDD",size=1.1,halign="middle",valign="bottom");
// &"VSS" @WIRE(mode="straight",linecolor="#30485d",linewidth=0.16) {#XSTD_GNNCN:4 (76,-10)};
// (76,-10.4) @TEXT("VSS",size=1.1,halign="middle",valign="top");
// &"VDD" @WIRE(mode="straight",linecolor="#30485d",linewidth=0.16) {#XSTD_GNNBN:3 (47,10)};
// (47,10.4) @TEXT("VDD",size=1.1,halign="middle",valign="bottom");
// &"VSS" @WIRE(mode="straight",linecolor="#30485d",linewidth=0.16) {#XSTD_GNNBN:4 (47,-10)};
// (47,-10.4) @TEXT("VSS",size=1.1,halign="middle",valign="top");
// &"VDD" @WIRE(mode="straight",linecolor="#30485d",linewidth=0.16) {#XSTD_GNNAN:3 (18,10)};
// (18,10.4) @TEXT("VDD",size=1.1,halign="middle",valign="bottom");
// &"VSS" @WIRE(mode="straight",linecolor="#30485d",linewidth=0.16) {#XSTD_GNNAN:4 (18,-10)};
// (18,-10.4) @TEXT("VSS",size=1.1,halign="middle",valign="top");
// &"VDD" @WIRE(mode="straight",linecolor="#30485d",linewidth=0.16) {#XSTD_GNPCN:3 (76,-28)};
// (76,-27.6) @TEXT("VDD",size=1.1,halign="middle",valign="bottom");
// &"VSS" @WIRE(mode="straight",linecolor="#30485d",linewidth=0.16) {#XSTD_GNPCN:4 (76,-48)};
// (76,-48.4) @TEXT("VSS",size=1.1,halign="middle",valign="top");
// &"VDD" @WIRE(mode="straight",linecolor="#30485d",linewidth=0.16) {#XSTD_GNPBN:3 (47,-28)};
// (47,-27.6) @TEXT("VDD",size=1.1,halign="middle",valign="bottom");
// &"VSS" @WIRE(mode="straight",linecolor="#30485d",linewidth=0.16) {#XSTD_GNPBN:4 (47,-48)};
// (47,-48.4) @TEXT("VSS",size=1.1,halign="middle",valign="top");
// &"VDD" @WIRE(mode="straight",linecolor="#30485d",linewidth=0.16) {#XSTD_GNPAN:3 (18,-28)};
// (18,-27.6) @TEXT("VDD",size=1.1,halign="middle",valign="bottom");
// &"VSS" @WIRE(mode="straight",linecolor="#30485d",linewidth=0.16) {#XSTD_GNPAN:4 (18,-48)};
// (18,-48.4) @TEXT("VSS",size=1.1,halign="middle",valign="top");
// &"VDD" @WIRE(mode="straight",linecolor="#30485d",linewidth=0.16) {#XSTD_GPNCN:3 (76,-66)};
// (76,-65.6) @TEXT("VDD",size=1.1,halign="middle",valign="bottom");
// &"VSS" @WIRE(mode="straight",linecolor="#30485d",linewidth=0.16) {#XSTD_GPNCN:4 (76,-86)};
// (76,-86.4) @TEXT("VSS",size=1.1,halign="middle",valign="top");
// &"VDD" @WIRE(mode="straight",linecolor="#30485d",linewidth=0.16) {#XSTD_GPNBN:3 (47,-66)};
// (47,-65.6) @TEXT("VDD",size=1.1,halign="middle",valign="bottom");
// &"VSS" @WIRE(mode="straight",linecolor="#30485d",linewidth=0.16) {#XSTD_GPNBN:4 (47,-86)};
// (47,-86.4) @TEXT("VSS",size=1.1,halign="middle",valign="top");
// &"VDD" @WIRE(mode="straight",linecolor="#30485d",linewidth=0.16) {#XSTD_GPNAN:3 (18,-66)};
// (18,-65.6) @TEXT("VDD",size=1.1,halign="middle",valign="bottom");
// &"VSS" @WIRE(mode="straight",linecolor="#30485d",linewidth=0.16) {#XSTD_GPNAN:4 (18,-86)};
// (18,-86.4) @TEXT("VSS",size=1.1,halign="middle",valign="top");
// &"VDD" @WIRE(mode="straight",linecolor="#30485d",linewidth=0.16) {#XSTD_GPPCN:3 (76,-104)};
// (76,-103.6) @TEXT("VDD",size=1.1,halign="middle",valign="bottom");
// &"VSS" @WIRE(mode="straight",linecolor="#30485d",linewidth=0.16) {#XSTD_GPPCN:4 (76,-124)};
// (76,-124.4) @TEXT("VSS",size=1.1,halign="middle",valign="top");
// &"VDD" @WIRE(mode="straight",linecolor="#30485d",linewidth=0.16) {#XSTD_GPPBN:3 (47,-104)};
// (47,-103.6) @TEXT("VDD",size=1.1,halign="middle",valign="bottom");
// &"VSS" @WIRE(mode="straight",linecolor="#30485d",linewidth=0.16) {#XSTD_GPPBN:4 (47,-124)};
// (47,-124.4) @TEXT("VSS",size=1.1,halign="middle",valign="top");
// &"L" @WIRE(mode="straight",linecolor="#30485d",linewidth=0.16) {#XSTD_GPPAN:1 (8,-114)};
// (7.6,-114) @TEXT("L",size=1.1,halign="end",valign="middle");
// &"VDD" @WIRE(mode="straight",linecolor="#30485d",linewidth=0.16) {#XSTD_GPPAN:3 (18,-104)};
// (18,-103.6) @TEXT("VDD",size=1.1,halign="middle",valign="bottom");
// &"VSS" @WIRE(mode="straight",linecolor="#30485d",linewidth=0.16) {#XSTD_GPPAN:4 (18,-124)};
// (18,-124.4) @TEXT("VSS",size=1.1,halign="middle",valign="top");
// &"GNN" @WIRE(mode="straight",linecolor="#30485d",linewidth=0.16) {#RGNN1_5__dmy0:2 (340,0)};
// (340.4,0) @TEXT("GNN",size=1.1,halign="start",valign="middle");
// &"GNP" @WIRE(mode="straight",linecolor="#30485d",linewidth=0.16) {#RGNP1_5__dmy0:2 (340,-38)};
// (340.4,-38) @TEXT("GNP",size=1.1,halign="start",valign="middle");
// &"GPN" @WIRE(mode="straight",linecolor="#30485d",linewidth=0.16) {#RGPN1_5__dmy0:2 (340,-76)};
// (340.4,-76) @TEXT("GPN",size=1.1,halign="start",valign="middle");
// &"GPP" @WIRE(mode="straight",linecolor="#30485d",linewidth=0.16) {#RGPP1_5__dmy0:2 (340,-114)};
// (340.4,-114) @TEXT("GPP",size=1.1,halign="start",valign="middle");
// &"L" @WIRE(mode="straight",linecolor="#30485d",linewidth=0.16) {#X025:1 (-27,0)};
// (-27.4,0) @TEXT("L",size=1.1,halign="end",valign="middle");
// &"VDD" @WIRE(mode="straight",linecolor="#30485d",linewidth=0.16) {#X025:2 (-17,10)};
// (-17,10.4) @TEXT("VDD",size=1.1,halign="middle",valign="bottom");
// &"VSS" @WIRE(mode="straight",linecolor="#30485d",linewidth=0.16) {#X025:3 (-17,-10)};
// (-17,-10.4) @TEXT("VSS",size=1.1,halign="middle",valign="top");
// &"VDD" @WIRE(mode="straight",linecolor="#30485d",linewidth=0.16) {#X008:2 (-17,-66)};
// (-17,-65.6) @TEXT("VDD",size=1.1,halign="middle",valign="bottom");
// &"VSS" @WIRE(mode="straight",linecolor="#30485d",linewidth=0.16) {#X008:3 (-17,-86)};
// (-17,-86.4) @TEXT("VSS",size=1.1,halign="middle",valign="top");
// }
// END SARADC RNL
ends sar8p_refdrv_b2

subckt sar8p_refdrv_b3 GNN GNP GPN GPP H L VDD VSS
    XSTD_GNNCN (GNNB GNNDRV VDD VSS) INVD1BWP12T30P140
    XSTD_GNNBN (GNNA GNNB VDD VSS) INVD1BWP12T30P140
    XSTD_GNNAN (GNNPRE GNNA VDD VSS) INVD1BWP12T30P140
    XSTD_GNPCN (GNPB GNPDRV VDD VSS) INVD1BWP12T30P140
    XSTD_GNPBN (GNPA GNPB VDD VSS) INVD1BWP12T30P140
    XSTD_GNPAN (H GNPA VDD VSS) INVD1BWP12T30P140
    XSTD_GPNCN (GPNB GPNDRV VDD VSS) INVD1BWP12T30P140
    XSTD_GPNBN (GPNA GPNB VDD VSS) INVD1BWP12T30P140
    XSTD_GPNAN (GPNPRE GPNA VDD VSS) INVD1BWP12T30P140
    XSTD_GPPCN (GPPB GPPDRV VDD VSS) INVD1BWP12T30P140
    XSTD_GPPBN (GPPA GPPB VDD VSS) INVD1BWP12T30P140
    XSTD_GPPAN (L GPPA VDD VSS) INVD1BWP12T30P140
//Series configuration of RGNN1
RGNN1  (GNNRG RGNN1_1__dmy0 ) rupolym l=17.13u w=1u m=8 multi=(1)
RGNN1_2__dmy0  (RGNN1_1__dmy0 RGNN1_2__dmy0 ) rupolym l=17.13u w=1u m=8 \
        multi=(1)
RGNN1_3__dmy0  (RGNN1_2__dmy0 RGNN1_3__dmy0 ) rupolym l=17.13u w=1u m=8 \
        multi=(1)
RGNN1_4__dmy0  (RGNN1_3__dmy0 RGNN1_4__dmy0 ) rupolym l=17.13u w=1u m=8 \
        multi=(1)
RGNN1_5__dmy0  (RGNN1_4__dmy0 GNN ) rupolym l=17.13u w=1u m=8 multi=(1)
//End of RGNN1

//Series configuration of RGNN0
RGNN0  (GNNDRV RGNN0_1__dmy0 ) rupolym l=17.13u w=1u m=8 multi=(1)
RGNN0_2__dmy0  (RGNN0_1__dmy0 RGNN0_2__dmy0 ) rupolym l=17.13u w=1u m=8 \
        multi=(1)
RGNN0_3__dmy0  (RGNN0_2__dmy0 RGNN0_3__dmy0 ) rupolym l=17.13u w=1u m=8 \
        multi=(1)
RGNN0_4__dmy0  (RGNN0_3__dmy0 RGNN0_4__dmy0 ) rupolym l=17.13u w=1u m=8 \
        multi=(1)
RGNN0_5__dmy0  (RGNN0_4__dmy0 GNNRG ) rupolym l=17.13u w=1u m=8 multi=(1)
//End of RGNN0

//Series configuration of RGNP1
RGNP1  (GNPRG RGNP1_1__dmy0 ) rupolym l=17.13u w=1u m=8 multi=(1)
RGNP1_2__dmy0  (RGNP1_1__dmy0 RGNP1_2__dmy0 ) rupolym l=17.13u w=1u m=8 \
        multi=(1)
RGNP1_3__dmy0  (RGNP1_2__dmy0 RGNP1_3__dmy0 ) rupolym l=17.13u w=1u m=8 \
        multi=(1)
RGNP1_4__dmy0  (RGNP1_3__dmy0 RGNP1_4__dmy0 ) rupolym l=17.13u w=1u m=8 \
        multi=(1)
RGNP1_5__dmy0  (RGNP1_4__dmy0 GNP ) rupolym l=17.13u w=1u m=8 multi=(1)
//End of RGNP1

//Series configuration of RGNP0
RGNP0  (GNPDRV RGNP0_1__dmy0 ) rupolym l=17.13u w=1u m=8 multi=(1)
RGNP0_2__dmy0  (RGNP0_1__dmy0 RGNP0_2__dmy0 ) rupolym l=17.13u w=1u m=8 \
        multi=(1)
RGNP0_3__dmy0  (RGNP0_2__dmy0 RGNP0_3__dmy0 ) rupolym l=17.13u w=1u m=8 \
        multi=(1)
RGNP0_4__dmy0  (RGNP0_3__dmy0 RGNP0_4__dmy0 ) rupolym l=17.13u w=1u m=8 \
        multi=(1)
RGNP0_5__dmy0  (RGNP0_4__dmy0 GNPRG ) rupolym l=17.13u w=1u m=8 multi=(1)
//End of RGNP0

//Series configuration of RGPN1
RGPN1  (GPNRG RGPN1_1__dmy0 ) rupolym l=17.13u w=1u m=8 multi=(1)
RGPN1_2__dmy0  (RGPN1_1__dmy0 RGPN1_2__dmy0 ) rupolym l=17.13u w=1u m=8 \
        multi=(1)
RGPN1_3__dmy0  (RGPN1_2__dmy0 RGPN1_3__dmy0 ) rupolym l=17.13u w=1u m=8 \
        multi=(1)
RGPN1_4__dmy0  (RGPN1_3__dmy0 RGPN1_4__dmy0 ) rupolym l=17.13u w=1u m=8 \
        multi=(1)
RGPN1_5__dmy0  (RGPN1_4__dmy0 GPN ) rupolym l=17.13u w=1u m=8 multi=(1)
//End of RGPN1

//Series configuration of RGPN0
RGPN0  (GPNDRV RGPN0_1__dmy0 ) rupolym l=17.13u w=1u m=8 multi=(1)
RGPN0_2__dmy0  (RGPN0_1__dmy0 RGPN0_2__dmy0 ) rupolym l=17.13u w=1u m=8 \
        multi=(1)
RGPN0_3__dmy0  (RGPN0_2__dmy0 RGPN0_3__dmy0 ) rupolym l=17.13u w=1u m=8 \
        multi=(1)
RGPN0_4__dmy0  (RGPN0_3__dmy0 RGPN0_4__dmy0 ) rupolym l=17.13u w=1u m=8 \
        multi=(1)
RGPN0_5__dmy0  (RGPN0_4__dmy0 GPNRG ) rupolym l=17.13u w=1u m=8 multi=(1)
//End of RGPN0

//Series configuration of RGPP1
RGPP1  (GPPRG RGPP1_1__dmy0 ) rupolym l=17.13u w=1u m=8 multi=(1)
RGPP1_2__dmy0  (RGPP1_1__dmy0 RGPP1_2__dmy0 ) rupolym l=17.13u w=1u m=8 \
        multi=(1)
RGPP1_3__dmy0  (RGPP1_2__dmy0 RGPP1_3__dmy0 ) rupolym l=17.13u w=1u m=8 \
        multi=(1)
RGPP1_4__dmy0  (RGPP1_3__dmy0 RGPP1_4__dmy0 ) rupolym l=17.13u w=1u m=8 \
        multi=(1)
RGPP1_5__dmy0  (RGPP1_4__dmy0 GPP ) rupolym l=17.13u w=1u m=8 multi=(1)
//End of RGPP1

//Series configuration of RGPP0
RGPP0  (GPPDRV RGPP0_1__dmy0 ) rupolym l=17.13u w=1u m=8 multi=(1)
RGPP0_2__dmy0  (RGPP0_1__dmy0 RGPP0_2__dmy0 ) rupolym l=17.13u w=1u m=8 \
        multi=(1)
RGPP0_3__dmy0  (RGPP0_2__dmy0 RGPP0_3__dmy0 ) rupolym l=17.13u w=1u m=8 \
        multi=(1)
RGPP0_4__dmy0  (RGPP0_3__dmy0 RGPP0_4__dmy0 ) rupolym l=17.13u w=1u m=8 \
        multi=(1)
RGPP0_5__dmy0  (RGPP0_4__dmy0 GPPRG ) rupolym l=17.13u w=1u m=8 multi=(1)
//End of RGPP0

    X025 (L VDD VSS GNNPRE) sar8p_inv
    X008 (H VDD VSS GPNPRE) sar8p_inv
// BEGIN SARADC RNL
// @RNL(author="saradc topology") {
// (-28,27) @TEXT("sar8p_refdrv_b3 / four physical gate-driver chains",size=1.5,halign="start",textcolor="#223d52");
// #X025 @SET-SYMBOL $S_sar8p_inv;
// #X025 @PLACE(-17,0) => @ORIENT("R0");
// #XSTD_GNNAN @SET-SYMBOL $S_INVD1BWP12T30P140;
// #XSTD_GNNAN @PLACE(18,0) => @ORIENT("R0");
// #XSTD_GNNBN @SET-SYMBOL $S_INVD1BWP12T30P140;
// #XSTD_GNNBN @PLACE(47,0) => @ORIENT("R0");
// #XSTD_GNNCN @SET-SYMBOL $S_INVD1BWP12T30P140;
// #XSTD_GNNCN @PLACE(76,0) => @ORIENT("R0");
// #RGNN0 @SET-SYMBOL $RESISTOR;
// #RGNN0 @PLACE(110,0) => @ORIENT("R90");
// #RGNN0 @TEXT("RGNN0",key="name",size=1.3,halign="start") => @PLACE(113,3);
// #RGNN0 @TEXT("l=17.13u w=1u multi=(1)",key="value",size=0.9,halign="start") => @PLACE(113,-4);
// #RGNN0 @TEXT("",key="model");
// #RGNN0_2__dmy0 @SET-SYMBOL $RESISTOR;
// #RGNN0_2__dmy0 @PLACE(135,0) => @ORIENT("R90");
// #RGNN0_2__dmy0 @TEXT("RGNN0_2__dmy0",key="name",size=1.3,halign="start") => @PLACE(138,3);
// #RGNN0_2__dmy0 @TEXT("l=17.13u w=1u multi=(1)",key="value",size=0.9,halign="start") => @PLACE(138,-4);
// #RGNN0_2__dmy0 @TEXT("",key="model");
// #RGNN0_3__dmy0 @SET-SYMBOL $RESISTOR;
// #RGNN0_3__dmy0 @PLACE(160,0) => @ORIENT("R90");
// #RGNN0_3__dmy0 @TEXT("RGNN0_3__dmy0",key="name",size=1.3,halign="start") => @PLACE(163,3);
// #RGNN0_3__dmy0 @TEXT("l=17.13u w=1u multi=(1)",key="value",size=0.9,halign="start") => @PLACE(163,-4);
// #RGNN0_3__dmy0 @TEXT("",key="model");
// #RGNN0_4__dmy0 @SET-SYMBOL $RESISTOR;
// #RGNN0_4__dmy0 @PLACE(185,0) => @ORIENT("R90");
// #RGNN0_4__dmy0 @TEXT("RGNN0_4__dmy0",key="name",size=1.3,halign="start") => @PLACE(188,3);
// #RGNN0_4__dmy0 @TEXT("l=17.13u w=1u multi=(1)",key="value",size=0.9,halign="start") => @PLACE(188,-4);
// #RGNN0_4__dmy0 @TEXT("",key="model");
// #RGNN0_5__dmy0 @SET-SYMBOL $RESISTOR;
// #RGNN0_5__dmy0 @PLACE(210,0) => @ORIENT("R90");
// #RGNN0_5__dmy0 @TEXT("RGNN0_5__dmy0",key="name",size=1.3,halign="start") => @PLACE(213,3);
// #RGNN0_5__dmy0 @TEXT("l=17.13u w=1u multi=(1)",key="value",size=0.9,halign="start") => @PLACE(213,-4);
// #RGNN0_5__dmy0 @TEXT("",key="model");
// #RGNN1 @SET-SYMBOL $RESISTOR;
// #RGNN1 @PLACE(235,0) => @ORIENT("R90");
// #RGNN1 @TEXT("RGNN1",key="name",size=1.3,halign="start") => @PLACE(238,3);
// #RGNN1 @TEXT("l=17.13u w=1u multi=(1)",key="value",size=0.9,halign="start") => @PLACE(238,-4);
// #RGNN1 @TEXT("",key="model");
// #RGNN1_2__dmy0 @SET-SYMBOL $RESISTOR;
// #RGNN1_2__dmy0 @PLACE(260,0) => @ORIENT("R90");
// #RGNN1_2__dmy0 @TEXT("RGNN1_2__dmy0",key="name",size=1.3,halign="start") => @PLACE(263,3);
// #RGNN1_2__dmy0 @TEXT("l=17.13u w=1u multi=(1)",key="value",size=0.9,halign="start") => @PLACE(263,-4);
// #RGNN1_2__dmy0 @TEXT("",key="model");
// #RGNN1_3__dmy0 @SET-SYMBOL $RESISTOR;
// #RGNN1_3__dmy0 @PLACE(285,0) => @ORIENT("R90");
// #RGNN1_3__dmy0 @TEXT("RGNN1_3__dmy0",key="name",size=1.3,halign="start") => @PLACE(288,3);
// #RGNN1_3__dmy0 @TEXT("l=17.13u w=1u multi=(1)",key="value",size=0.9,halign="start") => @PLACE(288,-4);
// #RGNN1_3__dmy0 @TEXT("",key="model");
// #RGNN1_4__dmy0 @SET-SYMBOL $RESISTOR;
// #RGNN1_4__dmy0 @PLACE(310,0) => @ORIENT("R90");
// #RGNN1_4__dmy0 @TEXT("RGNN1_4__dmy0",key="name",size=1.3,halign="start") => @PLACE(313,3);
// #RGNN1_4__dmy0 @TEXT("l=17.13u w=1u multi=(1)",key="value",size=0.9,halign="start") => @PLACE(313,-4);
// #RGNN1_4__dmy0 @TEXT("",key="model");
// #RGNN1_5__dmy0 @SET-SYMBOL $RESISTOR;
// #RGNN1_5__dmy0 @PLACE(335,0) => @ORIENT("R90");
// #RGNN1_5__dmy0 @TEXT("RGNN1_5__dmy0",key="name",size=1.3,halign="start") => @PLACE(338,3);
// #RGNN1_5__dmy0 @TEXT("l=17.13u w=1u multi=(1)",key="value",size=0.9,halign="start") => @PLACE(338,-4);
// #RGNN1_5__dmy0 @TEXT("",key="model");
// (104,15) @TEXT("GNN / 10 series poly sections",size=0.95,halign="start",textcolor="#223d52");
// #XSTD_GNPAN @SET-SYMBOL $S_INVD1BWP12T30P140;
// #XSTD_GNPAN @PLACE(18,-38) => @ORIENT("R0");
// #XSTD_GNPBN @SET-SYMBOL $S_INVD1BWP12T30P140;
// #XSTD_GNPBN @PLACE(47,-38) => @ORIENT("R0");
// #XSTD_GNPCN @SET-SYMBOL $S_INVD1BWP12T30P140;
// #XSTD_GNPCN @PLACE(76,-38) => @ORIENT("R0");
// #RGNP0 @SET-SYMBOL $RESISTOR;
// #RGNP0 @PLACE(110,-38) => @ORIENT("R90");
// #RGNP0 @TEXT("RGNP0",key="name",size=1.3,halign="start") => @PLACE(113,-35);
// #RGNP0 @TEXT("l=17.13u w=1u multi=(1)",key="value",size=0.9,halign="start") => @PLACE(113,-42);
// #RGNP0 @TEXT("",key="model");
// #RGNP0_2__dmy0 @SET-SYMBOL $RESISTOR;
// #RGNP0_2__dmy0 @PLACE(135,-38) => @ORIENT("R90");
// #RGNP0_2__dmy0 @TEXT("RGNP0_2__dmy0",key="name",size=1.3,halign="start") => @PLACE(138,-35);
// #RGNP0_2__dmy0 @TEXT("l=17.13u w=1u multi=(1)",key="value",size=0.9,halign="start") => @PLACE(138,-42);
// #RGNP0_2__dmy0 @TEXT("",key="model");
// #RGNP0_3__dmy0 @SET-SYMBOL $RESISTOR;
// #RGNP0_3__dmy0 @PLACE(160,-38) => @ORIENT("R90");
// #RGNP0_3__dmy0 @TEXT("RGNP0_3__dmy0",key="name",size=1.3,halign="start") => @PLACE(163,-35);
// #RGNP0_3__dmy0 @TEXT("l=17.13u w=1u multi=(1)",key="value",size=0.9,halign="start") => @PLACE(163,-42);
// #RGNP0_3__dmy0 @TEXT("",key="model");
// #RGNP0_4__dmy0 @SET-SYMBOL $RESISTOR;
// #RGNP0_4__dmy0 @PLACE(185,-38) => @ORIENT("R90");
// #RGNP0_4__dmy0 @TEXT("RGNP0_4__dmy0",key="name",size=1.3,halign="start") => @PLACE(188,-35);
// #RGNP0_4__dmy0 @TEXT("l=17.13u w=1u multi=(1)",key="value",size=0.9,halign="start") => @PLACE(188,-42);
// #RGNP0_4__dmy0 @TEXT("",key="model");
// #RGNP0_5__dmy0 @SET-SYMBOL $RESISTOR;
// #RGNP0_5__dmy0 @PLACE(210,-38) => @ORIENT("R90");
// #RGNP0_5__dmy0 @TEXT("RGNP0_5__dmy0",key="name",size=1.3,halign="start") => @PLACE(213,-35);
// #RGNP0_5__dmy0 @TEXT("l=17.13u w=1u multi=(1)",key="value",size=0.9,halign="start") => @PLACE(213,-42);
// #RGNP0_5__dmy0 @TEXT("",key="model");
// #RGNP1 @SET-SYMBOL $RESISTOR;
// #RGNP1 @PLACE(235,-38) => @ORIENT("R90");
// #RGNP1 @TEXT("RGNP1",key="name",size=1.3,halign="start") => @PLACE(238,-35);
// #RGNP1 @TEXT("l=17.13u w=1u multi=(1)",key="value",size=0.9,halign="start") => @PLACE(238,-42);
// #RGNP1 @TEXT("",key="model");
// #RGNP1_2__dmy0 @SET-SYMBOL $RESISTOR;
// #RGNP1_2__dmy0 @PLACE(260,-38) => @ORIENT("R90");
// #RGNP1_2__dmy0 @TEXT("RGNP1_2__dmy0",key="name",size=1.3,halign="start") => @PLACE(263,-35);
// #RGNP1_2__dmy0 @TEXT("l=17.13u w=1u multi=(1)",key="value",size=0.9,halign="start") => @PLACE(263,-42);
// #RGNP1_2__dmy0 @TEXT("",key="model");
// #RGNP1_3__dmy0 @SET-SYMBOL $RESISTOR;
// #RGNP1_3__dmy0 @PLACE(285,-38) => @ORIENT("R90");
// #RGNP1_3__dmy0 @TEXT("RGNP1_3__dmy0",key="name",size=1.3,halign="start") => @PLACE(288,-35);
// #RGNP1_3__dmy0 @TEXT("l=17.13u w=1u multi=(1)",key="value",size=0.9,halign="start") => @PLACE(288,-42);
// #RGNP1_3__dmy0 @TEXT("",key="model");
// #RGNP1_4__dmy0 @SET-SYMBOL $RESISTOR;
// #RGNP1_4__dmy0 @PLACE(310,-38) => @ORIENT("R90");
// #RGNP1_4__dmy0 @TEXT("RGNP1_4__dmy0",key="name",size=1.3,halign="start") => @PLACE(313,-35);
// #RGNP1_4__dmy0 @TEXT("l=17.13u w=1u multi=(1)",key="value",size=0.9,halign="start") => @PLACE(313,-42);
// #RGNP1_4__dmy0 @TEXT("",key="model");
// #RGNP1_5__dmy0 @SET-SYMBOL $RESISTOR;
// #RGNP1_5__dmy0 @PLACE(335,-38) => @ORIENT("R90");
// #RGNP1_5__dmy0 @TEXT("RGNP1_5__dmy0",key="name",size=1.3,halign="start") => @PLACE(338,-35);
// #RGNP1_5__dmy0 @TEXT("l=17.13u w=1u multi=(1)",key="value",size=0.9,halign="start") => @PLACE(338,-42);
// #RGNP1_5__dmy0 @TEXT("",key="model");
// (104,-23) @TEXT("GNP / 10 series poly sections",size=0.95,halign="start",textcolor="#223d52");
// #X008 @SET-SYMBOL $S_sar8p_inv;
// #X008 @PLACE(-17,-76) => @ORIENT("R0");
// #XSTD_GPNAN @SET-SYMBOL $S_INVD1BWP12T30P140;
// #XSTD_GPNAN @PLACE(18,-76) => @ORIENT("R0");
// #XSTD_GPNBN @SET-SYMBOL $S_INVD1BWP12T30P140;
// #XSTD_GPNBN @PLACE(47,-76) => @ORIENT("R0");
// #XSTD_GPNCN @SET-SYMBOL $S_INVD1BWP12T30P140;
// #XSTD_GPNCN @PLACE(76,-76) => @ORIENT("R0");
// #RGPN0 @SET-SYMBOL $RESISTOR;
// #RGPN0 @PLACE(110,-76) => @ORIENT("R90");
// #RGPN0 @TEXT("RGPN0",key="name",size=1.3,halign="start") => @PLACE(113,-73);
// #RGPN0 @TEXT("l=17.13u w=1u multi=(1)",key="value",size=0.9,halign="start") => @PLACE(113,-80);
// #RGPN0 @TEXT("",key="model");
// #RGPN0_2__dmy0 @SET-SYMBOL $RESISTOR;
// #RGPN0_2__dmy0 @PLACE(135,-76) => @ORIENT("R90");
// #RGPN0_2__dmy0 @TEXT("RGPN0_2__dmy0",key="name",size=1.3,halign="start") => @PLACE(138,-73);
// #RGPN0_2__dmy0 @TEXT("l=17.13u w=1u multi=(1)",key="value",size=0.9,halign="start") => @PLACE(138,-80);
// #RGPN0_2__dmy0 @TEXT("",key="model");
// #RGPN0_3__dmy0 @SET-SYMBOL $RESISTOR;
// #RGPN0_3__dmy0 @PLACE(160,-76) => @ORIENT("R90");
// #RGPN0_3__dmy0 @TEXT("RGPN0_3__dmy0",key="name",size=1.3,halign="start") => @PLACE(163,-73);
// #RGPN0_3__dmy0 @TEXT("l=17.13u w=1u multi=(1)",key="value",size=0.9,halign="start") => @PLACE(163,-80);
// #RGPN0_3__dmy0 @TEXT("",key="model");
// #RGPN0_4__dmy0 @SET-SYMBOL $RESISTOR;
// #RGPN0_4__dmy0 @PLACE(185,-76) => @ORIENT("R90");
// #RGPN0_4__dmy0 @TEXT("RGPN0_4__dmy0",key="name",size=1.3,halign="start") => @PLACE(188,-73);
// #RGPN0_4__dmy0 @TEXT("l=17.13u w=1u multi=(1)",key="value",size=0.9,halign="start") => @PLACE(188,-80);
// #RGPN0_4__dmy0 @TEXT("",key="model");
// #RGPN0_5__dmy0 @SET-SYMBOL $RESISTOR;
// #RGPN0_5__dmy0 @PLACE(210,-76) => @ORIENT("R90");
// #RGPN0_5__dmy0 @TEXT("RGPN0_5__dmy0",key="name",size=1.3,halign="start") => @PLACE(213,-73);
// #RGPN0_5__dmy0 @TEXT("l=17.13u w=1u multi=(1)",key="value",size=0.9,halign="start") => @PLACE(213,-80);
// #RGPN0_5__dmy0 @TEXT("",key="model");
// #RGPN1 @SET-SYMBOL $RESISTOR;
// #RGPN1 @PLACE(235,-76) => @ORIENT("R90");
// #RGPN1 @TEXT("RGPN1",key="name",size=1.3,halign="start") => @PLACE(238,-73);
// #RGPN1 @TEXT("l=17.13u w=1u multi=(1)",key="value",size=0.9,halign="start") => @PLACE(238,-80);
// #RGPN1 @TEXT("",key="model");
// #RGPN1_2__dmy0 @SET-SYMBOL $RESISTOR;
// #RGPN1_2__dmy0 @PLACE(260,-76) => @ORIENT("R90");
// #RGPN1_2__dmy0 @TEXT("RGPN1_2__dmy0",key="name",size=1.3,halign="start") => @PLACE(263,-73);
// #RGPN1_2__dmy0 @TEXT("l=17.13u w=1u multi=(1)",key="value",size=0.9,halign="start") => @PLACE(263,-80);
// #RGPN1_2__dmy0 @TEXT("",key="model");
// #RGPN1_3__dmy0 @SET-SYMBOL $RESISTOR;
// #RGPN1_3__dmy0 @PLACE(285,-76) => @ORIENT("R90");
// #RGPN1_3__dmy0 @TEXT("RGPN1_3__dmy0",key="name",size=1.3,halign="start") => @PLACE(288,-73);
// #RGPN1_3__dmy0 @TEXT("l=17.13u w=1u multi=(1)",key="value",size=0.9,halign="start") => @PLACE(288,-80);
// #RGPN1_3__dmy0 @TEXT("",key="model");
// #RGPN1_4__dmy0 @SET-SYMBOL $RESISTOR;
// #RGPN1_4__dmy0 @PLACE(310,-76) => @ORIENT("R90");
// #RGPN1_4__dmy0 @TEXT("RGPN1_4__dmy0",key="name",size=1.3,halign="start") => @PLACE(313,-73);
// #RGPN1_4__dmy0 @TEXT("l=17.13u w=1u multi=(1)",key="value",size=0.9,halign="start") => @PLACE(313,-80);
// #RGPN1_4__dmy0 @TEXT("",key="model");
// #RGPN1_5__dmy0 @SET-SYMBOL $RESISTOR;
// #RGPN1_5__dmy0 @PLACE(335,-76) => @ORIENT("R90");
// #RGPN1_5__dmy0 @TEXT("RGPN1_5__dmy0",key="name",size=1.3,halign="start") => @PLACE(338,-73);
// #RGPN1_5__dmy0 @TEXT("l=17.13u w=1u multi=(1)",key="value",size=0.9,halign="start") => @PLACE(338,-80);
// #RGPN1_5__dmy0 @TEXT("",key="model");
// (104,-61) @TEXT("GPN / 10 series poly sections",size=0.95,halign="start",textcolor="#223d52");
// #XSTD_GPPAN @SET-SYMBOL $S_INVD1BWP12T30P140;
// #XSTD_GPPAN @PLACE(18,-114) => @ORIENT("R0");
// #XSTD_GPPBN @SET-SYMBOL $S_INVD1BWP12T30P140;
// #XSTD_GPPBN @PLACE(47,-114) => @ORIENT("R0");
// #XSTD_GPPCN @SET-SYMBOL $S_INVD1BWP12T30P140;
// #XSTD_GPPCN @PLACE(76,-114) => @ORIENT("R0");
// #RGPP0 @SET-SYMBOL $RESISTOR;
// #RGPP0 @PLACE(110,-114) => @ORIENT("R90");
// #RGPP0 @TEXT("RGPP0",key="name",size=1.3,halign="start") => @PLACE(113,-111);
// #RGPP0 @TEXT("l=17.13u w=1u multi=(1)",key="value",size=0.9,halign="start") => @PLACE(113,-118);
// #RGPP0 @TEXT("",key="model");
// #RGPP0_2__dmy0 @SET-SYMBOL $RESISTOR;
// #RGPP0_2__dmy0 @PLACE(135,-114) => @ORIENT("R90");
// #RGPP0_2__dmy0 @TEXT("RGPP0_2__dmy0",key="name",size=1.3,halign="start") => @PLACE(138,-111);
// #RGPP0_2__dmy0 @TEXT("l=17.13u w=1u multi=(1)",key="value",size=0.9,halign="start") => @PLACE(138,-118);
// #RGPP0_2__dmy0 @TEXT("",key="model");
// #RGPP0_3__dmy0 @SET-SYMBOL $RESISTOR;
// #RGPP0_3__dmy0 @PLACE(160,-114) => @ORIENT("R90");
// #RGPP0_3__dmy0 @TEXT("RGPP0_3__dmy0",key="name",size=1.3,halign="start") => @PLACE(163,-111);
// #RGPP0_3__dmy0 @TEXT("l=17.13u w=1u multi=(1)",key="value",size=0.9,halign="start") => @PLACE(163,-118);
// #RGPP0_3__dmy0 @TEXT("",key="model");
// #RGPP0_4__dmy0 @SET-SYMBOL $RESISTOR;
// #RGPP0_4__dmy0 @PLACE(185,-114) => @ORIENT("R90");
// #RGPP0_4__dmy0 @TEXT("RGPP0_4__dmy0",key="name",size=1.3,halign="start") => @PLACE(188,-111);
// #RGPP0_4__dmy0 @TEXT("l=17.13u w=1u multi=(1)",key="value",size=0.9,halign="start") => @PLACE(188,-118);
// #RGPP0_4__dmy0 @TEXT("",key="model");
// #RGPP0_5__dmy0 @SET-SYMBOL $RESISTOR;
// #RGPP0_5__dmy0 @PLACE(210,-114) => @ORIENT("R90");
// #RGPP0_5__dmy0 @TEXT("RGPP0_5__dmy0",key="name",size=1.3,halign="start") => @PLACE(213,-111);
// #RGPP0_5__dmy0 @TEXT("l=17.13u w=1u multi=(1)",key="value",size=0.9,halign="start") => @PLACE(213,-118);
// #RGPP0_5__dmy0 @TEXT("",key="model");
// #RGPP1 @SET-SYMBOL $RESISTOR;
// #RGPP1 @PLACE(235,-114) => @ORIENT("R90");
// #RGPP1 @TEXT("RGPP1",key="name",size=1.3,halign="start") => @PLACE(238,-111);
// #RGPP1 @TEXT("l=17.13u w=1u multi=(1)",key="value",size=0.9,halign="start") => @PLACE(238,-118);
// #RGPP1 @TEXT("",key="model");
// #RGPP1_2__dmy0 @SET-SYMBOL $RESISTOR;
// #RGPP1_2__dmy0 @PLACE(260,-114) => @ORIENT("R90");
// #RGPP1_2__dmy0 @TEXT("RGPP1_2__dmy0",key="name",size=1.3,halign="start") => @PLACE(263,-111);
// #RGPP1_2__dmy0 @TEXT("l=17.13u w=1u multi=(1)",key="value",size=0.9,halign="start") => @PLACE(263,-118);
// #RGPP1_2__dmy0 @TEXT("",key="model");
// #RGPP1_3__dmy0 @SET-SYMBOL $RESISTOR;
// #RGPP1_3__dmy0 @PLACE(285,-114) => @ORIENT("R90");
// #RGPP1_3__dmy0 @TEXT("RGPP1_3__dmy0",key="name",size=1.3,halign="start") => @PLACE(288,-111);
// #RGPP1_3__dmy0 @TEXT("l=17.13u w=1u multi=(1)",key="value",size=0.9,halign="start") => @PLACE(288,-118);
// #RGPP1_3__dmy0 @TEXT("",key="model");
// #RGPP1_4__dmy0 @SET-SYMBOL $RESISTOR;
// #RGPP1_4__dmy0 @PLACE(310,-114) => @ORIENT("R90");
// #RGPP1_4__dmy0 @TEXT("RGPP1_4__dmy0",key="name",size=1.3,halign="start") => @PLACE(313,-111);
// #RGPP1_4__dmy0 @TEXT("l=17.13u w=1u multi=(1)",key="value",size=0.9,halign="start") => @PLACE(313,-118);
// #RGPP1_4__dmy0 @TEXT("",key="model");
// #RGPP1_5__dmy0 @SET-SYMBOL $RESISTOR;
// #RGPP1_5__dmy0 @PLACE(335,-114) => @ORIENT("R90");
// #RGPP1_5__dmy0 @TEXT("RGPP1_5__dmy0",key="name",size=1.3,halign="start") => @PLACE(338,-111);
// #RGPP1_5__dmy0 @TEXT("l=17.13u w=1u multi=(1)",key="value",size=0.9,halign="start") => @PLACE(338,-118);
// #RGPP1_5__dmy0 @TEXT("",key="model");
// (104,-99) @TEXT("GPP / 10 series poly sections",size=0.95,halign="start",textcolor="#223d52");
// &"GNNB" @WIRE(mode="straight",linecolor="#30485d",linewidth=0.16) {#XSTD_GNNCN:1 (61.5,0) (61.5,0) #XSTD_GNNBN:2};
// &"GNNDRV" @WIRE(mode="straight",linecolor="#30485d",linewidth=0.16) {#XSTD_GNNCN:2 (95.5,0) (95.5,0) #RGNN0:1};
// &"GNNA" @WIRE(mode="straight",linecolor="#30485d",linewidth=0.16) {#XSTD_GNNBN:1 (32.5,0) (32.5,0) #XSTD_GNNAN:2};
// &"GNNPRE" @WIRE(mode="straight",linecolor="#30485d",linewidth=0.16) {#XSTD_GNNAN:1 (0.5,0) (0.5,0) #X025:4};
// &"GNPB" @WIRE(mode="straight",linecolor="#30485d",linewidth=0.16) {#XSTD_GNPCN:1 (61.5,-38) (61.5,-38) #XSTD_GNPBN:2};
// &"GNPDRV" @WIRE(mode="straight",linecolor="#30485d",linewidth=0.16) {#XSTD_GNPCN:2 (95.5,-38) (95.5,-38) #RGNP0:1};
// &"GNPA" @WIRE(mode="straight",linecolor="#30485d",linewidth=0.16) {#XSTD_GNPBN:1 (32.5,-38) (32.5,-38) #XSTD_GNPAN:2};
// &"H" @WIRE(mode="straight",linecolor="#30485d",linewidth=0.16) {#XSTD_GNPAN:1 (-6.5,-38) (-6.5,-76) #X008:1};
// &"GPNB" @WIRE(mode="straight",linecolor="#30485d",linewidth=0.16) {#XSTD_GPNCN:1 (61.5,-76) (61.5,-76) #XSTD_GPNBN:2};
// &"GPNDRV" @WIRE(mode="straight",linecolor="#30485d",linewidth=0.16) {#XSTD_GPNCN:2 (95.5,-76) (95.5,-76) #RGPN0:1};
// &"GPNA" @WIRE(mode="straight",linecolor="#30485d",linewidth=0.16) {#XSTD_GPNBN:1 (32.5,-76) (32.5,-76) #XSTD_GPNAN:2};
// &"GPNPRE" @WIRE(mode="straight",linecolor="#30485d",linewidth=0.16) {#XSTD_GPNAN:1 (0.5,-76) (0.5,-76) #X008:4};
// &"GPPB" @WIRE(mode="straight",linecolor="#30485d",linewidth=0.16) {#XSTD_GPPCN:1 (61.5,-114) (61.5,-114) #XSTD_GPPBN:2};
// &"GPPDRV" @WIRE(mode="straight",linecolor="#30485d",linewidth=0.16) {#XSTD_GPPCN:2 (95.5,-114) (95.5,-114) #RGPP0:1};
// &"GPPA" @WIRE(mode="straight",linecolor="#30485d",linewidth=0.16) {#XSTD_GPPBN:1 (32.5,-114) (32.5,-114) #XSTD_GPPAN:2};
// &"GNNRG" @WIRE(mode="straight",linecolor="#30485d",linewidth=0.16) {#RGNN1:1 (222.5,0) (222.5,0) #RGNN0_5__dmy0:2};
// &"RGNN1_1__dmy0" @WIRE(mode="straight",linecolor="#30485d",linewidth=0.16) {#RGNN1:2 (247.5,0) (247.5,0) #RGNN1_2__dmy0:1};
// &"RGNN1_2__dmy0" @WIRE(mode="straight",linecolor="#30485d",linewidth=0.16) {#RGNN1_2__dmy0:2 (272.5,0) (272.5,0) #RGNN1_3__dmy0:1};
// &"RGNN1_3__dmy0" @WIRE(mode="straight",linecolor="#30485d",linewidth=0.16) {#RGNN1_3__dmy0:2 (297.5,0) (297.5,0) #RGNN1_4__dmy0:1};
// &"RGNN1_4__dmy0" @WIRE(mode="straight",linecolor="#30485d",linewidth=0.16) {#RGNN1_4__dmy0:2 (322.5,0) (322.5,0) #RGNN1_5__dmy0:1};
// &"RGNN0_1__dmy0" @WIRE(mode="straight",linecolor="#30485d",linewidth=0.16) {#RGNN0:2 (122.5,0) (122.5,0) #RGNN0_2__dmy0:1};
// &"RGNN0_2__dmy0" @WIRE(mode="straight",linecolor="#30485d",linewidth=0.16) {#RGNN0_2__dmy0:2 (147.5,0) (147.5,0) #RGNN0_3__dmy0:1};
// &"RGNN0_3__dmy0" @WIRE(mode="straight",linecolor="#30485d",linewidth=0.16) {#RGNN0_3__dmy0:2 (172.5,0) (172.5,0) #RGNN0_4__dmy0:1};
// &"RGNN0_4__dmy0" @WIRE(mode="straight",linecolor="#30485d",linewidth=0.16) {#RGNN0_4__dmy0:2 (197.5,0) (197.5,0) #RGNN0_5__dmy0:1};
// &"GNPRG" @WIRE(mode="straight",linecolor="#30485d",linewidth=0.16) {#RGNP1:1 (222.5,-38) (222.5,-38) #RGNP0_5__dmy0:2};
// &"RGNP1_1__dmy0" @WIRE(mode="straight",linecolor="#30485d",linewidth=0.16) {#RGNP1:2 (247.5,-38) (247.5,-38) #RGNP1_2__dmy0:1};
// &"RGNP1_2__dmy0" @WIRE(mode="straight",linecolor="#30485d",linewidth=0.16) {#RGNP1_2__dmy0:2 (272.5,-38) (272.5,-38) #RGNP1_3__dmy0:1};
// &"RGNP1_3__dmy0" @WIRE(mode="straight",linecolor="#30485d",linewidth=0.16) {#RGNP1_3__dmy0:2 (297.5,-38) (297.5,-38) #RGNP1_4__dmy0:1};
// &"RGNP1_4__dmy0" @WIRE(mode="straight",linecolor="#30485d",linewidth=0.16) {#RGNP1_4__dmy0:2 (322.5,-38) (322.5,-38) #RGNP1_5__dmy0:1};
// &"RGNP0_1__dmy0" @WIRE(mode="straight",linecolor="#30485d",linewidth=0.16) {#RGNP0:2 (122.5,-38) (122.5,-38) #RGNP0_2__dmy0:1};
// &"RGNP0_2__dmy0" @WIRE(mode="straight",linecolor="#30485d",linewidth=0.16) {#RGNP0_2__dmy0:2 (147.5,-38) (147.5,-38) #RGNP0_3__dmy0:1};
// &"RGNP0_3__dmy0" @WIRE(mode="straight",linecolor="#30485d",linewidth=0.16) {#RGNP0_3__dmy0:2 (172.5,-38) (172.5,-38) #RGNP0_4__dmy0:1};
// &"RGNP0_4__dmy0" @WIRE(mode="straight",linecolor="#30485d",linewidth=0.16) {#RGNP0_4__dmy0:2 (197.5,-38) (197.5,-38) #RGNP0_5__dmy0:1};
// &"GPNRG" @WIRE(mode="straight",linecolor="#30485d",linewidth=0.16) {#RGPN1:1 (222.5,-76) (222.5,-76) #RGPN0_5__dmy0:2};
// &"RGPN1_1__dmy0" @WIRE(mode="straight",linecolor="#30485d",linewidth=0.16) {#RGPN1:2 (247.5,-76) (247.5,-76) #RGPN1_2__dmy0:1};
// &"RGPN1_2__dmy0" @WIRE(mode="straight",linecolor="#30485d",linewidth=0.16) {#RGPN1_2__dmy0:2 (272.5,-76) (272.5,-76) #RGPN1_3__dmy0:1};
// &"RGPN1_3__dmy0" @WIRE(mode="straight",linecolor="#30485d",linewidth=0.16) {#RGPN1_3__dmy0:2 (297.5,-76) (297.5,-76) #RGPN1_4__dmy0:1};
// &"RGPN1_4__dmy0" @WIRE(mode="straight",linecolor="#30485d",linewidth=0.16) {#RGPN1_4__dmy0:2 (322.5,-76) (322.5,-76) #RGPN1_5__dmy0:1};
// &"RGPN0_1__dmy0" @WIRE(mode="straight",linecolor="#30485d",linewidth=0.16) {#RGPN0:2 (122.5,-76) (122.5,-76) #RGPN0_2__dmy0:1};
// &"RGPN0_2__dmy0" @WIRE(mode="straight",linecolor="#30485d",linewidth=0.16) {#RGPN0_2__dmy0:2 (147.5,-76) (147.5,-76) #RGPN0_3__dmy0:1};
// &"RGPN0_3__dmy0" @WIRE(mode="straight",linecolor="#30485d",linewidth=0.16) {#RGPN0_3__dmy0:2 (172.5,-76) (172.5,-76) #RGPN0_4__dmy0:1};
// &"RGPN0_4__dmy0" @WIRE(mode="straight",linecolor="#30485d",linewidth=0.16) {#RGPN0_4__dmy0:2 (197.5,-76) (197.5,-76) #RGPN0_5__dmy0:1};
// &"GPPRG" @WIRE(mode="straight",linecolor="#30485d",linewidth=0.16) {#RGPP1:1 (222.5,-114) (222.5,-114) #RGPP0_5__dmy0:2};
// &"RGPP1_1__dmy0" @WIRE(mode="straight",linecolor="#30485d",linewidth=0.16) {#RGPP1:2 (247.5,-114) (247.5,-114) #RGPP1_2__dmy0:1};
// &"RGPP1_2__dmy0" @WIRE(mode="straight",linecolor="#30485d",linewidth=0.16) {#RGPP1_2__dmy0:2 (272.5,-114) (272.5,-114) #RGPP1_3__dmy0:1};
// &"RGPP1_3__dmy0" @WIRE(mode="straight",linecolor="#30485d",linewidth=0.16) {#RGPP1_3__dmy0:2 (297.5,-114) (297.5,-114) #RGPP1_4__dmy0:1};
// &"RGPP1_4__dmy0" @WIRE(mode="straight",linecolor="#30485d",linewidth=0.16) {#RGPP1_4__dmy0:2 (322.5,-114) (322.5,-114) #RGPP1_5__dmy0:1};
// &"RGPP0_1__dmy0" @WIRE(mode="straight",linecolor="#30485d",linewidth=0.16) {#RGPP0:2 (122.5,-114) (122.5,-114) #RGPP0_2__dmy0:1};
// &"RGPP0_2__dmy0" @WIRE(mode="straight",linecolor="#30485d",linewidth=0.16) {#RGPP0_2__dmy0:2 (147.5,-114) (147.5,-114) #RGPP0_3__dmy0:1};
// &"RGPP0_3__dmy0" @WIRE(mode="straight",linecolor="#30485d",linewidth=0.16) {#RGPP0_3__dmy0:2 (172.5,-114) (172.5,-114) #RGPP0_4__dmy0:1};
// &"RGPP0_4__dmy0" @WIRE(mode="straight",linecolor="#30485d",linewidth=0.16) {#RGPP0_4__dmy0:2 (197.5,-114) (197.5,-114) #RGPP0_5__dmy0:1};
// (-28,-148) @TEXT("GP and GN chains keep their source polarity, device sizing and series R; no zero-delay abstraction.",size=1,halign="start",textcolor="#223d52");
// &"VDD" @WIRE(mode="straight",linecolor="#30485d",linewidth=0.16) {#XSTD_GNNCN:3 (76,10)};
// (76,10.4) @TEXT("VDD",size=1.1,halign="middle",valign="bottom");
// &"VSS" @WIRE(mode="straight",linecolor="#30485d",linewidth=0.16) {#XSTD_GNNCN:4 (76,-10)};
// (76,-10.4) @TEXT("VSS",size=1.1,halign="middle",valign="top");
// &"VDD" @WIRE(mode="straight",linecolor="#30485d",linewidth=0.16) {#XSTD_GNNBN:3 (47,10)};
// (47,10.4) @TEXT("VDD",size=1.1,halign="middle",valign="bottom");
// &"VSS" @WIRE(mode="straight",linecolor="#30485d",linewidth=0.16) {#XSTD_GNNBN:4 (47,-10)};
// (47,-10.4) @TEXT("VSS",size=1.1,halign="middle",valign="top");
// &"VDD" @WIRE(mode="straight",linecolor="#30485d",linewidth=0.16) {#XSTD_GNNAN:3 (18,10)};
// (18,10.4) @TEXT("VDD",size=1.1,halign="middle",valign="bottom");
// &"VSS" @WIRE(mode="straight",linecolor="#30485d",linewidth=0.16) {#XSTD_GNNAN:4 (18,-10)};
// (18,-10.4) @TEXT("VSS",size=1.1,halign="middle",valign="top");
// &"VDD" @WIRE(mode="straight",linecolor="#30485d",linewidth=0.16) {#XSTD_GNPCN:3 (76,-28)};
// (76,-27.6) @TEXT("VDD",size=1.1,halign="middle",valign="bottom");
// &"VSS" @WIRE(mode="straight",linecolor="#30485d",linewidth=0.16) {#XSTD_GNPCN:4 (76,-48)};
// (76,-48.4) @TEXT("VSS",size=1.1,halign="middle",valign="top");
// &"VDD" @WIRE(mode="straight",linecolor="#30485d",linewidth=0.16) {#XSTD_GNPBN:3 (47,-28)};
// (47,-27.6) @TEXT("VDD",size=1.1,halign="middle",valign="bottom");
// &"VSS" @WIRE(mode="straight",linecolor="#30485d",linewidth=0.16) {#XSTD_GNPBN:4 (47,-48)};
// (47,-48.4) @TEXT("VSS",size=1.1,halign="middle",valign="top");
// &"VDD" @WIRE(mode="straight",linecolor="#30485d",linewidth=0.16) {#XSTD_GNPAN:3 (18,-28)};
// (18,-27.6) @TEXT("VDD",size=1.1,halign="middle",valign="bottom");
// &"VSS" @WIRE(mode="straight",linecolor="#30485d",linewidth=0.16) {#XSTD_GNPAN:4 (18,-48)};
// (18,-48.4) @TEXT("VSS",size=1.1,halign="middle",valign="top");
// &"VDD" @WIRE(mode="straight",linecolor="#30485d",linewidth=0.16) {#XSTD_GPNCN:3 (76,-66)};
// (76,-65.6) @TEXT("VDD",size=1.1,halign="middle",valign="bottom");
// &"VSS" @WIRE(mode="straight",linecolor="#30485d",linewidth=0.16) {#XSTD_GPNCN:4 (76,-86)};
// (76,-86.4) @TEXT("VSS",size=1.1,halign="middle",valign="top");
// &"VDD" @WIRE(mode="straight",linecolor="#30485d",linewidth=0.16) {#XSTD_GPNBN:3 (47,-66)};
// (47,-65.6) @TEXT("VDD",size=1.1,halign="middle",valign="bottom");
// &"VSS" @WIRE(mode="straight",linecolor="#30485d",linewidth=0.16) {#XSTD_GPNBN:4 (47,-86)};
// (47,-86.4) @TEXT("VSS",size=1.1,halign="middle",valign="top");
// &"VDD" @WIRE(mode="straight",linecolor="#30485d",linewidth=0.16) {#XSTD_GPNAN:3 (18,-66)};
// (18,-65.6) @TEXT("VDD",size=1.1,halign="middle",valign="bottom");
// &"VSS" @WIRE(mode="straight",linecolor="#30485d",linewidth=0.16) {#XSTD_GPNAN:4 (18,-86)};
// (18,-86.4) @TEXT("VSS",size=1.1,halign="middle",valign="top");
// &"VDD" @WIRE(mode="straight",linecolor="#30485d",linewidth=0.16) {#XSTD_GPPCN:3 (76,-104)};
// (76,-103.6) @TEXT("VDD",size=1.1,halign="middle",valign="bottom");
// &"VSS" @WIRE(mode="straight",linecolor="#30485d",linewidth=0.16) {#XSTD_GPPCN:4 (76,-124)};
// (76,-124.4) @TEXT("VSS",size=1.1,halign="middle",valign="top");
// &"VDD" @WIRE(mode="straight",linecolor="#30485d",linewidth=0.16) {#XSTD_GPPBN:3 (47,-104)};
// (47,-103.6) @TEXT("VDD",size=1.1,halign="middle",valign="bottom");
// &"VSS" @WIRE(mode="straight",linecolor="#30485d",linewidth=0.16) {#XSTD_GPPBN:4 (47,-124)};
// (47,-124.4) @TEXT("VSS",size=1.1,halign="middle",valign="top");
// &"L" @WIRE(mode="straight",linecolor="#30485d",linewidth=0.16) {#XSTD_GPPAN:1 (8,-114)};
// (7.6,-114) @TEXT("L",size=1.1,halign="end",valign="middle");
// &"VDD" @WIRE(mode="straight",linecolor="#30485d",linewidth=0.16) {#XSTD_GPPAN:3 (18,-104)};
// (18,-103.6) @TEXT("VDD",size=1.1,halign="middle",valign="bottom");
// &"VSS" @WIRE(mode="straight",linecolor="#30485d",linewidth=0.16) {#XSTD_GPPAN:4 (18,-124)};
// (18,-124.4) @TEXT("VSS",size=1.1,halign="middle",valign="top");
// &"GNN" @WIRE(mode="straight",linecolor="#30485d",linewidth=0.16) {#RGNN1_5__dmy0:2 (340,0)};
// (340.4,0) @TEXT("GNN",size=1.1,halign="start",valign="middle");
// &"GNP" @WIRE(mode="straight",linecolor="#30485d",linewidth=0.16) {#RGNP1_5__dmy0:2 (340,-38)};
// (340.4,-38) @TEXT("GNP",size=1.1,halign="start",valign="middle");
// &"GPN" @WIRE(mode="straight",linecolor="#30485d",linewidth=0.16) {#RGPN1_5__dmy0:2 (340,-76)};
// (340.4,-76) @TEXT("GPN",size=1.1,halign="start",valign="middle");
// &"GPP" @WIRE(mode="straight",linecolor="#30485d",linewidth=0.16) {#RGPP1_5__dmy0:2 (340,-114)};
// (340.4,-114) @TEXT("GPP",size=1.1,halign="start",valign="middle");
// &"L" @WIRE(mode="straight",linecolor="#30485d",linewidth=0.16) {#X025:1 (-27,0)};
// (-27.4,0) @TEXT("L",size=1.1,halign="end",valign="middle");
// &"VDD" @WIRE(mode="straight",linecolor="#30485d",linewidth=0.16) {#X025:2 (-17,10)};
// (-17,10.4) @TEXT("VDD",size=1.1,halign="middle",valign="bottom");
// &"VSS" @WIRE(mode="straight",linecolor="#30485d",linewidth=0.16) {#X025:3 (-17,-10)};
// (-17,-10.4) @TEXT("VSS",size=1.1,halign="middle",valign="top");
// &"VDD" @WIRE(mode="straight",linecolor="#30485d",linewidth=0.16) {#X008:2 (-17,-66)};
// (-17,-65.6) @TEXT("VDD",size=1.1,halign="middle",valign="bottom");
// &"VSS" @WIRE(mode="straight",linecolor="#30485d",linewidth=0.16) {#X008:3 (-17,-86)};
// (-17,-86.4) @TEXT("VSS",size=1.1,halign="middle",valign="top");
// }
// END SARADC RNL
ends sar8p_refdrv_b3

subckt sar8p_refdrv_b4 GNN GNP GPN GPP H L VDD VSS
    XSTD_GNNCN (GNNB GNNDRV VDD VSS) INVD1BWP12T30P140
    XSTD_GNNBN (GNNA GNNB VDD VSS) INVD1BWP12T30P140
    XSTD_GNNAN (GNNPRE GNNA VDD VSS) INVD1BWP12T30P140
    XSTD_GNPCN (GNPB GNPDRV VDD VSS) INVD1BWP12T30P140
    XSTD_GNPBN (GNPA GNPB VDD VSS) INVD1BWP12T30P140
    XSTD_GNPAN (H GNPA VDD VSS) INVD1BWP12T30P140
    XSTD_GPNCN (GPNB GPNDRV VDD VSS) INVD1BWP12T30P140
    XSTD_GPNBN (GPNA GPNB VDD VSS) INVD1BWP12T30P140
    XSTD_GPNAN (GPNPRE GPNA VDD VSS) INVD1BWP12T30P140
    XSTD_GPPCN (GPPB GPPDRV VDD VSS) INVD1BWP12T30P140
    XSTD_GPPBN (GPPA GPPB VDD VSS) INVD1BWP12T30P140
    XSTD_GPPAN (L GPPA VDD VSS) INVD1BWP12T30P140
//Series configuration of RGNN1
RGNN1  (GNNRG RGNN1_1__dmy0 ) rupolym l=17.13u w=1u m=16 multi=(1)
RGNN1_2__dmy0  (RGNN1_1__dmy0 RGNN1_2__dmy0 ) rupolym l=17.13u w=1u m=16 \
        multi=(1)
RGNN1_3__dmy0  (RGNN1_2__dmy0 RGNN1_3__dmy0 ) rupolym l=17.13u w=1u m=16 \
        multi=(1)
RGNN1_4__dmy0  (RGNN1_3__dmy0 RGNN1_4__dmy0 ) rupolym l=17.13u w=1u m=16 \
        multi=(1)
RGNN1_5__dmy0  (RGNN1_4__dmy0 GNN ) rupolym l=17.13u w=1u m=16 multi=(1)
//End of RGNN1

//Series configuration of RGNN0
RGNN0  (GNNDRV RGNN0_1__dmy0 ) rupolym l=17.13u w=1u m=16 multi=(1)
RGNN0_2__dmy0  (RGNN0_1__dmy0 RGNN0_2__dmy0 ) rupolym l=17.13u w=1u m=16 \
        multi=(1)
RGNN0_3__dmy0  (RGNN0_2__dmy0 RGNN0_3__dmy0 ) rupolym l=17.13u w=1u m=16 \
        multi=(1)
RGNN0_4__dmy0  (RGNN0_3__dmy0 RGNN0_4__dmy0 ) rupolym l=17.13u w=1u m=16 \
        multi=(1)
RGNN0_5__dmy0  (RGNN0_4__dmy0 GNNRG ) rupolym l=17.13u w=1u m=16 multi=(1)
//End of RGNN0

//Series configuration of RGNP1
RGNP1  (GNPRG RGNP1_1__dmy0 ) rupolym l=17.13u w=1u m=16 multi=(1)
RGNP1_2__dmy0  (RGNP1_1__dmy0 RGNP1_2__dmy0 ) rupolym l=17.13u w=1u m=16 \
        multi=(1)
RGNP1_3__dmy0  (RGNP1_2__dmy0 RGNP1_3__dmy0 ) rupolym l=17.13u w=1u m=16 \
        multi=(1)
RGNP1_4__dmy0  (RGNP1_3__dmy0 RGNP1_4__dmy0 ) rupolym l=17.13u w=1u m=16 \
        multi=(1)
RGNP1_5__dmy0  (RGNP1_4__dmy0 GNP ) rupolym l=17.13u w=1u m=16 multi=(1)
//End of RGNP1

//Series configuration of RGNP0
RGNP0  (GNPDRV RGNP0_1__dmy0 ) rupolym l=17.13u w=1u m=16 multi=(1)
RGNP0_2__dmy0  (RGNP0_1__dmy0 RGNP0_2__dmy0 ) rupolym l=17.13u w=1u m=16 \
        multi=(1)
RGNP0_3__dmy0  (RGNP0_2__dmy0 RGNP0_3__dmy0 ) rupolym l=17.13u w=1u m=16 \
        multi=(1)
RGNP0_4__dmy0  (RGNP0_3__dmy0 RGNP0_4__dmy0 ) rupolym l=17.13u w=1u m=16 \
        multi=(1)
RGNP0_5__dmy0  (RGNP0_4__dmy0 GNPRG ) rupolym l=17.13u w=1u m=16 multi=(1)
//End of RGNP0

//Series configuration of RGPN1
RGPN1  (GPNRG RGPN1_1__dmy0 ) rupolym l=17.13u w=1u m=16 multi=(1)
RGPN1_2__dmy0  (RGPN1_1__dmy0 RGPN1_2__dmy0 ) rupolym l=17.13u w=1u m=16 \
        multi=(1)
RGPN1_3__dmy0  (RGPN1_2__dmy0 RGPN1_3__dmy0 ) rupolym l=17.13u w=1u m=16 \
        multi=(1)
RGPN1_4__dmy0  (RGPN1_3__dmy0 RGPN1_4__dmy0 ) rupolym l=17.13u w=1u m=16 \
        multi=(1)
RGPN1_5__dmy0  (RGPN1_4__dmy0 GPN ) rupolym l=17.13u w=1u m=16 multi=(1)
//End of RGPN1

//Series configuration of RGPN0
RGPN0  (GPNDRV RGPN0_1__dmy0 ) rupolym l=17.13u w=1u m=16 multi=(1)
RGPN0_2__dmy0  (RGPN0_1__dmy0 RGPN0_2__dmy0 ) rupolym l=17.13u w=1u m=16 \
        multi=(1)
RGPN0_3__dmy0  (RGPN0_2__dmy0 RGPN0_3__dmy0 ) rupolym l=17.13u w=1u m=16 \
        multi=(1)
RGPN0_4__dmy0  (RGPN0_3__dmy0 RGPN0_4__dmy0 ) rupolym l=17.13u w=1u m=16 \
        multi=(1)
RGPN0_5__dmy0  (RGPN0_4__dmy0 GPNRG ) rupolym l=17.13u w=1u m=16 multi=(1)
//End of RGPN0

//Series configuration of RGPP1
RGPP1  (GPPRG RGPP1_1__dmy0 ) rupolym l=17.13u w=1u m=16 multi=(1)
RGPP1_2__dmy0  (RGPP1_1__dmy0 RGPP1_2__dmy0 ) rupolym l=17.13u w=1u m=16 \
        multi=(1)
RGPP1_3__dmy0  (RGPP1_2__dmy0 RGPP1_3__dmy0 ) rupolym l=17.13u w=1u m=16 \
        multi=(1)
RGPP1_4__dmy0  (RGPP1_3__dmy0 RGPP1_4__dmy0 ) rupolym l=17.13u w=1u m=16 \
        multi=(1)
RGPP1_5__dmy0  (RGPP1_4__dmy0 GPP ) rupolym l=17.13u w=1u m=16 multi=(1)
//End of RGPP1

//Series configuration of RGPP0
RGPP0  (GPPDRV RGPP0_1__dmy0 ) rupolym l=17.13u w=1u m=16 multi=(1)
RGPP0_2__dmy0  (RGPP0_1__dmy0 RGPP0_2__dmy0 ) rupolym l=17.13u w=1u m=16 \
        multi=(1)
RGPP0_3__dmy0  (RGPP0_2__dmy0 RGPP0_3__dmy0 ) rupolym l=17.13u w=1u m=16 \
        multi=(1)
RGPP0_4__dmy0  (RGPP0_3__dmy0 RGPP0_4__dmy0 ) rupolym l=17.13u w=1u m=16 \
        multi=(1)
RGPP0_5__dmy0  (RGPP0_4__dmy0 GPPRG ) rupolym l=17.13u w=1u m=16 multi=(1)
//End of RGPP0

    X025 (L VDD VSS GNNPRE) sar8p_inv
    X008 (H VDD VSS GPNPRE) sar8p_inv
// BEGIN SARADC RNL
// @RNL(author="saradc topology") {
// (-28,27) @TEXT("sar8p_refdrv_b4 / four physical gate-driver chains",size=1.5,halign="start",textcolor="#223d52");
// #X025 @SET-SYMBOL $S_sar8p_inv;
// #X025 @PLACE(-17,0) => @ORIENT("R0");
// #XSTD_GNNAN @SET-SYMBOL $S_INVD1BWP12T30P140;
// #XSTD_GNNAN @PLACE(18,0) => @ORIENT("R0");
// #XSTD_GNNBN @SET-SYMBOL $S_INVD1BWP12T30P140;
// #XSTD_GNNBN @PLACE(47,0) => @ORIENT("R0");
// #XSTD_GNNCN @SET-SYMBOL $S_INVD1BWP12T30P140;
// #XSTD_GNNCN @PLACE(76,0) => @ORIENT("R0");
// #RGNN0 @SET-SYMBOL $RESISTOR;
// #RGNN0 @PLACE(110,0) => @ORIENT("R90");
// #RGNN0 @TEXT("RGNN0",key="name",size=1.3,halign="start") => @PLACE(113,3);
// #RGNN0 @TEXT("l=17.13u w=1u multi=(1)",key="value",size=0.9,halign="start") => @PLACE(113,-4);
// #RGNN0 @TEXT("",key="model");
// #RGNN0_2__dmy0 @SET-SYMBOL $RESISTOR;
// #RGNN0_2__dmy0 @PLACE(135,0) => @ORIENT("R90");
// #RGNN0_2__dmy0 @TEXT("RGNN0_2__dmy0",key="name",size=1.3,halign="start") => @PLACE(138,3);
// #RGNN0_2__dmy0 @TEXT("l=17.13u w=1u multi=(1)",key="value",size=0.9,halign="start") => @PLACE(138,-4);
// #RGNN0_2__dmy0 @TEXT("",key="model");
// #RGNN0_3__dmy0 @SET-SYMBOL $RESISTOR;
// #RGNN0_3__dmy0 @PLACE(160,0) => @ORIENT("R90");
// #RGNN0_3__dmy0 @TEXT("RGNN0_3__dmy0",key="name",size=1.3,halign="start") => @PLACE(163,3);
// #RGNN0_3__dmy0 @TEXT("l=17.13u w=1u multi=(1)",key="value",size=0.9,halign="start") => @PLACE(163,-4);
// #RGNN0_3__dmy0 @TEXT("",key="model");
// #RGNN0_4__dmy0 @SET-SYMBOL $RESISTOR;
// #RGNN0_4__dmy0 @PLACE(185,0) => @ORIENT("R90");
// #RGNN0_4__dmy0 @TEXT("RGNN0_4__dmy0",key="name",size=1.3,halign="start") => @PLACE(188,3);
// #RGNN0_4__dmy0 @TEXT("l=17.13u w=1u multi=(1)",key="value",size=0.9,halign="start") => @PLACE(188,-4);
// #RGNN0_4__dmy0 @TEXT("",key="model");
// #RGNN0_5__dmy0 @SET-SYMBOL $RESISTOR;
// #RGNN0_5__dmy0 @PLACE(210,0) => @ORIENT("R90");
// #RGNN0_5__dmy0 @TEXT("RGNN0_5__dmy0",key="name",size=1.3,halign="start") => @PLACE(213,3);
// #RGNN0_5__dmy0 @TEXT("l=17.13u w=1u multi=(1)",key="value",size=0.9,halign="start") => @PLACE(213,-4);
// #RGNN0_5__dmy0 @TEXT("",key="model");
// #RGNN1 @SET-SYMBOL $RESISTOR;
// #RGNN1 @PLACE(235,0) => @ORIENT("R90");
// #RGNN1 @TEXT("RGNN1",key="name",size=1.3,halign="start") => @PLACE(238,3);
// #RGNN1 @TEXT("l=17.13u w=1u multi=(1)",key="value",size=0.9,halign="start") => @PLACE(238,-4);
// #RGNN1 @TEXT("",key="model");
// #RGNN1_2__dmy0 @SET-SYMBOL $RESISTOR;
// #RGNN1_2__dmy0 @PLACE(260,0) => @ORIENT("R90");
// #RGNN1_2__dmy0 @TEXT("RGNN1_2__dmy0",key="name",size=1.3,halign="start") => @PLACE(263,3);
// #RGNN1_2__dmy0 @TEXT("l=17.13u w=1u multi=(1)",key="value",size=0.9,halign="start") => @PLACE(263,-4);
// #RGNN1_2__dmy0 @TEXT("",key="model");
// #RGNN1_3__dmy0 @SET-SYMBOL $RESISTOR;
// #RGNN1_3__dmy0 @PLACE(285,0) => @ORIENT("R90");
// #RGNN1_3__dmy0 @TEXT("RGNN1_3__dmy0",key="name",size=1.3,halign="start") => @PLACE(288,3);
// #RGNN1_3__dmy0 @TEXT("l=17.13u w=1u multi=(1)",key="value",size=0.9,halign="start") => @PLACE(288,-4);
// #RGNN1_3__dmy0 @TEXT("",key="model");
// #RGNN1_4__dmy0 @SET-SYMBOL $RESISTOR;
// #RGNN1_4__dmy0 @PLACE(310,0) => @ORIENT("R90");
// #RGNN1_4__dmy0 @TEXT("RGNN1_4__dmy0",key="name",size=1.3,halign="start") => @PLACE(313,3);
// #RGNN1_4__dmy0 @TEXT("l=17.13u w=1u multi=(1)",key="value",size=0.9,halign="start") => @PLACE(313,-4);
// #RGNN1_4__dmy0 @TEXT("",key="model");
// #RGNN1_5__dmy0 @SET-SYMBOL $RESISTOR;
// #RGNN1_5__dmy0 @PLACE(335,0) => @ORIENT("R90");
// #RGNN1_5__dmy0 @TEXT("RGNN1_5__dmy0",key="name",size=1.3,halign="start") => @PLACE(338,3);
// #RGNN1_5__dmy0 @TEXT("l=17.13u w=1u multi=(1)",key="value",size=0.9,halign="start") => @PLACE(338,-4);
// #RGNN1_5__dmy0 @TEXT("",key="model");
// (104,15) @TEXT("GNN / 10 series poly sections",size=0.95,halign="start",textcolor="#223d52");
// #XSTD_GNPAN @SET-SYMBOL $S_INVD1BWP12T30P140;
// #XSTD_GNPAN @PLACE(18,-38) => @ORIENT("R0");
// #XSTD_GNPBN @SET-SYMBOL $S_INVD1BWP12T30P140;
// #XSTD_GNPBN @PLACE(47,-38) => @ORIENT("R0");
// #XSTD_GNPCN @SET-SYMBOL $S_INVD1BWP12T30P140;
// #XSTD_GNPCN @PLACE(76,-38) => @ORIENT("R0");
// #RGNP0 @SET-SYMBOL $RESISTOR;
// #RGNP0 @PLACE(110,-38) => @ORIENT("R90");
// #RGNP0 @TEXT("RGNP0",key="name",size=1.3,halign="start") => @PLACE(113,-35);
// #RGNP0 @TEXT("l=17.13u w=1u multi=(1)",key="value",size=0.9,halign="start") => @PLACE(113,-42);
// #RGNP0 @TEXT("",key="model");
// #RGNP0_2__dmy0 @SET-SYMBOL $RESISTOR;
// #RGNP0_2__dmy0 @PLACE(135,-38) => @ORIENT("R90");
// #RGNP0_2__dmy0 @TEXT("RGNP0_2__dmy0",key="name",size=1.3,halign="start") => @PLACE(138,-35);
// #RGNP0_2__dmy0 @TEXT("l=17.13u w=1u multi=(1)",key="value",size=0.9,halign="start") => @PLACE(138,-42);
// #RGNP0_2__dmy0 @TEXT("",key="model");
// #RGNP0_3__dmy0 @SET-SYMBOL $RESISTOR;
// #RGNP0_3__dmy0 @PLACE(160,-38) => @ORIENT("R90");
// #RGNP0_3__dmy0 @TEXT("RGNP0_3__dmy0",key="name",size=1.3,halign="start") => @PLACE(163,-35);
// #RGNP0_3__dmy0 @TEXT("l=17.13u w=1u multi=(1)",key="value",size=0.9,halign="start") => @PLACE(163,-42);
// #RGNP0_3__dmy0 @TEXT("",key="model");
// #RGNP0_4__dmy0 @SET-SYMBOL $RESISTOR;
// #RGNP0_4__dmy0 @PLACE(185,-38) => @ORIENT("R90");
// #RGNP0_4__dmy0 @TEXT("RGNP0_4__dmy0",key="name",size=1.3,halign="start") => @PLACE(188,-35);
// #RGNP0_4__dmy0 @TEXT("l=17.13u w=1u multi=(1)",key="value",size=0.9,halign="start") => @PLACE(188,-42);
// #RGNP0_4__dmy0 @TEXT("",key="model");
// #RGNP0_5__dmy0 @SET-SYMBOL $RESISTOR;
// #RGNP0_5__dmy0 @PLACE(210,-38) => @ORIENT("R90");
// #RGNP0_5__dmy0 @TEXT("RGNP0_5__dmy0",key="name",size=1.3,halign="start") => @PLACE(213,-35);
// #RGNP0_5__dmy0 @TEXT("l=17.13u w=1u multi=(1)",key="value",size=0.9,halign="start") => @PLACE(213,-42);
// #RGNP0_5__dmy0 @TEXT("",key="model");
// #RGNP1 @SET-SYMBOL $RESISTOR;
// #RGNP1 @PLACE(235,-38) => @ORIENT("R90");
// #RGNP1 @TEXT("RGNP1",key="name",size=1.3,halign="start") => @PLACE(238,-35);
// #RGNP1 @TEXT("l=17.13u w=1u multi=(1)",key="value",size=0.9,halign="start") => @PLACE(238,-42);
// #RGNP1 @TEXT("",key="model");
// #RGNP1_2__dmy0 @SET-SYMBOL $RESISTOR;
// #RGNP1_2__dmy0 @PLACE(260,-38) => @ORIENT("R90");
// #RGNP1_2__dmy0 @TEXT("RGNP1_2__dmy0",key="name",size=1.3,halign="start") => @PLACE(263,-35);
// #RGNP1_2__dmy0 @TEXT("l=17.13u w=1u multi=(1)",key="value",size=0.9,halign="start") => @PLACE(263,-42);
// #RGNP1_2__dmy0 @TEXT("",key="model");
// #RGNP1_3__dmy0 @SET-SYMBOL $RESISTOR;
// #RGNP1_3__dmy0 @PLACE(285,-38) => @ORIENT("R90");
// #RGNP1_3__dmy0 @TEXT("RGNP1_3__dmy0",key="name",size=1.3,halign="start") => @PLACE(288,-35);
// #RGNP1_3__dmy0 @TEXT("l=17.13u w=1u multi=(1)",key="value",size=0.9,halign="start") => @PLACE(288,-42);
// #RGNP1_3__dmy0 @TEXT("",key="model");
// #RGNP1_4__dmy0 @SET-SYMBOL $RESISTOR;
// #RGNP1_4__dmy0 @PLACE(310,-38) => @ORIENT("R90");
// #RGNP1_4__dmy0 @TEXT("RGNP1_4__dmy0",key="name",size=1.3,halign="start") => @PLACE(313,-35);
// #RGNP1_4__dmy0 @TEXT("l=17.13u w=1u multi=(1)",key="value",size=0.9,halign="start") => @PLACE(313,-42);
// #RGNP1_4__dmy0 @TEXT("",key="model");
// #RGNP1_5__dmy0 @SET-SYMBOL $RESISTOR;
// #RGNP1_5__dmy0 @PLACE(335,-38) => @ORIENT("R90");
// #RGNP1_5__dmy0 @TEXT("RGNP1_5__dmy0",key="name",size=1.3,halign="start") => @PLACE(338,-35);
// #RGNP1_5__dmy0 @TEXT("l=17.13u w=1u multi=(1)",key="value",size=0.9,halign="start") => @PLACE(338,-42);
// #RGNP1_5__dmy0 @TEXT("",key="model");
// (104,-23) @TEXT("GNP / 10 series poly sections",size=0.95,halign="start",textcolor="#223d52");
// #X008 @SET-SYMBOL $S_sar8p_inv;
// #X008 @PLACE(-17,-76) => @ORIENT("R0");
// #XSTD_GPNAN @SET-SYMBOL $S_INVD1BWP12T30P140;
// #XSTD_GPNAN @PLACE(18,-76) => @ORIENT("R0");
// #XSTD_GPNBN @SET-SYMBOL $S_INVD1BWP12T30P140;
// #XSTD_GPNBN @PLACE(47,-76) => @ORIENT("R0");
// #XSTD_GPNCN @SET-SYMBOL $S_INVD1BWP12T30P140;
// #XSTD_GPNCN @PLACE(76,-76) => @ORIENT("R0");
// #RGPN0 @SET-SYMBOL $RESISTOR;
// #RGPN0 @PLACE(110,-76) => @ORIENT("R90");
// #RGPN0 @TEXT("RGPN0",key="name",size=1.3,halign="start") => @PLACE(113,-73);
// #RGPN0 @TEXT("l=17.13u w=1u multi=(1)",key="value",size=0.9,halign="start") => @PLACE(113,-80);
// #RGPN0 @TEXT("",key="model");
// #RGPN0_2__dmy0 @SET-SYMBOL $RESISTOR;
// #RGPN0_2__dmy0 @PLACE(135,-76) => @ORIENT("R90");
// #RGPN0_2__dmy0 @TEXT("RGPN0_2__dmy0",key="name",size=1.3,halign="start") => @PLACE(138,-73);
// #RGPN0_2__dmy0 @TEXT("l=17.13u w=1u multi=(1)",key="value",size=0.9,halign="start") => @PLACE(138,-80);
// #RGPN0_2__dmy0 @TEXT("",key="model");
// #RGPN0_3__dmy0 @SET-SYMBOL $RESISTOR;
// #RGPN0_3__dmy0 @PLACE(160,-76) => @ORIENT("R90");
// #RGPN0_3__dmy0 @TEXT("RGPN0_3__dmy0",key="name",size=1.3,halign="start") => @PLACE(163,-73);
// #RGPN0_3__dmy0 @TEXT("l=17.13u w=1u multi=(1)",key="value",size=0.9,halign="start") => @PLACE(163,-80);
// #RGPN0_3__dmy0 @TEXT("",key="model");
// #RGPN0_4__dmy0 @SET-SYMBOL $RESISTOR;
// #RGPN0_4__dmy0 @PLACE(185,-76) => @ORIENT("R90");
// #RGPN0_4__dmy0 @TEXT("RGPN0_4__dmy0",key="name",size=1.3,halign="start") => @PLACE(188,-73);
// #RGPN0_4__dmy0 @TEXT("l=17.13u w=1u multi=(1)",key="value",size=0.9,halign="start") => @PLACE(188,-80);
// #RGPN0_4__dmy0 @TEXT("",key="model");
// #RGPN0_5__dmy0 @SET-SYMBOL $RESISTOR;
// #RGPN0_5__dmy0 @PLACE(210,-76) => @ORIENT("R90");
// #RGPN0_5__dmy0 @TEXT("RGPN0_5__dmy0",key="name",size=1.3,halign="start") => @PLACE(213,-73);
// #RGPN0_5__dmy0 @TEXT("l=17.13u w=1u multi=(1)",key="value",size=0.9,halign="start") => @PLACE(213,-80);
// #RGPN0_5__dmy0 @TEXT("",key="model");
// #RGPN1 @SET-SYMBOL $RESISTOR;
// #RGPN1 @PLACE(235,-76) => @ORIENT("R90");
// #RGPN1 @TEXT("RGPN1",key="name",size=1.3,halign="start") => @PLACE(238,-73);
// #RGPN1 @TEXT("l=17.13u w=1u multi=(1)",key="value",size=0.9,halign="start") => @PLACE(238,-80);
// #RGPN1 @TEXT("",key="model");
// #RGPN1_2__dmy0 @SET-SYMBOL $RESISTOR;
// #RGPN1_2__dmy0 @PLACE(260,-76) => @ORIENT("R90");
// #RGPN1_2__dmy0 @TEXT("RGPN1_2__dmy0",key="name",size=1.3,halign="start") => @PLACE(263,-73);
// #RGPN1_2__dmy0 @TEXT("l=17.13u w=1u multi=(1)",key="value",size=0.9,halign="start") => @PLACE(263,-80);
// #RGPN1_2__dmy0 @TEXT("",key="model");
// #RGPN1_3__dmy0 @SET-SYMBOL $RESISTOR;
// #RGPN1_3__dmy0 @PLACE(285,-76) => @ORIENT("R90");
// #RGPN1_3__dmy0 @TEXT("RGPN1_3__dmy0",key="name",size=1.3,halign="start") => @PLACE(288,-73);
// #RGPN1_3__dmy0 @TEXT("l=17.13u w=1u multi=(1)",key="value",size=0.9,halign="start") => @PLACE(288,-80);
// #RGPN1_3__dmy0 @TEXT("",key="model");
// #RGPN1_4__dmy0 @SET-SYMBOL $RESISTOR;
// #RGPN1_4__dmy0 @PLACE(310,-76) => @ORIENT("R90");
// #RGPN1_4__dmy0 @TEXT("RGPN1_4__dmy0",key="name",size=1.3,halign="start") => @PLACE(313,-73);
// #RGPN1_4__dmy0 @TEXT("l=17.13u w=1u multi=(1)",key="value",size=0.9,halign="start") => @PLACE(313,-80);
// #RGPN1_4__dmy0 @TEXT("",key="model");
// #RGPN1_5__dmy0 @SET-SYMBOL $RESISTOR;
// #RGPN1_5__dmy0 @PLACE(335,-76) => @ORIENT("R90");
// #RGPN1_5__dmy0 @TEXT("RGPN1_5__dmy0",key="name",size=1.3,halign="start") => @PLACE(338,-73);
// #RGPN1_5__dmy0 @TEXT("l=17.13u w=1u multi=(1)",key="value",size=0.9,halign="start") => @PLACE(338,-80);
// #RGPN1_5__dmy0 @TEXT("",key="model");
// (104,-61) @TEXT("GPN / 10 series poly sections",size=0.95,halign="start",textcolor="#223d52");
// #XSTD_GPPAN @SET-SYMBOL $S_INVD1BWP12T30P140;
// #XSTD_GPPAN @PLACE(18,-114) => @ORIENT("R0");
// #XSTD_GPPBN @SET-SYMBOL $S_INVD1BWP12T30P140;
// #XSTD_GPPBN @PLACE(47,-114) => @ORIENT("R0");
// #XSTD_GPPCN @SET-SYMBOL $S_INVD1BWP12T30P140;
// #XSTD_GPPCN @PLACE(76,-114) => @ORIENT("R0");
// #RGPP0 @SET-SYMBOL $RESISTOR;
// #RGPP0 @PLACE(110,-114) => @ORIENT("R90");
// #RGPP0 @TEXT("RGPP0",key="name",size=1.3,halign="start") => @PLACE(113,-111);
// #RGPP0 @TEXT("l=17.13u w=1u multi=(1)",key="value",size=0.9,halign="start") => @PLACE(113,-118);
// #RGPP0 @TEXT("",key="model");
// #RGPP0_2__dmy0 @SET-SYMBOL $RESISTOR;
// #RGPP0_2__dmy0 @PLACE(135,-114) => @ORIENT("R90");
// #RGPP0_2__dmy0 @TEXT("RGPP0_2__dmy0",key="name",size=1.3,halign="start") => @PLACE(138,-111);
// #RGPP0_2__dmy0 @TEXT("l=17.13u w=1u multi=(1)",key="value",size=0.9,halign="start") => @PLACE(138,-118);
// #RGPP0_2__dmy0 @TEXT("",key="model");
// #RGPP0_3__dmy0 @SET-SYMBOL $RESISTOR;
// #RGPP0_3__dmy0 @PLACE(160,-114) => @ORIENT("R90");
// #RGPP0_3__dmy0 @TEXT("RGPP0_3__dmy0",key="name",size=1.3,halign="start") => @PLACE(163,-111);
// #RGPP0_3__dmy0 @TEXT("l=17.13u w=1u multi=(1)",key="value",size=0.9,halign="start") => @PLACE(163,-118);
// #RGPP0_3__dmy0 @TEXT("",key="model");
// #RGPP0_4__dmy0 @SET-SYMBOL $RESISTOR;
// #RGPP0_4__dmy0 @PLACE(185,-114) => @ORIENT("R90");
// #RGPP0_4__dmy0 @TEXT("RGPP0_4__dmy0",key="name",size=1.3,halign="start") => @PLACE(188,-111);
// #RGPP0_4__dmy0 @TEXT("l=17.13u w=1u multi=(1)",key="value",size=0.9,halign="start") => @PLACE(188,-118);
// #RGPP0_4__dmy0 @TEXT("",key="model");
// #RGPP0_5__dmy0 @SET-SYMBOL $RESISTOR;
// #RGPP0_5__dmy0 @PLACE(210,-114) => @ORIENT("R90");
// #RGPP0_5__dmy0 @TEXT("RGPP0_5__dmy0",key="name",size=1.3,halign="start") => @PLACE(213,-111);
// #RGPP0_5__dmy0 @TEXT("l=17.13u w=1u multi=(1)",key="value",size=0.9,halign="start") => @PLACE(213,-118);
// #RGPP0_5__dmy0 @TEXT("",key="model");
// #RGPP1 @SET-SYMBOL $RESISTOR;
// #RGPP1 @PLACE(235,-114) => @ORIENT("R90");
// #RGPP1 @TEXT("RGPP1",key="name",size=1.3,halign="start") => @PLACE(238,-111);
// #RGPP1 @TEXT("l=17.13u w=1u multi=(1)",key="value",size=0.9,halign="start") => @PLACE(238,-118);
// #RGPP1 @TEXT("",key="model");
// #RGPP1_2__dmy0 @SET-SYMBOL $RESISTOR;
// #RGPP1_2__dmy0 @PLACE(260,-114) => @ORIENT("R90");
// #RGPP1_2__dmy0 @TEXT("RGPP1_2__dmy0",key="name",size=1.3,halign="start") => @PLACE(263,-111);
// #RGPP1_2__dmy0 @TEXT("l=17.13u w=1u multi=(1)",key="value",size=0.9,halign="start") => @PLACE(263,-118);
// #RGPP1_2__dmy0 @TEXT("",key="model");
// #RGPP1_3__dmy0 @SET-SYMBOL $RESISTOR;
// #RGPP1_3__dmy0 @PLACE(285,-114) => @ORIENT("R90");
// #RGPP1_3__dmy0 @TEXT("RGPP1_3__dmy0",key="name",size=1.3,halign="start") => @PLACE(288,-111);
// #RGPP1_3__dmy0 @TEXT("l=17.13u w=1u multi=(1)",key="value",size=0.9,halign="start") => @PLACE(288,-118);
// #RGPP1_3__dmy0 @TEXT("",key="model");
// #RGPP1_4__dmy0 @SET-SYMBOL $RESISTOR;
// #RGPP1_4__dmy0 @PLACE(310,-114) => @ORIENT("R90");
// #RGPP1_4__dmy0 @TEXT("RGPP1_4__dmy0",key="name",size=1.3,halign="start") => @PLACE(313,-111);
// #RGPP1_4__dmy0 @TEXT("l=17.13u w=1u multi=(1)",key="value",size=0.9,halign="start") => @PLACE(313,-118);
// #RGPP1_4__dmy0 @TEXT("",key="model");
// #RGPP1_5__dmy0 @SET-SYMBOL $RESISTOR;
// #RGPP1_5__dmy0 @PLACE(335,-114) => @ORIENT("R90");
// #RGPP1_5__dmy0 @TEXT("RGPP1_5__dmy0",key="name",size=1.3,halign="start") => @PLACE(338,-111);
// #RGPP1_5__dmy0 @TEXT("l=17.13u w=1u multi=(1)",key="value",size=0.9,halign="start") => @PLACE(338,-118);
// #RGPP1_5__dmy0 @TEXT("",key="model");
// (104,-99) @TEXT("GPP / 10 series poly sections",size=0.95,halign="start",textcolor="#223d52");
// &"GNNB" @WIRE(mode="straight",linecolor="#30485d",linewidth=0.16) {#XSTD_GNNCN:1 (61.5,0) (61.5,0) #XSTD_GNNBN:2};
// &"GNNDRV" @WIRE(mode="straight",linecolor="#30485d",linewidth=0.16) {#XSTD_GNNCN:2 (95.5,0) (95.5,0) #RGNN0:1};
// &"GNNA" @WIRE(mode="straight",linecolor="#30485d",linewidth=0.16) {#XSTD_GNNBN:1 (32.5,0) (32.5,0) #XSTD_GNNAN:2};
// &"GNNPRE" @WIRE(mode="straight",linecolor="#30485d",linewidth=0.16) {#XSTD_GNNAN:1 (0.5,0) (0.5,0) #X025:4};
// &"GNPB" @WIRE(mode="straight",linecolor="#30485d",linewidth=0.16) {#XSTD_GNPCN:1 (61.5,-38) (61.5,-38) #XSTD_GNPBN:2};
// &"GNPDRV" @WIRE(mode="straight",linecolor="#30485d",linewidth=0.16) {#XSTD_GNPCN:2 (95.5,-38) (95.5,-38) #RGNP0:1};
// &"GNPA" @WIRE(mode="straight",linecolor="#30485d",linewidth=0.16) {#XSTD_GNPBN:1 (32.5,-38) (32.5,-38) #XSTD_GNPAN:2};
// &"H" @WIRE(mode="straight",linecolor="#30485d",linewidth=0.16) {#XSTD_GNPAN:1 (-6.5,-38) (-6.5,-76) #X008:1};
// &"GPNB" @WIRE(mode="straight",linecolor="#30485d",linewidth=0.16) {#XSTD_GPNCN:1 (61.5,-76) (61.5,-76) #XSTD_GPNBN:2};
// &"GPNDRV" @WIRE(mode="straight",linecolor="#30485d",linewidth=0.16) {#XSTD_GPNCN:2 (95.5,-76) (95.5,-76) #RGPN0:1};
// &"GPNA" @WIRE(mode="straight",linecolor="#30485d",linewidth=0.16) {#XSTD_GPNBN:1 (32.5,-76) (32.5,-76) #XSTD_GPNAN:2};
// &"GPNPRE" @WIRE(mode="straight",linecolor="#30485d",linewidth=0.16) {#XSTD_GPNAN:1 (0.5,-76) (0.5,-76) #X008:4};
// &"GPPB" @WIRE(mode="straight",linecolor="#30485d",linewidth=0.16) {#XSTD_GPPCN:1 (61.5,-114) (61.5,-114) #XSTD_GPPBN:2};
// &"GPPDRV" @WIRE(mode="straight",linecolor="#30485d",linewidth=0.16) {#XSTD_GPPCN:2 (95.5,-114) (95.5,-114) #RGPP0:1};
// &"GPPA" @WIRE(mode="straight",linecolor="#30485d",linewidth=0.16) {#XSTD_GPPBN:1 (32.5,-114) (32.5,-114) #XSTD_GPPAN:2};
// &"GNNRG" @WIRE(mode="straight",linecolor="#30485d",linewidth=0.16) {#RGNN1:1 (222.5,0) (222.5,0) #RGNN0_5__dmy0:2};
// &"RGNN1_1__dmy0" @WIRE(mode="straight",linecolor="#30485d",linewidth=0.16) {#RGNN1:2 (247.5,0) (247.5,0) #RGNN1_2__dmy0:1};
// &"RGNN1_2__dmy0" @WIRE(mode="straight",linecolor="#30485d",linewidth=0.16) {#RGNN1_2__dmy0:2 (272.5,0) (272.5,0) #RGNN1_3__dmy0:1};
// &"RGNN1_3__dmy0" @WIRE(mode="straight",linecolor="#30485d",linewidth=0.16) {#RGNN1_3__dmy0:2 (297.5,0) (297.5,0) #RGNN1_4__dmy0:1};
// &"RGNN1_4__dmy0" @WIRE(mode="straight",linecolor="#30485d",linewidth=0.16) {#RGNN1_4__dmy0:2 (322.5,0) (322.5,0) #RGNN1_5__dmy0:1};
// &"RGNN0_1__dmy0" @WIRE(mode="straight",linecolor="#30485d",linewidth=0.16) {#RGNN0:2 (122.5,0) (122.5,0) #RGNN0_2__dmy0:1};
// &"RGNN0_2__dmy0" @WIRE(mode="straight",linecolor="#30485d",linewidth=0.16) {#RGNN0_2__dmy0:2 (147.5,0) (147.5,0) #RGNN0_3__dmy0:1};
// &"RGNN0_3__dmy0" @WIRE(mode="straight",linecolor="#30485d",linewidth=0.16) {#RGNN0_3__dmy0:2 (172.5,0) (172.5,0) #RGNN0_4__dmy0:1};
// &"RGNN0_4__dmy0" @WIRE(mode="straight",linecolor="#30485d",linewidth=0.16) {#RGNN0_4__dmy0:2 (197.5,0) (197.5,0) #RGNN0_5__dmy0:1};
// &"GNPRG" @WIRE(mode="straight",linecolor="#30485d",linewidth=0.16) {#RGNP1:1 (222.5,-38) (222.5,-38) #RGNP0_5__dmy0:2};
// &"RGNP1_1__dmy0" @WIRE(mode="straight",linecolor="#30485d",linewidth=0.16) {#RGNP1:2 (247.5,-38) (247.5,-38) #RGNP1_2__dmy0:1};
// &"RGNP1_2__dmy0" @WIRE(mode="straight",linecolor="#30485d",linewidth=0.16) {#RGNP1_2__dmy0:2 (272.5,-38) (272.5,-38) #RGNP1_3__dmy0:1};
// &"RGNP1_3__dmy0" @WIRE(mode="straight",linecolor="#30485d",linewidth=0.16) {#RGNP1_3__dmy0:2 (297.5,-38) (297.5,-38) #RGNP1_4__dmy0:1};
// &"RGNP1_4__dmy0" @WIRE(mode="straight",linecolor="#30485d",linewidth=0.16) {#RGNP1_4__dmy0:2 (322.5,-38) (322.5,-38) #RGNP1_5__dmy0:1};
// &"RGNP0_1__dmy0" @WIRE(mode="straight",linecolor="#30485d",linewidth=0.16) {#RGNP0:2 (122.5,-38) (122.5,-38) #RGNP0_2__dmy0:1};
// &"RGNP0_2__dmy0" @WIRE(mode="straight",linecolor="#30485d",linewidth=0.16) {#RGNP0_2__dmy0:2 (147.5,-38) (147.5,-38) #RGNP0_3__dmy0:1};
// &"RGNP0_3__dmy0" @WIRE(mode="straight",linecolor="#30485d",linewidth=0.16) {#RGNP0_3__dmy0:2 (172.5,-38) (172.5,-38) #RGNP0_4__dmy0:1};
// &"RGNP0_4__dmy0" @WIRE(mode="straight",linecolor="#30485d",linewidth=0.16) {#RGNP0_4__dmy0:2 (197.5,-38) (197.5,-38) #RGNP0_5__dmy0:1};
// &"GPNRG" @WIRE(mode="straight",linecolor="#30485d",linewidth=0.16) {#RGPN1:1 (222.5,-76) (222.5,-76) #RGPN0_5__dmy0:2};
// &"RGPN1_1__dmy0" @WIRE(mode="straight",linecolor="#30485d",linewidth=0.16) {#RGPN1:2 (247.5,-76) (247.5,-76) #RGPN1_2__dmy0:1};
// &"RGPN1_2__dmy0" @WIRE(mode="straight",linecolor="#30485d",linewidth=0.16) {#RGPN1_2__dmy0:2 (272.5,-76) (272.5,-76) #RGPN1_3__dmy0:1};
// &"RGPN1_3__dmy0" @WIRE(mode="straight",linecolor="#30485d",linewidth=0.16) {#RGPN1_3__dmy0:2 (297.5,-76) (297.5,-76) #RGPN1_4__dmy0:1};
// &"RGPN1_4__dmy0" @WIRE(mode="straight",linecolor="#30485d",linewidth=0.16) {#RGPN1_4__dmy0:2 (322.5,-76) (322.5,-76) #RGPN1_5__dmy0:1};
// &"RGPN0_1__dmy0" @WIRE(mode="straight",linecolor="#30485d",linewidth=0.16) {#RGPN0:2 (122.5,-76) (122.5,-76) #RGPN0_2__dmy0:1};
// &"RGPN0_2__dmy0" @WIRE(mode="straight",linecolor="#30485d",linewidth=0.16) {#RGPN0_2__dmy0:2 (147.5,-76) (147.5,-76) #RGPN0_3__dmy0:1};
// &"RGPN0_3__dmy0" @WIRE(mode="straight",linecolor="#30485d",linewidth=0.16) {#RGPN0_3__dmy0:2 (172.5,-76) (172.5,-76) #RGPN0_4__dmy0:1};
// &"RGPN0_4__dmy0" @WIRE(mode="straight",linecolor="#30485d",linewidth=0.16) {#RGPN0_4__dmy0:2 (197.5,-76) (197.5,-76) #RGPN0_5__dmy0:1};
// &"GPPRG" @WIRE(mode="straight",linecolor="#30485d",linewidth=0.16) {#RGPP1:1 (222.5,-114) (222.5,-114) #RGPP0_5__dmy0:2};
// &"RGPP1_1__dmy0" @WIRE(mode="straight",linecolor="#30485d",linewidth=0.16) {#RGPP1:2 (247.5,-114) (247.5,-114) #RGPP1_2__dmy0:1};
// &"RGPP1_2__dmy0" @WIRE(mode="straight",linecolor="#30485d",linewidth=0.16) {#RGPP1_2__dmy0:2 (272.5,-114) (272.5,-114) #RGPP1_3__dmy0:1};
// &"RGPP1_3__dmy0" @WIRE(mode="straight",linecolor="#30485d",linewidth=0.16) {#RGPP1_3__dmy0:2 (297.5,-114) (297.5,-114) #RGPP1_4__dmy0:1};
// &"RGPP1_4__dmy0" @WIRE(mode="straight",linecolor="#30485d",linewidth=0.16) {#RGPP1_4__dmy0:2 (322.5,-114) (322.5,-114) #RGPP1_5__dmy0:1};
// &"RGPP0_1__dmy0" @WIRE(mode="straight",linecolor="#30485d",linewidth=0.16) {#RGPP0:2 (122.5,-114) (122.5,-114) #RGPP0_2__dmy0:1};
// &"RGPP0_2__dmy0" @WIRE(mode="straight",linecolor="#30485d",linewidth=0.16) {#RGPP0_2__dmy0:2 (147.5,-114) (147.5,-114) #RGPP0_3__dmy0:1};
// &"RGPP0_3__dmy0" @WIRE(mode="straight",linecolor="#30485d",linewidth=0.16) {#RGPP0_3__dmy0:2 (172.5,-114) (172.5,-114) #RGPP0_4__dmy0:1};
// &"RGPP0_4__dmy0" @WIRE(mode="straight",linecolor="#30485d",linewidth=0.16) {#RGPP0_4__dmy0:2 (197.5,-114) (197.5,-114) #RGPP0_5__dmy0:1};
// (-28,-148) @TEXT("GP and GN chains keep their source polarity, device sizing and series R; no zero-delay abstraction.",size=1,halign="start",textcolor="#223d52");
// &"VDD" @WIRE(mode="straight",linecolor="#30485d",linewidth=0.16) {#XSTD_GNNCN:3 (76,10)};
// (76,10.4) @TEXT("VDD",size=1.1,halign="middle",valign="bottom");
// &"VSS" @WIRE(mode="straight",linecolor="#30485d",linewidth=0.16) {#XSTD_GNNCN:4 (76,-10)};
// (76,-10.4) @TEXT("VSS",size=1.1,halign="middle",valign="top");
// &"VDD" @WIRE(mode="straight",linecolor="#30485d",linewidth=0.16) {#XSTD_GNNBN:3 (47,10)};
// (47,10.4) @TEXT("VDD",size=1.1,halign="middle",valign="bottom");
// &"VSS" @WIRE(mode="straight",linecolor="#30485d",linewidth=0.16) {#XSTD_GNNBN:4 (47,-10)};
// (47,-10.4) @TEXT("VSS",size=1.1,halign="middle",valign="top");
// &"VDD" @WIRE(mode="straight",linecolor="#30485d",linewidth=0.16) {#XSTD_GNNAN:3 (18,10)};
// (18,10.4) @TEXT("VDD",size=1.1,halign="middle",valign="bottom");
// &"VSS" @WIRE(mode="straight",linecolor="#30485d",linewidth=0.16) {#XSTD_GNNAN:4 (18,-10)};
// (18,-10.4) @TEXT("VSS",size=1.1,halign="middle",valign="top");
// &"VDD" @WIRE(mode="straight",linecolor="#30485d",linewidth=0.16) {#XSTD_GNPCN:3 (76,-28)};
// (76,-27.6) @TEXT("VDD",size=1.1,halign="middle",valign="bottom");
// &"VSS" @WIRE(mode="straight",linecolor="#30485d",linewidth=0.16) {#XSTD_GNPCN:4 (76,-48)};
// (76,-48.4) @TEXT("VSS",size=1.1,halign="middle",valign="top");
// &"VDD" @WIRE(mode="straight",linecolor="#30485d",linewidth=0.16) {#XSTD_GNPBN:3 (47,-28)};
// (47,-27.6) @TEXT("VDD",size=1.1,halign="middle",valign="bottom");
// &"VSS" @WIRE(mode="straight",linecolor="#30485d",linewidth=0.16) {#XSTD_GNPBN:4 (47,-48)};
// (47,-48.4) @TEXT("VSS",size=1.1,halign="middle",valign="top");
// &"VDD" @WIRE(mode="straight",linecolor="#30485d",linewidth=0.16) {#XSTD_GNPAN:3 (18,-28)};
// (18,-27.6) @TEXT("VDD",size=1.1,halign="middle",valign="bottom");
// &"VSS" @WIRE(mode="straight",linecolor="#30485d",linewidth=0.16) {#XSTD_GNPAN:4 (18,-48)};
// (18,-48.4) @TEXT("VSS",size=1.1,halign="middle",valign="top");
// &"VDD" @WIRE(mode="straight",linecolor="#30485d",linewidth=0.16) {#XSTD_GPNCN:3 (76,-66)};
// (76,-65.6) @TEXT("VDD",size=1.1,halign="middle",valign="bottom");
// &"VSS" @WIRE(mode="straight",linecolor="#30485d",linewidth=0.16) {#XSTD_GPNCN:4 (76,-86)};
// (76,-86.4) @TEXT("VSS",size=1.1,halign="middle",valign="top");
// &"VDD" @WIRE(mode="straight",linecolor="#30485d",linewidth=0.16) {#XSTD_GPNBN:3 (47,-66)};
// (47,-65.6) @TEXT("VDD",size=1.1,halign="middle",valign="bottom");
// &"VSS" @WIRE(mode="straight",linecolor="#30485d",linewidth=0.16) {#XSTD_GPNBN:4 (47,-86)};
// (47,-86.4) @TEXT("VSS",size=1.1,halign="middle",valign="top");
// &"VDD" @WIRE(mode="straight",linecolor="#30485d",linewidth=0.16) {#XSTD_GPNAN:3 (18,-66)};
// (18,-65.6) @TEXT("VDD",size=1.1,halign="middle",valign="bottom");
// &"VSS" @WIRE(mode="straight",linecolor="#30485d",linewidth=0.16) {#XSTD_GPNAN:4 (18,-86)};
// (18,-86.4) @TEXT("VSS",size=1.1,halign="middle",valign="top");
// &"VDD" @WIRE(mode="straight",linecolor="#30485d",linewidth=0.16) {#XSTD_GPPCN:3 (76,-104)};
// (76,-103.6) @TEXT("VDD",size=1.1,halign="middle",valign="bottom");
// &"VSS" @WIRE(mode="straight",linecolor="#30485d",linewidth=0.16) {#XSTD_GPPCN:4 (76,-124)};
// (76,-124.4) @TEXT("VSS",size=1.1,halign="middle",valign="top");
// &"VDD" @WIRE(mode="straight",linecolor="#30485d",linewidth=0.16) {#XSTD_GPPBN:3 (47,-104)};
// (47,-103.6) @TEXT("VDD",size=1.1,halign="middle",valign="bottom");
// &"VSS" @WIRE(mode="straight",linecolor="#30485d",linewidth=0.16) {#XSTD_GPPBN:4 (47,-124)};
// (47,-124.4) @TEXT("VSS",size=1.1,halign="middle",valign="top");
// &"L" @WIRE(mode="straight",linecolor="#30485d",linewidth=0.16) {#XSTD_GPPAN:1 (8,-114)};
// (7.6,-114) @TEXT("L",size=1.1,halign="end",valign="middle");
// &"VDD" @WIRE(mode="straight",linecolor="#30485d",linewidth=0.16) {#XSTD_GPPAN:3 (18,-104)};
// (18,-103.6) @TEXT("VDD",size=1.1,halign="middle",valign="bottom");
// &"VSS" @WIRE(mode="straight",linecolor="#30485d",linewidth=0.16) {#XSTD_GPPAN:4 (18,-124)};
// (18,-124.4) @TEXT("VSS",size=1.1,halign="middle",valign="top");
// &"GNN" @WIRE(mode="straight",linecolor="#30485d",linewidth=0.16) {#RGNN1_5__dmy0:2 (340,0)};
// (340.4,0) @TEXT("GNN",size=1.1,halign="start",valign="middle");
// &"GNP" @WIRE(mode="straight",linecolor="#30485d",linewidth=0.16) {#RGNP1_5__dmy0:2 (340,-38)};
// (340.4,-38) @TEXT("GNP",size=1.1,halign="start",valign="middle");
// &"GPN" @WIRE(mode="straight",linecolor="#30485d",linewidth=0.16) {#RGPN1_5__dmy0:2 (340,-76)};
// (340.4,-76) @TEXT("GPN",size=1.1,halign="start",valign="middle");
// &"GPP" @WIRE(mode="straight",linecolor="#30485d",linewidth=0.16) {#RGPP1_5__dmy0:2 (340,-114)};
// (340.4,-114) @TEXT("GPP",size=1.1,halign="start",valign="middle");
// &"L" @WIRE(mode="straight",linecolor="#30485d",linewidth=0.16) {#X025:1 (-27,0)};
// (-27.4,0) @TEXT("L",size=1.1,halign="end",valign="middle");
// &"VDD" @WIRE(mode="straight",linecolor="#30485d",linewidth=0.16) {#X025:2 (-17,10)};
// (-17,10.4) @TEXT("VDD",size=1.1,halign="middle",valign="bottom");
// &"VSS" @WIRE(mode="straight",linecolor="#30485d",linewidth=0.16) {#X025:3 (-17,-10)};
// (-17,-10.4) @TEXT("VSS",size=1.1,halign="middle",valign="top");
// &"VDD" @WIRE(mode="straight",linecolor="#30485d",linewidth=0.16) {#X008:2 (-17,-66)};
// (-17,-65.6) @TEXT("VDD",size=1.1,halign="middle",valign="bottom");
// &"VSS" @WIRE(mode="straight",linecolor="#30485d",linewidth=0.16) {#X008:3 (-17,-86)};
// (-17,-86.4) @TEXT("VSS",size=1.1,halign="middle",valign="top");
// }
// END SARADC RNL
ends sar8p_refdrv_b4

subckt sar8p_refdrv_b5 GNN GNP GPN GPP H L VDD VSS
    XSTD_GNNCN (GNNB GNNDRV VDD VSS) INVD1BWP12T30P140
    XSTD_GNNBN (GNNA GNNB VDD VSS) INVD1BWP12T30P140
    XSTD_GNNAN (GNNPRE GNNA VDD VSS) INVD1BWP12T30P140
    XSTD_GNPCN (GNPB GNPDRV VDD VSS) INVD1BWP12T30P140
    XSTD_GNPBN (GNPA GNPB VDD VSS) INVD1BWP12T30P140
    XSTD_GNPAN (H GNPA VDD VSS) INVD1BWP12T30P140
    XSTD_GPNCN (GPNB GPNDRV VDD VSS) INVD1BWP12T30P140
    XSTD_GPNBN (GPNA GPNB VDD VSS) INVD1BWP12T30P140
    XSTD_GPNAN (GPNPRE GPNA VDD VSS) INVD1BWP12T30P140
    XSTD_GPPCN (GPPB GPPDRV VDD VSS) INVD1BWP12T30P140
    XSTD_GPPBN (GPPA GPPB VDD VSS) INVD1BWP12T30P140
    XSTD_GPPAN (L GPPA VDD VSS) INVD1BWP12T30P140
//Series configuration of RGNN1
RGNN1  (GNNRG RGNN1_1__dmy0 ) rupolym l=17.13u w=1u m=32 multi=(1)
RGNN1_2__dmy0  (RGNN1_1__dmy0 RGNN1_2__dmy0 ) rupolym l=17.13u w=1u m=32 \
        multi=(1)
RGNN1_3__dmy0  (RGNN1_2__dmy0 RGNN1_3__dmy0 ) rupolym l=17.13u w=1u m=32 \
        multi=(1)
RGNN1_4__dmy0  (RGNN1_3__dmy0 RGNN1_4__dmy0 ) rupolym l=17.13u w=1u m=32 \
        multi=(1)
RGNN1_5__dmy0  (RGNN1_4__dmy0 GNN ) rupolym l=17.13u w=1u m=32 multi=(1)
//End of RGNN1

//Series configuration of RGNN0
RGNN0  (GNNDRV RGNN0_1__dmy0 ) rupolym l=17.13u w=1u m=32 multi=(1)
RGNN0_2__dmy0  (RGNN0_1__dmy0 RGNN0_2__dmy0 ) rupolym l=17.13u w=1u m=32 \
        multi=(1)
RGNN0_3__dmy0  (RGNN0_2__dmy0 RGNN0_3__dmy0 ) rupolym l=17.13u w=1u m=32 \
        multi=(1)
RGNN0_4__dmy0  (RGNN0_3__dmy0 RGNN0_4__dmy0 ) rupolym l=17.13u w=1u m=32 \
        multi=(1)
RGNN0_5__dmy0  (RGNN0_4__dmy0 GNNRG ) rupolym l=17.13u w=1u m=32 multi=(1)
//End of RGNN0

//Series configuration of RGNP1
RGNP1  (GNPRG RGNP1_1__dmy0 ) rupolym l=17.13u w=1u m=32 multi=(1)
RGNP1_2__dmy0  (RGNP1_1__dmy0 RGNP1_2__dmy0 ) rupolym l=17.13u w=1u m=32 \
        multi=(1)
RGNP1_3__dmy0  (RGNP1_2__dmy0 RGNP1_3__dmy0 ) rupolym l=17.13u w=1u m=32 \
        multi=(1)
RGNP1_4__dmy0  (RGNP1_3__dmy0 RGNP1_4__dmy0 ) rupolym l=17.13u w=1u m=32 \
        multi=(1)
RGNP1_5__dmy0  (RGNP1_4__dmy0 GNP ) rupolym l=17.13u w=1u m=32 multi=(1)
//End of RGNP1

//Series configuration of RGNP0
RGNP0  (GNPDRV RGNP0_1__dmy0 ) rupolym l=17.13u w=1u m=32 multi=(1)
RGNP0_2__dmy0  (RGNP0_1__dmy0 RGNP0_2__dmy0 ) rupolym l=17.13u w=1u m=32 \
        multi=(1)
RGNP0_3__dmy0  (RGNP0_2__dmy0 RGNP0_3__dmy0 ) rupolym l=17.13u w=1u m=32 \
        multi=(1)
RGNP0_4__dmy0  (RGNP0_3__dmy0 RGNP0_4__dmy0 ) rupolym l=17.13u w=1u m=32 \
        multi=(1)
RGNP0_5__dmy0  (RGNP0_4__dmy0 GNPRG ) rupolym l=17.13u w=1u m=32 multi=(1)
//End of RGNP0

//Series configuration of RGPN1
RGPN1  (GPNRG RGPN1_1__dmy0 ) rupolym l=17.13u w=1u m=32 multi=(1)
RGPN1_2__dmy0  (RGPN1_1__dmy0 RGPN1_2__dmy0 ) rupolym l=17.13u w=1u m=32 \
        multi=(1)
RGPN1_3__dmy0  (RGPN1_2__dmy0 RGPN1_3__dmy0 ) rupolym l=17.13u w=1u m=32 \
        multi=(1)
RGPN1_4__dmy0  (RGPN1_3__dmy0 RGPN1_4__dmy0 ) rupolym l=17.13u w=1u m=32 \
        multi=(1)
RGPN1_5__dmy0  (RGPN1_4__dmy0 GPN ) rupolym l=17.13u w=1u m=32 multi=(1)
//End of RGPN1

//Series configuration of RGPN0
RGPN0  (GPNDRV RGPN0_1__dmy0 ) rupolym l=17.13u w=1u m=32 multi=(1)
RGPN0_2__dmy0  (RGPN0_1__dmy0 RGPN0_2__dmy0 ) rupolym l=17.13u w=1u m=32 \
        multi=(1)
RGPN0_3__dmy0  (RGPN0_2__dmy0 RGPN0_3__dmy0 ) rupolym l=17.13u w=1u m=32 \
        multi=(1)
RGPN0_4__dmy0  (RGPN0_3__dmy0 RGPN0_4__dmy0 ) rupolym l=17.13u w=1u m=32 \
        multi=(1)
RGPN0_5__dmy0  (RGPN0_4__dmy0 GPNRG ) rupolym l=17.13u w=1u m=32 multi=(1)
//End of RGPN0

//Series configuration of RGPP1
RGPP1  (GPPRG RGPP1_1__dmy0 ) rupolym l=17.13u w=1u m=32 multi=(1)
RGPP1_2__dmy0  (RGPP1_1__dmy0 RGPP1_2__dmy0 ) rupolym l=17.13u w=1u m=32 \
        multi=(1)
RGPP1_3__dmy0  (RGPP1_2__dmy0 RGPP1_3__dmy0 ) rupolym l=17.13u w=1u m=32 \
        multi=(1)
RGPP1_4__dmy0  (RGPP1_3__dmy0 RGPP1_4__dmy0 ) rupolym l=17.13u w=1u m=32 \
        multi=(1)
RGPP1_5__dmy0  (RGPP1_4__dmy0 GPP ) rupolym l=17.13u w=1u m=32 multi=(1)
//End of RGPP1

//Series configuration of RGPP0
RGPP0  (GPPDRV RGPP0_1__dmy0 ) rupolym l=17.13u w=1u m=32 multi=(1)
RGPP0_2__dmy0  (RGPP0_1__dmy0 RGPP0_2__dmy0 ) rupolym l=17.13u w=1u m=32 \
        multi=(1)
RGPP0_3__dmy0  (RGPP0_2__dmy0 RGPP0_3__dmy0 ) rupolym l=17.13u w=1u m=32 \
        multi=(1)
RGPP0_4__dmy0  (RGPP0_3__dmy0 RGPP0_4__dmy0 ) rupolym l=17.13u w=1u m=32 \
        multi=(1)
RGPP0_5__dmy0  (RGPP0_4__dmy0 GPPRG ) rupolym l=17.13u w=1u m=32 multi=(1)
//End of RGPP0

    X025 (L VDD VSS GNNPRE) sar8p_inv
    X008 (H VDD VSS GPNPRE) sar8p_inv
// BEGIN SARADC RNL
// @RNL(author="saradc topology") {
// (-28,27) @TEXT("sar8p_refdrv_b5 / four physical gate-driver chains",size=1.5,halign="start",textcolor="#223d52");
// #X025 @SET-SYMBOL $S_sar8p_inv;
// #X025 @PLACE(-17,0) => @ORIENT("R0");
// #XSTD_GNNAN @SET-SYMBOL $S_INVD1BWP12T30P140;
// #XSTD_GNNAN @PLACE(18,0) => @ORIENT("R0");
// #XSTD_GNNBN @SET-SYMBOL $S_INVD1BWP12T30P140;
// #XSTD_GNNBN @PLACE(47,0) => @ORIENT("R0");
// #XSTD_GNNCN @SET-SYMBOL $S_INVD1BWP12T30P140;
// #XSTD_GNNCN @PLACE(76,0) => @ORIENT("R0");
// #RGNN0 @SET-SYMBOL $RESISTOR;
// #RGNN0 @PLACE(110,0) => @ORIENT("R90");
// #RGNN0 @TEXT("RGNN0",key="name",size=1.3,halign="start") => @PLACE(113,3);
// #RGNN0 @TEXT("l=17.13u w=1u multi=(1)",key="value",size=0.9,halign="start") => @PLACE(113,-4);
// #RGNN0 @TEXT("",key="model");
// #RGNN0_2__dmy0 @SET-SYMBOL $RESISTOR;
// #RGNN0_2__dmy0 @PLACE(135,0) => @ORIENT("R90");
// #RGNN0_2__dmy0 @TEXT("RGNN0_2__dmy0",key="name",size=1.3,halign="start") => @PLACE(138,3);
// #RGNN0_2__dmy0 @TEXT("l=17.13u w=1u multi=(1)",key="value",size=0.9,halign="start") => @PLACE(138,-4);
// #RGNN0_2__dmy0 @TEXT("",key="model");
// #RGNN0_3__dmy0 @SET-SYMBOL $RESISTOR;
// #RGNN0_3__dmy0 @PLACE(160,0) => @ORIENT("R90");
// #RGNN0_3__dmy0 @TEXT("RGNN0_3__dmy0",key="name",size=1.3,halign="start") => @PLACE(163,3);
// #RGNN0_3__dmy0 @TEXT("l=17.13u w=1u multi=(1)",key="value",size=0.9,halign="start") => @PLACE(163,-4);
// #RGNN0_3__dmy0 @TEXT("",key="model");
// #RGNN0_4__dmy0 @SET-SYMBOL $RESISTOR;
// #RGNN0_4__dmy0 @PLACE(185,0) => @ORIENT("R90");
// #RGNN0_4__dmy0 @TEXT("RGNN0_4__dmy0",key="name",size=1.3,halign="start") => @PLACE(188,3);
// #RGNN0_4__dmy0 @TEXT("l=17.13u w=1u multi=(1)",key="value",size=0.9,halign="start") => @PLACE(188,-4);
// #RGNN0_4__dmy0 @TEXT("",key="model");
// #RGNN0_5__dmy0 @SET-SYMBOL $RESISTOR;
// #RGNN0_5__dmy0 @PLACE(210,0) => @ORIENT("R90");
// #RGNN0_5__dmy0 @TEXT("RGNN0_5__dmy0",key="name",size=1.3,halign="start") => @PLACE(213,3);
// #RGNN0_5__dmy0 @TEXT("l=17.13u w=1u multi=(1)",key="value",size=0.9,halign="start") => @PLACE(213,-4);
// #RGNN0_5__dmy0 @TEXT("",key="model");
// #RGNN1 @SET-SYMBOL $RESISTOR;
// #RGNN1 @PLACE(235,0) => @ORIENT("R90");
// #RGNN1 @TEXT("RGNN1",key="name",size=1.3,halign="start") => @PLACE(238,3);
// #RGNN1 @TEXT("l=17.13u w=1u multi=(1)",key="value",size=0.9,halign="start") => @PLACE(238,-4);
// #RGNN1 @TEXT("",key="model");
// #RGNN1_2__dmy0 @SET-SYMBOL $RESISTOR;
// #RGNN1_2__dmy0 @PLACE(260,0) => @ORIENT("R90");
// #RGNN1_2__dmy0 @TEXT("RGNN1_2__dmy0",key="name",size=1.3,halign="start") => @PLACE(263,3);
// #RGNN1_2__dmy0 @TEXT("l=17.13u w=1u multi=(1)",key="value",size=0.9,halign="start") => @PLACE(263,-4);
// #RGNN1_2__dmy0 @TEXT("",key="model");
// #RGNN1_3__dmy0 @SET-SYMBOL $RESISTOR;
// #RGNN1_3__dmy0 @PLACE(285,0) => @ORIENT("R90");
// #RGNN1_3__dmy0 @TEXT("RGNN1_3__dmy0",key="name",size=1.3,halign="start") => @PLACE(288,3);
// #RGNN1_3__dmy0 @TEXT("l=17.13u w=1u multi=(1)",key="value",size=0.9,halign="start") => @PLACE(288,-4);
// #RGNN1_3__dmy0 @TEXT("",key="model");
// #RGNN1_4__dmy0 @SET-SYMBOL $RESISTOR;
// #RGNN1_4__dmy0 @PLACE(310,0) => @ORIENT("R90");
// #RGNN1_4__dmy0 @TEXT("RGNN1_4__dmy0",key="name",size=1.3,halign="start") => @PLACE(313,3);
// #RGNN1_4__dmy0 @TEXT("l=17.13u w=1u multi=(1)",key="value",size=0.9,halign="start") => @PLACE(313,-4);
// #RGNN1_4__dmy0 @TEXT("",key="model");
// #RGNN1_5__dmy0 @SET-SYMBOL $RESISTOR;
// #RGNN1_5__dmy0 @PLACE(335,0) => @ORIENT("R90");
// #RGNN1_5__dmy0 @TEXT("RGNN1_5__dmy0",key="name",size=1.3,halign="start") => @PLACE(338,3);
// #RGNN1_5__dmy0 @TEXT("l=17.13u w=1u multi=(1)",key="value",size=0.9,halign="start") => @PLACE(338,-4);
// #RGNN1_5__dmy0 @TEXT("",key="model");
// (104,15) @TEXT("GNN / 10 series poly sections",size=0.95,halign="start",textcolor="#223d52");
// #XSTD_GNPAN @SET-SYMBOL $S_INVD1BWP12T30P140;
// #XSTD_GNPAN @PLACE(18,-38) => @ORIENT("R0");
// #XSTD_GNPBN @SET-SYMBOL $S_INVD1BWP12T30P140;
// #XSTD_GNPBN @PLACE(47,-38) => @ORIENT("R0");
// #XSTD_GNPCN @SET-SYMBOL $S_INVD1BWP12T30P140;
// #XSTD_GNPCN @PLACE(76,-38) => @ORIENT("R0");
// #RGNP0 @SET-SYMBOL $RESISTOR;
// #RGNP0 @PLACE(110,-38) => @ORIENT("R90");
// #RGNP0 @TEXT("RGNP0",key="name",size=1.3,halign="start") => @PLACE(113,-35);
// #RGNP0 @TEXT("l=17.13u w=1u multi=(1)",key="value",size=0.9,halign="start") => @PLACE(113,-42);
// #RGNP0 @TEXT("",key="model");
// #RGNP0_2__dmy0 @SET-SYMBOL $RESISTOR;
// #RGNP0_2__dmy0 @PLACE(135,-38) => @ORIENT("R90");
// #RGNP0_2__dmy0 @TEXT("RGNP0_2__dmy0",key="name",size=1.3,halign="start") => @PLACE(138,-35);
// #RGNP0_2__dmy0 @TEXT("l=17.13u w=1u multi=(1)",key="value",size=0.9,halign="start") => @PLACE(138,-42);
// #RGNP0_2__dmy0 @TEXT("",key="model");
// #RGNP0_3__dmy0 @SET-SYMBOL $RESISTOR;
// #RGNP0_3__dmy0 @PLACE(160,-38) => @ORIENT("R90");
// #RGNP0_3__dmy0 @TEXT("RGNP0_3__dmy0",key="name",size=1.3,halign="start") => @PLACE(163,-35);
// #RGNP0_3__dmy0 @TEXT("l=17.13u w=1u multi=(1)",key="value",size=0.9,halign="start") => @PLACE(163,-42);
// #RGNP0_3__dmy0 @TEXT("",key="model");
// #RGNP0_4__dmy0 @SET-SYMBOL $RESISTOR;
// #RGNP0_4__dmy0 @PLACE(185,-38) => @ORIENT("R90");
// #RGNP0_4__dmy0 @TEXT("RGNP0_4__dmy0",key="name",size=1.3,halign="start") => @PLACE(188,-35);
// #RGNP0_4__dmy0 @TEXT("l=17.13u w=1u multi=(1)",key="value",size=0.9,halign="start") => @PLACE(188,-42);
// #RGNP0_4__dmy0 @TEXT("",key="model");
// #RGNP0_5__dmy0 @SET-SYMBOL $RESISTOR;
// #RGNP0_5__dmy0 @PLACE(210,-38) => @ORIENT("R90");
// #RGNP0_5__dmy0 @TEXT("RGNP0_5__dmy0",key="name",size=1.3,halign="start") => @PLACE(213,-35);
// #RGNP0_5__dmy0 @TEXT("l=17.13u w=1u multi=(1)",key="value",size=0.9,halign="start") => @PLACE(213,-42);
// #RGNP0_5__dmy0 @TEXT("",key="model");
// #RGNP1 @SET-SYMBOL $RESISTOR;
// #RGNP1 @PLACE(235,-38) => @ORIENT("R90");
// #RGNP1 @TEXT("RGNP1",key="name",size=1.3,halign="start") => @PLACE(238,-35);
// #RGNP1 @TEXT("l=17.13u w=1u multi=(1)",key="value",size=0.9,halign="start") => @PLACE(238,-42);
// #RGNP1 @TEXT("",key="model");
// #RGNP1_2__dmy0 @SET-SYMBOL $RESISTOR;
// #RGNP1_2__dmy0 @PLACE(260,-38) => @ORIENT("R90");
// #RGNP1_2__dmy0 @TEXT("RGNP1_2__dmy0",key="name",size=1.3,halign="start") => @PLACE(263,-35);
// #RGNP1_2__dmy0 @TEXT("l=17.13u w=1u multi=(1)",key="value",size=0.9,halign="start") => @PLACE(263,-42);
// #RGNP1_2__dmy0 @TEXT("",key="model");
// #RGNP1_3__dmy0 @SET-SYMBOL $RESISTOR;
// #RGNP1_3__dmy0 @PLACE(285,-38) => @ORIENT("R90");
// #RGNP1_3__dmy0 @TEXT("RGNP1_3__dmy0",key="name",size=1.3,halign="start") => @PLACE(288,-35);
// #RGNP1_3__dmy0 @TEXT("l=17.13u w=1u multi=(1)",key="value",size=0.9,halign="start") => @PLACE(288,-42);
// #RGNP1_3__dmy0 @TEXT("",key="model");
// #RGNP1_4__dmy0 @SET-SYMBOL $RESISTOR;
// #RGNP1_4__dmy0 @PLACE(310,-38) => @ORIENT("R90");
// #RGNP1_4__dmy0 @TEXT("RGNP1_4__dmy0",key="name",size=1.3,halign="start") => @PLACE(313,-35);
// #RGNP1_4__dmy0 @TEXT("l=17.13u w=1u multi=(1)",key="value",size=0.9,halign="start") => @PLACE(313,-42);
// #RGNP1_4__dmy0 @TEXT("",key="model");
// #RGNP1_5__dmy0 @SET-SYMBOL $RESISTOR;
// #RGNP1_5__dmy0 @PLACE(335,-38) => @ORIENT("R90");
// #RGNP1_5__dmy0 @TEXT("RGNP1_5__dmy0",key="name",size=1.3,halign="start") => @PLACE(338,-35);
// #RGNP1_5__dmy0 @TEXT("l=17.13u w=1u multi=(1)",key="value",size=0.9,halign="start") => @PLACE(338,-42);
// #RGNP1_5__dmy0 @TEXT("",key="model");
// (104,-23) @TEXT("GNP / 10 series poly sections",size=0.95,halign="start",textcolor="#223d52");
// #X008 @SET-SYMBOL $S_sar8p_inv;
// #X008 @PLACE(-17,-76) => @ORIENT("R0");
// #XSTD_GPNAN @SET-SYMBOL $S_INVD1BWP12T30P140;
// #XSTD_GPNAN @PLACE(18,-76) => @ORIENT("R0");
// #XSTD_GPNBN @SET-SYMBOL $S_INVD1BWP12T30P140;
// #XSTD_GPNBN @PLACE(47,-76) => @ORIENT("R0");
// #XSTD_GPNCN @SET-SYMBOL $S_INVD1BWP12T30P140;
// #XSTD_GPNCN @PLACE(76,-76) => @ORIENT("R0");
// #RGPN0 @SET-SYMBOL $RESISTOR;
// #RGPN0 @PLACE(110,-76) => @ORIENT("R90");
// #RGPN0 @TEXT("RGPN0",key="name",size=1.3,halign="start") => @PLACE(113,-73);
// #RGPN0 @TEXT("l=17.13u w=1u multi=(1)",key="value",size=0.9,halign="start") => @PLACE(113,-80);
// #RGPN0 @TEXT("",key="model");
// #RGPN0_2__dmy0 @SET-SYMBOL $RESISTOR;
// #RGPN0_2__dmy0 @PLACE(135,-76) => @ORIENT("R90");
// #RGPN0_2__dmy0 @TEXT("RGPN0_2__dmy0",key="name",size=1.3,halign="start") => @PLACE(138,-73);
// #RGPN0_2__dmy0 @TEXT("l=17.13u w=1u multi=(1)",key="value",size=0.9,halign="start") => @PLACE(138,-80);
// #RGPN0_2__dmy0 @TEXT("",key="model");
// #RGPN0_3__dmy0 @SET-SYMBOL $RESISTOR;
// #RGPN0_3__dmy0 @PLACE(160,-76) => @ORIENT("R90");
// #RGPN0_3__dmy0 @TEXT("RGPN0_3__dmy0",key="name",size=1.3,halign="start") => @PLACE(163,-73);
// #RGPN0_3__dmy0 @TEXT("l=17.13u w=1u multi=(1)",key="value",size=0.9,halign="start") => @PLACE(163,-80);
// #RGPN0_3__dmy0 @TEXT("",key="model");
// #RGPN0_4__dmy0 @SET-SYMBOL $RESISTOR;
// #RGPN0_4__dmy0 @PLACE(185,-76) => @ORIENT("R90");
// #RGPN0_4__dmy0 @TEXT("RGPN0_4__dmy0",key="name",size=1.3,halign="start") => @PLACE(188,-73);
// #RGPN0_4__dmy0 @TEXT("l=17.13u w=1u multi=(1)",key="value",size=0.9,halign="start") => @PLACE(188,-80);
// #RGPN0_4__dmy0 @TEXT("",key="model");
// #RGPN0_5__dmy0 @SET-SYMBOL $RESISTOR;
// #RGPN0_5__dmy0 @PLACE(210,-76) => @ORIENT("R90");
// #RGPN0_5__dmy0 @TEXT("RGPN0_5__dmy0",key="name",size=1.3,halign="start") => @PLACE(213,-73);
// #RGPN0_5__dmy0 @TEXT("l=17.13u w=1u multi=(1)",key="value",size=0.9,halign="start") => @PLACE(213,-80);
// #RGPN0_5__dmy0 @TEXT("",key="model");
// #RGPN1 @SET-SYMBOL $RESISTOR;
// #RGPN1 @PLACE(235,-76) => @ORIENT("R90");
// #RGPN1 @TEXT("RGPN1",key="name",size=1.3,halign="start") => @PLACE(238,-73);
// #RGPN1 @TEXT("l=17.13u w=1u multi=(1)",key="value",size=0.9,halign="start") => @PLACE(238,-80);
// #RGPN1 @TEXT("",key="model");
// #RGPN1_2__dmy0 @SET-SYMBOL $RESISTOR;
// #RGPN1_2__dmy0 @PLACE(260,-76) => @ORIENT("R90");
// #RGPN1_2__dmy0 @TEXT("RGPN1_2__dmy0",key="name",size=1.3,halign="start") => @PLACE(263,-73);
// #RGPN1_2__dmy0 @TEXT("l=17.13u w=1u multi=(1)",key="value",size=0.9,halign="start") => @PLACE(263,-80);
// #RGPN1_2__dmy0 @TEXT("",key="model");
// #RGPN1_3__dmy0 @SET-SYMBOL $RESISTOR;
// #RGPN1_3__dmy0 @PLACE(285,-76) => @ORIENT("R90");
// #RGPN1_3__dmy0 @TEXT("RGPN1_3__dmy0",key="name",size=1.3,halign="start") => @PLACE(288,-73);
// #RGPN1_3__dmy0 @TEXT("l=17.13u w=1u multi=(1)",key="value",size=0.9,halign="start") => @PLACE(288,-80);
// #RGPN1_3__dmy0 @TEXT("",key="model");
// #RGPN1_4__dmy0 @SET-SYMBOL $RESISTOR;
// #RGPN1_4__dmy0 @PLACE(310,-76) => @ORIENT("R90");
// #RGPN1_4__dmy0 @TEXT("RGPN1_4__dmy0",key="name",size=1.3,halign="start") => @PLACE(313,-73);
// #RGPN1_4__dmy0 @TEXT("l=17.13u w=1u multi=(1)",key="value",size=0.9,halign="start") => @PLACE(313,-80);
// #RGPN1_4__dmy0 @TEXT("",key="model");
// #RGPN1_5__dmy0 @SET-SYMBOL $RESISTOR;
// #RGPN1_5__dmy0 @PLACE(335,-76) => @ORIENT("R90");
// #RGPN1_5__dmy0 @TEXT("RGPN1_5__dmy0",key="name",size=1.3,halign="start") => @PLACE(338,-73);
// #RGPN1_5__dmy0 @TEXT("l=17.13u w=1u multi=(1)",key="value",size=0.9,halign="start") => @PLACE(338,-80);
// #RGPN1_5__dmy0 @TEXT("",key="model");
// (104,-61) @TEXT("GPN / 10 series poly sections",size=0.95,halign="start",textcolor="#223d52");
// #XSTD_GPPAN @SET-SYMBOL $S_INVD1BWP12T30P140;
// #XSTD_GPPAN @PLACE(18,-114) => @ORIENT("R0");
// #XSTD_GPPBN @SET-SYMBOL $S_INVD1BWP12T30P140;
// #XSTD_GPPBN @PLACE(47,-114) => @ORIENT("R0");
// #XSTD_GPPCN @SET-SYMBOL $S_INVD1BWP12T30P140;
// #XSTD_GPPCN @PLACE(76,-114) => @ORIENT("R0");
// #RGPP0 @SET-SYMBOL $RESISTOR;
// #RGPP0 @PLACE(110,-114) => @ORIENT("R90");
// #RGPP0 @TEXT("RGPP0",key="name",size=1.3,halign="start") => @PLACE(113,-111);
// #RGPP0 @TEXT("l=17.13u w=1u multi=(1)",key="value",size=0.9,halign="start") => @PLACE(113,-118);
// #RGPP0 @TEXT("",key="model");
// #RGPP0_2__dmy0 @SET-SYMBOL $RESISTOR;
// #RGPP0_2__dmy0 @PLACE(135,-114) => @ORIENT("R90");
// #RGPP0_2__dmy0 @TEXT("RGPP0_2__dmy0",key="name",size=1.3,halign="start") => @PLACE(138,-111);
// #RGPP0_2__dmy0 @TEXT("l=17.13u w=1u multi=(1)",key="value",size=0.9,halign="start") => @PLACE(138,-118);
// #RGPP0_2__dmy0 @TEXT("",key="model");
// #RGPP0_3__dmy0 @SET-SYMBOL $RESISTOR;
// #RGPP0_3__dmy0 @PLACE(160,-114) => @ORIENT("R90");
// #RGPP0_3__dmy0 @TEXT("RGPP0_3__dmy0",key="name",size=1.3,halign="start") => @PLACE(163,-111);
// #RGPP0_3__dmy0 @TEXT("l=17.13u w=1u multi=(1)",key="value",size=0.9,halign="start") => @PLACE(163,-118);
// #RGPP0_3__dmy0 @TEXT("",key="model");
// #RGPP0_4__dmy0 @SET-SYMBOL $RESISTOR;
// #RGPP0_4__dmy0 @PLACE(185,-114) => @ORIENT("R90");
// #RGPP0_4__dmy0 @TEXT("RGPP0_4__dmy0",key="name",size=1.3,halign="start") => @PLACE(188,-111);
// #RGPP0_4__dmy0 @TEXT("l=17.13u w=1u multi=(1)",key="value",size=0.9,halign="start") => @PLACE(188,-118);
// #RGPP0_4__dmy0 @TEXT("",key="model");
// #RGPP0_5__dmy0 @SET-SYMBOL $RESISTOR;
// #RGPP0_5__dmy0 @PLACE(210,-114) => @ORIENT("R90");
// #RGPP0_5__dmy0 @TEXT("RGPP0_5__dmy0",key="name",size=1.3,halign="start") => @PLACE(213,-111);
// #RGPP0_5__dmy0 @TEXT("l=17.13u w=1u multi=(1)",key="value",size=0.9,halign="start") => @PLACE(213,-118);
// #RGPP0_5__dmy0 @TEXT("",key="model");
// #RGPP1 @SET-SYMBOL $RESISTOR;
// #RGPP1 @PLACE(235,-114) => @ORIENT("R90");
// #RGPP1 @TEXT("RGPP1",key="name",size=1.3,halign="start") => @PLACE(238,-111);
// #RGPP1 @TEXT("l=17.13u w=1u multi=(1)",key="value",size=0.9,halign="start") => @PLACE(238,-118);
// #RGPP1 @TEXT("",key="model");
// #RGPP1_2__dmy0 @SET-SYMBOL $RESISTOR;
// #RGPP1_2__dmy0 @PLACE(260,-114) => @ORIENT("R90");
// #RGPP1_2__dmy0 @TEXT("RGPP1_2__dmy0",key="name",size=1.3,halign="start") => @PLACE(263,-111);
// #RGPP1_2__dmy0 @TEXT("l=17.13u w=1u multi=(1)",key="value",size=0.9,halign="start") => @PLACE(263,-118);
// #RGPP1_2__dmy0 @TEXT("",key="model");
// #RGPP1_3__dmy0 @SET-SYMBOL $RESISTOR;
// #RGPP1_3__dmy0 @PLACE(285,-114) => @ORIENT("R90");
// #RGPP1_3__dmy0 @TEXT("RGPP1_3__dmy0",key="name",size=1.3,halign="start") => @PLACE(288,-111);
// #RGPP1_3__dmy0 @TEXT("l=17.13u w=1u multi=(1)",key="value",size=0.9,halign="start") => @PLACE(288,-118);
// #RGPP1_3__dmy0 @TEXT("",key="model");
// #RGPP1_4__dmy0 @SET-SYMBOL $RESISTOR;
// #RGPP1_4__dmy0 @PLACE(310,-114) => @ORIENT("R90");
// #RGPP1_4__dmy0 @TEXT("RGPP1_4__dmy0",key="name",size=1.3,halign="start") => @PLACE(313,-111);
// #RGPP1_4__dmy0 @TEXT("l=17.13u w=1u multi=(1)",key="value",size=0.9,halign="start") => @PLACE(313,-118);
// #RGPP1_4__dmy0 @TEXT("",key="model");
// #RGPP1_5__dmy0 @SET-SYMBOL $RESISTOR;
// #RGPP1_5__dmy0 @PLACE(335,-114) => @ORIENT("R90");
// #RGPP1_5__dmy0 @TEXT("RGPP1_5__dmy0",key="name",size=1.3,halign="start") => @PLACE(338,-111);
// #RGPP1_5__dmy0 @TEXT("l=17.13u w=1u multi=(1)",key="value",size=0.9,halign="start") => @PLACE(338,-118);
// #RGPP1_5__dmy0 @TEXT("",key="model");
// (104,-99) @TEXT("GPP / 10 series poly sections",size=0.95,halign="start",textcolor="#223d52");
// &"GNNB" @WIRE(mode="straight",linecolor="#30485d",linewidth=0.16) {#XSTD_GNNCN:1 (61.5,0) (61.5,0) #XSTD_GNNBN:2};
// &"GNNDRV" @WIRE(mode="straight",linecolor="#30485d",linewidth=0.16) {#XSTD_GNNCN:2 (95.5,0) (95.5,0) #RGNN0:1};
// &"GNNA" @WIRE(mode="straight",linecolor="#30485d",linewidth=0.16) {#XSTD_GNNBN:1 (32.5,0) (32.5,0) #XSTD_GNNAN:2};
// &"GNNPRE" @WIRE(mode="straight",linecolor="#30485d",linewidth=0.16) {#XSTD_GNNAN:1 (0.5,0) (0.5,0) #X025:4};
// &"GNPB" @WIRE(mode="straight",linecolor="#30485d",linewidth=0.16) {#XSTD_GNPCN:1 (61.5,-38) (61.5,-38) #XSTD_GNPBN:2};
// &"GNPDRV" @WIRE(mode="straight",linecolor="#30485d",linewidth=0.16) {#XSTD_GNPCN:2 (95.5,-38) (95.5,-38) #RGNP0:1};
// &"GNPA" @WIRE(mode="straight",linecolor="#30485d",linewidth=0.16) {#XSTD_GNPBN:1 (32.5,-38) (32.5,-38) #XSTD_GNPAN:2};
// &"H" @WIRE(mode="straight",linecolor="#30485d",linewidth=0.16) {#XSTD_GNPAN:1 (-6.5,-38) (-6.5,-76) #X008:1};
// &"GPNB" @WIRE(mode="straight",linecolor="#30485d",linewidth=0.16) {#XSTD_GPNCN:1 (61.5,-76) (61.5,-76) #XSTD_GPNBN:2};
// &"GPNDRV" @WIRE(mode="straight",linecolor="#30485d",linewidth=0.16) {#XSTD_GPNCN:2 (95.5,-76) (95.5,-76) #RGPN0:1};
// &"GPNA" @WIRE(mode="straight",linecolor="#30485d",linewidth=0.16) {#XSTD_GPNBN:1 (32.5,-76) (32.5,-76) #XSTD_GPNAN:2};
// &"GPNPRE" @WIRE(mode="straight",linecolor="#30485d",linewidth=0.16) {#XSTD_GPNAN:1 (0.5,-76) (0.5,-76) #X008:4};
// &"GPPB" @WIRE(mode="straight",linecolor="#30485d",linewidth=0.16) {#XSTD_GPPCN:1 (61.5,-114) (61.5,-114) #XSTD_GPPBN:2};
// &"GPPDRV" @WIRE(mode="straight",linecolor="#30485d",linewidth=0.16) {#XSTD_GPPCN:2 (95.5,-114) (95.5,-114) #RGPP0:1};
// &"GPPA" @WIRE(mode="straight",linecolor="#30485d",linewidth=0.16) {#XSTD_GPPBN:1 (32.5,-114) (32.5,-114) #XSTD_GPPAN:2};
// &"GNNRG" @WIRE(mode="straight",linecolor="#30485d",linewidth=0.16) {#RGNN1:1 (222.5,0) (222.5,0) #RGNN0_5__dmy0:2};
// &"RGNN1_1__dmy0" @WIRE(mode="straight",linecolor="#30485d",linewidth=0.16) {#RGNN1:2 (247.5,0) (247.5,0) #RGNN1_2__dmy0:1};
// &"RGNN1_2__dmy0" @WIRE(mode="straight",linecolor="#30485d",linewidth=0.16) {#RGNN1_2__dmy0:2 (272.5,0) (272.5,0) #RGNN1_3__dmy0:1};
// &"RGNN1_3__dmy0" @WIRE(mode="straight",linecolor="#30485d",linewidth=0.16) {#RGNN1_3__dmy0:2 (297.5,0) (297.5,0) #RGNN1_4__dmy0:1};
// &"RGNN1_4__dmy0" @WIRE(mode="straight",linecolor="#30485d",linewidth=0.16) {#RGNN1_4__dmy0:2 (322.5,0) (322.5,0) #RGNN1_5__dmy0:1};
// &"RGNN0_1__dmy0" @WIRE(mode="straight",linecolor="#30485d",linewidth=0.16) {#RGNN0:2 (122.5,0) (122.5,0) #RGNN0_2__dmy0:1};
// &"RGNN0_2__dmy0" @WIRE(mode="straight",linecolor="#30485d",linewidth=0.16) {#RGNN0_2__dmy0:2 (147.5,0) (147.5,0) #RGNN0_3__dmy0:1};
// &"RGNN0_3__dmy0" @WIRE(mode="straight",linecolor="#30485d",linewidth=0.16) {#RGNN0_3__dmy0:2 (172.5,0) (172.5,0) #RGNN0_4__dmy0:1};
// &"RGNN0_4__dmy0" @WIRE(mode="straight",linecolor="#30485d",linewidth=0.16) {#RGNN0_4__dmy0:2 (197.5,0) (197.5,0) #RGNN0_5__dmy0:1};
// &"GNPRG" @WIRE(mode="straight",linecolor="#30485d",linewidth=0.16) {#RGNP1:1 (222.5,-38) (222.5,-38) #RGNP0_5__dmy0:2};
// &"RGNP1_1__dmy0" @WIRE(mode="straight",linecolor="#30485d",linewidth=0.16) {#RGNP1:2 (247.5,-38) (247.5,-38) #RGNP1_2__dmy0:1};
// &"RGNP1_2__dmy0" @WIRE(mode="straight",linecolor="#30485d",linewidth=0.16) {#RGNP1_2__dmy0:2 (272.5,-38) (272.5,-38) #RGNP1_3__dmy0:1};
// &"RGNP1_3__dmy0" @WIRE(mode="straight",linecolor="#30485d",linewidth=0.16) {#RGNP1_3__dmy0:2 (297.5,-38) (297.5,-38) #RGNP1_4__dmy0:1};
// &"RGNP1_4__dmy0" @WIRE(mode="straight",linecolor="#30485d",linewidth=0.16) {#RGNP1_4__dmy0:2 (322.5,-38) (322.5,-38) #RGNP1_5__dmy0:1};
// &"RGNP0_1__dmy0" @WIRE(mode="straight",linecolor="#30485d",linewidth=0.16) {#RGNP0:2 (122.5,-38) (122.5,-38) #RGNP0_2__dmy0:1};
// &"RGNP0_2__dmy0" @WIRE(mode="straight",linecolor="#30485d",linewidth=0.16) {#RGNP0_2__dmy0:2 (147.5,-38) (147.5,-38) #RGNP0_3__dmy0:1};
// &"RGNP0_3__dmy0" @WIRE(mode="straight",linecolor="#30485d",linewidth=0.16) {#RGNP0_3__dmy0:2 (172.5,-38) (172.5,-38) #RGNP0_4__dmy0:1};
// &"RGNP0_4__dmy0" @WIRE(mode="straight",linecolor="#30485d",linewidth=0.16) {#RGNP0_4__dmy0:2 (197.5,-38) (197.5,-38) #RGNP0_5__dmy0:1};
// &"GPNRG" @WIRE(mode="straight",linecolor="#30485d",linewidth=0.16) {#RGPN1:1 (222.5,-76) (222.5,-76) #RGPN0_5__dmy0:2};
// &"RGPN1_1__dmy0" @WIRE(mode="straight",linecolor="#30485d",linewidth=0.16) {#RGPN1:2 (247.5,-76) (247.5,-76) #RGPN1_2__dmy0:1};
// &"RGPN1_2__dmy0" @WIRE(mode="straight",linecolor="#30485d",linewidth=0.16) {#RGPN1_2__dmy0:2 (272.5,-76) (272.5,-76) #RGPN1_3__dmy0:1};
// &"RGPN1_3__dmy0" @WIRE(mode="straight",linecolor="#30485d",linewidth=0.16) {#RGPN1_3__dmy0:2 (297.5,-76) (297.5,-76) #RGPN1_4__dmy0:1};
// &"RGPN1_4__dmy0" @WIRE(mode="straight",linecolor="#30485d",linewidth=0.16) {#RGPN1_4__dmy0:2 (322.5,-76) (322.5,-76) #RGPN1_5__dmy0:1};
// &"RGPN0_1__dmy0" @WIRE(mode="straight",linecolor="#30485d",linewidth=0.16) {#RGPN0:2 (122.5,-76) (122.5,-76) #RGPN0_2__dmy0:1};
// &"RGPN0_2__dmy0" @WIRE(mode="straight",linecolor="#30485d",linewidth=0.16) {#RGPN0_2__dmy0:2 (147.5,-76) (147.5,-76) #RGPN0_3__dmy0:1};
// &"RGPN0_3__dmy0" @WIRE(mode="straight",linecolor="#30485d",linewidth=0.16) {#RGPN0_3__dmy0:2 (172.5,-76) (172.5,-76) #RGPN0_4__dmy0:1};
// &"RGPN0_4__dmy0" @WIRE(mode="straight",linecolor="#30485d",linewidth=0.16) {#RGPN0_4__dmy0:2 (197.5,-76) (197.5,-76) #RGPN0_5__dmy0:1};
// &"GPPRG" @WIRE(mode="straight",linecolor="#30485d",linewidth=0.16) {#RGPP1:1 (222.5,-114) (222.5,-114) #RGPP0_5__dmy0:2};
// &"RGPP1_1__dmy0" @WIRE(mode="straight",linecolor="#30485d",linewidth=0.16) {#RGPP1:2 (247.5,-114) (247.5,-114) #RGPP1_2__dmy0:1};
// &"RGPP1_2__dmy0" @WIRE(mode="straight",linecolor="#30485d",linewidth=0.16) {#RGPP1_2__dmy0:2 (272.5,-114) (272.5,-114) #RGPP1_3__dmy0:1};
// &"RGPP1_3__dmy0" @WIRE(mode="straight",linecolor="#30485d",linewidth=0.16) {#RGPP1_3__dmy0:2 (297.5,-114) (297.5,-114) #RGPP1_4__dmy0:1};
// &"RGPP1_4__dmy0" @WIRE(mode="straight",linecolor="#30485d",linewidth=0.16) {#RGPP1_4__dmy0:2 (322.5,-114) (322.5,-114) #RGPP1_5__dmy0:1};
// &"RGPP0_1__dmy0" @WIRE(mode="straight",linecolor="#30485d",linewidth=0.16) {#RGPP0:2 (122.5,-114) (122.5,-114) #RGPP0_2__dmy0:1};
// &"RGPP0_2__dmy0" @WIRE(mode="straight",linecolor="#30485d",linewidth=0.16) {#RGPP0_2__dmy0:2 (147.5,-114) (147.5,-114) #RGPP0_3__dmy0:1};
// &"RGPP0_3__dmy0" @WIRE(mode="straight",linecolor="#30485d",linewidth=0.16) {#RGPP0_3__dmy0:2 (172.5,-114) (172.5,-114) #RGPP0_4__dmy0:1};
// &"RGPP0_4__dmy0" @WIRE(mode="straight",linecolor="#30485d",linewidth=0.16) {#RGPP0_4__dmy0:2 (197.5,-114) (197.5,-114) #RGPP0_5__dmy0:1};
// (-28,-148) @TEXT("GP and GN chains keep their source polarity, device sizing and series R; no zero-delay abstraction.",size=1,halign="start",textcolor="#223d52");
// &"VDD" @WIRE(mode="straight",linecolor="#30485d",linewidth=0.16) {#XSTD_GNNCN:3 (76,10)};
// (76,10.4) @TEXT("VDD",size=1.1,halign="middle",valign="bottom");
// &"VSS" @WIRE(mode="straight",linecolor="#30485d",linewidth=0.16) {#XSTD_GNNCN:4 (76,-10)};
// (76,-10.4) @TEXT("VSS",size=1.1,halign="middle",valign="top");
// &"VDD" @WIRE(mode="straight",linecolor="#30485d",linewidth=0.16) {#XSTD_GNNBN:3 (47,10)};
// (47,10.4) @TEXT("VDD",size=1.1,halign="middle",valign="bottom");
// &"VSS" @WIRE(mode="straight",linecolor="#30485d",linewidth=0.16) {#XSTD_GNNBN:4 (47,-10)};
// (47,-10.4) @TEXT("VSS",size=1.1,halign="middle",valign="top");
// &"VDD" @WIRE(mode="straight",linecolor="#30485d",linewidth=0.16) {#XSTD_GNNAN:3 (18,10)};
// (18,10.4) @TEXT("VDD",size=1.1,halign="middle",valign="bottom");
// &"VSS" @WIRE(mode="straight",linecolor="#30485d",linewidth=0.16) {#XSTD_GNNAN:4 (18,-10)};
// (18,-10.4) @TEXT("VSS",size=1.1,halign="middle",valign="top");
// &"VDD" @WIRE(mode="straight",linecolor="#30485d",linewidth=0.16) {#XSTD_GNPCN:3 (76,-28)};
// (76,-27.6) @TEXT("VDD",size=1.1,halign="middle",valign="bottom");
// &"VSS" @WIRE(mode="straight",linecolor="#30485d",linewidth=0.16) {#XSTD_GNPCN:4 (76,-48)};
// (76,-48.4) @TEXT("VSS",size=1.1,halign="middle",valign="top");
// &"VDD" @WIRE(mode="straight",linecolor="#30485d",linewidth=0.16) {#XSTD_GNPBN:3 (47,-28)};
// (47,-27.6) @TEXT("VDD",size=1.1,halign="middle",valign="bottom");
// &"VSS" @WIRE(mode="straight",linecolor="#30485d",linewidth=0.16) {#XSTD_GNPBN:4 (47,-48)};
// (47,-48.4) @TEXT("VSS",size=1.1,halign="middle",valign="top");
// &"VDD" @WIRE(mode="straight",linecolor="#30485d",linewidth=0.16) {#XSTD_GNPAN:3 (18,-28)};
// (18,-27.6) @TEXT("VDD",size=1.1,halign="middle",valign="bottom");
// &"VSS" @WIRE(mode="straight",linecolor="#30485d",linewidth=0.16) {#XSTD_GNPAN:4 (18,-48)};
// (18,-48.4) @TEXT("VSS",size=1.1,halign="middle",valign="top");
// &"VDD" @WIRE(mode="straight",linecolor="#30485d",linewidth=0.16) {#XSTD_GPNCN:3 (76,-66)};
// (76,-65.6) @TEXT("VDD",size=1.1,halign="middle",valign="bottom");
// &"VSS" @WIRE(mode="straight",linecolor="#30485d",linewidth=0.16) {#XSTD_GPNCN:4 (76,-86)};
// (76,-86.4) @TEXT("VSS",size=1.1,halign="middle",valign="top");
// &"VDD" @WIRE(mode="straight",linecolor="#30485d",linewidth=0.16) {#XSTD_GPNBN:3 (47,-66)};
// (47,-65.6) @TEXT("VDD",size=1.1,halign="middle",valign="bottom");
// &"VSS" @WIRE(mode="straight",linecolor="#30485d",linewidth=0.16) {#XSTD_GPNBN:4 (47,-86)};
// (47,-86.4) @TEXT("VSS",size=1.1,halign="middle",valign="top");
// &"VDD" @WIRE(mode="straight",linecolor="#30485d",linewidth=0.16) {#XSTD_GPNAN:3 (18,-66)};
// (18,-65.6) @TEXT("VDD",size=1.1,halign="middle",valign="bottom");
// &"VSS" @WIRE(mode="straight",linecolor="#30485d",linewidth=0.16) {#XSTD_GPNAN:4 (18,-86)};
// (18,-86.4) @TEXT("VSS",size=1.1,halign="middle",valign="top");
// &"VDD" @WIRE(mode="straight",linecolor="#30485d",linewidth=0.16) {#XSTD_GPPCN:3 (76,-104)};
// (76,-103.6) @TEXT("VDD",size=1.1,halign="middle",valign="bottom");
// &"VSS" @WIRE(mode="straight",linecolor="#30485d",linewidth=0.16) {#XSTD_GPPCN:4 (76,-124)};
// (76,-124.4) @TEXT("VSS",size=1.1,halign="middle",valign="top");
// &"VDD" @WIRE(mode="straight",linecolor="#30485d",linewidth=0.16) {#XSTD_GPPBN:3 (47,-104)};
// (47,-103.6) @TEXT("VDD",size=1.1,halign="middle",valign="bottom");
// &"VSS" @WIRE(mode="straight",linecolor="#30485d",linewidth=0.16) {#XSTD_GPPBN:4 (47,-124)};
// (47,-124.4) @TEXT("VSS",size=1.1,halign="middle",valign="top");
// &"L" @WIRE(mode="straight",linecolor="#30485d",linewidth=0.16) {#XSTD_GPPAN:1 (8,-114)};
// (7.6,-114) @TEXT("L",size=1.1,halign="end",valign="middle");
// &"VDD" @WIRE(mode="straight",linecolor="#30485d",linewidth=0.16) {#XSTD_GPPAN:3 (18,-104)};
// (18,-103.6) @TEXT("VDD",size=1.1,halign="middle",valign="bottom");
// &"VSS" @WIRE(mode="straight",linecolor="#30485d",linewidth=0.16) {#XSTD_GPPAN:4 (18,-124)};
// (18,-124.4) @TEXT("VSS",size=1.1,halign="middle",valign="top");
// &"GNN" @WIRE(mode="straight",linecolor="#30485d",linewidth=0.16) {#RGNN1_5__dmy0:2 (340,0)};
// (340.4,0) @TEXT("GNN",size=1.1,halign="start",valign="middle");
// &"GNP" @WIRE(mode="straight",linecolor="#30485d",linewidth=0.16) {#RGNP1_5__dmy0:2 (340,-38)};
// (340.4,-38) @TEXT("GNP",size=1.1,halign="start",valign="middle");
// &"GPN" @WIRE(mode="straight",linecolor="#30485d",linewidth=0.16) {#RGPN1_5__dmy0:2 (340,-76)};
// (340.4,-76) @TEXT("GPN",size=1.1,halign="start",valign="middle");
// &"GPP" @WIRE(mode="straight",linecolor="#30485d",linewidth=0.16) {#RGPP1_5__dmy0:2 (340,-114)};
// (340.4,-114) @TEXT("GPP",size=1.1,halign="start",valign="middle");
// &"L" @WIRE(mode="straight",linecolor="#30485d",linewidth=0.16) {#X025:1 (-27,0)};
// (-27.4,0) @TEXT("L",size=1.1,halign="end",valign="middle");
// &"VDD" @WIRE(mode="straight",linecolor="#30485d",linewidth=0.16) {#X025:2 (-17,10)};
// (-17,10.4) @TEXT("VDD",size=1.1,halign="middle",valign="bottom");
// &"VSS" @WIRE(mode="straight",linecolor="#30485d",linewidth=0.16) {#X025:3 (-17,-10)};
// (-17,-10.4) @TEXT("VSS",size=1.1,halign="middle",valign="top");
// &"VDD" @WIRE(mode="straight",linecolor="#30485d",linewidth=0.16) {#X008:2 (-17,-66)};
// (-17,-65.6) @TEXT("VDD",size=1.1,halign="middle",valign="bottom");
// &"VSS" @WIRE(mode="straight",linecolor="#30485d",linewidth=0.16) {#X008:3 (-17,-86)};
// (-17,-86.4) @TEXT("VSS",size=1.1,halign="middle",valign="top");
// }
// END SARADC RNL
ends sar8p_refdrv_b5

subckt sar8p_refdrv_b6 GNN GNP GPN GPP H L VDD VSS
    XSTD_GNNCN (GNNB GNNDRV VDD VSS) INVD1BWP12T30P140
    XSTD_GNNBN (GNNA GNNB VDD VSS) INVD1BWP12T30P140
    XSTD_GNNAN (GNNPRE GNNA VDD VSS) INVD1BWP12T30P140
    XSTD_GNPCN (GNPB GNPDRV VDD VSS) INVD1BWP12T30P140
    XSTD_GNPBN (GNPA GNPB VDD VSS) INVD1BWP12T30P140
    XSTD_GNPAN (H GNPA VDD VSS) INVD1BWP12T30P140
    XSTD_GPNCN (GPNB GPNDRV VDD VSS) INVD1BWP12T30P140
    XSTD_GPNBN (GPNA GPNB VDD VSS) INVD1BWP12T30P140
    XSTD_GPNAN (GPNPRE GPNA VDD VSS) INVD1BWP12T30P140
    XSTD_GPPCN (GPPB GPPDRV VDD VSS) INVD1BWP12T30P140
    XSTD_GPPBN (GPPA GPPB VDD VSS) INVD1BWP12T30P140
    XSTD_GPPAN (L GPPA VDD VSS) INVD1BWP12T30P140
//Series configuration of RGNN1
RGNN1  (GNNRG RGNN1_1__dmy0 ) rupolym l=17.13u w=1u m=64 multi=(1)
RGNN1_2__dmy0  (RGNN1_1__dmy0 RGNN1_2__dmy0 ) rupolym l=17.13u w=1u m=64 \
        multi=(1)
RGNN1_3__dmy0  (RGNN1_2__dmy0 RGNN1_3__dmy0 ) rupolym l=17.13u w=1u m=64 \
        multi=(1)
RGNN1_4__dmy0  (RGNN1_3__dmy0 RGNN1_4__dmy0 ) rupolym l=17.13u w=1u m=64 \
        multi=(1)
RGNN1_5__dmy0  (RGNN1_4__dmy0 GNN ) rupolym l=17.13u w=1u m=64 multi=(1)
//End of RGNN1

//Series configuration of RGNN0
RGNN0  (GNNDRV RGNN0_1__dmy0 ) rupolym l=17.13u w=1u m=64 multi=(1)
RGNN0_2__dmy0  (RGNN0_1__dmy0 RGNN0_2__dmy0 ) rupolym l=17.13u w=1u m=64 \
        multi=(1)
RGNN0_3__dmy0  (RGNN0_2__dmy0 RGNN0_3__dmy0 ) rupolym l=17.13u w=1u m=64 \
        multi=(1)
RGNN0_4__dmy0  (RGNN0_3__dmy0 RGNN0_4__dmy0 ) rupolym l=17.13u w=1u m=64 \
        multi=(1)
RGNN0_5__dmy0  (RGNN0_4__dmy0 GNNRG ) rupolym l=17.13u w=1u m=64 multi=(1)
//End of RGNN0

//Series configuration of RGNP1
RGNP1  (GNPRG RGNP1_1__dmy0 ) rupolym l=17.13u w=1u m=64 multi=(1)
RGNP1_2__dmy0  (RGNP1_1__dmy0 RGNP1_2__dmy0 ) rupolym l=17.13u w=1u m=64 \
        multi=(1)
RGNP1_3__dmy0  (RGNP1_2__dmy0 RGNP1_3__dmy0 ) rupolym l=17.13u w=1u m=64 \
        multi=(1)
RGNP1_4__dmy0  (RGNP1_3__dmy0 RGNP1_4__dmy0 ) rupolym l=17.13u w=1u m=64 \
        multi=(1)
RGNP1_5__dmy0  (RGNP1_4__dmy0 GNP ) rupolym l=17.13u w=1u m=64 multi=(1)
//End of RGNP1

//Series configuration of RGNP0
RGNP0  (GNPDRV RGNP0_1__dmy0 ) rupolym l=17.13u w=1u m=64 multi=(1)
RGNP0_2__dmy0  (RGNP0_1__dmy0 RGNP0_2__dmy0 ) rupolym l=17.13u w=1u m=64 \
        multi=(1)
RGNP0_3__dmy0  (RGNP0_2__dmy0 RGNP0_3__dmy0 ) rupolym l=17.13u w=1u m=64 \
        multi=(1)
RGNP0_4__dmy0  (RGNP0_3__dmy0 RGNP0_4__dmy0 ) rupolym l=17.13u w=1u m=64 \
        multi=(1)
RGNP0_5__dmy0  (RGNP0_4__dmy0 GNPRG ) rupolym l=17.13u w=1u m=64 multi=(1)
//End of RGNP0

//Series configuration of RGPN1
RGPN1  (GPNRG RGPN1_1__dmy0 ) rupolym l=17.13u w=1u m=64 multi=(1)
RGPN1_2__dmy0  (RGPN1_1__dmy0 RGPN1_2__dmy0 ) rupolym l=17.13u w=1u m=64 \
        multi=(1)
RGPN1_3__dmy0  (RGPN1_2__dmy0 RGPN1_3__dmy0 ) rupolym l=17.13u w=1u m=64 \
        multi=(1)
RGPN1_4__dmy0  (RGPN1_3__dmy0 RGPN1_4__dmy0 ) rupolym l=17.13u w=1u m=64 \
        multi=(1)
RGPN1_5__dmy0  (RGPN1_4__dmy0 GPN ) rupolym l=17.13u w=1u m=64 multi=(1)
//End of RGPN1

//Series configuration of RGPN0
RGPN0  (GPNDRV RGPN0_1__dmy0 ) rupolym l=17.13u w=1u m=64 multi=(1)
RGPN0_2__dmy0  (RGPN0_1__dmy0 RGPN0_2__dmy0 ) rupolym l=17.13u w=1u m=64 \
        multi=(1)
RGPN0_3__dmy0  (RGPN0_2__dmy0 RGPN0_3__dmy0 ) rupolym l=17.13u w=1u m=64 \
        multi=(1)
RGPN0_4__dmy0  (RGPN0_3__dmy0 RGPN0_4__dmy0 ) rupolym l=17.13u w=1u m=64 \
        multi=(1)
RGPN0_5__dmy0  (RGPN0_4__dmy0 GPNRG ) rupolym l=17.13u w=1u m=64 multi=(1)
//End of RGPN0

//Series configuration of RGPP1
RGPP1  (GPPRG RGPP1_1__dmy0 ) rupolym l=17.13u w=1u m=64 multi=(1)
RGPP1_2__dmy0  (RGPP1_1__dmy0 RGPP1_2__dmy0 ) rupolym l=17.13u w=1u m=64 \
        multi=(1)
RGPP1_3__dmy0  (RGPP1_2__dmy0 RGPP1_3__dmy0 ) rupolym l=17.13u w=1u m=64 \
        multi=(1)
RGPP1_4__dmy0  (RGPP1_3__dmy0 RGPP1_4__dmy0 ) rupolym l=17.13u w=1u m=64 \
        multi=(1)
RGPP1_5__dmy0  (RGPP1_4__dmy0 GPP ) rupolym l=17.13u w=1u m=64 multi=(1)
//End of RGPP1

//Series configuration of RGPP0
RGPP0  (GPPDRV RGPP0_1__dmy0 ) rupolym l=17.13u w=1u m=64 multi=(1)
RGPP0_2__dmy0  (RGPP0_1__dmy0 RGPP0_2__dmy0 ) rupolym l=17.13u w=1u m=64 \
        multi=(1)
RGPP0_3__dmy0  (RGPP0_2__dmy0 RGPP0_3__dmy0 ) rupolym l=17.13u w=1u m=64 \
        multi=(1)
RGPP0_4__dmy0  (RGPP0_3__dmy0 RGPP0_4__dmy0 ) rupolym l=17.13u w=1u m=64 \
        multi=(1)
RGPP0_5__dmy0  (RGPP0_4__dmy0 GPPRG ) rupolym l=17.13u w=1u m=64 multi=(1)
//End of RGPP0

    X025 (L VDD VSS GNNPRE) sar8p_inv
    X008 (H VDD VSS GPNPRE) sar8p_inv
// BEGIN SARADC RNL
// @RNL(author="saradc topology") {
// (-28,27) @TEXT("sar8p_refdrv_b6 / four physical gate-driver chains",size=1.5,halign="start",textcolor="#223d52");
// #X025 @SET-SYMBOL $S_sar8p_inv;
// #X025 @PLACE(-17,0) => @ORIENT("R0");
// #XSTD_GNNAN @SET-SYMBOL $S_INVD1BWP12T30P140;
// #XSTD_GNNAN @PLACE(18,0) => @ORIENT("R0");
// #XSTD_GNNBN @SET-SYMBOL $S_INVD1BWP12T30P140;
// #XSTD_GNNBN @PLACE(47,0) => @ORIENT("R0");
// #XSTD_GNNCN @SET-SYMBOL $S_INVD1BWP12T30P140;
// #XSTD_GNNCN @PLACE(76,0) => @ORIENT("R0");
// #RGNN0 @SET-SYMBOL $RESISTOR;
// #RGNN0 @PLACE(110,0) => @ORIENT("R90");
// #RGNN0 @TEXT("RGNN0",key="name",size=1.3,halign="start") => @PLACE(113,3);
// #RGNN0 @TEXT("l=17.13u w=1u multi=(1)",key="value",size=0.9,halign="start") => @PLACE(113,-4);
// #RGNN0 @TEXT("",key="model");
// #RGNN0_2__dmy0 @SET-SYMBOL $RESISTOR;
// #RGNN0_2__dmy0 @PLACE(135,0) => @ORIENT("R90");
// #RGNN0_2__dmy0 @TEXT("RGNN0_2__dmy0",key="name",size=1.3,halign="start") => @PLACE(138,3);
// #RGNN0_2__dmy0 @TEXT("l=17.13u w=1u multi=(1)",key="value",size=0.9,halign="start") => @PLACE(138,-4);
// #RGNN0_2__dmy0 @TEXT("",key="model");
// #RGNN0_3__dmy0 @SET-SYMBOL $RESISTOR;
// #RGNN0_3__dmy0 @PLACE(160,0) => @ORIENT("R90");
// #RGNN0_3__dmy0 @TEXT("RGNN0_3__dmy0",key="name",size=1.3,halign="start") => @PLACE(163,3);
// #RGNN0_3__dmy0 @TEXT("l=17.13u w=1u multi=(1)",key="value",size=0.9,halign="start") => @PLACE(163,-4);
// #RGNN0_3__dmy0 @TEXT("",key="model");
// #RGNN0_4__dmy0 @SET-SYMBOL $RESISTOR;
// #RGNN0_4__dmy0 @PLACE(185,0) => @ORIENT("R90");
// #RGNN0_4__dmy0 @TEXT("RGNN0_4__dmy0",key="name",size=1.3,halign="start") => @PLACE(188,3);
// #RGNN0_4__dmy0 @TEXT("l=17.13u w=1u multi=(1)",key="value",size=0.9,halign="start") => @PLACE(188,-4);
// #RGNN0_4__dmy0 @TEXT("",key="model");
// #RGNN0_5__dmy0 @SET-SYMBOL $RESISTOR;
// #RGNN0_5__dmy0 @PLACE(210,0) => @ORIENT("R90");
// #RGNN0_5__dmy0 @TEXT("RGNN0_5__dmy0",key="name",size=1.3,halign="start") => @PLACE(213,3);
// #RGNN0_5__dmy0 @TEXT("l=17.13u w=1u multi=(1)",key="value",size=0.9,halign="start") => @PLACE(213,-4);
// #RGNN0_5__dmy0 @TEXT("",key="model");
// #RGNN1 @SET-SYMBOL $RESISTOR;
// #RGNN1 @PLACE(235,0) => @ORIENT("R90");
// #RGNN1 @TEXT("RGNN1",key="name",size=1.3,halign="start") => @PLACE(238,3);
// #RGNN1 @TEXT("l=17.13u w=1u multi=(1)",key="value",size=0.9,halign="start") => @PLACE(238,-4);
// #RGNN1 @TEXT("",key="model");
// #RGNN1_2__dmy0 @SET-SYMBOL $RESISTOR;
// #RGNN1_2__dmy0 @PLACE(260,0) => @ORIENT("R90");
// #RGNN1_2__dmy0 @TEXT("RGNN1_2__dmy0",key="name",size=1.3,halign="start") => @PLACE(263,3);
// #RGNN1_2__dmy0 @TEXT("l=17.13u w=1u multi=(1)",key="value",size=0.9,halign="start") => @PLACE(263,-4);
// #RGNN1_2__dmy0 @TEXT("",key="model");
// #RGNN1_3__dmy0 @SET-SYMBOL $RESISTOR;
// #RGNN1_3__dmy0 @PLACE(285,0) => @ORIENT("R90");
// #RGNN1_3__dmy0 @TEXT("RGNN1_3__dmy0",key="name",size=1.3,halign="start") => @PLACE(288,3);
// #RGNN1_3__dmy0 @TEXT("l=17.13u w=1u multi=(1)",key="value",size=0.9,halign="start") => @PLACE(288,-4);
// #RGNN1_3__dmy0 @TEXT("",key="model");
// #RGNN1_4__dmy0 @SET-SYMBOL $RESISTOR;
// #RGNN1_4__dmy0 @PLACE(310,0) => @ORIENT("R90");
// #RGNN1_4__dmy0 @TEXT("RGNN1_4__dmy0",key="name",size=1.3,halign="start") => @PLACE(313,3);
// #RGNN1_4__dmy0 @TEXT("l=17.13u w=1u multi=(1)",key="value",size=0.9,halign="start") => @PLACE(313,-4);
// #RGNN1_4__dmy0 @TEXT("",key="model");
// #RGNN1_5__dmy0 @SET-SYMBOL $RESISTOR;
// #RGNN1_5__dmy0 @PLACE(335,0) => @ORIENT("R90");
// #RGNN1_5__dmy0 @TEXT("RGNN1_5__dmy0",key="name",size=1.3,halign="start") => @PLACE(338,3);
// #RGNN1_5__dmy0 @TEXT("l=17.13u w=1u multi=(1)",key="value",size=0.9,halign="start") => @PLACE(338,-4);
// #RGNN1_5__dmy0 @TEXT("",key="model");
// (104,15) @TEXT("GNN / 10 series poly sections",size=0.95,halign="start",textcolor="#223d52");
// #XSTD_GNPAN @SET-SYMBOL $S_INVD1BWP12T30P140;
// #XSTD_GNPAN @PLACE(18,-38) => @ORIENT("R0");
// #XSTD_GNPBN @SET-SYMBOL $S_INVD1BWP12T30P140;
// #XSTD_GNPBN @PLACE(47,-38) => @ORIENT("R0");
// #XSTD_GNPCN @SET-SYMBOL $S_INVD1BWP12T30P140;
// #XSTD_GNPCN @PLACE(76,-38) => @ORIENT("R0");
// #RGNP0 @SET-SYMBOL $RESISTOR;
// #RGNP0 @PLACE(110,-38) => @ORIENT("R90");
// #RGNP0 @TEXT("RGNP0",key="name",size=1.3,halign="start") => @PLACE(113,-35);
// #RGNP0 @TEXT("l=17.13u w=1u multi=(1)",key="value",size=0.9,halign="start") => @PLACE(113,-42);
// #RGNP0 @TEXT("",key="model");
// #RGNP0_2__dmy0 @SET-SYMBOL $RESISTOR;
// #RGNP0_2__dmy0 @PLACE(135,-38) => @ORIENT("R90");
// #RGNP0_2__dmy0 @TEXT("RGNP0_2__dmy0",key="name",size=1.3,halign="start") => @PLACE(138,-35);
// #RGNP0_2__dmy0 @TEXT("l=17.13u w=1u multi=(1)",key="value",size=0.9,halign="start") => @PLACE(138,-42);
// #RGNP0_2__dmy0 @TEXT("",key="model");
// #RGNP0_3__dmy0 @SET-SYMBOL $RESISTOR;
// #RGNP0_3__dmy0 @PLACE(160,-38) => @ORIENT("R90");
// #RGNP0_3__dmy0 @TEXT("RGNP0_3__dmy0",key="name",size=1.3,halign="start") => @PLACE(163,-35);
// #RGNP0_3__dmy0 @TEXT("l=17.13u w=1u multi=(1)",key="value",size=0.9,halign="start") => @PLACE(163,-42);
// #RGNP0_3__dmy0 @TEXT("",key="model");
// #RGNP0_4__dmy0 @SET-SYMBOL $RESISTOR;
// #RGNP0_4__dmy0 @PLACE(185,-38) => @ORIENT("R90");
// #RGNP0_4__dmy0 @TEXT("RGNP0_4__dmy0",key="name",size=1.3,halign="start") => @PLACE(188,-35);
// #RGNP0_4__dmy0 @TEXT("l=17.13u w=1u multi=(1)",key="value",size=0.9,halign="start") => @PLACE(188,-42);
// #RGNP0_4__dmy0 @TEXT("",key="model");
// #RGNP0_5__dmy0 @SET-SYMBOL $RESISTOR;
// #RGNP0_5__dmy0 @PLACE(210,-38) => @ORIENT("R90");
// #RGNP0_5__dmy0 @TEXT("RGNP0_5__dmy0",key="name",size=1.3,halign="start") => @PLACE(213,-35);
// #RGNP0_5__dmy0 @TEXT("l=17.13u w=1u multi=(1)",key="value",size=0.9,halign="start") => @PLACE(213,-42);
// #RGNP0_5__dmy0 @TEXT("",key="model");
// #RGNP1 @SET-SYMBOL $RESISTOR;
// #RGNP1 @PLACE(235,-38) => @ORIENT("R90");
// #RGNP1 @TEXT("RGNP1",key="name",size=1.3,halign="start") => @PLACE(238,-35);
// #RGNP1 @TEXT("l=17.13u w=1u multi=(1)",key="value",size=0.9,halign="start") => @PLACE(238,-42);
// #RGNP1 @TEXT("",key="model");
// #RGNP1_2__dmy0 @SET-SYMBOL $RESISTOR;
// #RGNP1_2__dmy0 @PLACE(260,-38) => @ORIENT("R90");
// #RGNP1_2__dmy0 @TEXT("RGNP1_2__dmy0",key="name",size=1.3,halign="start") => @PLACE(263,-35);
// #RGNP1_2__dmy0 @TEXT("l=17.13u w=1u multi=(1)",key="value",size=0.9,halign="start") => @PLACE(263,-42);
// #RGNP1_2__dmy0 @TEXT("",key="model");
// #RGNP1_3__dmy0 @SET-SYMBOL $RESISTOR;
// #RGNP1_3__dmy0 @PLACE(285,-38) => @ORIENT("R90");
// #RGNP1_3__dmy0 @TEXT("RGNP1_3__dmy0",key="name",size=1.3,halign="start") => @PLACE(288,-35);
// #RGNP1_3__dmy0 @TEXT("l=17.13u w=1u multi=(1)",key="value",size=0.9,halign="start") => @PLACE(288,-42);
// #RGNP1_3__dmy0 @TEXT("",key="model");
// #RGNP1_4__dmy0 @SET-SYMBOL $RESISTOR;
// #RGNP1_4__dmy0 @PLACE(310,-38) => @ORIENT("R90");
// #RGNP1_4__dmy0 @TEXT("RGNP1_4__dmy0",key="name",size=1.3,halign="start") => @PLACE(313,-35);
// #RGNP1_4__dmy0 @TEXT("l=17.13u w=1u multi=(1)",key="value",size=0.9,halign="start") => @PLACE(313,-42);
// #RGNP1_4__dmy0 @TEXT("",key="model");
// #RGNP1_5__dmy0 @SET-SYMBOL $RESISTOR;
// #RGNP1_5__dmy0 @PLACE(335,-38) => @ORIENT("R90");
// #RGNP1_5__dmy0 @TEXT("RGNP1_5__dmy0",key="name",size=1.3,halign="start") => @PLACE(338,-35);
// #RGNP1_5__dmy0 @TEXT("l=17.13u w=1u multi=(1)",key="value",size=0.9,halign="start") => @PLACE(338,-42);
// #RGNP1_5__dmy0 @TEXT("",key="model");
// (104,-23) @TEXT("GNP / 10 series poly sections",size=0.95,halign="start",textcolor="#223d52");
// #X008 @SET-SYMBOL $S_sar8p_inv;
// #X008 @PLACE(-17,-76) => @ORIENT("R0");
// #XSTD_GPNAN @SET-SYMBOL $S_INVD1BWP12T30P140;
// #XSTD_GPNAN @PLACE(18,-76) => @ORIENT("R0");
// #XSTD_GPNBN @SET-SYMBOL $S_INVD1BWP12T30P140;
// #XSTD_GPNBN @PLACE(47,-76) => @ORIENT("R0");
// #XSTD_GPNCN @SET-SYMBOL $S_INVD1BWP12T30P140;
// #XSTD_GPNCN @PLACE(76,-76) => @ORIENT("R0");
// #RGPN0 @SET-SYMBOL $RESISTOR;
// #RGPN0 @PLACE(110,-76) => @ORIENT("R90");
// #RGPN0 @TEXT("RGPN0",key="name",size=1.3,halign="start") => @PLACE(113,-73);
// #RGPN0 @TEXT("l=17.13u w=1u multi=(1)",key="value",size=0.9,halign="start") => @PLACE(113,-80);
// #RGPN0 @TEXT("",key="model");
// #RGPN0_2__dmy0 @SET-SYMBOL $RESISTOR;
// #RGPN0_2__dmy0 @PLACE(135,-76) => @ORIENT("R90");
// #RGPN0_2__dmy0 @TEXT("RGPN0_2__dmy0",key="name",size=1.3,halign="start") => @PLACE(138,-73);
// #RGPN0_2__dmy0 @TEXT("l=17.13u w=1u multi=(1)",key="value",size=0.9,halign="start") => @PLACE(138,-80);
// #RGPN0_2__dmy0 @TEXT("",key="model");
// #RGPN0_3__dmy0 @SET-SYMBOL $RESISTOR;
// #RGPN0_3__dmy0 @PLACE(160,-76) => @ORIENT("R90");
// #RGPN0_3__dmy0 @TEXT("RGPN0_3__dmy0",key="name",size=1.3,halign="start") => @PLACE(163,-73);
// #RGPN0_3__dmy0 @TEXT("l=17.13u w=1u multi=(1)",key="value",size=0.9,halign="start") => @PLACE(163,-80);
// #RGPN0_3__dmy0 @TEXT("",key="model");
// #RGPN0_4__dmy0 @SET-SYMBOL $RESISTOR;
// #RGPN0_4__dmy0 @PLACE(185,-76) => @ORIENT("R90");
// #RGPN0_4__dmy0 @TEXT("RGPN0_4__dmy0",key="name",size=1.3,halign="start") => @PLACE(188,-73);
// #RGPN0_4__dmy0 @TEXT("l=17.13u w=1u multi=(1)",key="value",size=0.9,halign="start") => @PLACE(188,-80);
// #RGPN0_4__dmy0 @TEXT("",key="model");
// #RGPN0_5__dmy0 @SET-SYMBOL $RESISTOR;
// #RGPN0_5__dmy0 @PLACE(210,-76) => @ORIENT("R90");
// #RGPN0_5__dmy0 @TEXT("RGPN0_5__dmy0",key="name",size=1.3,halign="start") => @PLACE(213,-73);
// #RGPN0_5__dmy0 @TEXT("l=17.13u w=1u multi=(1)",key="value",size=0.9,halign="start") => @PLACE(213,-80);
// #RGPN0_5__dmy0 @TEXT("",key="model");
// #RGPN1 @SET-SYMBOL $RESISTOR;
// #RGPN1 @PLACE(235,-76) => @ORIENT("R90");
// #RGPN1 @TEXT("RGPN1",key="name",size=1.3,halign="start") => @PLACE(238,-73);
// #RGPN1 @TEXT("l=17.13u w=1u multi=(1)",key="value",size=0.9,halign="start") => @PLACE(238,-80);
// #RGPN1 @TEXT("",key="model");
// #RGPN1_2__dmy0 @SET-SYMBOL $RESISTOR;
// #RGPN1_2__dmy0 @PLACE(260,-76) => @ORIENT("R90");
// #RGPN1_2__dmy0 @TEXT("RGPN1_2__dmy0",key="name",size=1.3,halign="start") => @PLACE(263,-73);
// #RGPN1_2__dmy0 @TEXT("l=17.13u w=1u multi=(1)",key="value",size=0.9,halign="start") => @PLACE(263,-80);
// #RGPN1_2__dmy0 @TEXT("",key="model");
// #RGPN1_3__dmy0 @SET-SYMBOL $RESISTOR;
// #RGPN1_3__dmy0 @PLACE(285,-76) => @ORIENT("R90");
// #RGPN1_3__dmy0 @TEXT("RGPN1_3__dmy0",key="name",size=1.3,halign="start") => @PLACE(288,-73);
// #RGPN1_3__dmy0 @TEXT("l=17.13u w=1u multi=(1)",key="value",size=0.9,halign="start") => @PLACE(288,-80);
// #RGPN1_3__dmy0 @TEXT("",key="model");
// #RGPN1_4__dmy0 @SET-SYMBOL $RESISTOR;
// #RGPN1_4__dmy0 @PLACE(310,-76) => @ORIENT("R90");
// #RGPN1_4__dmy0 @TEXT("RGPN1_4__dmy0",key="name",size=1.3,halign="start") => @PLACE(313,-73);
// #RGPN1_4__dmy0 @TEXT("l=17.13u w=1u multi=(1)",key="value",size=0.9,halign="start") => @PLACE(313,-80);
// #RGPN1_4__dmy0 @TEXT("",key="model");
// #RGPN1_5__dmy0 @SET-SYMBOL $RESISTOR;
// #RGPN1_5__dmy0 @PLACE(335,-76) => @ORIENT("R90");
// #RGPN1_5__dmy0 @TEXT("RGPN1_5__dmy0",key="name",size=1.3,halign="start") => @PLACE(338,-73);
// #RGPN1_5__dmy0 @TEXT("l=17.13u w=1u multi=(1)",key="value",size=0.9,halign="start") => @PLACE(338,-80);
// #RGPN1_5__dmy0 @TEXT("",key="model");
// (104,-61) @TEXT("GPN / 10 series poly sections",size=0.95,halign="start",textcolor="#223d52");
// #XSTD_GPPAN @SET-SYMBOL $S_INVD1BWP12T30P140;
// #XSTD_GPPAN @PLACE(18,-114) => @ORIENT("R0");
// #XSTD_GPPBN @SET-SYMBOL $S_INVD1BWP12T30P140;
// #XSTD_GPPBN @PLACE(47,-114) => @ORIENT("R0");
// #XSTD_GPPCN @SET-SYMBOL $S_INVD1BWP12T30P140;
// #XSTD_GPPCN @PLACE(76,-114) => @ORIENT("R0");
// #RGPP0 @SET-SYMBOL $RESISTOR;
// #RGPP0 @PLACE(110,-114) => @ORIENT("R90");
// #RGPP0 @TEXT("RGPP0",key="name",size=1.3,halign="start") => @PLACE(113,-111);
// #RGPP0 @TEXT("l=17.13u w=1u multi=(1)",key="value",size=0.9,halign="start") => @PLACE(113,-118);
// #RGPP0 @TEXT("",key="model");
// #RGPP0_2__dmy0 @SET-SYMBOL $RESISTOR;
// #RGPP0_2__dmy0 @PLACE(135,-114) => @ORIENT("R90");
// #RGPP0_2__dmy0 @TEXT("RGPP0_2__dmy0",key="name",size=1.3,halign="start") => @PLACE(138,-111);
// #RGPP0_2__dmy0 @TEXT("l=17.13u w=1u multi=(1)",key="value",size=0.9,halign="start") => @PLACE(138,-118);
// #RGPP0_2__dmy0 @TEXT("",key="model");
// #RGPP0_3__dmy0 @SET-SYMBOL $RESISTOR;
// #RGPP0_3__dmy0 @PLACE(160,-114) => @ORIENT("R90");
// #RGPP0_3__dmy0 @TEXT("RGPP0_3__dmy0",key="name",size=1.3,halign="start") => @PLACE(163,-111);
// #RGPP0_3__dmy0 @TEXT("l=17.13u w=1u multi=(1)",key="value",size=0.9,halign="start") => @PLACE(163,-118);
// #RGPP0_3__dmy0 @TEXT("",key="model");
// #RGPP0_4__dmy0 @SET-SYMBOL $RESISTOR;
// #RGPP0_4__dmy0 @PLACE(185,-114) => @ORIENT("R90");
// #RGPP0_4__dmy0 @TEXT("RGPP0_4__dmy0",key="name",size=1.3,halign="start") => @PLACE(188,-111);
// #RGPP0_4__dmy0 @TEXT("l=17.13u w=1u multi=(1)",key="value",size=0.9,halign="start") => @PLACE(188,-118);
// #RGPP0_4__dmy0 @TEXT("",key="model");
// #RGPP0_5__dmy0 @SET-SYMBOL $RESISTOR;
// #RGPP0_5__dmy0 @PLACE(210,-114) => @ORIENT("R90");
// #RGPP0_5__dmy0 @TEXT("RGPP0_5__dmy0",key="name",size=1.3,halign="start") => @PLACE(213,-111);
// #RGPP0_5__dmy0 @TEXT("l=17.13u w=1u multi=(1)",key="value",size=0.9,halign="start") => @PLACE(213,-118);
// #RGPP0_5__dmy0 @TEXT("",key="model");
// #RGPP1 @SET-SYMBOL $RESISTOR;
// #RGPP1 @PLACE(235,-114) => @ORIENT("R90");
// #RGPP1 @TEXT("RGPP1",key="name",size=1.3,halign="start") => @PLACE(238,-111);
// #RGPP1 @TEXT("l=17.13u w=1u multi=(1)",key="value",size=0.9,halign="start") => @PLACE(238,-118);
// #RGPP1 @TEXT("",key="model");
// #RGPP1_2__dmy0 @SET-SYMBOL $RESISTOR;
// #RGPP1_2__dmy0 @PLACE(260,-114) => @ORIENT("R90");
// #RGPP1_2__dmy0 @TEXT("RGPP1_2__dmy0",key="name",size=1.3,halign="start") => @PLACE(263,-111);
// #RGPP1_2__dmy0 @TEXT("l=17.13u w=1u multi=(1)",key="value",size=0.9,halign="start") => @PLACE(263,-118);
// #RGPP1_2__dmy0 @TEXT("",key="model");
// #RGPP1_3__dmy0 @SET-SYMBOL $RESISTOR;
// #RGPP1_3__dmy0 @PLACE(285,-114) => @ORIENT("R90");
// #RGPP1_3__dmy0 @TEXT("RGPP1_3__dmy0",key="name",size=1.3,halign="start") => @PLACE(288,-111);
// #RGPP1_3__dmy0 @TEXT("l=17.13u w=1u multi=(1)",key="value",size=0.9,halign="start") => @PLACE(288,-118);
// #RGPP1_3__dmy0 @TEXT("",key="model");
// #RGPP1_4__dmy0 @SET-SYMBOL $RESISTOR;
// #RGPP1_4__dmy0 @PLACE(310,-114) => @ORIENT("R90");
// #RGPP1_4__dmy0 @TEXT("RGPP1_4__dmy0",key="name",size=1.3,halign="start") => @PLACE(313,-111);
// #RGPP1_4__dmy0 @TEXT("l=17.13u w=1u multi=(1)",key="value",size=0.9,halign="start") => @PLACE(313,-118);
// #RGPP1_4__dmy0 @TEXT("",key="model");
// #RGPP1_5__dmy0 @SET-SYMBOL $RESISTOR;
// #RGPP1_5__dmy0 @PLACE(335,-114) => @ORIENT("R90");
// #RGPP1_5__dmy0 @TEXT("RGPP1_5__dmy0",key="name",size=1.3,halign="start") => @PLACE(338,-111);
// #RGPP1_5__dmy0 @TEXT("l=17.13u w=1u multi=(1)",key="value",size=0.9,halign="start") => @PLACE(338,-118);
// #RGPP1_5__dmy0 @TEXT("",key="model");
// (104,-99) @TEXT("GPP / 10 series poly sections",size=0.95,halign="start",textcolor="#223d52");
// &"GNNB" @WIRE(mode="straight",linecolor="#30485d",linewidth=0.16) {#XSTD_GNNCN:1 (61.5,0) (61.5,0) #XSTD_GNNBN:2};
// &"GNNDRV" @WIRE(mode="straight",linecolor="#30485d",linewidth=0.16) {#XSTD_GNNCN:2 (95.5,0) (95.5,0) #RGNN0:1};
// &"GNNA" @WIRE(mode="straight",linecolor="#30485d",linewidth=0.16) {#XSTD_GNNBN:1 (32.5,0) (32.5,0) #XSTD_GNNAN:2};
// &"GNNPRE" @WIRE(mode="straight",linecolor="#30485d",linewidth=0.16) {#XSTD_GNNAN:1 (0.5,0) (0.5,0) #X025:4};
// &"GNPB" @WIRE(mode="straight",linecolor="#30485d",linewidth=0.16) {#XSTD_GNPCN:1 (61.5,-38) (61.5,-38) #XSTD_GNPBN:2};
// &"GNPDRV" @WIRE(mode="straight",linecolor="#30485d",linewidth=0.16) {#XSTD_GNPCN:2 (95.5,-38) (95.5,-38) #RGNP0:1};
// &"GNPA" @WIRE(mode="straight",linecolor="#30485d",linewidth=0.16) {#XSTD_GNPBN:1 (32.5,-38) (32.5,-38) #XSTD_GNPAN:2};
// &"H" @WIRE(mode="straight",linecolor="#30485d",linewidth=0.16) {#XSTD_GNPAN:1 (-6.5,-38) (-6.5,-76) #X008:1};
// &"GPNB" @WIRE(mode="straight",linecolor="#30485d",linewidth=0.16) {#XSTD_GPNCN:1 (61.5,-76) (61.5,-76) #XSTD_GPNBN:2};
// &"GPNDRV" @WIRE(mode="straight",linecolor="#30485d",linewidth=0.16) {#XSTD_GPNCN:2 (95.5,-76) (95.5,-76) #RGPN0:1};
// &"GPNA" @WIRE(mode="straight",linecolor="#30485d",linewidth=0.16) {#XSTD_GPNBN:1 (32.5,-76) (32.5,-76) #XSTD_GPNAN:2};
// &"GPNPRE" @WIRE(mode="straight",linecolor="#30485d",linewidth=0.16) {#XSTD_GPNAN:1 (0.5,-76) (0.5,-76) #X008:4};
// &"GPPB" @WIRE(mode="straight",linecolor="#30485d",linewidth=0.16) {#XSTD_GPPCN:1 (61.5,-114) (61.5,-114) #XSTD_GPPBN:2};
// &"GPPDRV" @WIRE(mode="straight",linecolor="#30485d",linewidth=0.16) {#XSTD_GPPCN:2 (95.5,-114) (95.5,-114) #RGPP0:1};
// &"GPPA" @WIRE(mode="straight",linecolor="#30485d",linewidth=0.16) {#XSTD_GPPBN:1 (32.5,-114) (32.5,-114) #XSTD_GPPAN:2};
// &"GNNRG" @WIRE(mode="straight",linecolor="#30485d",linewidth=0.16) {#RGNN1:1 (222.5,0) (222.5,0) #RGNN0_5__dmy0:2};
// &"RGNN1_1__dmy0" @WIRE(mode="straight",linecolor="#30485d",linewidth=0.16) {#RGNN1:2 (247.5,0) (247.5,0) #RGNN1_2__dmy0:1};
// &"RGNN1_2__dmy0" @WIRE(mode="straight",linecolor="#30485d",linewidth=0.16) {#RGNN1_2__dmy0:2 (272.5,0) (272.5,0) #RGNN1_3__dmy0:1};
// &"RGNN1_3__dmy0" @WIRE(mode="straight",linecolor="#30485d",linewidth=0.16) {#RGNN1_3__dmy0:2 (297.5,0) (297.5,0) #RGNN1_4__dmy0:1};
// &"RGNN1_4__dmy0" @WIRE(mode="straight",linecolor="#30485d",linewidth=0.16) {#RGNN1_4__dmy0:2 (322.5,0) (322.5,0) #RGNN1_5__dmy0:1};
// &"RGNN0_1__dmy0" @WIRE(mode="straight",linecolor="#30485d",linewidth=0.16) {#RGNN0:2 (122.5,0) (122.5,0) #RGNN0_2__dmy0:1};
// &"RGNN0_2__dmy0" @WIRE(mode="straight",linecolor="#30485d",linewidth=0.16) {#RGNN0_2__dmy0:2 (147.5,0) (147.5,0) #RGNN0_3__dmy0:1};
// &"RGNN0_3__dmy0" @WIRE(mode="straight",linecolor="#30485d",linewidth=0.16) {#RGNN0_3__dmy0:2 (172.5,0) (172.5,0) #RGNN0_4__dmy0:1};
// &"RGNN0_4__dmy0" @WIRE(mode="straight",linecolor="#30485d",linewidth=0.16) {#RGNN0_4__dmy0:2 (197.5,0) (197.5,0) #RGNN0_5__dmy0:1};
// &"GNPRG" @WIRE(mode="straight",linecolor="#30485d",linewidth=0.16) {#RGNP1:1 (222.5,-38) (222.5,-38) #RGNP0_5__dmy0:2};
// &"RGNP1_1__dmy0" @WIRE(mode="straight",linecolor="#30485d",linewidth=0.16) {#RGNP1:2 (247.5,-38) (247.5,-38) #RGNP1_2__dmy0:1};
// &"RGNP1_2__dmy0" @WIRE(mode="straight",linecolor="#30485d",linewidth=0.16) {#RGNP1_2__dmy0:2 (272.5,-38) (272.5,-38) #RGNP1_3__dmy0:1};
// &"RGNP1_3__dmy0" @WIRE(mode="straight",linecolor="#30485d",linewidth=0.16) {#RGNP1_3__dmy0:2 (297.5,-38) (297.5,-38) #RGNP1_4__dmy0:1};
// &"RGNP1_4__dmy0" @WIRE(mode="straight",linecolor="#30485d",linewidth=0.16) {#RGNP1_4__dmy0:2 (322.5,-38) (322.5,-38) #RGNP1_5__dmy0:1};
// &"RGNP0_1__dmy0" @WIRE(mode="straight",linecolor="#30485d",linewidth=0.16) {#RGNP0:2 (122.5,-38) (122.5,-38) #RGNP0_2__dmy0:1};
// &"RGNP0_2__dmy0" @WIRE(mode="straight",linecolor="#30485d",linewidth=0.16) {#RGNP0_2__dmy0:2 (147.5,-38) (147.5,-38) #RGNP0_3__dmy0:1};
// &"RGNP0_3__dmy0" @WIRE(mode="straight",linecolor="#30485d",linewidth=0.16) {#RGNP0_3__dmy0:2 (172.5,-38) (172.5,-38) #RGNP0_4__dmy0:1};
// &"RGNP0_4__dmy0" @WIRE(mode="straight",linecolor="#30485d",linewidth=0.16) {#RGNP0_4__dmy0:2 (197.5,-38) (197.5,-38) #RGNP0_5__dmy0:1};
// &"GPNRG" @WIRE(mode="straight",linecolor="#30485d",linewidth=0.16) {#RGPN1:1 (222.5,-76) (222.5,-76) #RGPN0_5__dmy0:2};
// &"RGPN1_1__dmy0" @WIRE(mode="straight",linecolor="#30485d",linewidth=0.16) {#RGPN1:2 (247.5,-76) (247.5,-76) #RGPN1_2__dmy0:1};
// &"RGPN1_2__dmy0" @WIRE(mode="straight",linecolor="#30485d",linewidth=0.16) {#RGPN1_2__dmy0:2 (272.5,-76) (272.5,-76) #RGPN1_3__dmy0:1};
// &"RGPN1_3__dmy0" @WIRE(mode="straight",linecolor="#30485d",linewidth=0.16) {#RGPN1_3__dmy0:2 (297.5,-76) (297.5,-76) #RGPN1_4__dmy0:1};
// &"RGPN1_4__dmy0" @WIRE(mode="straight",linecolor="#30485d",linewidth=0.16) {#RGPN1_4__dmy0:2 (322.5,-76) (322.5,-76) #RGPN1_5__dmy0:1};
// &"RGPN0_1__dmy0" @WIRE(mode="straight",linecolor="#30485d",linewidth=0.16) {#RGPN0:2 (122.5,-76) (122.5,-76) #RGPN0_2__dmy0:1};
// &"RGPN0_2__dmy0" @WIRE(mode="straight",linecolor="#30485d",linewidth=0.16) {#RGPN0_2__dmy0:2 (147.5,-76) (147.5,-76) #RGPN0_3__dmy0:1};
// &"RGPN0_3__dmy0" @WIRE(mode="straight",linecolor="#30485d",linewidth=0.16) {#RGPN0_3__dmy0:2 (172.5,-76) (172.5,-76) #RGPN0_4__dmy0:1};
// &"RGPN0_4__dmy0" @WIRE(mode="straight",linecolor="#30485d",linewidth=0.16) {#RGPN0_4__dmy0:2 (197.5,-76) (197.5,-76) #RGPN0_5__dmy0:1};
// &"GPPRG" @WIRE(mode="straight",linecolor="#30485d",linewidth=0.16) {#RGPP1:1 (222.5,-114) (222.5,-114) #RGPP0_5__dmy0:2};
// &"RGPP1_1__dmy0" @WIRE(mode="straight",linecolor="#30485d",linewidth=0.16) {#RGPP1:2 (247.5,-114) (247.5,-114) #RGPP1_2__dmy0:1};
// &"RGPP1_2__dmy0" @WIRE(mode="straight",linecolor="#30485d",linewidth=0.16) {#RGPP1_2__dmy0:2 (272.5,-114) (272.5,-114) #RGPP1_3__dmy0:1};
// &"RGPP1_3__dmy0" @WIRE(mode="straight",linecolor="#30485d",linewidth=0.16) {#RGPP1_3__dmy0:2 (297.5,-114) (297.5,-114) #RGPP1_4__dmy0:1};
// &"RGPP1_4__dmy0" @WIRE(mode="straight",linecolor="#30485d",linewidth=0.16) {#RGPP1_4__dmy0:2 (322.5,-114) (322.5,-114) #RGPP1_5__dmy0:1};
// &"RGPP0_1__dmy0" @WIRE(mode="straight",linecolor="#30485d",linewidth=0.16) {#RGPP0:2 (122.5,-114) (122.5,-114) #RGPP0_2__dmy0:1};
// &"RGPP0_2__dmy0" @WIRE(mode="straight",linecolor="#30485d",linewidth=0.16) {#RGPP0_2__dmy0:2 (147.5,-114) (147.5,-114) #RGPP0_3__dmy0:1};
// &"RGPP0_3__dmy0" @WIRE(mode="straight",linecolor="#30485d",linewidth=0.16) {#RGPP0_3__dmy0:2 (172.5,-114) (172.5,-114) #RGPP0_4__dmy0:1};
// &"RGPP0_4__dmy0" @WIRE(mode="straight",linecolor="#30485d",linewidth=0.16) {#RGPP0_4__dmy0:2 (197.5,-114) (197.5,-114) #RGPP0_5__dmy0:1};
// (-28,-148) @TEXT("GP and GN chains keep their source polarity, device sizing and series R; no zero-delay abstraction.",size=1,halign="start",textcolor="#223d52");
// &"VDD" @WIRE(mode="straight",linecolor="#30485d",linewidth=0.16) {#XSTD_GNNCN:3 (76,10)};
// (76,10.4) @TEXT("VDD",size=1.1,halign="middle",valign="bottom");
// &"VSS" @WIRE(mode="straight",linecolor="#30485d",linewidth=0.16) {#XSTD_GNNCN:4 (76,-10)};
// (76,-10.4) @TEXT("VSS",size=1.1,halign="middle",valign="top");
// &"VDD" @WIRE(mode="straight",linecolor="#30485d",linewidth=0.16) {#XSTD_GNNBN:3 (47,10)};
// (47,10.4) @TEXT("VDD",size=1.1,halign="middle",valign="bottom");
// &"VSS" @WIRE(mode="straight",linecolor="#30485d",linewidth=0.16) {#XSTD_GNNBN:4 (47,-10)};
// (47,-10.4) @TEXT("VSS",size=1.1,halign="middle",valign="top");
// &"VDD" @WIRE(mode="straight",linecolor="#30485d",linewidth=0.16) {#XSTD_GNNAN:3 (18,10)};
// (18,10.4) @TEXT("VDD",size=1.1,halign="middle",valign="bottom");
// &"VSS" @WIRE(mode="straight",linecolor="#30485d",linewidth=0.16) {#XSTD_GNNAN:4 (18,-10)};
// (18,-10.4) @TEXT("VSS",size=1.1,halign="middle",valign="top");
// &"VDD" @WIRE(mode="straight",linecolor="#30485d",linewidth=0.16) {#XSTD_GNPCN:3 (76,-28)};
// (76,-27.6) @TEXT("VDD",size=1.1,halign="middle",valign="bottom");
// &"VSS" @WIRE(mode="straight",linecolor="#30485d",linewidth=0.16) {#XSTD_GNPCN:4 (76,-48)};
// (76,-48.4) @TEXT("VSS",size=1.1,halign="middle",valign="top");
// &"VDD" @WIRE(mode="straight",linecolor="#30485d",linewidth=0.16) {#XSTD_GNPBN:3 (47,-28)};
// (47,-27.6) @TEXT("VDD",size=1.1,halign="middle",valign="bottom");
// &"VSS" @WIRE(mode="straight",linecolor="#30485d",linewidth=0.16) {#XSTD_GNPBN:4 (47,-48)};
// (47,-48.4) @TEXT("VSS",size=1.1,halign="middle",valign="top");
// &"VDD" @WIRE(mode="straight",linecolor="#30485d",linewidth=0.16) {#XSTD_GNPAN:3 (18,-28)};
// (18,-27.6) @TEXT("VDD",size=1.1,halign="middle",valign="bottom");
// &"VSS" @WIRE(mode="straight",linecolor="#30485d",linewidth=0.16) {#XSTD_GNPAN:4 (18,-48)};
// (18,-48.4) @TEXT("VSS",size=1.1,halign="middle",valign="top");
// &"VDD" @WIRE(mode="straight",linecolor="#30485d",linewidth=0.16) {#XSTD_GPNCN:3 (76,-66)};
// (76,-65.6) @TEXT("VDD",size=1.1,halign="middle",valign="bottom");
// &"VSS" @WIRE(mode="straight",linecolor="#30485d",linewidth=0.16) {#XSTD_GPNCN:4 (76,-86)};
// (76,-86.4) @TEXT("VSS",size=1.1,halign="middle",valign="top");
// &"VDD" @WIRE(mode="straight",linecolor="#30485d",linewidth=0.16) {#XSTD_GPNBN:3 (47,-66)};
// (47,-65.6) @TEXT("VDD",size=1.1,halign="middle",valign="bottom");
// &"VSS" @WIRE(mode="straight",linecolor="#30485d",linewidth=0.16) {#XSTD_GPNBN:4 (47,-86)};
// (47,-86.4) @TEXT("VSS",size=1.1,halign="middle",valign="top");
// &"VDD" @WIRE(mode="straight",linecolor="#30485d",linewidth=0.16) {#XSTD_GPNAN:3 (18,-66)};
// (18,-65.6) @TEXT("VDD",size=1.1,halign="middle",valign="bottom");
// &"VSS" @WIRE(mode="straight",linecolor="#30485d",linewidth=0.16) {#XSTD_GPNAN:4 (18,-86)};
// (18,-86.4) @TEXT("VSS",size=1.1,halign="middle",valign="top");
// &"VDD" @WIRE(mode="straight",linecolor="#30485d",linewidth=0.16) {#XSTD_GPPCN:3 (76,-104)};
// (76,-103.6) @TEXT("VDD",size=1.1,halign="middle",valign="bottom");
// &"VSS" @WIRE(mode="straight",linecolor="#30485d",linewidth=0.16) {#XSTD_GPPCN:4 (76,-124)};
// (76,-124.4) @TEXT("VSS",size=1.1,halign="middle",valign="top");
// &"VDD" @WIRE(mode="straight",linecolor="#30485d",linewidth=0.16) {#XSTD_GPPBN:3 (47,-104)};
// (47,-103.6) @TEXT("VDD",size=1.1,halign="middle",valign="bottom");
// &"VSS" @WIRE(mode="straight",linecolor="#30485d",linewidth=0.16) {#XSTD_GPPBN:4 (47,-124)};
// (47,-124.4) @TEXT("VSS",size=1.1,halign="middle",valign="top");
// &"L" @WIRE(mode="straight",linecolor="#30485d",linewidth=0.16) {#XSTD_GPPAN:1 (8,-114)};
// (7.6,-114) @TEXT("L",size=1.1,halign="end",valign="middle");
// &"VDD" @WIRE(mode="straight",linecolor="#30485d",linewidth=0.16) {#XSTD_GPPAN:3 (18,-104)};
// (18,-103.6) @TEXT("VDD",size=1.1,halign="middle",valign="bottom");
// &"VSS" @WIRE(mode="straight",linecolor="#30485d",linewidth=0.16) {#XSTD_GPPAN:4 (18,-124)};
// (18,-124.4) @TEXT("VSS",size=1.1,halign="middle",valign="top");
// &"GNN" @WIRE(mode="straight",linecolor="#30485d",linewidth=0.16) {#RGNN1_5__dmy0:2 (340,0)};
// (340.4,0) @TEXT("GNN",size=1.1,halign="start",valign="middle");
// &"GNP" @WIRE(mode="straight",linecolor="#30485d",linewidth=0.16) {#RGNP1_5__dmy0:2 (340,-38)};
// (340.4,-38) @TEXT("GNP",size=1.1,halign="start",valign="middle");
// &"GPN" @WIRE(mode="straight",linecolor="#30485d",linewidth=0.16) {#RGPN1_5__dmy0:2 (340,-76)};
// (340.4,-76) @TEXT("GPN",size=1.1,halign="start",valign="middle");
// &"GPP" @WIRE(mode="straight",linecolor="#30485d",linewidth=0.16) {#RGPP1_5__dmy0:2 (340,-114)};
// (340.4,-114) @TEXT("GPP",size=1.1,halign="start",valign="middle");
// &"L" @WIRE(mode="straight",linecolor="#30485d",linewidth=0.16) {#X025:1 (-27,0)};
// (-27.4,0) @TEXT("L",size=1.1,halign="end",valign="middle");
// &"VDD" @WIRE(mode="straight",linecolor="#30485d",linewidth=0.16) {#X025:2 (-17,10)};
// (-17,10.4) @TEXT("VDD",size=1.1,halign="middle",valign="bottom");
// &"VSS" @WIRE(mode="straight",linecolor="#30485d",linewidth=0.16) {#X025:3 (-17,-10)};
// (-17,-10.4) @TEXT("VSS",size=1.1,halign="middle",valign="top");
// &"VDD" @WIRE(mode="straight",linecolor="#30485d",linewidth=0.16) {#X008:2 (-17,-66)};
// (-17,-65.6) @TEXT("VDD",size=1.1,halign="middle",valign="bottom");
// &"VSS" @WIRE(mode="straight",linecolor="#30485d",linewidth=0.16) {#X008:3 (-17,-86)};
// (-17,-86.4) @TEXT("VSS",size=1.1,halign="middle",valign="top");
// }
// END SARADC RNL
ends sar8p_refdrv_b6

subckt sar8p_refdrv_b7 GNN GNP GPN GPP H L VDD VSS
    XSTD_GNNCN (GNNB GNNDRV VDD VSS) INVD1BWP12T30P140
    XSTD_GNNBN (GNNA GNNB VDD VSS) INVD1BWP12T30P140
    XSTD_GNNAN (GNNPRE GNNA VDD VSS) INVD1BWP12T30P140
    XSTD_GNPCN (GNPB GNPDRV VDD VSS) INVD1BWP12T30P140
    XSTD_GNPBN (GNPA GNPB VDD VSS) INVD1BWP12T30P140
    XSTD_GNPAN (H GNPA VDD VSS) INVD1BWP12T30P140
    XSTD_GPNCN (GPNB GPNDRV VDD VSS) INVD1BWP12T30P140
    XSTD_GPNBN (GPNA GPNB VDD VSS) INVD1BWP12T30P140
    XSTD_GPNAN (GPNPRE GPNA VDD VSS) INVD1BWP12T30P140
    XSTD_GPPCN (GPPB GPPDRV VDD VSS) INVD1BWP12T30P140
    XSTD_GPPBN (GPPA GPPB VDD VSS) INVD1BWP12T30P140
    XSTD_GPPAN (L GPPA VDD VSS) INVD1BWP12T30P140
//Series configuration of RGNN1
RGNN1  (GNNRG RGNN1_1__dmy0 ) rupolym l=17.13u w=1u m=128 multi=(1)
RGNN1_2__dmy0  (RGNN1_1__dmy0 RGNN1_2__dmy0 ) rupolym l=17.13u w=1u m=128 \
        multi=(1)
RGNN1_3__dmy0  (RGNN1_2__dmy0 RGNN1_3__dmy0 ) rupolym l=17.13u w=1u m=128 \
        multi=(1)
RGNN1_4__dmy0  (RGNN1_3__dmy0 RGNN1_4__dmy0 ) rupolym l=17.13u w=1u m=128 \
        multi=(1)
RGNN1_5__dmy0  (RGNN1_4__dmy0 GNN ) rupolym l=17.13u w=1u m=128 multi=(1)
//End of RGNN1

//Series configuration of RGNN0
RGNN0  (GNNDRV RGNN0_1__dmy0 ) rupolym l=17.13u w=1u m=128 multi=(1)
RGNN0_2__dmy0  (RGNN0_1__dmy0 RGNN0_2__dmy0 ) rupolym l=17.13u w=1u m=128 \
        multi=(1)
RGNN0_3__dmy0  (RGNN0_2__dmy0 RGNN0_3__dmy0 ) rupolym l=17.13u w=1u m=128 \
        multi=(1)
RGNN0_4__dmy0  (RGNN0_3__dmy0 RGNN0_4__dmy0 ) rupolym l=17.13u w=1u m=128 \
        multi=(1)
RGNN0_5__dmy0  (RGNN0_4__dmy0 GNNRG ) rupolym l=17.13u w=1u m=128 \
        multi=(1)
//End of RGNN0

//Series configuration of RGNP1
RGNP1  (GNPRG RGNP1_1__dmy0 ) rupolym l=17.13u w=1u m=128 multi=(1)
RGNP1_2__dmy0  (RGNP1_1__dmy0 RGNP1_2__dmy0 ) rupolym l=17.13u w=1u m=128 \
        multi=(1)
RGNP1_3__dmy0  (RGNP1_2__dmy0 RGNP1_3__dmy0 ) rupolym l=17.13u w=1u m=128 \
        multi=(1)
RGNP1_4__dmy0  (RGNP1_3__dmy0 RGNP1_4__dmy0 ) rupolym l=17.13u w=1u m=128 \
        multi=(1)
RGNP1_5__dmy0  (RGNP1_4__dmy0 GNP ) rupolym l=17.13u w=1u m=128 multi=(1)
//End of RGNP1

//Series configuration of RGNP0
RGNP0  (GNPDRV RGNP0_1__dmy0 ) rupolym l=17.13u w=1u m=128 multi=(1)
RGNP0_2__dmy0  (RGNP0_1__dmy0 RGNP0_2__dmy0 ) rupolym l=17.13u w=1u m=128 \
        multi=(1)
RGNP0_3__dmy0  (RGNP0_2__dmy0 RGNP0_3__dmy0 ) rupolym l=17.13u w=1u m=128 \
        multi=(1)
RGNP0_4__dmy0  (RGNP0_3__dmy0 RGNP0_4__dmy0 ) rupolym l=17.13u w=1u m=128 \
        multi=(1)
RGNP0_5__dmy0  (RGNP0_4__dmy0 GNPRG ) rupolym l=17.13u w=1u m=128 \
        multi=(1)
//End of RGNP0

//Series configuration of RGPN1
RGPN1  (GPNRG RGPN1_1__dmy0 ) rupolym l=17.13u w=1u m=128 multi=(1)
RGPN1_2__dmy0  (RGPN1_1__dmy0 RGPN1_2__dmy0 ) rupolym l=17.13u w=1u m=128 \
        multi=(1)
RGPN1_3__dmy0  (RGPN1_2__dmy0 RGPN1_3__dmy0 ) rupolym l=17.13u w=1u m=128 \
        multi=(1)
RGPN1_4__dmy0  (RGPN1_3__dmy0 RGPN1_4__dmy0 ) rupolym l=17.13u w=1u m=128 \
        multi=(1)
RGPN1_5__dmy0  (RGPN1_4__dmy0 GPN ) rupolym l=17.13u w=1u m=128 multi=(1)
//End of RGPN1

//Series configuration of RGPN0
RGPN0  (GPNDRV RGPN0_1__dmy0 ) rupolym l=17.13u w=1u m=128 multi=(1)
RGPN0_2__dmy0  (RGPN0_1__dmy0 RGPN0_2__dmy0 ) rupolym l=17.13u w=1u m=128 \
        multi=(1)
RGPN0_3__dmy0  (RGPN0_2__dmy0 RGPN0_3__dmy0 ) rupolym l=17.13u w=1u m=128 \
        multi=(1)
RGPN0_4__dmy0  (RGPN0_3__dmy0 RGPN0_4__dmy0 ) rupolym l=17.13u w=1u m=128 \
        multi=(1)
RGPN0_5__dmy0  (RGPN0_4__dmy0 GPNRG ) rupolym l=17.13u w=1u m=128 \
        multi=(1)
//End of RGPN0

//Series configuration of RGPP1
RGPP1  (GPPRG RGPP1_1__dmy0 ) rupolym l=17.13u w=1u m=128 multi=(1)
RGPP1_2__dmy0  (RGPP1_1__dmy0 RGPP1_2__dmy0 ) rupolym l=17.13u w=1u m=128 \
        multi=(1)
RGPP1_3__dmy0  (RGPP1_2__dmy0 RGPP1_3__dmy0 ) rupolym l=17.13u w=1u m=128 \
        multi=(1)
RGPP1_4__dmy0  (RGPP1_3__dmy0 RGPP1_4__dmy0 ) rupolym l=17.13u w=1u m=128 \
        multi=(1)
RGPP1_5__dmy0  (RGPP1_4__dmy0 GPP ) rupolym l=17.13u w=1u m=128 multi=(1)
//End of RGPP1

//Series configuration of RGPP0
RGPP0  (GPPDRV RGPP0_1__dmy0 ) rupolym l=17.13u w=1u m=128 multi=(1)
RGPP0_2__dmy0  (RGPP0_1__dmy0 RGPP0_2__dmy0 ) rupolym l=17.13u w=1u m=128 \
        multi=(1)
RGPP0_3__dmy0  (RGPP0_2__dmy0 RGPP0_3__dmy0 ) rupolym l=17.13u w=1u m=128 \
        multi=(1)
RGPP0_4__dmy0  (RGPP0_3__dmy0 RGPP0_4__dmy0 ) rupolym l=17.13u w=1u m=128 \
        multi=(1)
RGPP0_5__dmy0  (RGPP0_4__dmy0 GPPRG ) rupolym l=17.13u w=1u m=128 \
        multi=(1)
//End of RGPP0

    X025 (L VDD VSS GNNPRE) sar8p_inv
    X008 (H VDD VSS GPNPRE) sar8p_inv
// BEGIN SARADC RNL
// @RNL(author="saradc topology") {
// (-28,27) @TEXT("sar8p_refdrv_b7 / four physical gate-driver chains",size=1.5,halign="start",textcolor="#223d52");
// #X025 @SET-SYMBOL $S_sar8p_inv;
// #X025 @PLACE(-17,0) => @ORIENT("R0");
// #XSTD_GNNAN @SET-SYMBOL $S_INVD1BWP12T30P140;
// #XSTD_GNNAN @PLACE(18,0) => @ORIENT("R0");
// #XSTD_GNNBN @SET-SYMBOL $S_INVD1BWP12T30P140;
// #XSTD_GNNBN @PLACE(47,0) => @ORIENT("R0");
// #XSTD_GNNCN @SET-SYMBOL $S_INVD1BWP12T30P140;
// #XSTD_GNNCN @PLACE(76,0) => @ORIENT("R0");
// #RGNN0 @SET-SYMBOL $RESISTOR;
// #RGNN0 @PLACE(110,0) => @ORIENT("R90");
// #RGNN0 @TEXT("RGNN0",key="name",size=1.3,halign="start") => @PLACE(113,3);
// #RGNN0 @TEXT("l=17.13u w=1u multi=(1)",key="value",size=0.9,halign="start") => @PLACE(113,-4);
// #RGNN0 @TEXT("",key="model");
// #RGNN0_2__dmy0 @SET-SYMBOL $RESISTOR;
// #RGNN0_2__dmy0 @PLACE(135,0) => @ORIENT("R90");
// #RGNN0_2__dmy0 @TEXT("RGNN0_2__dmy0",key="name",size=1.3,halign="start") => @PLACE(138,3);
// #RGNN0_2__dmy0 @TEXT("l=17.13u w=1u multi=(1)",key="value",size=0.9,halign="start") => @PLACE(138,-4);
// #RGNN0_2__dmy0 @TEXT("",key="model");
// #RGNN0_3__dmy0 @SET-SYMBOL $RESISTOR;
// #RGNN0_3__dmy0 @PLACE(160,0) => @ORIENT("R90");
// #RGNN0_3__dmy0 @TEXT("RGNN0_3__dmy0",key="name",size=1.3,halign="start") => @PLACE(163,3);
// #RGNN0_3__dmy0 @TEXT("l=17.13u w=1u multi=(1)",key="value",size=0.9,halign="start") => @PLACE(163,-4);
// #RGNN0_3__dmy0 @TEXT("",key="model");
// #RGNN0_4__dmy0 @SET-SYMBOL $RESISTOR;
// #RGNN0_4__dmy0 @PLACE(185,0) => @ORIENT("R90");
// #RGNN0_4__dmy0 @TEXT("RGNN0_4__dmy0",key="name",size=1.3,halign="start") => @PLACE(188,3);
// #RGNN0_4__dmy0 @TEXT("l=17.13u w=1u multi=(1)",key="value",size=0.9,halign="start") => @PLACE(188,-4);
// #RGNN0_4__dmy0 @TEXT("",key="model");
// #RGNN0_5__dmy0 @SET-SYMBOL $RESISTOR;
// #RGNN0_5__dmy0 @PLACE(210,0) => @ORIENT("R90");
// #RGNN0_5__dmy0 @TEXT("RGNN0_5__dmy0",key="name",size=1.3,halign="start") => @PLACE(213,3);
// #RGNN0_5__dmy0 @TEXT("l=17.13u w=1u multi=(1)",key="value",size=0.9,halign="start") => @PLACE(213,-4);
// #RGNN0_5__dmy0 @TEXT("",key="model");
// #RGNN1 @SET-SYMBOL $RESISTOR;
// #RGNN1 @PLACE(235,0) => @ORIENT("R90");
// #RGNN1 @TEXT("RGNN1",key="name",size=1.3,halign="start") => @PLACE(238,3);
// #RGNN1 @TEXT("l=17.13u w=1u multi=(1)",key="value",size=0.9,halign="start") => @PLACE(238,-4);
// #RGNN1 @TEXT("",key="model");
// #RGNN1_2__dmy0 @SET-SYMBOL $RESISTOR;
// #RGNN1_2__dmy0 @PLACE(260,0) => @ORIENT("R90");
// #RGNN1_2__dmy0 @TEXT("RGNN1_2__dmy0",key="name",size=1.3,halign="start") => @PLACE(263,3);
// #RGNN1_2__dmy0 @TEXT("l=17.13u w=1u multi=(1)",key="value",size=0.9,halign="start") => @PLACE(263,-4);
// #RGNN1_2__dmy0 @TEXT("",key="model");
// #RGNN1_3__dmy0 @SET-SYMBOL $RESISTOR;
// #RGNN1_3__dmy0 @PLACE(285,0) => @ORIENT("R90");
// #RGNN1_3__dmy0 @TEXT("RGNN1_3__dmy0",key="name",size=1.3,halign="start") => @PLACE(288,3);
// #RGNN1_3__dmy0 @TEXT("l=17.13u w=1u multi=(1)",key="value",size=0.9,halign="start") => @PLACE(288,-4);
// #RGNN1_3__dmy0 @TEXT("",key="model");
// #RGNN1_4__dmy0 @SET-SYMBOL $RESISTOR;
// #RGNN1_4__dmy0 @PLACE(310,0) => @ORIENT("R90");
// #RGNN1_4__dmy0 @TEXT("RGNN1_4__dmy0",key="name",size=1.3,halign="start") => @PLACE(313,3);
// #RGNN1_4__dmy0 @TEXT("l=17.13u w=1u multi=(1)",key="value",size=0.9,halign="start") => @PLACE(313,-4);
// #RGNN1_4__dmy0 @TEXT("",key="model");
// #RGNN1_5__dmy0 @SET-SYMBOL $RESISTOR;
// #RGNN1_5__dmy0 @PLACE(335,0) => @ORIENT("R90");
// #RGNN1_5__dmy0 @TEXT("RGNN1_5__dmy0",key="name",size=1.3,halign="start") => @PLACE(338,3);
// #RGNN1_5__dmy0 @TEXT("l=17.13u w=1u multi=(1)",key="value",size=0.9,halign="start") => @PLACE(338,-4);
// #RGNN1_5__dmy0 @TEXT("",key="model");
// (104,15) @TEXT("GNN / 10 series poly sections",size=0.95,halign="start",textcolor="#223d52");
// #XSTD_GNPAN @SET-SYMBOL $S_INVD1BWP12T30P140;
// #XSTD_GNPAN @PLACE(18,-38) => @ORIENT("R0");
// #XSTD_GNPBN @SET-SYMBOL $S_INVD1BWP12T30P140;
// #XSTD_GNPBN @PLACE(47,-38) => @ORIENT("R0");
// #XSTD_GNPCN @SET-SYMBOL $S_INVD1BWP12T30P140;
// #XSTD_GNPCN @PLACE(76,-38) => @ORIENT("R0");
// #RGNP0 @SET-SYMBOL $RESISTOR;
// #RGNP0 @PLACE(110,-38) => @ORIENT("R90");
// #RGNP0 @TEXT("RGNP0",key="name",size=1.3,halign="start") => @PLACE(113,-35);
// #RGNP0 @TEXT("l=17.13u w=1u multi=(1)",key="value",size=0.9,halign="start") => @PLACE(113,-42);
// #RGNP0 @TEXT("",key="model");
// #RGNP0_2__dmy0 @SET-SYMBOL $RESISTOR;
// #RGNP0_2__dmy0 @PLACE(135,-38) => @ORIENT("R90");
// #RGNP0_2__dmy0 @TEXT("RGNP0_2__dmy0",key="name",size=1.3,halign="start") => @PLACE(138,-35);
// #RGNP0_2__dmy0 @TEXT("l=17.13u w=1u multi=(1)",key="value",size=0.9,halign="start") => @PLACE(138,-42);
// #RGNP0_2__dmy0 @TEXT("",key="model");
// #RGNP0_3__dmy0 @SET-SYMBOL $RESISTOR;
// #RGNP0_3__dmy0 @PLACE(160,-38) => @ORIENT("R90");
// #RGNP0_3__dmy0 @TEXT("RGNP0_3__dmy0",key="name",size=1.3,halign="start") => @PLACE(163,-35);
// #RGNP0_3__dmy0 @TEXT("l=17.13u w=1u multi=(1)",key="value",size=0.9,halign="start") => @PLACE(163,-42);
// #RGNP0_3__dmy0 @TEXT("",key="model");
// #RGNP0_4__dmy0 @SET-SYMBOL $RESISTOR;
// #RGNP0_4__dmy0 @PLACE(185,-38) => @ORIENT("R90");
// #RGNP0_4__dmy0 @TEXT("RGNP0_4__dmy0",key="name",size=1.3,halign="start") => @PLACE(188,-35);
// #RGNP0_4__dmy0 @TEXT("l=17.13u w=1u multi=(1)",key="value",size=0.9,halign="start") => @PLACE(188,-42);
// #RGNP0_4__dmy0 @TEXT("",key="model");
// #RGNP0_5__dmy0 @SET-SYMBOL $RESISTOR;
// #RGNP0_5__dmy0 @PLACE(210,-38) => @ORIENT("R90");
// #RGNP0_5__dmy0 @TEXT("RGNP0_5__dmy0",key="name",size=1.3,halign="start") => @PLACE(213,-35);
// #RGNP0_5__dmy0 @TEXT("l=17.13u w=1u multi=(1)",key="value",size=0.9,halign="start") => @PLACE(213,-42);
// #RGNP0_5__dmy0 @TEXT("",key="model");
// #RGNP1 @SET-SYMBOL $RESISTOR;
// #RGNP1 @PLACE(235,-38) => @ORIENT("R90");
// #RGNP1 @TEXT("RGNP1",key="name",size=1.3,halign="start") => @PLACE(238,-35);
// #RGNP1 @TEXT("l=17.13u w=1u multi=(1)",key="value",size=0.9,halign="start") => @PLACE(238,-42);
// #RGNP1 @TEXT("",key="model");
// #RGNP1_2__dmy0 @SET-SYMBOL $RESISTOR;
// #RGNP1_2__dmy0 @PLACE(260,-38) => @ORIENT("R90");
// #RGNP1_2__dmy0 @TEXT("RGNP1_2__dmy0",key="name",size=1.3,halign="start") => @PLACE(263,-35);
// #RGNP1_2__dmy0 @TEXT("l=17.13u w=1u multi=(1)",key="value",size=0.9,halign="start") => @PLACE(263,-42);
// #RGNP1_2__dmy0 @TEXT("",key="model");
// #RGNP1_3__dmy0 @SET-SYMBOL $RESISTOR;
// #RGNP1_3__dmy0 @PLACE(285,-38) => @ORIENT("R90");
// #RGNP1_3__dmy0 @TEXT("RGNP1_3__dmy0",key="name",size=1.3,halign="start") => @PLACE(288,-35);
// #RGNP1_3__dmy0 @TEXT("l=17.13u w=1u multi=(1)",key="value",size=0.9,halign="start") => @PLACE(288,-42);
// #RGNP1_3__dmy0 @TEXT("",key="model");
// #RGNP1_4__dmy0 @SET-SYMBOL $RESISTOR;
// #RGNP1_4__dmy0 @PLACE(310,-38) => @ORIENT("R90");
// #RGNP1_4__dmy0 @TEXT("RGNP1_4__dmy0",key="name",size=1.3,halign="start") => @PLACE(313,-35);
// #RGNP1_4__dmy0 @TEXT("l=17.13u w=1u multi=(1)",key="value",size=0.9,halign="start") => @PLACE(313,-42);
// #RGNP1_4__dmy0 @TEXT("",key="model");
// #RGNP1_5__dmy0 @SET-SYMBOL $RESISTOR;
// #RGNP1_5__dmy0 @PLACE(335,-38) => @ORIENT("R90");
// #RGNP1_5__dmy0 @TEXT("RGNP1_5__dmy0",key="name",size=1.3,halign="start") => @PLACE(338,-35);
// #RGNP1_5__dmy0 @TEXT("l=17.13u w=1u multi=(1)",key="value",size=0.9,halign="start") => @PLACE(338,-42);
// #RGNP1_5__dmy0 @TEXT("",key="model");
// (104,-23) @TEXT("GNP / 10 series poly sections",size=0.95,halign="start",textcolor="#223d52");
// #X008 @SET-SYMBOL $S_sar8p_inv;
// #X008 @PLACE(-17,-76) => @ORIENT("R0");
// #XSTD_GPNAN @SET-SYMBOL $S_INVD1BWP12T30P140;
// #XSTD_GPNAN @PLACE(18,-76) => @ORIENT("R0");
// #XSTD_GPNBN @SET-SYMBOL $S_INVD1BWP12T30P140;
// #XSTD_GPNBN @PLACE(47,-76) => @ORIENT("R0");
// #XSTD_GPNCN @SET-SYMBOL $S_INVD1BWP12T30P140;
// #XSTD_GPNCN @PLACE(76,-76) => @ORIENT("R0");
// #RGPN0 @SET-SYMBOL $RESISTOR;
// #RGPN0 @PLACE(110,-76) => @ORIENT("R90");
// #RGPN0 @TEXT("RGPN0",key="name",size=1.3,halign="start") => @PLACE(113,-73);
// #RGPN0 @TEXT("l=17.13u w=1u multi=(1)",key="value",size=0.9,halign="start") => @PLACE(113,-80);
// #RGPN0 @TEXT("",key="model");
// #RGPN0_2__dmy0 @SET-SYMBOL $RESISTOR;
// #RGPN0_2__dmy0 @PLACE(135,-76) => @ORIENT("R90");
// #RGPN0_2__dmy0 @TEXT("RGPN0_2__dmy0",key="name",size=1.3,halign="start") => @PLACE(138,-73);
// #RGPN0_2__dmy0 @TEXT("l=17.13u w=1u multi=(1)",key="value",size=0.9,halign="start") => @PLACE(138,-80);
// #RGPN0_2__dmy0 @TEXT("",key="model");
// #RGPN0_3__dmy0 @SET-SYMBOL $RESISTOR;
// #RGPN0_3__dmy0 @PLACE(160,-76) => @ORIENT("R90");
// #RGPN0_3__dmy0 @TEXT("RGPN0_3__dmy0",key="name",size=1.3,halign="start") => @PLACE(163,-73);
// #RGPN0_3__dmy0 @TEXT("l=17.13u w=1u multi=(1)",key="value",size=0.9,halign="start") => @PLACE(163,-80);
// #RGPN0_3__dmy0 @TEXT("",key="model");
// #RGPN0_4__dmy0 @SET-SYMBOL $RESISTOR;
// #RGPN0_4__dmy0 @PLACE(185,-76) => @ORIENT("R90");
// #RGPN0_4__dmy0 @TEXT("RGPN0_4__dmy0",key="name",size=1.3,halign="start") => @PLACE(188,-73);
// #RGPN0_4__dmy0 @TEXT("l=17.13u w=1u multi=(1)",key="value",size=0.9,halign="start") => @PLACE(188,-80);
// #RGPN0_4__dmy0 @TEXT("",key="model");
// #RGPN0_5__dmy0 @SET-SYMBOL $RESISTOR;
// #RGPN0_5__dmy0 @PLACE(210,-76) => @ORIENT("R90");
// #RGPN0_5__dmy0 @TEXT("RGPN0_5__dmy0",key="name",size=1.3,halign="start") => @PLACE(213,-73);
// #RGPN0_5__dmy0 @TEXT("l=17.13u w=1u multi=(1)",key="value",size=0.9,halign="start") => @PLACE(213,-80);
// #RGPN0_5__dmy0 @TEXT("",key="model");
// #RGPN1 @SET-SYMBOL $RESISTOR;
// #RGPN1 @PLACE(235,-76) => @ORIENT("R90");
// #RGPN1 @TEXT("RGPN1",key="name",size=1.3,halign="start") => @PLACE(238,-73);
// #RGPN1 @TEXT("l=17.13u w=1u multi=(1)",key="value",size=0.9,halign="start") => @PLACE(238,-80);
// #RGPN1 @TEXT("",key="model");
// #RGPN1_2__dmy0 @SET-SYMBOL $RESISTOR;
// #RGPN1_2__dmy0 @PLACE(260,-76) => @ORIENT("R90");
// #RGPN1_2__dmy0 @TEXT("RGPN1_2__dmy0",key="name",size=1.3,halign="start") => @PLACE(263,-73);
// #RGPN1_2__dmy0 @TEXT("l=17.13u w=1u multi=(1)",key="value",size=0.9,halign="start") => @PLACE(263,-80);
// #RGPN1_2__dmy0 @TEXT("",key="model");
// #RGPN1_3__dmy0 @SET-SYMBOL $RESISTOR;
// #RGPN1_3__dmy0 @PLACE(285,-76) => @ORIENT("R90");
// #RGPN1_3__dmy0 @TEXT("RGPN1_3__dmy0",key="name",size=1.3,halign="start") => @PLACE(288,-73);
// #RGPN1_3__dmy0 @TEXT("l=17.13u w=1u multi=(1)",key="value",size=0.9,halign="start") => @PLACE(288,-80);
// #RGPN1_3__dmy0 @TEXT("",key="model");
// #RGPN1_4__dmy0 @SET-SYMBOL $RESISTOR;
// #RGPN1_4__dmy0 @PLACE(310,-76) => @ORIENT("R90");
// #RGPN1_4__dmy0 @TEXT("RGPN1_4__dmy0",key="name",size=1.3,halign="start") => @PLACE(313,-73);
// #RGPN1_4__dmy0 @TEXT("l=17.13u w=1u multi=(1)",key="value",size=0.9,halign="start") => @PLACE(313,-80);
// #RGPN1_4__dmy0 @TEXT("",key="model");
// #RGPN1_5__dmy0 @SET-SYMBOL $RESISTOR;
// #RGPN1_5__dmy0 @PLACE(335,-76) => @ORIENT("R90");
// #RGPN1_5__dmy0 @TEXT("RGPN1_5__dmy0",key="name",size=1.3,halign="start") => @PLACE(338,-73);
// #RGPN1_5__dmy0 @TEXT("l=17.13u w=1u multi=(1)",key="value",size=0.9,halign="start") => @PLACE(338,-80);
// #RGPN1_5__dmy0 @TEXT("",key="model");
// (104,-61) @TEXT("GPN / 10 series poly sections",size=0.95,halign="start",textcolor="#223d52");
// #XSTD_GPPAN @SET-SYMBOL $S_INVD1BWP12T30P140;
// #XSTD_GPPAN @PLACE(18,-114) => @ORIENT("R0");
// #XSTD_GPPBN @SET-SYMBOL $S_INVD1BWP12T30P140;
// #XSTD_GPPBN @PLACE(47,-114) => @ORIENT("R0");
// #XSTD_GPPCN @SET-SYMBOL $S_INVD1BWP12T30P140;
// #XSTD_GPPCN @PLACE(76,-114) => @ORIENT("R0");
// #RGPP0 @SET-SYMBOL $RESISTOR;
// #RGPP0 @PLACE(110,-114) => @ORIENT("R90");
// #RGPP0 @TEXT("RGPP0",key="name",size=1.3,halign="start") => @PLACE(113,-111);
// #RGPP0 @TEXT("l=17.13u w=1u multi=(1)",key="value",size=0.9,halign="start") => @PLACE(113,-118);
// #RGPP0 @TEXT("",key="model");
// #RGPP0_2__dmy0 @SET-SYMBOL $RESISTOR;
// #RGPP0_2__dmy0 @PLACE(135,-114) => @ORIENT("R90");
// #RGPP0_2__dmy0 @TEXT("RGPP0_2__dmy0",key="name",size=1.3,halign="start") => @PLACE(138,-111);
// #RGPP0_2__dmy0 @TEXT("l=17.13u w=1u multi=(1)",key="value",size=0.9,halign="start") => @PLACE(138,-118);
// #RGPP0_2__dmy0 @TEXT("",key="model");
// #RGPP0_3__dmy0 @SET-SYMBOL $RESISTOR;
// #RGPP0_3__dmy0 @PLACE(160,-114) => @ORIENT("R90");
// #RGPP0_3__dmy0 @TEXT("RGPP0_3__dmy0",key="name",size=1.3,halign="start") => @PLACE(163,-111);
// #RGPP0_3__dmy0 @TEXT("l=17.13u w=1u multi=(1)",key="value",size=0.9,halign="start") => @PLACE(163,-118);
// #RGPP0_3__dmy0 @TEXT("",key="model");
// #RGPP0_4__dmy0 @SET-SYMBOL $RESISTOR;
// #RGPP0_4__dmy0 @PLACE(185,-114) => @ORIENT("R90");
// #RGPP0_4__dmy0 @TEXT("RGPP0_4__dmy0",key="name",size=1.3,halign="start") => @PLACE(188,-111);
// #RGPP0_4__dmy0 @TEXT("l=17.13u w=1u multi=(1)",key="value",size=0.9,halign="start") => @PLACE(188,-118);
// #RGPP0_4__dmy0 @TEXT("",key="model");
// #RGPP0_5__dmy0 @SET-SYMBOL $RESISTOR;
// #RGPP0_5__dmy0 @PLACE(210,-114) => @ORIENT("R90");
// #RGPP0_5__dmy0 @TEXT("RGPP0_5__dmy0",key="name",size=1.3,halign="start") => @PLACE(213,-111);
// #RGPP0_5__dmy0 @TEXT("l=17.13u w=1u multi=(1)",key="value",size=0.9,halign="start") => @PLACE(213,-118);
// #RGPP0_5__dmy0 @TEXT("",key="model");
// #RGPP1 @SET-SYMBOL $RESISTOR;
// #RGPP1 @PLACE(235,-114) => @ORIENT("R90");
// #RGPP1 @TEXT("RGPP1",key="name",size=1.3,halign="start") => @PLACE(238,-111);
// #RGPP1 @TEXT("l=17.13u w=1u multi=(1)",key="value",size=0.9,halign="start") => @PLACE(238,-118);
// #RGPP1 @TEXT("",key="model");
// #RGPP1_2__dmy0 @SET-SYMBOL $RESISTOR;
// #RGPP1_2__dmy0 @PLACE(260,-114) => @ORIENT("R90");
// #RGPP1_2__dmy0 @TEXT("RGPP1_2__dmy0",key="name",size=1.3,halign="start") => @PLACE(263,-111);
// #RGPP1_2__dmy0 @TEXT("l=17.13u w=1u multi=(1)",key="value",size=0.9,halign="start") => @PLACE(263,-118);
// #RGPP1_2__dmy0 @TEXT("",key="model");
// #RGPP1_3__dmy0 @SET-SYMBOL $RESISTOR;
// #RGPP1_3__dmy0 @PLACE(285,-114) => @ORIENT("R90");
// #RGPP1_3__dmy0 @TEXT("RGPP1_3__dmy0",key="name",size=1.3,halign="start") => @PLACE(288,-111);
// #RGPP1_3__dmy0 @TEXT("l=17.13u w=1u multi=(1)",key="value",size=0.9,halign="start") => @PLACE(288,-118);
// #RGPP1_3__dmy0 @TEXT("",key="model");
// #RGPP1_4__dmy0 @SET-SYMBOL $RESISTOR;
// #RGPP1_4__dmy0 @PLACE(310,-114) => @ORIENT("R90");
// #RGPP1_4__dmy0 @TEXT("RGPP1_4__dmy0",key="name",size=1.3,halign="start") => @PLACE(313,-111);
// #RGPP1_4__dmy0 @TEXT("l=17.13u w=1u multi=(1)",key="value",size=0.9,halign="start") => @PLACE(313,-118);
// #RGPP1_4__dmy0 @TEXT("",key="model");
// #RGPP1_5__dmy0 @SET-SYMBOL $RESISTOR;
// #RGPP1_5__dmy0 @PLACE(335,-114) => @ORIENT("R90");
// #RGPP1_5__dmy0 @TEXT("RGPP1_5__dmy0",key="name",size=1.3,halign="start") => @PLACE(338,-111);
// #RGPP1_5__dmy0 @TEXT("l=17.13u w=1u multi=(1)",key="value",size=0.9,halign="start") => @PLACE(338,-118);
// #RGPP1_5__dmy0 @TEXT("",key="model");
// (104,-99) @TEXT("GPP / 10 series poly sections",size=0.95,halign="start",textcolor="#223d52");
// &"GNNB" @WIRE(mode="straight",linecolor="#30485d",linewidth=0.16) {#XSTD_GNNCN:1 (61.5,0) (61.5,0) #XSTD_GNNBN:2};
// &"GNNDRV" @WIRE(mode="straight",linecolor="#30485d",linewidth=0.16) {#XSTD_GNNCN:2 (95.5,0) (95.5,0) #RGNN0:1};
// &"GNNA" @WIRE(mode="straight",linecolor="#30485d",linewidth=0.16) {#XSTD_GNNBN:1 (32.5,0) (32.5,0) #XSTD_GNNAN:2};
// &"GNNPRE" @WIRE(mode="straight",linecolor="#30485d",linewidth=0.16) {#XSTD_GNNAN:1 (0.5,0) (0.5,0) #X025:4};
// &"GNPB" @WIRE(mode="straight",linecolor="#30485d",linewidth=0.16) {#XSTD_GNPCN:1 (61.5,-38) (61.5,-38) #XSTD_GNPBN:2};
// &"GNPDRV" @WIRE(mode="straight",linecolor="#30485d",linewidth=0.16) {#XSTD_GNPCN:2 (95.5,-38) (95.5,-38) #RGNP0:1};
// &"GNPA" @WIRE(mode="straight",linecolor="#30485d",linewidth=0.16) {#XSTD_GNPBN:1 (32.5,-38) (32.5,-38) #XSTD_GNPAN:2};
// &"H" @WIRE(mode="straight",linecolor="#30485d",linewidth=0.16) {#XSTD_GNPAN:1 (-6.5,-38) (-6.5,-76) #X008:1};
// &"GPNB" @WIRE(mode="straight",linecolor="#30485d",linewidth=0.16) {#XSTD_GPNCN:1 (61.5,-76) (61.5,-76) #XSTD_GPNBN:2};
// &"GPNDRV" @WIRE(mode="straight",linecolor="#30485d",linewidth=0.16) {#XSTD_GPNCN:2 (95.5,-76) (95.5,-76) #RGPN0:1};
// &"GPNA" @WIRE(mode="straight",linecolor="#30485d",linewidth=0.16) {#XSTD_GPNBN:1 (32.5,-76) (32.5,-76) #XSTD_GPNAN:2};
// &"GPNPRE" @WIRE(mode="straight",linecolor="#30485d",linewidth=0.16) {#XSTD_GPNAN:1 (0.5,-76) (0.5,-76) #X008:4};
// &"GPPB" @WIRE(mode="straight",linecolor="#30485d",linewidth=0.16) {#XSTD_GPPCN:1 (61.5,-114) (61.5,-114) #XSTD_GPPBN:2};
// &"GPPDRV" @WIRE(mode="straight",linecolor="#30485d",linewidth=0.16) {#XSTD_GPPCN:2 (95.5,-114) (95.5,-114) #RGPP0:1};
// &"GPPA" @WIRE(mode="straight",linecolor="#30485d",linewidth=0.16) {#XSTD_GPPBN:1 (32.5,-114) (32.5,-114) #XSTD_GPPAN:2};
// &"GNNRG" @WIRE(mode="straight",linecolor="#30485d",linewidth=0.16) {#RGNN1:1 (222.5,0) (222.5,0) #RGNN0_5__dmy0:2};
// &"RGNN1_1__dmy0" @WIRE(mode="straight",linecolor="#30485d",linewidth=0.16) {#RGNN1:2 (247.5,0) (247.5,0) #RGNN1_2__dmy0:1};
// &"RGNN1_2__dmy0" @WIRE(mode="straight",linecolor="#30485d",linewidth=0.16) {#RGNN1_2__dmy0:2 (272.5,0) (272.5,0) #RGNN1_3__dmy0:1};
// &"RGNN1_3__dmy0" @WIRE(mode="straight",linecolor="#30485d",linewidth=0.16) {#RGNN1_3__dmy0:2 (297.5,0) (297.5,0) #RGNN1_4__dmy0:1};
// &"RGNN1_4__dmy0" @WIRE(mode="straight",linecolor="#30485d",linewidth=0.16) {#RGNN1_4__dmy0:2 (322.5,0) (322.5,0) #RGNN1_5__dmy0:1};
// &"RGNN0_1__dmy0" @WIRE(mode="straight",linecolor="#30485d",linewidth=0.16) {#RGNN0:2 (122.5,0) (122.5,0) #RGNN0_2__dmy0:1};
// &"RGNN0_2__dmy0" @WIRE(mode="straight",linecolor="#30485d",linewidth=0.16) {#RGNN0_2__dmy0:2 (147.5,0) (147.5,0) #RGNN0_3__dmy0:1};
// &"RGNN0_3__dmy0" @WIRE(mode="straight",linecolor="#30485d",linewidth=0.16) {#RGNN0_3__dmy0:2 (172.5,0) (172.5,0) #RGNN0_4__dmy0:1};
// &"RGNN0_4__dmy0" @WIRE(mode="straight",linecolor="#30485d",linewidth=0.16) {#RGNN0_4__dmy0:2 (197.5,0) (197.5,0) #RGNN0_5__dmy0:1};
// &"GNPRG" @WIRE(mode="straight",linecolor="#30485d",linewidth=0.16) {#RGNP1:1 (222.5,-38) (222.5,-38) #RGNP0_5__dmy0:2};
// &"RGNP1_1__dmy0" @WIRE(mode="straight",linecolor="#30485d",linewidth=0.16) {#RGNP1:2 (247.5,-38) (247.5,-38) #RGNP1_2__dmy0:1};
// &"RGNP1_2__dmy0" @WIRE(mode="straight",linecolor="#30485d",linewidth=0.16) {#RGNP1_2__dmy0:2 (272.5,-38) (272.5,-38) #RGNP1_3__dmy0:1};
// &"RGNP1_3__dmy0" @WIRE(mode="straight",linecolor="#30485d",linewidth=0.16) {#RGNP1_3__dmy0:2 (297.5,-38) (297.5,-38) #RGNP1_4__dmy0:1};
// &"RGNP1_4__dmy0" @WIRE(mode="straight",linecolor="#30485d",linewidth=0.16) {#RGNP1_4__dmy0:2 (322.5,-38) (322.5,-38) #RGNP1_5__dmy0:1};
// &"RGNP0_1__dmy0" @WIRE(mode="straight",linecolor="#30485d",linewidth=0.16) {#RGNP0:2 (122.5,-38) (122.5,-38) #RGNP0_2__dmy0:1};
// &"RGNP0_2__dmy0" @WIRE(mode="straight",linecolor="#30485d",linewidth=0.16) {#RGNP0_2__dmy0:2 (147.5,-38) (147.5,-38) #RGNP0_3__dmy0:1};
// &"RGNP0_3__dmy0" @WIRE(mode="straight",linecolor="#30485d",linewidth=0.16) {#RGNP0_3__dmy0:2 (172.5,-38) (172.5,-38) #RGNP0_4__dmy0:1};
// &"RGNP0_4__dmy0" @WIRE(mode="straight",linecolor="#30485d",linewidth=0.16) {#RGNP0_4__dmy0:2 (197.5,-38) (197.5,-38) #RGNP0_5__dmy0:1};
// &"GPNRG" @WIRE(mode="straight",linecolor="#30485d",linewidth=0.16) {#RGPN1:1 (222.5,-76) (222.5,-76) #RGPN0_5__dmy0:2};
// &"RGPN1_1__dmy0" @WIRE(mode="straight",linecolor="#30485d",linewidth=0.16) {#RGPN1:2 (247.5,-76) (247.5,-76) #RGPN1_2__dmy0:1};
// &"RGPN1_2__dmy0" @WIRE(mode="straight",linecolor="#30485d",linewidth=0.16) {#RGPN1_2__dmy0:2 (272.5,-76) (272.5,-76) #RGPN1_3__dmy0:1};
// &"RGPN1_3__dmy0" @WIRE(mode="straight",linecolor="#30485d",linewidth=0.16) {#RGPN1_3__dmy0:2 (297.5,-76) (297.5,-76) #RGPN1_4__dmy0:1};
// &"RGPN1_4__dmy0" @WIRE(mode="straight",linecolor="#30485d",linewidth=0.16) {#RGPN1_4__dmy0:2 (322.5,-76) (322.5,-76) #RGPN1_5__dmy0:1};
// &"RGPN0_1__dmy0" @WIRE(mode="straight",linecolor="#30485d",linewidth=0.16) {#RGPN0:2 (122.5,-76) (122.5,-76) #RGPN0_2__dmy0:1};
// &"RGPN0_2__dmy0" @WIRE(mode="straight",linecolor="#30485d",linewidth=0.16) {#RGPN0_2__dmy0:2 (147.5,-76) (147.5,-76) #RGPN0_3__dmy0:1};
// &"RGPN0_3__dmy0" @WIRE(mode="straight",linecolor="#30485d",linewidth=0.16) {#RGPN0_3__dmy0:2 (172.5,-76) (172.5,-76) #RGPN0_4__dmy0:1};
// &"RGPN0_4__dmy0" @WIRE(mode="straight",linecolor="#30485d",linewidth=0.16) {#RGPN0_4__dmy0:2 (197.5,-76) (197.5,-76) #RGPN0_5__dmy0:1};
// &"GPPRG" @WIRE(mode="straight",linecolor="#30485d",linewidth=0.16) {#RGPP1:1 (222.5,-114) (222.5,-114) #RGPP0_5__dmy0:2};
// &"RGPP1_1__dmy0" @WIRE(mode="straight",linecolor="#30485d",linewidth=0.16) {#RGPP1:2 (247.5,-114) (247.5,-114) #RGPP1_2__dmy0:1};
// &"RGPP1_2__dmy0" @WIRE(mode="straight",linecolor="#30485d",linewidth=0.16) {#RGPP1_2__dmy0:2 (272.5,-114) (272.5,-114) #RGPP1_3__dmy0:1};
// &"RGPP1_3__dmy0" @WIRE(mode="straight",linecolor="#30485d",linewidth=0.16) {#RGPP1_3__dmy0:2 (297.5,-114) (297.5,-114) #RGPP1_4__dmy0:1};
// &"RGPP1_4__dmy0" @WIRE(mode="straight",linecolor="#30485d",linewidth=0.16) {#RGPP1_4__dmy0:2 (322.5,-114) (322.5,-114) #RGPP1_5__dmy0:1};
// &"RGPP0_1__dmy0" @WIRE(mode="straight",linecolor="#30485d",linewidth=0.16) {#RGPP0:2 (122.5,-114) (122.5,-114) #RGPP0_2__dmy0:1};
// &"RGPP0_2__dmy0" @WIRE(mode="straight",linecolor="#30485d",linewidth=0.16) {#RGPP0_2__dmy0:2 (147.5,-114) (147.5,-114) #RGPP0_3__dmy0:1};
// &"RGPP0_3__dmy0" @WIRE(mode="straight",linecolor="#30485d",linewidth=0.16) {#RGPP0_3__dmy0:2 (172.5,-114) (172.5,-114) #RGPP0_4__dmy0:1};
// &"RGPP0_4__dmy0" @WIRE(mode="straight",linecolor="#30485d",linewidth=0.16) {#RGPP0_4__dmy0:2 (197.5,-114) (197.5,-114) #RGPP0_5__dmy0:1};
// (-28,-148) @TEXT("GP and GN chains keep their source polarity, device sizing and series R; no zero-delay abstraction.",size=1,halign="start",textcolor="#223d52");
// &"VDD" @WIRE(mode="straight",linecolor="#30485d",linewidth=0.16) {#XSTD_GNNCN:3 (76,10)};
// (76,10.4) @TEXT("VDD",size=1.1,halign="middle",valign="bottom");
// &"VSS" @WIRE(mode="straight",linecolor="#30485d",linewidth=0.16) {#XSTD_GNNCN:4 (76,-10)};
// (76,-10.4) @TEXT("VSS",size=1.1,halign="middle",valign="top");
// &"VDD" @WIRE(mode="straight",linecolor="#30485d",linewidth=0.16) {#XSTD_GNNBN:3 (47,10)};
// (47,10.4) @TEXT("VDD",size=1.1,halign="middle",valign="bottom");
// &"VSS" @WIRE(mode="straight",linecolor="#30485d",linewidth=0.16) {#XSTD_GNNBN:4 (47,-10)};
// (47,-10.4) @TEXT("VSS",size=1.1,halign="middle",valign="top");
// &"VDD" @WIRE(mode="straight",linecolor="#30485d",linewidth=0.16) {#XSTD_GNNAN:3 (18,10)};
// (18,10.4) @TEXT("VDD",size=1.1,halign="middle",valign="bottom");
// &"VSS" @WIRE(mode="straight",linecolor="#30485d",linewidth=0.16) {#XSTD_GNNAN:4 (18,-10)};
// (18,-10.4) @TEXT("VSS",size=1.1,halign="middle",valign="top");
// &"VDD" @WIRE(mode="straight",linecolor="#30485d",linewidth=0.16) {#XSTD_GNPCN:3 (76,-28)};
// (76,-27.6) @TEXT("VDD",size=1.1,halign="middle",valign="bottom");
// &"VSS" @WIRE(mode="straight",linecolor="#30485d",linewidth=0.16) {#XSTD_GNPCN:4 (76,-48)};
// (76,-48.4) @TEXT("VSS",size=1.1,halign="middle",valign="top");
// &"VDD" @WIRE(mode="straight",linecolor="#30485d",linewidth=0.16) {#XSTD_GNPBN:3 (47,-28)};
// (47,-27.6) @TEXT("VDD",size=1.1,halign="middle",valign="bottom");
// &"VSS" @WIRE(mode="straight",linecolor="#30485d",linewidth=0.16) {#XSTD_GNPBN:4 (47,-48)};
// (47,-48.4) @TEXT("VSS",size=1.1,halign="middle",valign="top");
// &"VDD" @WIRE(mode="straight",linecolor="#30485d",linewidth=0.16) {#XSTD_GNPAN:3 (18,-28)};
// (18,-27.6) @TEXT("VDD",size=1.1,halign="middle",valign="bottom");
// &"VSS" @WIRE(mode="straight",linecolor="#30485d",linewidth=0.16) {#XSTD_GNPAN:4 (18,-48)};
// (18,-48.4) @TEXT("VSS",size=1.1,halign="middle",valign="top");
// &"VDD" @WIRE(mode="straight",linecolor="#30485d",linewidth=0.16) {#XSTD_GPNCN:3 (76,-66)};
// (76,-65.6) @TEXT("VDD",size=1.1,halign="middle",valign="bottom");
// &"VSS" @WIRE(mode="straight",linecolor="#30485d",linewidth=0.16) {#XSTD_GPNCN:4 (76,-86)};
// (76,-86.4) @TEXT("VSS",size=1.1,halign="middle",valign="top");
// &"VDD" @WIRE(mode="straight",linecolor="#30485d",linewidth=0.16) {#XSTD_GPNBN:3 (47,-66)};
// (47,-65.6) @TEXT("VDD",size=1.1,halign="middle",valign="bottom");
// &"VSS" @WIRE(mode="straight",linecolor="#30485d",linewidth=0.16) {#XSTD_GPNBN:4 (47,-86)};
// (47,-86.4) @TEXT("VSS",size=1.1,halign="middle",valign="top");
// &"VDD" @WIRE(mode="straight",linecolor="#30485d",linewidth=0.16) {#XSTD_GPNAN:3 (18,-66)};
// (18,-65.6) @TEXT("VDD",size=1.1,halign="middle",valign="bottom");
// &"VSS" @WIRE(mode="straight",linecolor="#30485d",linewidth=0.16) {#XSTD_GPNAN:4 (18,-86)};
// (18,-86.4) @TEXT("VSS",size=1.1,halign="middle",valign="top");
// &"VDD" @WIRE(mode="straight",linecolor="#30485d",linewidth=0.16) {#XSTD_GPPCN:3 (76,-104)};
// (76,-103.6) @TEXT("VDD",size=1.1,halign="middle",valign="bottom");
// &"VSS" @WIRE(mode="straight",linecolor="#30485d",linewidth=0.16) {#XSTD_GPPCN:4 (76,-124)};
// (76,-124.4) @TEXT("VSS",size=1.1,halign="middle",valign="top");
// &"VDD" @WIRE(mode="straight",linecolor="#30485d",linewidth=0.16) {#XSTD_GPPBN:3 (47,-104)};
// (47,-103.6) @TEXT("VDD",size=1.1,halign="middle",valign="bottom");
// &"VSS" @WIRE(mode="straight",linecolor="#30485d",linewidth=0.16) {#XSTD_GPPBN:4 (47,-124)};
// (47,-124.4) @TEXT("VSS",size=1.1,halign="middle",valign="top");
// &"L" @WIRE(mode="straight",linecolor="#30485d",linewidth=0.16) {#XSTD_GPPAN:1 (8,-114)};
// (7.6,-114) @TEXT("L",size=1.1,halign="end",valign="middle");
// &"VDD" @WIRE(mode="straight",linecolor="#30485d",linewidth=0.16) {#XSTD_GPPAN:3 (18,-104)};
// (18,-103.6) @TEXT("VDD",size=1.1,halign="middle",valign="bottom");
// &"VSS" @WIRE(mode="straight",linecolor="#30485d",linewidth=0.16) {#XSTD_GPPAN:4 (18,-124)};
// (18,-124.4) @TEXT("VSS",size=1.1,halign="middle",valign="top");
// &"GNN" @WIRE(mode="straight",linecolor="#30485d",linewidth=0.16) {#RGNN1_5__dmy0:2 (340,0)};
// (340.4,0) @TEXT("GNN",size=1.1,halign="start",valign="middle");
// &"GNP" @WIRE(mode="straight",linecolor="#30485d",linewidth=0.16) {#RGNP1_5__dmy0:2 (340,-38)};
// (340.4,-38) @TEXT("GNP",size=1.1,halign="start",valign="middle");
// &"GPN" @WIRE(mode="straight",linecolor="#30485d",linewidth=0.16) {#RGPN1_5__dmy0:2 (340,-76)};
// (340.4,-76) @TEXT("GPN",size=1.1,halign="start",valign="middle");
// &"GPP" @WIRE(mode="straight",linecolor="#30485d",linewidth=0.16) {#RGPP1_5__dmy0:2 (340,-114)};
// (340.4,-114) @TEXT("GPP",size=1.1,halign="start",valign="middle");
// &"L" @WIRE(mode="straight",linecolor="#30485d",linewidth=0.16) {#X025:1 (-27,0)};
// (-27.4,0) @TEXT("L",size=1.1,halign="end",valign="middle");
// &"VDD" @WIRE(mode="straight",linecolor="#30485d",linewidth=0.16) {#X025:2 (-17,10)};
// (-17,10.4) @TEXT("VDD",size=1.1,halign="middle",valign="bottom");
// &"VSS" @WIRE(mode="straight",linecolor="#30485d",linewidth=0.16) {#X025:3 (-17,-10)};
// (-17,-10.4) @TEXT("VSS",size=1.1,halign="middle",valign="top");
// &"VDD" @WIRE(mode="straight",linecolor="#30485d",linewidth=0.16) {#X008:2 (-17,-66)};
// (-17,-65.6) @TEXT("VDD",size=1.1,halign="middle",valign="bottom");
// &"VSS" @WIRE(mode="straight",linecolor="#30485d",linewidth=0.16) {#X008:3 (-17,-86)};
// (-17,-86.4) @TEXT("VSS",size=1.1,halign="middle",valign="top");
// }
// END SARADC RNL
ends sar8p_refdrv_b7

subckt sar8p_refword CODE0 CODE1 CODE2 CODE3 CODE4 CODE5 CODE6 CODE7 D0 D1 \
        D2 D3 D4 D5 D6 D7 GNN0 GNN1 GNN2 GNN3 GNN4 GNN5 GNN6 GNN7 GNP0 \
        GNP1 GNP2 GNP3 GNP4 GNP5 GNP6 GNP7 GPN0 GPN1 GPN2 GPN3 GPN4 GPN5 \
        GPN6 GPN7 GPP0 GPP1 GPP2 GPP3 GPP4 GPP5 GPP6 GPP7 PHI_U SAMPLE VDD \
        VSS
    X002 (FIRST1 VDD VSS FIRST2) sar8p_buf
    X001 (FIRST0 VDD VSS FIRST1) sar8p_buf
    X000 (PHI_U VDD VSS FIRST0) sar8p_buf
    X007 (FIRST2 LATE_CLK VDD VSS CAP_REQ) sar8p_or2
    X003 (SAMPLE ACK VDD VSS REQ_RESET) sar8p_or2
    XREQUEST (REQ_Q REQ_RESET PHI_U VDD VSS) sar8p_sr
    XD_LATE_CLK (REQ_Q VDD VSS LATE_CLK) sar8p_delay_capture
    XD_ACK (LATE_CLK VDD VSS ACK) sar8p_delay_valid
    X008 (CAP_REQ VDD VSS CAP_CLK) sar8p_clkbuf
    XMUX7 (CODE7 D7 PHI_U VDD VSS TARGET7) sar8p_mux2
    XMUX6 (CODE6 D6 PHI_U VDD VSS TARGET6) sar8p_mux2
    XMUX5 (CODE5 D5 PHI_U VDD VSS TARGET5) sar8p_mux2
    XMUX4 (CODE4 D4 PHI_U VDD VSS TARGET4) sar8p_mux2
    XMUX3 (CODE3 D3 PHI_U VDD VSS TARGET3) sar8p_mux2
    XMUX2 (CODE2 D2 PHI_U VDD VSS TARGET2) sar8p_mux2
    XMUX1 (CODE1 D1 PHI_U VDD VSS TARGET1) sar8p_mux2
    XMUX0 (CODE0 D0 PHI_U VDD VSS TARGET0) sar8p_mux2
    X018 (MSB_QN VDD VSS Q7) sar8p_inv
    X017 (TARGET7 VDD VSS MSB_DN) sar8p_inv
    XSTORE7 (CAP_CLK MSB_DN MSB_QN SAMPLE VDD VSS) sar8p_dffr
    XSTORE6 (CAP_CLK TARGET6 Q6 SAMPLE VDD VSS) sar8p_dffr
    XSTORE5 (CAP_CLK TARGET5 Q5 SAMPLE VDD VSS) sar8p_dffr
    XSTORE4 (CAP_CLK TARGET4 Q4 SAMPLE VDD VSS) sar8p_dffr
    XSTORE3 (CAP_CLK TARGET3 Q3 SAMPLE VDD VSS) sar8p_dffr
    XSTORE2 (CAP_CLK TARGET2 Q2 SAMPLE VDD VSS) sar8p_dffr
    XSTORE1 (CAP_CLK TARGET1 Q1 SAMPLE VDD VSS) sar8p_dffr
    XSTORE0 (CAP_CLK TARGET0 Q0 SAMPLE VDD VSS) sar8p_dffr
    XBBM7 (Q7 H7 L7 VDD VSS) sar8p_nonoverlap
    XBBM6 (Q6 H6 L6 VDD VSS) sar8p_nonoverlap
    XBBM5 (Q5 H5 L5 VDD VSS) sar8p_nonoverlap
    XBBM4 (Q4 H4 L4 VDD VSS) sar8p_nonoverlap
    XBBM3 (Q3 H3 L3 VDD VSS) sar8p_nonoverlap
    XBBM2 (Q2 H2 L2 VDD VSS) sar8p_nonoverlap
    XBBM1 (Q1 H1 L1 VDD VSS) sar8p_nonoverlap
    XBBM0 (Q0 H0 L0 VDD VSS) sar8p_nonoverlap
    XDRV0 (GNN0 GNP0 GPN0 GPP0 H0 L0 VDD VSS) sar8p_refdrv_b0
    XDRV1 (GNN1 GNP1 GPN1 GPP1 H1 L1 VDD VSS) sar8p_refdrv_b1
    XDRV2 (GNN2 GNP2 GPN2 GPP2 H2 L2 VDD VSS) sar8p_refdrv_b2
    XDRV3 (GNN3 GNP3 GPN3 GPP3 H3 L3 VDD VSS) sar8p_refdrv_b3
    XDRV4 (GNN4 GNP4 GPN4 GPP4 H4 L4 VDD VSS) sar8p_refdrv_b4
    XDRV5 (GNN5 GNP5 GPN5 GPP5 H5 L5 VDD VSS) sar8p_refdrv_b5
    XDRV6 (GNN6 GNP6 GPN6 GPP6 H6 L6 VDD VSS) sar8p_refdrv_b6
    XDRV7 (GNN7 GNP7 GPN7 GPP7 H7 L7 VDD VSS) sar8p_refdrv_b7
// BEGIN SARADC RNL
// @RNL(author="saradc topology") {
// (-24,205) @TEXT("sar8p_refword / capture, sequential reset, nonoverlap and gate drive",size=1.5,halign="start",textcolor="#223d52");
// (-24,90) @TEXT("Capture request / first and late clocks / acknowledge",size=1.1,halign="start",textcolor="#223d52");
// #X000 @SET-SYMBOL $S_sar8p_buf;
// #X000 @PLACE(0,65) => @ORIENT("R0");
// #X001 @SET-SYMBOL $S_sar8p_buf;
// #X001 @PLACE(43,65) => @ORIENT("R0");
// #X002 @SET-SYMBOL $S_sar8p_buf;
// #X002 @PLACE(86,65) => @ORIENT("R0");
// #X007 @SET-SYMBOL $S_sar8p_or2;
// #X007 @PLACE(171,65) => @ORIENT("R0");
// #X008 @SET-SYMBOL $S_sar8p_clkbuf;
// #X008 @PLACE(214,65) => @ORIENT("R0");
// #X003 @SET-SYMBOL $S_sar8p_or2;
// #X003 @PLACE(0,25) => @ORIENT("R0");
// #XREQUEST @SET-SYMBOL $S_sar8p_sr;
// #XREQUEST @PLACE(43,25) => @ORIENT("R0");
// #XD_LATE_CLK @SET-SYMBOL $S_sar8p_delay_capture;
// #XD_LATE_CLK @PLACE(86,25) => @ORIENT("R0");
// #XD_ACK @SET-SYMBOL $S_sar8p_delay_valid;
// #XD_ACK @PLACE(129,25) => @ORIENT("R0");
// #XMUX7 @SET-SYMBOL $S_sar8p_mux2;
// #XMUX7 @PLACE(0,-25) => @ORIENT("R0");
// #XSTORE7 @SET-SYMBOL $S_sar8p_dffr;
// #XSTORE7 @PLACE(86,-25) => @ORIENT("R0");
// #XBBM7 @SET-SYMBOL $S_sar8p_nonoverlap;
// #XBBM7 @PLACE(155,-25) => @ORIENT("R0");
// #XDRV7 @SET-SYMBOL $S_sar8p_refdrv_b7;
// #XDRV7 @PLACE(218,-25) => @ORIENT("R0");
// (-24,-11) @TEXT("bit 7",size=1,halign="start",textcolor="#223d52");
// #XMUX6 @SET-SYMBOL $S_sar8p_mux2;
// #XMUX6 @PLACE(0,-63) => @ORIENT("R0");
// #XSTORE6 @SET-SYMBOL $S_sar8p_dffr;
// #XSTORE6 @PLACE(86,-63) => @ORIENT("R0");
// #XBBM6 @SET-SYMBOL $S_sar8p_nonoverlap;
// #XBBM6 @PLACE(155,-63) => @ORIENT("R0");
// #XDRV6 @SET-SYMBOL $S_sar8p_refdrv_b6;
// #XDRV6 @PLACE(218,-63) => @ORIENT("R0");
// (-24,-49) @TEXT("bit 6",size=1,halign="start",textcolor="#223d52");
// #XMUX5 @SET-SYMBOL $S_sar8p_mux2;
// #XMUX5 @PLACE(0,-101) => @ORIENT("R0");
// #XSTORE5 @SET-SYMBOL $S_sar8p_dffr;
// #XSTORE5 @PLACE(86,-101) => @ORIENT("R0");
// #XBBM5 @SET-SYMBOL $S_sar8p_nonoverlap;
// #XBBM5 @PLACE(155,-101) => @ORIENT("R0");
// #XDRV5 @SET-SYMBOL $S_sar8p_refdrv_b5;
// #XDRV5 @PLACE(218,-101) => @ORIENT("R0");
// (-24,-87) @TEXT("bit 5",size=1,halign="start",textcolor="#223d52");
// #XMUX4 @SET-SYMBOL $S_sar8p_mux2;
// #XMUX4 @PLACE(0,-139) => @ORIENT("R0");
// #XSTORE4 @SET-SYMBOL $S_sar8p_dffr;
// #XSTORE4 @PLACE(86,-139) => @ORIENT("R0");
// #XBBM4 @SET-SYMBOL $S_sar8p_nonoverlap;
// #XBBM4 @PLACE(155,-139) => @ORIENT("R0");
// #XDRV4 @SET-SYMBOL $S_sar8p_refdrv_b4;
// #XDRV4 @PLACE(218,-139) => @ORIENT("R0");
// (-24,-125) @TEXT("bit 4",size=1,halign="start",textcolor="#223d52");
// #XMUX3 @SET-SYMBOL $S_sar8p_mux2;
// #XMUX3 @PLACE(0,-177) => @ORIENT("R0");
// #XSTORE3 @SET-SYMBOL $S_sar8p_dffr;
// #XSTORE3 @PLACE(86,-177) => @ORIENT("R0");
// #XBBM3 @SET-SYMBOL $S_sar8p_nonoverlap;
// #XBBM3 @PLACE(155,-177) => @ORIENT("R0");
// #XDRV3 @SET-SYMBOL $S_sar8p_refdrv_b3;
// #XDRV3 @PLACE(218,-177) => @ORIENT("R0");
// (-24,-163) @TEXT("bit 3",size=1,halign="start",textcolor="#223d52");
// #XMUX2 @SET-SYMBOL $S_sar8p_mux2;
// #XMUX2 @PLACE(0,-215) => @ORIENT("R0");
// #XSTORE2 @SET-SYMBOL $S_sar8p_dffr;
// #XSTORE2 @PLACE(86,-215) => @ORIENT("R0");
// #XBBM2 @SET-SYMBOL $S_sar8p_nonoverlap;
// #XBBM2 @PLACE(155,-215) => @ORIENT("R0");
// #XDRV2 @SET-SYMBOL $S_sar8p_refdrv_b2;
// #XDRV2 @PLACE(218,-215) => @ORIENT("R0");
// (-24,-201) @TEXT("bit 2",size=1,halign="start",textcolor="#223d52");
// #XMUX1 @SET-SYMBOL $S_sar8p_mux2;
// #XMUX1 @PLACE(0,-253) => @ORIENT("R0");
// #XSTORE1 @SET-SYMBOL $S_sar8p_dffr;
// #XSTORE1 @PLACE(86,-253) => @ORIENT("R0");
// #XBBM1 @SET-SYMBOL $S_sar8p_nonoverlap;
// #XBBM1 @PLACE(155,-253) => @ORIENT("R0");
// #XDRV1 @SET-SYMBOL $S_sar8p_refdrv_b1;
// #XDRV1 @PLACE(218,-253) => @ORIENT("R0");
// (-24,-239) @TEXT("bit 1",size=1,halign="start",textcolor="#223d52");
// #XMUX0 @SET-SYMBOL $S_sar8p_mux2;
// #XMUX0 @PLACE(0,-291) => @ORIENT("R0");
// #XSTORE0 @SET-SYMBOL $S_sar8p_dffr;
// #XSTORE0 @PLACE(86,-291) => @ORIENT("R0");
// #XBBM0 @SET-SYMBOL $S_sar8p_nonoverlap;
// #XBBM0 @PLACE(155,-291) => @ORIENT("R0");
// #XDRV0 @SET-SYMBOL $S_sar8p_refdrv_b0;
// #XDRV0 @PLACE(218,-291) => @ORIENT("R0");
// (-24,-277) @TEXT("bit 0",size=1,halign="start",textcolor="#223d52");
// #X017 @SET-SYMBOL $S_sar8p_inv;
// #X017 @PLACE(43,-25) => @ORIENT("R0");
// #X018 @SET-SYMBOL $S_sar8p_inv;
// #X018 @PLACE(118,-25) => @ORIENT("R0");
// &"FIRST1" @WIRE(mode="straight",linecolor="#30485d",linewidth=0.16) {#X002:1 (64.5,65) (64.5,65) #X001:4};
// &"FIRST0" @WIRE(mode="straight",linecolor="#30485d",linewidth=0.16) {#X001:1 (21.5,65) (21.5,65) #X000:4};
// &"REQ_RESET" @WIRE(mode="straight",linecolor="#30485d",linewidth=0.16) {#X003:5 (18.5,25) (18.5,26.65) #XREQUEST:2};
// &"REQ_Q" @WIRE(mode="straight",linecolor="#30485d",linewidth=0.16) {#XREQUEST:1 (64.5,25) (64.5,25) #XD_LATE_CLK:1};
// &"TARGET7" @WIRE(mode="straight",linecolor="#30485d",linewidth=0.16) {#XMUX7:6 (21.5,-25) (21.5,-25) #X017:1};
// &"MSB_QN" @WIRE(mode="straight",linecolor="#30485d",linewidth=0.16) {#X018:1 (102,-25) (102,-25) #XSTORE7:3};
// &"Q7" @WIRE(mode="straight",linecolor="#30485d",linewidth=0.16) {#X018:4 (133.5,-25) (133.5,-25) #XBBM7:1};
// &"MSB_DN" @WIRE(mode="straight",linecolor="#30485d",linewidth=0.16) {#X017:4 (64.5,-25) (64.5,-25) #XSTORE7:2};
// &"Q6" @WIRE(mode="straight",linecolor="#30485d",linewidth=0.16) {#XSTORE6:3 (117.5,-63) (117.5,-63) #XBBM6:1};
// &"Q5" @WIRE(mode="straight",linecolor="#30485d",linewidth=0.16) {#XSTORE5:3 (117.5,-101) (117.5,-101) #XBBM5:1};
// &"Q4" @WIRE(mode="straight",linecolor="#30485d",linewidth=0.16) {#XSTORE4:3 (117.5,-139) (117.5,-139) #XBBM4:1};
// &"Q3" @WIRE(mode="straight",linecolor="#30485d",linewidth=0.16) {#XSTORE3:3 (117.5,-177) (117.5,-177) #XBBM3:1};
// &"Q2" @WIRE(mode="straight",linecolor="#30485d",linewidth=0.16) {#XSTORE2:3 (117.5,-215) (117.5,-215) #XBBM2:1};
// &"Q1" @WIRE(mode="straight",linecolor="#30485d",linewidth=0.16) {#XSTORE1:3 (117.5,-253) (117.5,-253) #XBBM1:1};
// &"Q0" @WIRE(mode="straight",linecolor="#30485d",linewidth=0.16) {#XSTORE0:3 (117.5,-291) (117.5,-291) #XBBM0:1};
// &"H7" @WIRE(mode="straight",linecolor="#30485d",linewidth=0.16) {#XBBM7:2 (199.5,-23.35) (199.5,-29.95) #XDRV7:5};
// &"L7" @WIRE(mode="straight",linecolor="#30485d",linewidth=0.16) {#XBBM7:3 (199.5,-26.65) (199.5,-33.25) #XDRV7:6};
// &"H6" @WIRE(mode="straight",linecolor="#30485d",linewidth=0.16) {#XBBM6:2 (199.5,-61.35) (199.5,-67.95) #XDRV6:5};
// &"L6" @WIRE(mode="straight",linecolor="#30485d",linewidth=0.16) {#XBBM6:3 (199.5,-64.65) (199.5,-71.25) #XDRV6:6};
// &"H5" @WIRE(mode="straight",linecolor="#30485d",linewidth=0.16) {#XBBM5:2 (199.5,-99.35) (199.5,-105.95) #XDRV5:5};
// &"L5" @WIRE(mode="straight",linecolor="#30485d",linewidth=0.16) {#XBBM5:3 (199.5,-102.65) (199.5,-109.25) #XDRV5:6};
// &"H4" @WIRE(mode="straight",linecolor="#30485d",linewidth=0.16) {#XBBM4:2 (199.5,-137.35) (199.5,-143.95) #XDRV4:5};
// &"L4" @WIRE(mode="straight",linecolor="#30485d",linewidth=0.16) {#XBBM4:3 (199.5,-140.65) (199.5,-147.25) #XDRV4:6};
// &"H3" @WIRE(mode="straight",linecolor="#30485d",linewidth=0.16) {#XBBM3:2 (199.5,-175.35) (199.5,-181.95) #XDRV3:5};
// &"L3" @WIRE(mode="straight",linecolor="#30485d",linewidth=0.16) {#XBBM3:3 (199.5,-178.65) (199.5,-185.25) #XDRV3:6};
// &"H2" @WIRE(mode="straight",linecolor="#30485d",linewidth=0.16) {#XBBM2:2 (199.5,-213.35) (199.5,-219.95) #XDRV2:5};
// &"L2" @WIRE(mode="straight",linecolor="#30485d",linewidth=0.16) {#XBBM2:3 (199.5,-216.65) (199.5,-223.25) #XDRV2:6};
// &"H1" @WIRE(mode="straight",linecolor="#30485d",linewidth=0.16) {#XBBM1:2 (199.5,-251.35) (199.5,-257.95) #XDRV1:5};
// &"L1" @WIRE(mode="straight",linecolor="#30485d",linewidth=0.16) {#XBBM1:3 (199.5,-254.65) (199.5,-261.25) #XDRV1:6};
// &"H0" @WIRE(mode="straight",linecolor="#30485d",linewidth=0.16) {#XBBM0:2 (199.5,-289.35) (199.5,-295.95) #XDRV0:5};
// &"L0" @WIRE(mode="straight",linecolor="#30485d",linewidth=0.16) {#XBBM0:3 (199.5,-292.65) (199.5,-299.25) #XDRV0:6};
// (-24,-318) @TEXT("CODE / D -> MUX -> resettable storage -> break-before-make -> physical GP/GN drivers",size=1.1,halign="start",textcolor="#223d52");
// &"VDD" @WIRE(mode="straight",linecolor="#30485d",linewidth=0.16) {#X002:2 (86,75)};
// (86,75.4) @TEXT("VDD",size=1.1,halign="middle",valign="bottom");
// &"VSS" @WIRE(mode="straight",linecolor="#30485d",linewidth=0.16) {#X002:3 (86,55)};
// (86,54.6) @TEXT("VSS",size=1.1,halign="middle",valign="top");
// &"FIRST2" @WIRE(mode="straight",linecolor="#30485d",linewidth=0.16) {#X002:4 (96,65)};
// (96.4,65) @TEXT("FIRST2",size=1.1,halign="start",valign="middle");
// &"VDD" @WIRE(mode="straight",linecolor="#30485d",linewidth=0.16) {#X001:2 (43,75)};
// (43,75.4) @TEXT("VDD",size=1.1,halign="middle",valign="bottom");
// &"VSS" @WIRE(mode="straight",linecolor="#30485d",linewidth=0.16) {#X001:3 (43,55)};
// (43,54.6) @TEXT("VSS",size=1.1,halign="middle",valign="top");
// &"PHI_U" @WIRE(mode="straight",linecolor="#30485d",linewidth=0.16) {#X000:1 (-10,65)};
// (-10.4,65) @TEXT("PHI_U",size=1.1,halign="end",valign="middle");
// &"VDD" @WIRE(mode="straight",linecolor="#30485d",linewidth=0.16) {#X000:2 (0,75)};
// (0,75.4) @TEXT("VDD",size=1.1,halign="middle",valign="bottom");
// &"VSS" @WIRE(mode="straight",linecolor="#30485d",linewidth=0.16) {#X000:3 (0,55)};
// (0,54.6) @TEXT("VSS",size=1.1,halign="middle",valign="top");
// &"FIRST2" @WIRE(mode="straight",linecolor="#30485d",linewidth=0.16) {#X007:1 (161,66.7)};
// (160.6,66.7) @TEXT("FIRST2",size=1.1,halign="end",valign="middle");
// &"LATE_CLK" @WIRE(mode="straight",linecolor="#30485d",linewidth=0.16) {#X007:2 (161,63.3)};
// (160.6,63.3) @TEXT("LATE_CLK",size=1.1,halign="end",valign="middle");
// &"VDD" @WIRE(mode="straight",linecolor="#30485d",linewidth=0.16) {#X007:3 (171,75)};
// (171,75.4) @TEXT("VDD",size=1.1,halign="middle",valign="bottom");
// &"VSS" @WIRE(mode="straight",linecolor="#30485d",linewidth=0.16) {#X007:4 (171,55)};
// (171,54.6) @TEXT("VSS",size=1.1,halign="middle",valign="top");
// &"CAP_REQ" @WIRE(mode="straight",linecolor="#30485d",linewidth=0.16) {#X007:5 (181,65)};
// (181.4,65) @TEXT("CAP_REQ",size=1.1,halign="start",valign="middle");
// &"SAMPLE" @WIRE(mode="straight",linecolor="#30485d",linewidth=0.16) {#X003:1 (-10,26.7)};
// (-10.4,26.7) @TEXT("SAMPLE",size=1.1,halign="end",valign="middle");
// &"ACK" @WIRE(mode="straight",linecolor="#30485d",linewidth=0.16) {#X003:2 (-10,23.3)};
// (-10.4,23.3) @TEXT("ACK",size=1.1,halign="end",valign="middle");
// &"VDD" @WIRE(mode="straight",linecolor="#30485d",linewidth=0.16) {#X003:3 (0,35)};
// (0,35.4) @TEXT("VDD",size=1.1,halign="middle",valign="bottom");
// &"VSS" @WIRE(mode="straight",linecolor="#30485d",linewidth=0.16) {#X003:4 (0,15)};
// (0,14.6) @TEXT("VSS",size=1.1,halign="middle",valign="top");
// &"PHI_U" @WIRE(mode="straight",linecolor="#30485d",linewidth=0.16) {#XREQUEST:3 (27,23.35)};
// (26.6,23.35) @TEXT("PHI_U",size=1.1,halign="end",valign="middle");
// &"VDD" @WIRE(mode="straight",linecolor="#30485d",linewidth=0.16) {#XREQUEST:4 (43,36)};
// (43,36.4) @TEXT("VDD",size=1.1,halign="middle",valign="bottom");
// &"VSS" @WIRE(mode="straight",linecolor="#30485d",linewidth=0.16) {#XREQUEST:5 (43,14)};
// (43,13.6) @TEXT("VSS",size=1.1,halign="middle",valign="top");
// &"VDD" @WIRE(mode="straight",linecolor="#30485d",linewidth=0.16) {#XD_LATE_CLK:2 (86,36)};
// (86,36.4) @TEXT("VDD",size=1.1,halign="middle",valign="bottom");
// &"VSS" @WIRE(mode="straight",linecolor="#30485d",linewidth=0.16) {#XD_LATE_CLK:3 (86,14)};
// (86,13.6) @TEXT("VSS",size=1.1,halign="middle",valign="top");
// &"LATE_CLK" @WIRE(mode="straight",linecolor="#30485d",linewidth=0.16) {#XD_LATE_CLK:4 (102,25)};
// (102.4,25) @TEXT("LATE_CLK",size=1.1,halign="start",valign="middle");
// &"LATE_CLK" @WIRE(mode="straight",linecolor="#30485d",linewidth=0.16) {#XD_ACK:1 (113,25)};
// (112.6,25) @TEXT("LATE_CLK",size=1.1,halign="end",valign="middle");
// &"VDD" @WIRE(mode="straight",linecolor="#30485d",linewidth=0.16) {#XD_ACK:2 (129,36)};
// (129,36.4) @TEXT("VDD",size=1.1,halign="middle",valign="bottom");
// &"VSS" @WIRE(mode="straight",linecolor="#30485d",linewidth=0.16) {#XD_ACK:3 (129,14)};
// (129,13.6) @TEXT("VSS",size=1.1,halign="middle",valign="top");
// &"ACK" @WIRE(mode="straight",linecolor="#30485d",linewidth=0.16) {#XD_ACK:4 (145,25)};
// (145.4,25) @TEXT("ACK",size=1.1,halign="start",valign="middle");
// &"CAP_REQ" @WIRE(mode="straight",linecolor="#30485d",linewidth=0.16) {#X008:1 (204,65)};
// (203.6,65) @TEXT("CAP_REQ",size=1.1,halign="end",valign="middle");
// &"VDD" @WIRE(mode="straight",linecolor="#30485d",linewidth=0.16) {#X008:2 (214,75)};
// (214,75.4) @TEXT("VDD",size=1.1,halign="middle",valign="bottom");
// &"VSS" @WIRE(mode="straight",linecolor="#30485d",linewidth=0.16) {#X008:3 (214,55)};
// (214,54.6) @TEXT("VSS",size=1.1,halign="middle",valign="top");
// &"CAP_CLK" @WIRE(mode="straight",linecolor="#30485d",linewidth=0.16) {#X008:4 (224,65)};
// (224.4,65) @TEXT("CAP_CLK",size=1.1,halign="start",valign="middle");
// &"CODE7" @WIRE(mode="straight",linecolor="#30485d",linewidth=0.16) {#XMUX7:1 (-10,-21.6)};
// (-10.4,-21.6) @TEXT("CODE7",size=1.1,halign="end",valign="middle");
// &"D7" @WIRE(mode="straight",linecolor="#30485d",linewidth=0.16) {#XMUX7:2 (-10,-25)};
// (-10.4,-25) @TEXT("D7",size=1.1,halign="end",valign="middle");
// &"PHI_U" @WIRE(mode="straight",linecolor="#30485d",linewidth=0.16) {#XMUX7:3 (-10,-28.4)};
// (-10.4,-28.4) @TEXT("PHI_U",size=1.1,halign="end",valign="middle");
// &"VDD" @WIRE(mode="straight",linecolor="#30485d",linewidth=0.16) {#XMUX7:4 (0,-15)};
// (0,-14.6) @TEXT("VDD",size=1.1,halign="middle",valign="bottom");
// &"VSS" @WIRE(mode="straight",linecolor="#30485d",linewidth=0.16) {#XMUX7:5 (0,-35)};
// (0,-35.4) @TEXT("VSS",size=1.1,halign="middle",valign="top");
// &"CODE6" @WIRE(mode="straight",linecolor="#30485d",linewidth=0.16) {#XMUX6:1 (-10,-59.6)};
// (-10.4,-59.6) @TEXT("CODE6",size=1.1,halign="end",valign="middle");
// &"D6" @WIRE(mode="straight",linecolor="#30485d",linewidth=0.16) {#XMUX6:2 (-10,-63)};
// (-10.4,-63) @TEXT("D6",size=1.1,halign="end",valign="middle");
// &"PHI_U" @WIRE(mode="straight",linecolor="#30485d",linewidth=0.16) {#XMUX6:3 (-10,-66.4)};
// (-10.4,-66.4) @TEXT("PHI_U",size=1.1,halign="end",valign="middle");
// &"VDD" @WIRE(mode="straight",linecolor="#30485d",linewidth=0.16) {#XMUX6:4 (0,-53)};
// (0,-52.6) @TEXT("VDD",size=1.1,halign="middle",valign="bottom");
// &"VSS" @WIRE(mode="straight",linecolor="#30485d",linewidth=0.16) {#XMUX6:5 (0,-73)};
// (0,-73.4) @TEXT("VSS",size=1.1,halign="middle",valign="top");
// &"TARGET6" @WIRE(mode="straight",linecolor="#30485d",linewidth=0.16) {#XMUX6:6 (10,-63)};
// (10.4,-63) @TEXT("TARGET6",size=1.1,halign="start",valign="middle");
// &"CODE5" @WIRE(mode="straight",linecolor="#30485d",linewidth=0.16) {#XMUX5:1 (-10,-97.6)};
// (-10.4,-97.6) @TEXT("CODE5",size=1.1,halign="end",valign="middle");
// &"D5" @WIRE(mode="straight",linecolor="#30485d",linewidth=0.16) {#XMUX5:2 (-10,-101)};
// (-10.4,-101) @TEXT("D5",size=1.1,halign="end",valign="middle");
// &"PHI_U" @WIRE(mode="straight",linecolor="#30485d",linewidth=0.16) {#XMUX5:3 (-10,-104.4)};
// (-10.4,-104.4) @TEXT("PHI_U",size=1.1,halign="end",valign="middle");
// &"VDD" @WIRE(mode="straight",linecolor="#30485d",linewidth=0.16) {#XMUX5:4 (0,-91)};
// (0,-90.6) @TEXT("VDD",size=1.1,halign="middle",valign="bottom");
// &"VSS" @WIRE(mode="straight",linecolor="#30485d",linewidth=0.16) {#XMUX5:5 (0,-111)};
// (0,-111.4) @TEXT("VSS",size=1.1,halign="middle",valign="top");
// &"TARGET5" @WIRE(mode="straight",linecolor="#30485d",linewidth=0.16) {#XMUX5:6 (10,-101)};
// (10.4,-101) @TEXT("TARGET5",size=1.1,halign="start",valign="middle");
// &"CODE4" @WIRE(mode="straight",linecolor="#30485d",linewidth=0.16) {#XMUX4:1 (-10,-135.6)};
// (-10.4,-135.6) @TEXT("CODE4",size=1.1,halign="end",valign="middle");
// &"D4" @WIRE(mode="straight",linecolor="#30485d",linewidth=0.16) {#XMUX4:2 (-10,-139)};
// (-10.4,-139) @TEXT("D4",size=1.1,halign="end",valign="middle");
// &"PHI_U" @WIRE(mode="straight",linecolor="#30485d",linewidth=0.16) {#XMUX4:3 (-10,-142.4)};
// (-10.4,-142.4) @TEXT("PHI_U",size=1.1,halign="end",valign="middle");
// &"VDD" @WIRE(mode="straight",linecolor="#30485d",linewidth=0.16) {#XMUX4:4 (0,-129)};
// (0,-128.6) @TEXT("VDD",size=1.1,halign="middle",valign="bottom");
// &"VSS" @WIRE(mode="straight",linecolor="#30485d",linewidth=0.16) {#XMUX4:5 (0,-149)};
// (0,-149.4) @TEXT("VSS",size=1.1,halign="middle",valign="top");
// &"TARGET4" @WIRE(mode="straight",linecolor="#30485d",linewidth=0.16) {#XMUX4:6 (10,-139)};
// (10.4,-139) @TEXT("TARGET4",size=1.1,halign="start",valign="middle");
// &"CODE3" @WIRE(mode="straight",linecolor="#30485d",linewidth=0.16) {#XMUX3:1 (-10,-173.6)};
// (-10.4,-173.6) @TEXT("CODE3",size=1.1,halign="end",valign="middle");
// &"D3" @WIRE(mode="straight",linecolor="#30485d",linewidth=0.16) {#XMUX3:2 (-10,-177)};
// (-10.4,-177) @TEXT("D3",size=1.1,halign="end",valign="middle");
// &"PHI_U" @WIRE(mode="straight",linecolor="#30485d",linewidth=0.16) {#XMUX3:3 (-10,-180.4)};
// (-10.4,-180.4) @TEXT("PHI_U",size=1.1,halign="end",valign="middle");
// &"VDD" @WIRE(mode="straight",linecolor="#30485d",linewidth=0.16) {#XMUX3:4 (0,-167)};
// (0,-166.6) @TEXT("VDD",size=1.1,halign="middle",valign="bottom");
// &"VSS" @WIRE(mode="straight",linecolor="#30485d",linewidth=0.16) {#XMUX3:5 (0,-187)};
// (0,-187.4) @TEXT("VSS",size=1.1,halign="middle",valign="top");
// &"TARGET3" @WIRE(mode="straight",linecolor="#30485d",linewidth=0.16) {#XMUX3:6 (10,-177)};
// (10.4,-177) @TEXT("TARGET3",size=1.1,halign="start",valign="middle");
// &"CODE2" @WIRE(mode="straight",linecolor="#30485d",linewidth=0.16) {#XMUX2:1 (-10,-211.6)};
// (-10.4,-211.6) @TEXT("CODE2",size=1.1,halign="end",valign="middle");
// &"D2" @WIRE(mode="straight",linecolor="#30485d",linewidth=0.16) {#XMUX2:2 (-10,-215)};
// (-10.4,-215) @TEXT("D2",size=1.1,halign="end",valign="middle");
// &"PHI_U" @WIRE(mode="straight",linecolor="#30485d",linewidth=0.16) {#XMUX2:3 (-10,-218.4)};
// (-10.4,-218.4) @TEXT("PHI_U",size=1.1,halign="end",valign="middle");
// &"VDD" @WIRE(mode="straight",linecolor="#30485d",linewidth=0.16) {#XMUX2:4 (0,-205)};
// (0,-204.6) @TEXT("VDD",size=1.1,halign="middle",valign="bottom");
// &"VSS" @WIRE(mode="straight",linecolor="#30485d",linewidth=0.16) {#XMUX2:5 (0,-225)};
// (0,-225.4) @TEXT("VSS",size=1.1,halign="middle",valign="top");
// &"TARGET2" @WIRE(mode="straight",linecolor="#30485d",linewidth=0.16) {#XMUX2:6 (10,-215)};
// (10.4,-215) @TEXT("TARGET2",size=1.1,halign="start",valign="middle");
// &"CODE1" @WIRE(mode="straight",linecolor="#30485d",linewidth=0.16) {#XMUX1:1 (-10,-249.6)};
// (-10.4,-249.6) @TEXT("CODE1",size=1.1,halign="end",valign="middle");
// &"D1" @WIRE(mode="straight",linecolor="#30485d",linewidth=0.16) {#XMUX1:2 (-10,-253)};
// (-10.4,-253) @TEXT("D1",size=1.1,halign="end",valign="middle");
// &"PHI_U" @WIRE(mode="straight",linecolor="#30485d",linewidth=0.16) {#XMUX1:3 (-10,-256.4)};
// (-10.4,-256.4) @TEXT("PHI_U",size=1.1,halign="end",valign="middle");
// &"VDD" @WIRE(mode="straight",linecolor="#30485d",linewidth=0.16) {#XMUX1:4 (0,-243)};
// (0,-242.6) @TEXT("VDD",size=1.1,halign="middle",valign="bottom");
// &"VSS" @WIRE(mode="straight",linecolor="#30485d",linewidth=0.16) {#XMUX1:5 (0,-263)};
// (0,-263.4) @TEXT("VSS",size=1.1,halign="middle",valign="top");
// &"TARGET1" @WIRE(mode="straight",linecolor="#30485d",linewidth=0.16) {#XMUX1:6 (10,-253)};
// (10.4,-253) @TEXT("TARGET1",size=1.1,halign="start",valign="middle");
// &"CODE0" @WIRE(mode="straight",linecolor="#30485d",linewidth=0.16) {#XMUX0:1 (-10,-287.6)};
// (-10.4,-287.6) @TEXT("CODE0",size=1.1,halign="end",valign="middle");
// &"D0" @WIRE(mode="straight",linecolor="#30485d",linewidth=0.16) {#XMUX0:2 (-10,-291)};
// (-10.4,-291) @TEXT("D0",size=1.1,halign="end",valign="middle");
// &"PHI_U" @WIRE(mode="straight",linecolor="#30485d",linewidth=0.16) {#XMUX0:3 (-10,-294.4)};
// (-10.4,-294.4) @TEXT("PHI_U",size=1.1,halign="end",valign="middle");
// &"VDD" @WIRE(mode="straight",linecolor="#30485d",linewidth=0.16) {#XMUX0:4 (0,-281)};
// (0,-280.6) @TEXT("VDD",size=1.1,halign="middle",valign="bottom");
// &"VSS" @WIRE(mode="straight",linecolor="#30485d",linewidth=0.16) {#XMUX0:5 (0,-301)};
// (0,-301.4) @TEXT("VSS",size=1.1,halign="middle",valign="top");
// &"TARGET0" @WIRE(mode="straight",linecolor="#30485d",linewidth=0.16) {#XMUX0:6 (10,-291)};
// (10.4,-291) @TEXT("TARGET0",size=1.1,halign="start",valign="middle");
// &"VDD" @WIRE(mode="straight",linecolor="#30485d",linewidth=0.16) {#X018:2 (118,-15)};
// (118,-14.6) @TEXT("VDD",size=1.1,halign="middle",valign="bottom");
// &"VSS" @WIRE(mode="straight",linecolor="#30485d",linewidth=0.16) {#X018:3 (118,-35)};
// (118,-35.4) @TEXT("VSS",size=1.1,halign="middle",valign="top");
// &"VDD" @WIRE(mode="straight",linecolor="#30485d",linewidth=0.16) {#X017:2 (43,-15)};
// (43,-14.6) @TEXT("VDD",size=1.1,halign="middle",valign="bottom");
// &"VSS" @WIRE(mode="straight",linecolor="#30485d",linewidth=0.16) {#X017:3 (43,-35)};
// (43,-35.4) @TEXT("VSS",size=1.1,halign="middle",valign="top");
// &"CAP_CLK" @WIRE(mode="straight",linecolor="#30485d",linewidth=0.16) {#XSTORE7:1 (76,-21.6)};
// (75.6,-21.6) @TEXT("CAP_CLK",size=1.1,halign="end",valign="middle");
// &"SAMPLE" @WIRE(mode="straight",linecolor="#30485d",linewidth=0.16) {#XSTORE7:4 (76,-28.4)};
// (75.6,-28.4) @TEXT("SAMPLE",size=1.1,halign="end",valign="middle");
// &"VDD" @WIRE(mode="straight",linecolor="#30485d",linewidth=0.16) {#XSTORE7:5 (86,-15)};
// (86,-14.6) @TEXT("VDD",size=1.1,halign="middle",valign="bottom");
// &"VSS" @WIRE(mode="straight",linecolor="#30485d",linewidth=0.16) {#XSTORE7:6 (86,-35)};
// (86,-35.4) @TEXT("VSS",size=1.1,halign="middle",valign="top");
// &"CAP_CLK" @WIRE(mode="straight",linecolor="#30485d",linewidth=0.16) {#XSTORE6:1 (76,-59.6)};
// (75.6,-59.6) @TEXT("CAP_CLK",size=1.1,halign="end",valign="middle");
// &"TARGET6" @WIRE(mode="straight",linecolor="#30485d",linewidth=0.16) {#XSTORE6:2 (76,-63)};
// (75.6,-63) @TEXT("TARGET6",size=1.1,halign="end",valign="middle");
// &"SAMPLE" @WIRE(mode="straight",linecolor="#30485d",linewidth=0.16) {#XSTORE6:4 (76,-66.4)};
// (75.6,-66.4) @TEXT("SAMPLE",size=1.1,halign="end",valign="middle");
// &"VDD" @WIRE(mode="straight",linecolor="#30485d",linewidth=0.16) {#XSTORE6:5 (86,-53)};
// (86,-52.6) @TEXT("VDD",size=1.1,halign="middle",valign="bottom");
// &"VSS" @WIRE(mode="straight",linecolor="#30485d",linewidth=0.16) {#XSTORE6:6 (86,-73)};
// (86,-73.4) @TEXT("VSS",size=1.1,halign="middle",valign="top");
// &"CAP_CLK" @WIRE(mode="straight",linecolor="#30485d",linewidth=0.16) {#XSTORE5:1 (76,-97.6)};
// (75.6,-97.6) @TEXT("CAP_CLK",size=1.1,halign="end",valign="middle");
// &"TARGET5" @WIRE(mode="straight",linecolor="#30485d",linewidth=0.16) {#XSTORE5:2 (76,-101)};
// (75.6,-101) @TEXT("TARGET5",size=1.1,halign="end",valign="middle");
// &"SAMPLE" @WIRE(mode="straight",linecolor="#30485d",linewidth=0.16) {#XSTORE5:4 (76,-104.4)};
// (75.6,-104.4) @TEXT("SAMPLE",size=1.1,halign="end",valign="middle");
// &"VDD" @WIRE(mode="straight",linecolor="#30485d",linewidth=0.16) {#XSTORE5:5 (86,-91)};
// (86,-90.6) @TEXT("VDD",size=1.1,halign="middle",valign="bottom");
// &"VSS" @WIRE(mode="straight",linecolor="#30485d",linewidth=0.16) {#XSTORE5:6 (86,-111)};
// (86,-111.4) @TEXT("VSS",size=1.1,halign="middle",valign="top");
// &"CAP_CLK" @WIRE(mode="straight",linecolor="#30485d",linewidth=0.16) {#XSTORE4:1 (76,-135.6)};
// (75.6,-135.6) @TEXT("CAP_CLK",size=1.1,halign="end",valign="middle");
// &"TARGET4" @WIRE(mode="straight",linecolor="#30485d",linewidth=0.16) {#XSTORE4:2 (76,-139)};
// (75.6,-139) @TEXT("TARGET4",size=1.1,halign="end",valign="middle");
// &"SAMPLE" @WIRE(mode="straight",linecolor="#30485d",linewidth=0.16) {#XSTORE4:4 (76,-142.4)};
// (75.6,-142.4) @TEXT("SAMPLE",size=1.1,halign="end",valign="middle");
// &"VDD" @WIRE(mode="straight",linecolor="#30485d",linewidth=0.16) {#XSTORE4:5 (86,-129)};
// (86,-128.6) @TEXT("VDD",size=1.1,halign="middle",valign="bottom");
// &"VSS" @WIRE(mode="straight",linecolor="#30485d",linewidth=0.16) {#XSTORE4:6 (86,-149)};
// (86,-149.4) @TEXT("VSS",size=1.1,halign="middle",valign="top");
// &"CAP_CLK" @WIRE(mode="straight",linecolor="#30485d",linewidth=0.16) {#XSTORE3:1 (76,-173.6)};
// (75.6,-173.6) @TEXT("CAP_CLK",size=1.1,halign="end",valign="middle");
// &"TARGET3" @WIRE(mode="straight",linecolor="#30485d",linewidth=0.16) {#XSTORE3:2 (76,-177)};
// (75.6,-177) @TEXT("TARGET3",size=1.1,halign="end",valign="middle");
// &"SAMPLE" @WIRE(mode="straight",linecolor="#30485d",linewidth=0.16) {#XSTORE3:4 (76,-180.4)};
// (75.6,-180.4) @TEXT("SAMPLE",size=1.1,halign="end",valign="middle");
// &"VDD" @WIRE(mode="straight",linecolor="#30485d",linewidth=0.16) {#XSTORE3:5 (86,-167)};
// (86,-166.6) @TEXT("VDD",size=1.1,halign="middle",valign="bottom");
// &"VSS" @WIRE(mode="straight",linecolor="#30485d",linewidth=0.16) {#XSTORE3:6 (86,-187)};
// (86,-187.4) @TEXT("VSS",size=1.1,halign="middle",valign="top");
// &"CAP_CLK" @WIRE(mode="straight",linecolor="#30485d",linewidth=0.16) {#XSTORE2:1 (76,-211.6)};
// (75.6,-211.6) @TEXT("CAP_CLK",size=1.1,halign="end",valign="middle");
// &"TARGET2" @WIRE(mode="straight",linecolor="#30485d",linewidth=0.16) {#XSTORE2:2 (76,-215)};
// (75.6,-215) @TEXT("TARGET2",size=1.1,halign="end",valign="middle");
// &"SAMPLE" @WIRE(mode="straight",linecolor="#30485d",linewidth=0.16) {#XSTORE2:4 (76,-218.4)};
// (75.6,-218.4) @TEXT("SAMPLE",size=1.1,halign="end",valign="middle");
// &"VDD" @WIRE(mode="straight",linecolor="#30485d",linewidth=0.16) {#XSTORE2:5 (86,-205)};
// (86,-204.6) @TEXT("VDD",size=1.1,halign="middle",valign="bottom");
// &"VSS" @WIRE(mode="straight",linecolor="#30485d",linewidth=0.16) {#XSTORE2:6 (86,-225)};
// (86,-225.4) @TEXT("VSS",size=1.1,halign="middle",valign="top");
// &"CAP_CLK" @WIRE(mode="straight",linecolor="#30485d",linewidth=0.16) {#XSTORE1:1 (76,-249.6)};
// (75.6,-249.6) @TEXT("CAP_CLK",size=1.1,halign="end",valign="middle");
// &"TARGET1" @WIRE(mode="straight",linecolor="#30485d",linewidth=0.16) {#XSTORE1:2 (76,-253)};
// (75.6,-253) @TEXT("TARGET1",size=1.1,halign="end",valign="middle");
// &"SAMPLE" @WIRE(mode="straight",linecolor="#30485d",linewidth=0.16) {#XSTORE1:4 (76,-256.4)};
// (75.6,-256.4) @TEXT("SAMPLE",size=1.1,halign="end",valign="middle");
// &"VDD" @WIRE(mode="straight",linecolor="#30485d",linewidth=0.16) {#XSTORE1:5 (86,-243)};
// (86,-242.6) @TEXT("VDD",size=1.1,halign="middle",valign="bottom");
// &"VSS" @WIRE(mode="straight",linecolor="#30485d",linewidth=0.16) {#XSTORE1:6 (86,-263)};
// (86,-263.4) @TEXT("VSS",size=1.1,halign="middle",valign="top");
// &"CAP_CLK" @WIRE(mode="straight",linecolor="#30485d",linewidth=0.16) {#XSTORE0:1 (76,-287.6)};
// (75.6,-287.6) @TEXT("CAP_CLK",size=1.1,halign="end",valign="middle");
// &"TARGET0" @WIRE(mode="straight",linecolor="#30485d",linewidth=0.16) {#XSTORE0:2 (76,-291)};
// (75.6,-291) @TEXT("TARGET0",size=1.1,halign="end",valign="middle");
// &"SAMPLE" @WIRE(mode="straight",linecolor="#30485d",linewidth=0.16) {#XSTORE0:4 (76,-294.4)};
// (75.6,-294.4) @TEXT("SAMPLE",size=1.1,halign="end",valign="middle");
// &"VDD" @WIRE(mode="straight",linecolor="#30485d",linewidth=0.16) {#XSTORE0:5 (86,-281)};
// (86,-280.6) @TEXT("VDD",size=1.1,halign="middle",valign="bottom");
// &"VSS" @WIRE(mode="straight",linecolor="#30485d",linewidth=0.16) {#XSTORE0:6 (86,-301)};
// (86,-301.4) @TEXT("VSS",size=1.1,halign="middle",valign="top");
// &"VDD" @WIRE(mode="straight",linecolor="#30485d",linewidth=0.16) {#XBBM7:4 (155,-14)};
// (155,-13.6) @TEXT("VDD",size=1.1,halign="middle",valign="bottom");
// &"VSS" @WIRE(mode="straight",linecolor="#30485d",linewidth=0.16) {#XBBM7:5 (155,-36)};
// (155,-36.4) @TEXT("VSS",size=1.1,halign="middle",valign="top");
// &"VDD" @WIRE(mode="straight",linecolor="#30485d",linewidth=0.16) {#XBBM6:4 (155,-52)};
// (155,-51.6) @TEXT("VDD",size=1.1,halign="middle",valign="bottom");
// &"VSS" @WIRE(mode="straight",linecolor="#30485d",linewidth=0.16) {#XBBM6:5 (155,-74)};
// (155,-74.4) @TEXT("VSS",size=1.1,halign="middle",valign="top");
// &"VDD" @WIRE(mode="straight",linecolor="#30485d",linewidth=0.16) {#XBBM5:4 (155,-90)};
// (155,-89.6) @TEXT("VDD",size=1.1,halign="middle",valign="bottom");
// &"VSS" @WIRE(mode="straight",linecolor="#30485d",linewidth=0.16) {#XBBM5:5 (155,-112)};
// (155,-112.4) @TEXT("VSS",size=1.1,halign="middle",valign="top");
// &"VDD" @WIRE(mode="straight",linecolor="#30485d",linewidth=0.16) {#XBBM4:4 (155,-128)};
// (155,-127.6) @TEXT("VDD",size=1.1,halign="middle",valign="bottom");
// &"VSS" @WIRE(mode="straight",linecolor="#30485d",linewidth=0.16) {#XBBM4:5 (155,-150)};
// (155,-150.4) @TEXT("VSS",size=1.1,halign="middle",valign="top");
// &"VDD" @WIRE(mode="straight",linecolor="#30485d",linewidth=0.16) {#XBBM3:4 (155,-166)};
// (155,-165.6) @TEXT("VDD",size=1.1,halign="middle",valign="bottom");
// &"VSS" @WIRE(mode="straight",linecolor="#30485d",linewidth=0.16) {#XBBM3:5 (155,-188)};
// (155,-188.4) @TEXT("VSS",size=1.1,halign="middle",valign="top");
// &"VDD" @WIRE(mode="straight",linecolor="#30485d",linewidth=0.16) {#XBBM2:4 (155,-204)};
// (155,-203.6) @TEXT("VDD",size=1.1,halign="middle",valign="bottom");
// &"VSS" @WIRE(mode="straight",linecolor="#30485d",linewidth=0.16) {#XBBM2:5 (155,-226)};
// (155,-226.4) @TEXT("VSS",size=1.1,halign="middle",valign="top");
// &"VDD" @WIRE(mode="straight",linecolor="#30485d",linewidth=0.16) {#XBBM1:4 (155,-242)};
// (155,-241.6) @TEXT("VDD",size=1.1,halign="middle",valign="bottom");
// &"VSS" @WIRE(mode="straight",linecolor="#30485d",linewidth=0.16) {#XBBM1:5 (155,-264)};
// (155,-264.4) @TEXT("VSS",size=1.1,halign="middle",valign="top");
// &"VDD" @WIRE(mode="straight",linecolor="#30485d",linewidth=0.16) {#XBBM0:4 (155,-280)};
// (155,-279.6) @TEXT("VDD",size=1.1,halign="middle",valign="bottom");
// &"VSS" @WIRE(mode="straight",linecolor="#30485d",linewidth=0.16) {#XBBM0:5 (155,-302)};
// (155,-302.4) @TEXT("VSS",size=1.1,halign="middle",valign="top");
// &"GNN0" @WIRE(mode="straight",linecolor="#30485d",linewidth=0.16) {#XDRV0:1 (234,-282.75)};
// (234.4,-282.75) @TEXT("GNN0",size=1.1,halign="start",valign="middle");
// &"GNP0" @WIRE(mode="straight",linecolor="#30485d",linewidth=0.16) {#XDRV0:2 (234,-286.05)};
// (234.4,-286.05) @TEXT("GNP0",size=1.1,halign="start",valign="middle");
// &"GPN0" @WIRE(mode="straight",linecolor="#30485d",linewidth=0.16) {#XDRV0:3 (234,-289.35)};
// (234.4,-289.35) @TEXT("GPN0",size=1.1,halign="start",valign="middle");
// &"GPP0" @WIRE(mode="straight",linecolor="#30485d",linewidth=0.16) {#XDRV0:4 (234,-292.65)};
// (234.4,-292.65) @TEXT("GPP0",size=1.1,halign="start",valign="middle");
// &"VDD" @WIRE(mode="straight",linecolor="#30485d",linewidth=0.16) {#XDRV0:7 (218,-274.45)};
// (218,-274.05) @TEXT("VDD",size=1.1,halign="middle",valign="bottom");
// &"VSS" @WIRE(mode="straight",linecolor="#30485d",linewidth=0.16) {#XDRV0:8 (218,-307.55)};
// (218,-307.95) @TEXT("VSS",size=1.1,halign="middle",valign="top");
// &"GNN1" @WIRE(mode="straight",linecolor="#30485d",linewidth=0.16) {#XDRV1:1 (234,-244.75)};
// (234.4,-244.75) @TEXT("GNN1",size=1.1,halign="start",valign="middle");
// &"GNP1" @WIRE(mode="straight",linecolor="#30485d",linewidth=0.16) {#XDRV1:2 (234,-248.05)};
// (234.4,-248.05) @TEXT("GNP1",size=1.1,halign="start",valign="middle");
// &"GPN1" @WIRE(mode="straight",linecolor="#30485d",linewidth=0.16) {#XDRV1:3 (234,-251.35)};
// (234.4,-251.35) @TEXT("GPN1",size=1.1,halign="start",valign="middle");
// &"GPP1" @WIRE(mode="straight",linecolor="#30485d",linewidth=0.16) {#XDRV1:4 (234,-254.65)};
// (234.4,-254.65) @TEXT("GPP1",size=1.1,halign="start",valign="middle");
// &"VDD" @WIRE(mode="straight",linecolor="#30485d",linewidth=0.16) {#XDRV1:7 (218,-236.45)};
// (218,-236.05) @TEXT("VDD",size=1.1,halign="middle",valign="bottom");
// &"VSS" @WIRE(mode="straight",linecolor="#30485d",linewidth=0.16) {#XDRV1:8 (218,-269.55)};
// (218,-269.95) @TEXT("VSS",size=1.1,halign="middle",valign="top");
// &"GNN2" @WIRE(mode="straight",linecolor="#30485d",linewidth=0.16) {#XDRV2:1 (234,-206.75)};
// (234.4,-206.75) @TEXT("GNN2",size=1.1,halign="start",valign="middle");
// &"GNP2" @WIRE(mode="straight",linecolor="#30485d",linewidth=0.16) {#XDRV2:2 (234,-210.05)};
// (234.4,-210.05) @TEXT("GNP2",size=1.1,halign="start",valign="middle");
// &"GPN2" @WIRE(mode="straight",linecolor="#30485d",linewidth=0.16) {#XDRV2:3 (234,-213.35)};
// (234.4,-213.35) @TEXT("GPN2",size=1.1,halign="start",valign="middle");
// &"GPP2" @WIRE(mode="straight",linecolor="#30485d",linewidth=0.16) {#XDRV2:4 (234,-216.65)};
// (234.4,-216.65) @TEXT("GPP2",size=1.1,halign="start",valign="middle");
// &"VDD" @WIRE(mode="straight",linecolor="#30485d",linewidth=0.16) {#XDRV2:7 (218,-198.45)};
// (218,-198.05) @TEXT("VDD",size=1.1,halign="middle",valign="bottom");
// &"VSS" @WIRE(mode="straight",linecolor="#30485d",linewidth=0.16) {#XDRV2:8 (218,-231.55)};
// (218,-231.95) @TEXT("VSS",size=1.1,halign="middle",valign="top");
// &"GNN3" @WIRE(mode="straight",linecolor="#30485d",linewidth=0.16) {#XDRV3:1 (234,-168.75)};
// (234.4,-168.75) @TEXT("GNN3",size=1.1,halign="start",valign="middle");
// &"GNP3" @WIRE(mode="straight",linecolor="#30485d",linewidth=0.16) {#XDRV3:2 (234,-172.05)};
// (234.4,-172.05) @TEXT("GNP3",size=1.1,halign="start",valign="middle");
// &"GPN3" @WIRE(mode="straight",linecolor="#30485d",linewidth=0.16) {#XDRV3:3 (234,-175.35)};
// (234.4,-175.35) @TEXT("GPN3",size=1.1,halign="start",valign="middle");
// &"GPP3" @WIRE(mode="straight",linecolor="#30485d",linewidth=0.16) {#XDRV3:4 (234,-178.65)};
// (234.4,-178.65) @TEXT("GPP3",size=1.1,halign="start",valign="middle");
// &"VDD" @WIRE(mode="straight",linecolor="#30485d",linewidth=0.16) {#XDRV3:7 (218,-160.45)};
// (218,-160.05) @TEXT("VDD",size=1.1,halign="middle",valign="bottom");
// &"VSS" @WIRE(mode="straight",linecolor="#30485d",linewidth=0.16) {#XDRV3:8 (218,-193.55)};
// (218,-193.95) @TEXT("VSS",size=1.1,halign="middle",valign="top");
// &"GNN4" @WIRE(mode="straight",linecolor="#30485d",linewidth=0.16) {#XDRV4:1 (234,-130.75)};
// (234.4,-130.75) @TEXT("GNN4",size=1.1,halign="start",valign="middle");
// &"GNP4" @WIRE(mode="straight",linecolor="#30485d",linewidth=0.16) {#XDRV4:2 (234,-134.05)};
// (234.4,-134.05) @TEXT("GNP4",size=1.1,halign="start",valign="middle");
// &"GPN4" @WIRE(mode="straight",linecolor="#30485d",linewidth=0.16) {#XDRV4:3 (234,-137.35)};
// (234.4,-137.35) @TEXT("GPN4",size=1.1,halign="start",valign="middle");
// &"GPP4" @WIRE(mode="straight",linecolor="#30485d",linewidth=0.16) {#XDRV4:4 (234,-140.65)};
// (234.4,-140.65) @TEXT("GPP4",size=1.1,halign="start",valign="middle");
// &"VDD" @WIRE(mode="straight",linecolor="#30485d",linewidth=0.16) {#XDRV4:7 (218,-122.45)};
// (218,-122.05) @TEXT("VDD",size=1.1,halign="middle",valign="bottom");
// &"VSS" @WIRE(mode="straight",linecolor="#30485d",linewidth=0.16) {#XDRV4:8 (218,-155.55)};
// (218,-155.95) @TEXT("VSS",size=1.1,halign="middle",valign="top");
// &"GNN5" @WIRE(mode="straight",linecolor="#30485d",linewidth=0.16) {#XDRV5:1 (234,-92.75)};
// (234.4,-92.75) @TEXT("GNN5",size=1.1,halign="start",valign="middle");
// &"GNP5" @WIRE(mode="straight",linecolor="#30485d",linewidth=0.16) {#XDRV5:2 (234,-96.05)};
// (234.4,-96.05) @TEXT("GNP5",size=1.1,halign="start",valign="middle");
// &"GPN5" @WIRE(mode="straight",linecolor="#30485d",linewidth=0.16) {#XDRV5:3 (234,-99.35)};
// (234.4,-99.35) @TEXT("GPN5",size=1.1,halign="start",valign="middle");
// &"GPP5" @WIRE(mode="straight",linecolor="#30485d",linewidth=0.16) {#XDRV5:4 (234,-102.65)};
// (234.4,-102.65) @TEXT("GPP5",size=1.1,halign="start",valign="middle");
// &"VDD" @WIRE(mode="straight",linecolor="#30485d",linewidth=0.16) {#XDRV5:7 (218,-84.45)};
// (218,-84.05) @TEXT("VDD",size=1.1,halign="middle",valign="bottom");
// &"VSS" @WIRE(mode="straight",linecolor="#30485d",linewidth=0.16) {#XDRV5:8 (218,-117.55)};
// (218,-117.95) @TEXT("VSS",size=1.1,halign="middle",valign="top");
// &"GNN6" @WIRE(mode="straight",linecolor="#30485d",linewidth=0.16) {#XDRV6:1 (234,-54.75)};
// (234.4,-54.75) @TEXT("GNN6",size=1.1,halign="start",valign="middle");
// &"GNP6" @WIRE(mode="straight",linecolor="#30485d",linewidth=0.16) {#XDRV6:2 (234,-58.05)};
// (234.4,-58.05) @TEXT("GNP6",size=1.1,halign="start",valign="middle");
// &"GPN6" @WIRE(mode="straight",linecolor="#30485d",linewidth=0.16) {#XDRV6:3 (234,-61.35)};
// (234.4,-61.35) @TEXT("GPN6",size=1.1,halign="start",valign="middle");
// &"GPP6" @WIRE(mode="straight",linecolor="#30485d",linewidth=0.16) {#XDRV6:4 (234,-64.65)};
// (234.4,-64.65) @TEXT("GPP6",size=1.1,halign="start",valign="middle");
// &"VDD" @WIRE(mode="straight",linecolor="#30485d",linewidth=0.16) {#XDRV6:7 (218,-46.45)};
// (218,-46.05) @TEXT("VDD",size=1.1,halign="middle",valign="bottom");
// &"VSS" @WIRE(mode="straight",linecolor="#30485d",linewidth=0.16) {#XDRV6:8 (218,-79.55)};
// (218,-79.95) @TEXT("VSS",size=1.1,halign="middle",valign="top");
// &"GNN7" @WIRE(mode="straight",linecolor="#30485d",linewidth=0.16) {#XDRV7:1 (234,-16.75)};
// (234.4,-16.75) @TEXT("GNN7",size=1.1,halign="start",valign="middle");
// &"GNP7" @WIRE(mode="straight",linecolor="#30485d",linewidth=0.16) {#XDRV7:2 (234,-20.05)};
// (234.4,-20.05) @TEXT("GNP7",size=1.1,halign="start",valign="middle");
// &"GPN7" @WIRE(mode="straight",linecolor="#30485d",linewidth=0.16) {#XDRV7:3 (234,-23.35)};
// (234.4,-23.35) @TEXT("GPN7",size=1.1,halign="start",valign="middle");
// &"GPP7" @WIRE(mode="straight",linecolor="#30485d",linewidth=0.16) {#XDRV7:4 (234,-26.65)};
// (234.4,-26.65) @TEXT("GPP7",size=1.1,halign="start",valign="middle");
// &"VDD" @WIRE(mode="straight",linecolor="#30485d",linewidth=0.16) {#XDRV7:7 (218,-8.45)};
// (218,-8.05) @TEXT("VDD",size=1.1,halign="middle",valign="bottom");
// &"VSS" @WIRE(mode="straight",linecolor="#30485d",linewidth=0.16) {#XDRV7:8 (218,-41.55)};
// (218,-41.95) @TEXT("VSS",size=1.1,halign="middle",valign="top");
// }
// END SARADC RNL
ends sar8p_refword

subckt sar8s_refword CODE0 CODE1 CODE2 CODE3 CODE4 CODE5 CODE6 CODE7 D0 D1  D2 D3 D4 D5 D6 D7 GNN0 GNN1 GNN2 GNN3 GNN4 GNN5 GNN6 GNN7 GNP0  GNP1 GNP2 GNP3 GNP4 GNP5 GNP6 GNP7 GPN0 GPN1 GPN2 GPN3 GPN4 GPN5  GPN6 GPN7 GPP0 GPP1 GPP2 GPP3 GPP4 GPP5 GPP6 GPP7 PHI_U SAMPLE VDD  VSS RST_DONE
    XRR7 (SAMPLE SAMPLE VDD VSS RST7) sar8p_and2
    XRSTEP1 (SAMPLE VDD VSS TAP1) sar8s_step
    XRR6 (SAMPLE TAP1 VDD VSS RST6) sar8p_and2
    XRSTEP2 (TAP1 VDD VSS TAP2) sar8s_step
    XRR5 (SAMPLE TAP2 VDD VSS RST5) sar8p_and2
    XRSTEP3 (TAP2 VDD VSS TAP3) sar8s_step
    XRR4 (SAMPLE TAP3 VDD VSS RST4) sar8p_and2
    XRSTEP4 (TAP3 VDD VSS TAP4) sar8s_step
    XRR3 (SAMPLE TAP4 VDD VSS RST3) sar8p_and2
    XRSTEP5 (TAP4 VDD VSS TAP5) sar8s_step
    XRR2 (SAMPLE TAP5 VDD VSS RST2) sar8p_and2
    XRSTEP6 (TAP5 VDD VSS TAP6) sar8s_step
    XRR1 (SAMPLE TAP6 VDD VSS RST1) sar8p_and2
    XRSTEP7 (TAP6 VDD VSS TAP7) sar8s_step
    XRR0 (SAMPLE TAP7 VDD VSS RST0) sar8p_and2
    XRDONE (RST0 VDD VSS RST_DONE) sar8p_buf
    X002 (FIRST1 VDD VSS FIRST2) sar8p_buf
    X001 (FIRST0 VDD VSS FIRST1) sar8p_buf
    X000 (PHI_U VDD VSS FIRST0) sar8p_buf
    X007 (FIRST2 LATE_CLK VDD VSS CAP_REQ) sar8p_or2
    X003 (SAMPLE ACK VDD VSS REQ_RESET) sar8p_or2
    XREQUEST (REQ_Q REQ_RESET PHI_U VDD VSS) sar8p_sr
    XD_LATE_CLK (REQ_Q VDD VSS LATE_CLK) sar8p_delay_capture
    XD_ACK (LATE_CLK VDD VSS ACK) sar8p_delay_valid
    X008 (CAP_REQ VDD VSS CAP_CLK) sar8p_clkbuf
    XMUX7 (CODE7 D7 PHI_U VDD VSS TARGET7) sar8p_mux2
    XMUX6 (CODE6 D6 PHI_U VDD VSS TARGET6) sar8p_mux2
    XMUX5 (CODE5 D5 PHI_U VDD VSS TARGET5) sar8p_mux2
    XMUX4 (CODE4 D4 PHI_U VDD VSS TARGET4) sar8p_mux2
    XMUX3 (CODE3 D3 PHI_U VDD VSS TARGET3) sar8p_mux2
    XMUX2 (CODE2 D2 PHI_U VDD VSS TARGET2) sar8p_mux2
    XMUX1 (CODE1 D1 PHI_U VDD VSS TARGET1) sar8p_mux2
    XMUX0 (CODE0 D0 PHI_U VDD VSS TARGET0) sar8p_mux2
    X018 (MSB_QN VDD VSS Q7) sar8p_inv
    X017 (TARGET7 VDD VSS MSB_DN) sar8p_inv
    XSTORE7 (CAP_CLK MSB_DN MSB_QN RST7 VDD VSS) sar8p_dffr
    XSTORE6 (CAP_CLK TARGET6 Q6 RST6 VDD VSS) sar8p_dffr
    XSTORE5 (CAP_CLK TARGET5 Q5 RST5 VDD VSS) sar8p_dffr
    XSTORE4 (CAP_CLK TARGET4 Q4 RST4 VDD VSS) sar8p_dffr
    XSTORE3 (CAP_CLK TARGET3 Q3 RST3 VDD VSS) sar8p_dffr
    XSTORE2 (CAP_CLK TARGET2 Q2 RST2 VDD VSS) sar8p_dffr
    XSTORE1 (CAP_CLK TARGET1 Q1 RST1 VDD VSS) sar8p_dffr
    XSTORE0 (CAP_CLK TARGET0 Q0 RST0 VDD VSS) sar8p_dffr
    XBBM7 (Q7 H7 L7 VDD VSS) sar8p_nonoverlap
    XBBM6 (Q6 H6 L6 VDD VSS) sar8p_nonoverlap
    XBBM5 (Q5 H5 L5 VDD VSS) sar8p_nonoverlap
    XBBM4 (Q4 H4 L4 VDD VSS) sar8p_nonoverlap
    XBBM3 (Q3 H3 L3 VDD VSS) sar8p_nonoverlap
    XBBM2 (Q2 H2 L2 VDD VSS) sar8p_nonoverlap
    XBBM1 (Q1 H1 L1 VDD VSS) sar8p_nonoverlap
    XBBM0 (Q0 H0 L0 VDD VSS) sar8p_nonoverlap
    XDRV0 (GNN0 GNP0 GPN0 GPP0 H0 L0 VDD VSS) sar8p_refdrv_b0
    XDRV1 (GNN1 GNP1 GPN1 GPP1 H1 L1 VDD VSS) sar8p_refdrv_b1
    XDRV2 (GNN2 GNP2 GPN2 GPP2 H2 L2 VDD VSS) sar8p_refdrv_b2
    XDRV3 (GNN3 GNP3 GPN3 GPP3 H3 L3 VDD VSS) sar8p_refdrv_b3
    XDRV4 (GNN4 GNP4 GPN4 GPP4 H4 L4 VDD VSS) sar8p_refdrv_b4
    XDRV5 (GNN5 GNP5 GPN5 GPP5 H5 L5 VDD VSS) sar8p_refdrv_b5
    XDRV6 (GNN6 GNP6 GPN6 GPP6 H6 L6 VDD VSS) sar8p_refdrv_b6
    XDRV7 (GNN7 GNP7 GPN7 GPP7 H7 L7 VDD VSS) sar8p_refdrv_b7
// BEGIN SARADC RNL
// @RNL(author="saradc topology") {
// (-24,205) @TEXT("sar8s_refword / capture, sequential reset, nonoverlap and gate drive",size=1.5,halign="start",textcolor="#223d52");
// (-24,187) @TEXT("Sequential preset / bit 7 -> bit 0",size=1.1,halign="start",textcolor="#223d52");
// #XRSTEP1 @SET-SYMBOL $S_sar8s_step;
// #XRSTEP1 @PLACE(43,160) => @ORIENT("R0");
// #XRSTEP2 @SET-SYMBOL $S_sar8s_step;
// #XRSTEP2 @PLACE(86,160) => @ORIENT("R0");
// #XRSTEP3 @SET-SYMBOL $S_sar8s_step;
// #XRSTEP3 @PLACE(129,160) => @ORIENT("R0");
// #XRSTEP4 @SET-SYMBOL $S_sar8s_step;
// #XRSTEP4 @PLACE(172,160) => @ORIENT("R0");
// #XRSTEP5 @SET-SYMBOL $S_sar8s_step;
// #XRSTEP5 @PLACE(215,160) => @ORIENT("R0");
// #XRSTEP6 @SET-SYMBOL $S_sar8s_step;
// #XRSTEP6 @PLACE(258,160) => @ORIENT("R0");
// #XRSTEP7 @SET-SYMBOL $S_sar8s_step;
// #XRSTEP7 @PLACE(301,160) => @ORIENT("R0");
// #XRR7 @SET-SYMBOL $S_sar8p_and2;
// #XRR7 @PLACE(0,125) => @ORIENT("R0");
// #XRR6 @SET-SYMBOL $S_sar8p_and2;
// #XRR6 @PLACE(43,125) => @ORIENT("R0");
// #XRR5 @SET-SYMBOL $S_sar8p_and2;
// #XRR5 @PLACE(86,125) => @ORIENT("R0");
// #XRR4 @SET-SYMBOL $S_sar8p_and2;
// #XRR4 @PLACE(129,125) => @ORIENT("R0");
// #XRR3 @SET-SYMBOL $S_sar8p_and2;
// #XRR3 @PLACE(172,125) => @ORIENT("R0");
// #XRR2 @SET-SYMBOL $S_sar8p_and2;
// #XRR2 @PLACE(215,125) => @ORIENT("R0");
// #XRR1 @SET-SYMBOL $S_sar8p_and2;
// #XRR1 @PLACE(258,125) => @ORIENT("R0");
// #XRR0 @SET-SYMBOL $S_sar8p_and2;
// #XRR0 @PLACE(301,125) => @ORIENT("R0");
// #XRDONE @SET-SYMBOL $S_sar8p_buf;
// #XRDONE @PLACE(344,125) => @ORIENT("R0");
// &"TAP1" @WIRE(mode="straight",linecolor="#30485d",linewidth=0.16) {(63,123.3) (63,160)};
// &"TAP1" @WIRE(mode="straight",linecolor="#30485d",linewidth=0.16) {#XRSTEP1:4 (63,160)};
// $JUNCTION @ATTACH (63,160);
// &"TAP1" @WIRE(mode="straight",linecolor="#30485d",linewidth=0.16) {#XRR6:2 (63,123.3)};
// $JUNCTION @ATTACH (63,123.3);
// &"TAP1" @WIRE(mode="straight",linecolor="#30485d",linewidth=0.16) {#XRSTEP2:1 (63,160)};
// $JUNCTION @ATTACH (63,160);
// &"TAP2" @WIRE(mode="straight",linecolor="#30485d",linewidth=0.16) {(106,123.3) (106,160)};
// &"TAP2" @WIRE(mode="straight",linecolor="#30485d",linewidth=0.16) {#XRSTEP2:4 (106,160)};
// $JUNCTION @ATTACH (106,160);
// &"TAP2" @WIRE(mode="straight",linecolor="#30485d",linewidth=0.16) {#XRR5:2 (106,123.3)};
// $JUNCTION @ATTACH (106,123.3);
// &"TAP2" @WIRE(mode="straight",linecolor="#30485d",linewidth=0.16) {#XRSTEP3:1 (106,160)};
// $JUNCTION @ATTACH (106,160);
// &"TAP3" @WIRE(mode="straight",linecolor="#30485d",linewidth=0.16) {(149,123.3) (149,160)};
// &"TAP3" @WIRE(mode="straight",linecolor="#30485d",linewidth=0.16) {#XRSTEP3:4 (149,160)};
// $JUNCTION @ATTACH (149,160);
// &"TAP3" @WIRE(mode="straight",linecolor="#30485d",linewidth=0.16) {#XRR4:2 (149,123.3)};
// $JUNCTION @ATTACH (149,123.3);
// &"TAP3" @WIRE(mode="straight",linecolor="#30485d",linewidth=0.16) {#XRSTEP4:1 (149,160)};
// $JUNCTION @ATTACH (149,160);
// &"TAP4" @WIRE(mode="straight",linecolor="#30485d",linewidth=0.16) {(192,123.3) (192,160)};
// &"TAP4" @WIRE(mode="straight",linecolor="#30485d",linewidth=0.16) {#XRSTEP4:4 (192,160)};
// $JUNCTION @ATTACH (192,160);
// &"TAP4" @WIRE(mode="straight",linecolor="#30485d",linewidth=0.16) {#XRR3:2 (192,123.3)};
// $JUNCTION @ATTACH (192,123.3);
// &"TAP4" @WIRE(mode="straight",linecolor="#30485d",linewidth=0.16) {#XRSTEP5:1 (192,160)};
// $JUNCTION @ATTACH (192,160);
// &"TAP5" @WIRE(mode="straight",linecolor="#30485d",linewidth=0.16) {(235,123.3) (235,160)};
// &"TAP5" @WIRE(mode="straight",linecolor="#30485d",linewidth=0.16) {#XRSTEP5:4 (235,160)};
// $JUNCTION @ATTACH (235,160);
// &"TAP5" @WIRE(mode="straight",linecolor="#30485d",linewidth=0.16) {#XRR2:2 (235,123.3)};
// $JUNCTION @ATTACH (235,123.3);
// &"TAP5" @WIRE(mode="straight",linecolor="#30485d",linewidth=0.16) {#XRSTEP6:1 (235,160)};
// $JUNCTION @ATTACH (235,160);
// &"TAP6" @WIRE(mode="straight",linecolor="#30485d",linewidth=0.16) {(278,123.3) (278,160)};
// &"TAP6" @WIRE(mode="straight",linecolor="#30485d",linewidth=0.16) {#XRSTEP6:4 (278,160)};
// $JUNCTION @ATTACH (278,160);
// &"TAP6" @WIRE(mode="straight",linecolor="#30485d",linewidth=0.16) {#XRR1:2 (278,123.3)};
// $JUNCTION @ATTACH (278,123.3);
// &"TAP6" @WIRE(mode="straight",linecolor="#30485d",linewidth=0.16) {#XRSTEP7:1 (278,160)};
// $JUNCTION @ATTACH (278,160);
// &"TAP7" @WIRE(mode="straight",linecolor="#30485d",linewidth=0.16) {(321,123.3) (321,160)};
// &"TAP7" @WIRE(mode="straight",linecolor="#30485d",linewidth=0.16) {#XRSTEP7:4 (321,160)};
// $JUNCTION @ATTACH (321,160);
// &"TAP7" @WIRE(mode="straight",linecolor="#30485d",linewidth=0.16) {#XRR0:2 (321,123.3)};
// $JUNCTION @ATTACH (321,123.3);
// (-24,90) @TEXT("Capture request / first and late clocks / acknowledge",size=1.1,halign="start",textcolor="#223d52");
// #X000 @SET-SYMBOL $S_sar8p_buf;
// #X000 @PLACE(0,65) => @ORIENT("R0");
// #X001 @SET-SYMBOL $S_sar8p_buf;
// #X001 @PLACE(43,65) => @ORIENT("R0");
// #X002 @SET-SYMBOL $S_sar8p_buf;
// #X002 @PLACE(86,65) => @ORIENT("R0");
// #X007 @SET-SYMBOL $S_sar8p_or2;
// #X007 @PLACE(171,65) => @ORIENT("R0");
// #X008 @SET-SYMBOL $S_sar8p_clkbuf;
// #X008 @PLACE(214,65) => @ORIENT("R0");
// #X003 @SET-SYMBOL $S_sar8p_or2;
// #X003 @PLACE(0,25) => @ORIENT("R0");
// #XREQUEST @SET-SYMBOL $S_sar8p_sr;
// #XREQUEST @PLACE(43,25) => @ORIENT("R0");
// #XD_LATE_CLK @SET-SYMBOL $S_sar8p_delay_capture;
// #XD_LATE_CLK @PLACE(86,25) => @ORIENT("R0");
// #XD_ACK @SET-SYMBOL $S_sar8p_delay_valid;
// #XD_ACK @PLACE(129,25) => @ORIENT("R0");
// #XMUX7 @SET-SYMBOL $S_sar8p_mux2;
// #XMUX7 @PLACE(0,-25) => @ORIENT("R0");
// #XSTORE7 @SET-SYMBOL $S_sar8p_dffr;
// #XSTORE7 @PLACE(86,-25) => @ORIENT("R0");
// #XBBM7 @SET-SYMBOL $S_sar8p_nonoverlap;
// #XBBM7 @PLACE(155,-25) => @ORIENT("R0");
// #XDRV7 @SET-SYMBOL $S_sar8p_refdrv_b7;
// #XDRV7 @PLACE(218,-25) => @ORIENT("R0");
// (-24,-11) @TEXT("bit 7",size=1,halign="start",textcolor="#223d52");
// #XMUX6 @SET-SYMBOL $S_sar8p_mux2;
// #XMUX6 @PLACE(0,-63) => @ORIENT("R0");
// #XSTORE6 @SET-SYMBOL $S_sar8p_dffr;
// #XSTORE6 @PLACE(86,-63) => @ORIENT("R0");
// #XBBM6 @SET-SYMBOL $S_sar8p_nonoverlap;
// #XBBM6 @PLACE(155,-63) => @ORIENT("R0");
// #XDRV6 @SET-SYMBOL $S_sar8p_refdrv_b6;
// #XDRV6 @PLACE(218,-63) => @ORIENT("R0");
// (-24,-49) @TEXT("bit 6",size=1,halign="start",textcolor="#223d52");
// #XMUX5 @SET-SYMBOL $S_sar8p_mux2;
// #XMUX5 @PLACE(0,-101) => @ORIENT("R0");
// #XSTORE5 @SET-SYMBOL $S_sar8p_dffr;
// #XSTORE5 @PLACE(86,-101) => @ORIENT("R0");
// #XBBM5 @SET-SYMBOL $S_sar8p_nonoverlap;
// #XBBM5 @PLACE(155,-101) => @ORIENT("R0");
// #XDRV5 @SET-SYMBOL $S_sar8p_refdrv_b5;
// #XDRV5 @PLACE(218,-101) => @ORIENT("R0");
// (-24,-87) @TEXT("bit 5",size=1,halign="start",textcolor="#223d52");
// #XMUX4 @SET-SYMBOL $S_sar8p_mux2;
// #XMUX4 @PLACE(0,-139) => @ORIENT("R0");
// #XSTORE4 @SET-SYMBOL $S_sar8p_dffr;
// #XSTORE4 @PLACE(86,-139) => @ORIENT("R0");
// #XBBM4 @SET-SYMBOL $S_sar8p_nonoverlap;
// #XBBM4 @PLACE(155,-139) => @ORIENT("R0");
// #XDRV4 @SET-SYMBOL $S_sar8p_refdrv_b4;
// #XDRV4 @PLACE(218,-139) => @ORIENT("R0");
// (-24,-125) @TEXT("bit 4",size=1,halign="start",textcolor="#223d52");
// #XMUX3 @SET-SYMBOL $S_sar8p_mux2;
// #XMUX3 @PLACE(0,-177) => @ORIENT("R0");
// #XSTORE3 @SET-SYMBOL $S_sar8p_dffr;
// #XSTORE3 @PLACE(86,-177) => @ORIENT("R0");
// #XBBM3 @SET-SYMBOL $S_sar8p_nonoverlap;
// #XBBM3 @PLACE(155,-177) => @ORIENT("R0");
// #XDRV3 @SET-SYMBOL $S_sar8p_refdrv_b3;
// #XDRV3 @PLACE(218,-177) => @ORIENT("R0");
// (-24,-163) @TEXT("bit 3",size=1,halign="start",textcolor="#223d52");
// #XMUX2 @SET-SYMBOL $S_sar8p_mux2;
// #XMUX2 @PLACE(0,-215) => @ORIENT("R0");
// #XSTORE2 @SET-SYMBOL $S_sar8p_dffr;
// #XSTORE2 @PLACE(86,-215) => @ORIENT("R0");
// #XBBM2 @SET-SYMBOL $S_sar8p_nonoverlap;
// #XBBM2 @PLACE(155,-215) => @ORIENT("R0");
// #XDRV2 @SET-SYMBOL $S_sar8p_refdrv_b2;
// #XDRV2 @PLACE(218,-215) => @ORIENT("R0");
// (-24,-201) @TEXT("bit 2",size=1,halign="start",textcolor="#223d52");
// #XMUX1 @SET-SYMBOL $S_sar8p_mux2;
// #XMUX1 @PLACE(0,-253) => @ORIENT("R0");
// #XSTORE1 @SET-SYMBOL $S_sar8p_dffr;
// #XSTORE1 @PLACE(86,-253) => @ORIENT("R0");
// #XBBM1 @SET-SYMBOL $S_sar8p_nonoverlap;
// #XBBM1 @PLACE(155,-253) => @ORIENT("R0");
// #XDRV1 @SET-SYMBOL $S_sar8p_refdrv_b1;
// #XDRV1 @PLACE(218,-253) => @ORIENT("R0");
// (-24,-239) @TEXT("bit 1",size=1,halign="start",textcolor="#223d52");
// #XMUX0 @SET-SYMBOL $S_sar8p_mux2;
// #XMUX0 @PLACE(0,-291) => @ORIENT("R0");
// #XSTORE0 @SET-SYMBOL $S_sar8p_dffr;
// #XSTORE0 @PLACE(86,-291) => @ORIENT("R0");
// #XBBM0 @SET-SYMBOL $S_sar8p_nonoverlap;
// #XBBM0 @PLACE(155,-291) => @ORIENT("R0");
// #XDRV0 @SET-SYMBOL $S_sar8p_refdrv_b0;
// #XDRV0 @PLACE(218,-291) => @ORIENT("R0");
// (-24,-277) @TEXT("bit 0",size=1,halign="start",textcolor="#223d52");
// #X017 @SET-SYMBOL $S_sar8p_inv;
// #X017 @PLACE(43,-25) => @ORIENT("R0");
// #X018 @SET-SYMBOL $S_sar8p_inv;
// #X018 @PLACE(118,-25) => @ORIENT("R0");
// &"FIRST1" @WIRE(mode="straight",linecolor="#30485d",linewidth=0.16) {#X002:1 (64.5,65) (64.5,65) #X001:4};
// &"FIRST0" @WIRE(mode="straight",linecolor="#30485d",linewidth=0.16) {#X001:1 (21.5,65) (21.5,65) #X000:4};
// &"REQ_RESET" @WIRE(mode="straight",linecolor="#30485d",linewidth=0.16) {#X003:5 (18.5,25) (18.5,26.65) #XREQUEST:2};
// &"REQ_Q" @WIRE(mode="straight",linecolor="#30485d",linewidth=0.16) {#XREQUEST:1 (64.5,25) (64.5,25) #XD_LATE_CLK:1};
// &"TARGET7" @WIRE(mode="straight",linecolor="#30485d",linewidth=0.16) {#XMUX7:6 (21.5,-25) (21.5,-25) #X017:1};
// &"MSB_QN" @WIRE(mode="straight",linecolor="#30485d",linewidth=0.16) {#X018:1 (102,-25) (102,-25) #XSTORE7:3};
// &"Q7" @WIRE(mode="straight",linecolor="#30485d",linewidth=0.16) {#X018:4 (133.5,-25) (133.5,-25) #XBBM7:1};
// &"MSB_DN" @WIRE(mode="straight",linecolor="#30485d",linewidth=0.16) {#X017:4 (64.5,-25) (64.5,-25) #XSTORE7:2};
// &"Q6" @WIRE(mode="straight",linecolor="#30485d",linewidth=0.16) {#XSTORE6:3 (117.5,-63) (117.5,-63) #XBBM6:1};
// &"Q5" @WIRE(mode="straight",linecolor="#30485d",linewidth=0.16) {#XSTORE5:3 (117.5,-101) (117.5,-101) #XBBM5:1};
// &"Q4" @WIRE(mode="straight",linecolor="#30485d",linewidth=0.16) {#XSTORE4:3 (117.5,-139) (117.5,-139) #XBBM4:1};
// &"Q3" @WIRE(mode="straight",linecolor="#30485d",linewidth=0.16) {#XSTORE3:3 (117.5,-177) (117.5,-177) #XBBM3:1};
// &"Q2" @WIRE(mode="straight",linecolor="#30485d",linewidth=0.16) {#XSTORE2:3 (117.5,-215) (117.5,-215) #XBBM2:1};
// &"Q1" @WIRE(mode="straight",linecolor="#30485d",linewidth=0.16) {#XSTORE1:3 (117.5,-253) (117.5,-253) #XBBM1:1};
// &"Q0" @WIRE(mode="straight",linecolor="#30485d",linewidth=0.16) {#XSTORE0:3 (117.5,-291) (117.5,-291) #XBBM0:1};
// &"H7" @WIRE(mode="straight",linecolor="#30485d",linewidth=0.16) {#XBBM7:2 (199.5,-23.35) (199.5,-29.95) #XDRV7:5};
// &"L7" @WIRE(mode="straight",linecolor="#30485d",linewidth=0.16) {#XBBM7:3 (199.5,-26.65) (199.5,-33.25) #XDRV7:6};
// &"H6" @WIRE(mode="straight",linecolor="#30485d",linewidth=0.16) {#XBBM6:2 (199.5,-61.35) (199.5,-67.95) #XDRV6:5};
// &"L6" @WIRE(mode="straight",linecolor="#30485d",linewidth=0.16) {#XBBM6:3 (199.5,-64.65) (199.5,-71.25) #XDRV6:6};
// &"H5" @WIRE(mode="straight",linecolor="#30485d",linewidth=0.16) {#XBBM5:2 (199.5,-99.35) (199.5,-105.95) #XDRV5:5};
// &"L5" @WIRE(mode="straight",linecolor="#30485d",linewidth=0.16) {#XBBM5:3 (199.5,-102.65) (199.5,-109.25) #XDRV5:6};
// &"H4" @WIRE(mode="straight",linecolor="#30485d",linewidth=0.16) {#XBBM4:2 (199.5,-137.35) (199.5,-143.95) #XDRV4:5};
// &"L4" @WIRE(mode="straight",linecolor="#30485d",linewidth=0.16) {#XBBM4:3 (199.5,-140.65) (199.5,-147.25) #XDRV4:6};
// &"H3" @WIRE(mode="straight",linecolor="#30485d",linewidth=0.16) {#XBBM3:2 (199.5,-175.35) (199.5,-181.95) #XDRV3:5};
// &"L3" @WIRE(mode="straight",linecolor="#30485d",linewidth=0.16) {#XBBM3:3 (199.5,-178.65) (199.5,-185.25) #XDRV3:6};
// &"H2" @WIRE(mode="straight",linecolor="#30485d",linewidth=0.16) {#XBBM2:2 (199.5,-213.35) (199.5,-219.95) #XDRV2:5};
// &"L2" @WIRE(mode="straight",linecolor="#30485d",linewidth=0.16) {#XBBM2:3 (199.5,-216.65) (199.5,-223.25) #XDRV2:6};
// &"H1" @WIRE(mode="straight",linecolor="#30485d",linewidth=0.16) {#XBBM1:2 (199.5,-251.35) (199.5,-257.95) #XDRV1:5};
// &"L1" @WIRE(mode="straight",linecolor="#30485d",linewidth=0.16) {#XBBM1:3 (199.5,-254.65) (199.5,-261.25) #XDRV1:6};
// &"H0" @WIRE(mode="straight",linecolor="#30485d",linewidth=0.16) {#XBBM0:2 (199.5,-289.35) (199.5,-295.95) #XDRV0:5};
// &"L0" @WIRE(mode="straight",linecolor="#30485d",linewidth=0.16) {#XBBM0:3 (199.5,-292.65) (199.5,-299.25) #XDRV0:6};
// (-24,-318) @TEXT("CODE / D -> MUX -> resettable storage -> break-before-make -> physical GP/GN drivers",size=1.1,halign="start",textcolor="#223d52");
// &"SAMPLE" @WIRE(mode="straight",linecolor="#30485d",linewidth=0.16) {#XRR7:1 (-10,126.7)};
// (-10.4,126.7) @TEXT("SAMPLE",size=1.1,halign="end",valign="middle");
// &"SAMPLE" @WIRE(mode="straight",linecolor="#30485d",linewidth=0.16) {#XRR7:2 (-10,123.3)};
// (-10.4,123.3) @TEXT("SAMPLE",size=1.1,halign="end",valign="middle");
// &"VDD" @WIRE(mode="straight",linecolor="#30485d",linewidth=0.16) {#XRR7:3 (0,135)};
// (0,135.4) @TEXT("VDD",size=1.1,halign="middle",valign="bottom");
// &"VSS" @WIRE(mode="straight",linecolor="#30485d",linewidth=0.16) {#XRR7:4 (0,115)};
// (0,114.6) @TEXT("VSS",size=1.1,halign="middle",valign="top");
// &"RST7" @WIRE(mode="straight",linecolor="#30485d",linewidth=0.16) {#XRR7:5 (10,125)};
// (10.4,125) @TEXT("RST7",size=1.1,halign="start",valign="middle");
// &"SAMPLE" @WIRE(mode="straight",linecolor="#30485d",linewidth=0.16) {#XRSTEP1:1 (27,160)};
// (26.6,160) @TEXT("SAMPLE",size=1.1,halign="end",valign="middle");
// &"VDD" @WIRE(mode="straight",linecolor="#30485d",linewidth=0.16) {#XRSTEP1:2 (43,171)};
// (43,171.4) @TEXT("VDD",size=1.1,halign="middle",valign="bottom");
// &"VSS" @WIRE(mode="straight",linecolor="#30485d",linewidth=0.16) {#XRSTEP1:3 (43,149)};
// (43,148.6) @TEXT("VSS",size=1.1,halign="middle",valign="top");
// &"SAMPLE" @WIRE(mode="straight",linecolor="#30485d",linewidth=0.16) {#XRR6:1 (33,126.7)};
// (32.6,126.7) @TEXT("SAMPLE",size=1.1,halign="end",valign="middle");
// &"VDD" @WIRE(mode="straight",linecolor="#30485d",linewidth=0.16) {#XRR6:3 (43,135)};
// (43,135.4) @TEXT("VDD",size=1.1,halign="middle",valign="bottom");
// &"VSS" @WIRE(mode="straight",linecolor="#30485d",linewidth=0.16) {#XRR6:4 (43,115)};
// (43,114.6) @TEXT("VSS",size=1.1,halign="middle",valign="top");
// &"RST6" @WIRE(mode="straight",linecolor="#30485d",linewidth=0.16) {#XRR6:5 (53,125)};
// (53.4,125) @TEXT("RST6",size=1.1,halign="start",valign="middle");
// &"VDD" @WIRE(mode="straight",linecolor="#30485d",linewidth=0.16) {#XRSTEP2:2 (86,171)};
// (86,171.4) @TEXT("VDD",size=1.1,halign="middle",valign="bottom");
// &"VSS" @WIRE(mode="straight",linecolor="#30485d",linewidth=0.16) {#XRSTEP2:3 (86,149)};
// (86,148.6) @TEXT("VSS",size=1.1,halign="middle",valign="top");
// &"SAMPLE" @WIRE(mode="straight",linecolor="#30485d",linewidth=0.16) {#XRR5:1 (76,126.7)};
// (75.6,126.7) @TEXT("SAMPLE",size=1.1,halign="end",valign="middle");
// &"VDD" @WIRE(mode="straight",linecolor="#30485d",linewidth=0.16) {#XRR5:3 (86,135)};
// (86,135.4) @TEXT("VDD",size=1.1,halign="middle",valign="bottom");
// &"VSS" @WIRE(mode="straight",linecolor="#30485d",linewidth=0.16) {#XRR5:4 (86,115)};
// (86,114.6) @TEXT("VSS",size=1.1,halign="middle",valign="top");
// &"RST5" @WIRE(mode="straight",linecolor="#30485d",linewidth=0.16) {#XRR5:5 (96,125)};
// (96.4,125) @TEXT("RST5",size=1.1,halign="start",valign="middle");
// &"VDD" @WIRE(mode="straight",linecolor="#30485d",linewidth=0.16) {#XRSTEP3:2 (129,171)};
// (129,171.4) @TEXT("VDD",size=1.1,halign="middle",valign="bottom");
// &"VSS" @WIRE(mode="straight",linecolor="#30485d",linewidth=0.16) {#XRSTEP3:3 (129,149)};
// (129,148.6) @TEXT("VSS",size=1.1,halign="middle",valign="top");
// &"SAMPLE" @WIRE(mode="straight",linecolor="#30485d",linewidth=0.16) {#XRR4:1 (119,126.7)};
// (118.6,126.7) @TEXT("SAMPLE",size=1.1,halign="end",valign="middle");
// &"VDD" @WIRE(mode="straight",linecolor="#30485d",linewidth=0.16) {#XRR4:3 (129,135)};
// (129,135.4) @TEXT("VDD",size=1.1,halign="middle",valign="bottom");
// &"VSS" @WIRE(mode="straight",linecolor="#30485d",linewidth=0.16) {#XRR4:4 (129,115)};
// (129,114.6) @TEXT("VSS",size=1.1,halign="middle",valign="top");
// &"RST4" @WIRE(mode="straight",linecolor="#30485d",linewidth=0.16) {#XRR4:5 (139,125)};
// (139.4,125) @TEXT("RST4",size=1.1,halign="start",valign="middle");
// &"VDD" @WIRE(mode="straight",linecolor="#30485d",linewidth=0.16) {#XRSTEP4:2 (172,171)};
// (172,171.4) @TEXT("VDD",size=1.1,halign="middle",valign="bottom");
// &"VSS" @WIRE(mode="straight",linecolor="#30485d",linewidth=0.16) {#XRSTEP4:3 (172,149)};
// (172,148.6) @TEXT("VSS",size=1.1,halign="middle",valign="top");
// &"SAMPLE" @WIRE(mode="straight",linecolor="#30485d",linewidth=0.16) {#XRR3:1 (162,126.7)};
// (161.6,126.7) @TEXT("SAMPLE",size=1.1,halign="end",valign="middle");
// &"VDD" @WIRE(mode="straight",linecolor="#30485d",linewidth=0.16) {#XRR3:3 (172,135)};
// (172,135.4) @TEXT("VDD",size=1.1,halign="middle",valign="bottom");
// &"VSS" @WIRE(mode="straight",linecolor="#30485d",linewidth=0.16) {#XRR3:4 (172,115)};
// (172,114.6) @TEXT("VSS",size=1.1,halign="middle",valign="top");
// &"RST3" @WIRE(mode="straight",linecolor="#30485d",linewidth=0.16) {#XRR3:5 (182,125)};
// (182.4,125) @TEXT("RST3",size=1.1,halign="start",valign="middle");
// &"VDD" @WIRE(mode="straight",linecolor="#30485d",linewidth=0.16) {#XRSTEP5:2 (215,171)};
// (215,171.4) @TEXT("VDD",size=1.1,halign="middle",valign="bottom");
// &"VSS" @WIRE(mode="straight",linecolor="#30485d",linewidth=0.16) {#XRSTEP5:3 (215,149)};
// (215,148.6) @TEXT("VSS",size=1.1,halign="middle",valign="top");
// &"SAMPLE" @WIRE(mode="straight",linecolor="#30485d",linewidth=0.16) {#XRR2:1 (205,126.7)};
// (204.6,126.7) @TEXT("SAMPLE",size=1.1,halign="end",valign="middle");
// &"VDD" @WIRE(mode="straight",linecolor="#30485d",linewidth=0.16) {#XRR2:3 (215,135)};
// (215,135.4) @TEXT("VDD",size=1.1,halign="middle",valign="bottom");
// &"VSS" @WIRE(mode="straight",linecolor="#30485d",linewidth=0.16) {#XRR2:4 (215,115)};
// (215,114.6) @TEXT("VSS",size=1.1,halign="middle",valign="top");
// &"RST2" @WIRE(mode="straight",linecolor="#30485d",linewidth=0.16) {#XRR2:5 (225,125)};
// (225.4,125) @TEXT("RST2",size=1.1,halign="start",valign="middle");
// &"VDD" @WIRE(mode="straight",linecolor="#30485d",linewidth=0.16) {#XRSTEP6:2 (258,171)};
// (258,171.4) @TEXT("VDD",size=1.1,halign="middle",valign="bottom");
// &"VSS" @WIRE(mode="straight",linecolor="#30485d",linewidth=0.16) {#XRSTEP6:3 (258,149)};
// (258,148.6) @TEXT("VSS",size=1.1,halign="middle",valign="top");
// &"SAMPLE" @WIRE(mode="straight",linecolor="#30485d",linewidth=0.16) {#XRR1:1 (248,126.7)};
// (247.6,126.7) @TEXT("SAMPLE",size=1.1,halign="end",valign="middle");
// &"VDD" @WIRE(mode="straight",linecolor="#30485d",linewidth=0.16) {#XRR1:3 (258,135)};
// (258,135.4) @TEXT("VDD",size=1.1,halign="middle",valign="bottom");
// &"VSS" @WIRE(mode="straight",linecolor="#30485d",linewidth=0.16) {#XRR1:4 (258,115)};
// (258,114.6) @TEXT("VSS",size=1.1,halign="middle",valign="top");
// &"RST1" @WIRE(mode="straight",linecolor="#30485d",linewidth=0.16) {#XRR1:5 (268,125)};
// (268.4,125) @TEXT("RST1",size=1.1,halign="start",valign="middle");
// &"VDD" @WIRE(mode="straight",linecolor="#30485d",linewidth=0.16) {#XRSTEP7:2 (301,171)};
// (301,171.4) @TEXT("VDD",size=1.1,halign="middle",valign="bottom");
// &"VSS" @WIRE(mode="straight",linecolor="#30485d",linewidth=0.16) {#XRSTEP7:3 (301,149)};
// (301,148.6) @TEXT("VSS",size=1.1,halign="middle",valign="top");
// &"SAMPLE" @WIRE(mode="straight",linecolor="#30485d",linewidth=0.16) {#XRR0:1 (291,126.7)};
// (290.6,126.7) @TEXT("SAMPLE",size=1.1,halign="end",valign="middle");
// &"VDD" @WIRE(mode="straight",linecolor="#30485d",linewidth=0.16) {#XRR0:3 (301,135)};
// (301,135.4) @TEXT("VDD",size=1.1,halign="middle",valign="bottom");
// &"VSS" @WIRE(mode="straight",linecolor="#30485d",linewidth=0.16) {#XRR0:4 (301,115)};
// (301,114.6) @TEXT("VSS",size=1.1,halign="middle",valign="top");
// &"RST0" @WIRE(mode="straight",linecolor="#30485d",linewidth=0.16) {#XRR0:5 (311,125)};
// (311.4,125) @TEXT("RST0",size=1.1,halign="start",valign="middle");
// &"RST0" @WIRE(mode="straight",linecolor="#30485d",linewidth=0.16) {#XRDONE:1 (334,125)};
// (333.6,125) @TEXT("RST0",size=1.1,halign="end",valign="middle");
// &"VDD" @WIRE(mode="straight",linecolor="#30485d",linewidth=0.16) {#XRDONE:2 (344,135)};
// (344,135.4) @TEXT("VDD",size=1.1,halign="middle",valign="bottom");
// &"VSS" @WIRE(mode="straight",linecolor="#30485d",linewidth=0.16) {#XRDONE:3 (344,115)};
// (344,114.6) @TEXT("VSS",size=1.1,halign="middle",valign="top");
// &"RST_DONE" @WIRE(mode="straight",linecolor="#30485d",linewidth=0.16) {#XRDONE:4 (354,125)};
// (354.4,125) @TEXT("RST_DONE",size=1.1,halign="start",valign="middle");
// &"VDD" @WIRE(mode="straight",linecolor="#30485d",linewidth=0.16) {#X002:2 (86,75)};
// (86,75.4) @TEXT("VDD",size=1.1,halign="middle",valign="bottom");
// &"VSS" @WIRE(mode="straight",linecolor="#30485d",linewidth=0.16) {#X002:3 (86,55)};
// (86,54.6) @TEXT("VSS",size=1.1,halign="middle",valign="top");
// &"FIRST2" @WIRE(mode="straight",linecolor="#30485d",linewidth=0.16) {#X002:4 (96,65)};
// (96.4,65) @TEXT("FIRST2",size=1.1,halign="start",valign="middle");
// &"VDD" @WIRE(mode="straight",linecolor="#30485d",linewidth=0.16) {#X001:2 (43,75)};
// (43,75.4) @TEXT("VDD",size=1.1,halign="middle",valign="bottom");
// &"VSS" @WIRE(mode="straight",linecolor="#30485d",linewidth=0.16) {#X001:3 (43,55)};
// (43,54.6) @TEXT("VSS",size=1.1,halign="middle",valign="top");
// &"PHI_U" @WIRE(mode="straight",linecolor="#30485d",linewidth=0.16) {#X000:1 (-10,65)};
// (-10.4,65) @TEXT("PHI_U",size=1.1,halign="end",valign="middle");
// &"VDD" @WIRE(mode="straight",linecolor="#30485d",linewidth=0.16) {#X000:2 (0,75)};
// (0,75.4) @TEXT("VDD",size=1.1,halign="middle",valign="bottom");
// &"VSS" @WIRE(mode="straight",linecolor="#30485d",linewidth=0.16) {#X000:3 (0,55)};
// (0,54.6) @TEXT("VSS",size=1.1,halign="middle",valign="top");
// &"FIRST2" @WIRE(mode="straight",linecolor="#30485d",linewidth=0.16) {#X007:1 (161,66.7)};
// (160.6,66.7) @TEXT("FIRST2",size=1.1,halign="end",valign="middle");
// &"LATE_CLK" @WIRE(mode="straight",linecolor="#30485d",linewidth=0.16) {#X007:2 (161,63.3)};
// (160.6,63.3) @TEXT("LATE_CLK",size=1.1,halign="end",valign="middle");
// &"VDD" @WIRE(mode="straight",linecolor="#30485d",linewidth=0.16) {#X007:3 (171,75)};
// (171,75.4) @TEXT("VDD",size=1.1,halign="middle",valign="bottom");
// &"VSS" @WIRE(mode="straight",linecolor="#30485d",linewidth=0.16) {#X007:4 (171,55)};
// (171,54.6) @TEXT("VSS",size=1.1,halign="middle",valign="top");
// &"CAP_REQ" @WIRE(mode="straight",linecolor="#30485d",linewidth=0.16) {#X007:5 (181,65)};
// (181.4,65) @TEXT("CAP_REQ",size=1.1,halign="start",valign="middle");
// &"SAMPLE" @WIRE(mode="straight",linecolor="#30485d",linewidth=0.16) {#X003:1 (-10,26.7)};
// (-10.4,26.7) @TEXT("SAMPLE",size=1.1,halign="end",valign="middle");
// &"ACK" @WIRE(mode="straight",linecolor="#30485d",linewidth=0.16) {#X003:2 (-10,23.3)};
// (-10.4,23.3) @TEXT("ACK",size=1.1,halign="end",valign="middle");
// &"VDD" @WIRE(mode="straight",linecolor="#30485d",linewidth=0.16) {#X003:3 (0,35)};
// (0,35.4) @TEXT("VDD",size=1.1,halign="middle",valign="bottom");
// &"VSS" @WIRE(mode="straight",linecolor="#30485d",linewidth=0.16) {#X003:4 (0,15)};
// (0,14.6) @TEXT("VSS",size=1.1,halign="middle",valign="top");
// &"PHI_U" @WIRE(mode="straight",linecolor="#30485d",linewidth=0.16) {#XREQUEST:3 (27,23.35)};
// (26.6,23.35) @TEXT("PHI_U",size=1.1,halign="end",valign="middle");
// &"VDD" @WIRE(mode="straight",linecolor="#30485d",linewidth=0.16) {#XREQUEST:4 (43,36)};
// (43,36.4) @TEXT("VDD",size=1.1,halign="middle",valign="bottom");
// &"VSS" @WIRE(mode="straight",linecolor="#30485d",linewidth=0.16) {#XREQUEST:5 (43,14)};
// (43,13.6) @TEXT("VSS",size=1.1,halign="middle",valign="top");
// &"VDD" @WIRE(mode="straight",linecolor="#30485d",linewidth=0.16) {#XD_LATE_CLK:2 (86,36)};
// (86,36.4) @TEXT("VDD",size=1.1,halign="middle",valign="bottom");
// &"VSS" @WIRE(mode="straight",linecolor="#30485d",linewidth=0.16) {#XD_LATE_CLK:3 (86,14)};
// (86,13.6) @TEXT("VSS",size=1.1,halign="middle",valign="top");
// &"LATE_CLK" @WIRE(mode="straight",linecolor="#30485d",linewidth=0.16) {#XD_LATE_CLK:4 (102,25)};
// (102.4,25) @TEXT("LATE_CLK",size=1.1,halign="start",valign="middle");
// &"LATE_CLK" @WIRE(mode="straight",linecolor="#30485d",linewidth=0.16) {#XD_ACK:1 (113,25)};
// (112.6,25) @TEXT("LATE_CLK",size=1.1,halign="end",valign="middle");
// &"VDD" @WIRE(mode="straight",linecolor="#30485d",linewidth=0.16) {#XD_ACK:2 (129,36)};
// (129,36.4) @TEXT("VDD",size=1.1,halign="middle",valign="bottom");
// &"VSS" @WIRE(mode="straight",linecolor="#30485d",linewidth=0.16) {#XD_ACK:3 (129,14)};
// (129,13.6) @TEXT("VSS",size=1.1,halign="middle",valign="top");
// &"ACK" @WIRE(mode="straight",linecolor="#30485d",linewidth=0.16) {#XD_ACK:4 (145,25)};
// (145.4,25) @TEXT("ACK",size=1.1,halign="start",valign="middle");
// &"CAP_REQ" @WIRE(mode="straight",linecolor="#30485d",linewidth=0.16) {#X008:1 (204,65)};
// (203.6,65) @TEXT("CAP_REQ",size=1.1,halign="end",valign="middle");
// &"VDD" @WIRE(mode="straight",linecolor="#30485d",linewidth=0.16) {#X008:2 (214,75)};
// (214,75.4) @TEXT("VDD",size=1.1,halign="middle",valign="bottom");
// &"VSS" @WIRE(mode="straight",linecolor="#30485d",linewidth=0.16) {#X008:3 (214,55)};
// (214,54.6) @TEXT("VSS",size=1.1,halign="middle",valign="top");
// &"CAP_CLK" @WIRE(mode="straight",linecolor="#30485d",linewidth=0.16) {#X008:4 (224,65)};
// (224.4,65) @TEXT("CAP_CLK",size=1.1,halign="start",valign="middle");
// &"CODE7" @WIRE(mode="straight",linecolor="#30485d",linewidth=0.16) {#XMUX7:1 (-10,-21.6)};
// (-10.4,-21.6) @TEXT("CODE7",size=1.1,halign="end",valign="middle");
// &"D7" @WIRE(mode="straight",linecolor="#30485d",linewidth=0.16) {#XMUX7:2 (-10,-25)};
// (-10.4,-25) @TEXT("D7",size=1.1,halign="end",valign="middle");
// &"PHI_U" @WIRE(mode="straight",linecolor="#30485d",linewidth=0.16) {#XMUX7:3 (-10,-28.4)};
// (-10.4,-28.4) @TEXT("PHI_U",size=1.1,halign="end",valign="middle");
// &"VDD" @WIRE(mode="straight",linecolor="#30485d",linewidth=0.16) {#XMUX7:4 (0,-15)};
// (0,-14.6) @TEXT("VDD",size=1.1,halign="middle",valign="bottom");
// &"VSS" @WIRE(mode="straight",linecolor="#30485d",linewidth=0.16) {#XMUX7:5 (0,-35)};
// (0,-35.4) @TEXT("VSS",size=1.1,halign="middle",valign="top");
// &"CODE6" @WIRE(mode="straight",linecolor="#30485d",linewidth=0.16) {#XMUX6:1 (-10,-59.6)};
// (-10.4,-59.6) @TEXT("CODE6",size=1.1,halign="end",valign="middle");
// &"D6" @WIRE(mode="straight",linecolor="#30485d",linewidth=0.16) {#XMUX6:2 (-10,-63)};
// (-10.4,-63) @TEXT("D6",size=1.1,halign="end",valign="middle");
// &"PHI_U" @WIRE(mode="straight",linecolor="#30485d",linewidth=0.16) {#XMUX6:3 (-10,-66.4)};
// (-10.4,-66.4) @TEXT("PHI_U",size=1.1,halign="end",valign="middle");
// &"VDD" @WIRE(mode="straight",linecolor="#30485d",linewidth=0.16) {#XMUX6:4 (0,-53)};
// (0,-52.6) @TEXT("VDD",size=1.1,halign="middle",valign="bottom");
// &"VSS" @WIRE(mode="straight",linecolor="#30485d",linewidth=0.16) {#XMUX6:5 (0,-73)};
// (0,-73.4) @TEXT("VSS",size=1.1,halign="middle",valign="top");
// &"TARGET6" @WIRE(mode="straight",linecolor="#30485d",linewidth=0.16) {#XMUX6:6 (10,-63)};
// (10.4,-63) @TEXT("TARGET6",size=1.1,halign="start",valign="middle");
// &"CODE5" @WIRE(mode="straight",linecolor="#30485d",linewidth=0.16) {#XMUX5:1 (-10,-97.6)};
// (-10.4,-97.6) @TEXT("CODE5",size=1.1,halign="end",valign="middle");
// &"D5" @WIRE(mode="straight",linecolor="#30485d",linewidth=0.16) {#XMUX5:2 (-10,-101)};
// (-10.4,-101) @TEXT("D5",size=1.1,halign="end",valign="middle");
// &"PHI_U" @WIRE(mode="straight",linecolor="#30485d",linewidth=0.16) {#XMUX5:3 (-10,-104.4)};
// (-10.4,-104.4) @TEXT("PHI_U",size=1.1,halign="end",valign="middle");
// &"VDD" @WIRE(mode="straight",linecolor="#30485d",linewidth=0.16) {#XMUX5:4 (0,-91)};
// (0,-90.6) @TEXT("VDD",size=1.1,halign="middle",valign="bottom");
// &"VSS" @WIRE(mode="straight",linecolor="#30485d",linewidth=0.16) {#XMUX5:5 (0,-111)};
// (0,-111.4) @TEXT("VSS",size=1.1,halign="middle",valign="top");
// &"TARGET5" @WIRE(mode="straight",linecolor="#30485d",linewidth=0.16) {#XMUX5:6 (10,-101)};
// (10.4,-101) @TEXT("TARGET5",size=1.1,halign="start",valign="middle");
// &"CODE4" @WIRE(mode="straight",linecolor="#30485d",linewidth=0.16) {#XMUX4:1 (-10,-135.6)};
// (-10.4,-135.6) @TEXT("CODE4",size=1.1,halign="end",valign="middle");
// &"D4" @WIRE(mode="straight",linecolor="#30485d",linewidth=0.16) {#XMUX4:2 (-10,-139)};
// (-10.4,-139) @TEXT("D4",size=1.1,halign="end",valign="middle");
// &"PHI_U" @WIRE(mode="straight",linecolor="#30485d",linewidth=0.16) {#XMUX4:3 (-10,-142.4)};
// (-10.4,-142.4) @TEXT("PHI_U",size=1.1,halign="end",valign="middle");
// &"VDD" @WIRE(mode="straight",linecolor="#30485d",linewidth=0.16) {#XMUX4:4 (0,-129)};
// (0,-128.6) @TEXT("VDD",size=1.1,halign="middle",valign="bottom");
// &"VSS" @WIRE(mode="straight",linecolor="#30485d",linewidth=0.16) {#XMUX4:5 (0,-149)};
// (0,-149.4) @TEXT("VSS",size=1.1,halign="middle",valign="top");
// &"TARGET4" @WIRE(mode="straight",linecolor="#30485d",linewidth=0.16) {#XMUX4:6 (10,-139)};
// (10.4,-139) @TEXT("TARGET4",size=1.1,halign="start",valign="middle");
// &"CODE3" @WIRE(mode="straight",linecolor="#30485d",linewidth=0.16) {#XMUX3:1 (-10,-173.6)};
// (-10.4,-173.6) @TEXT("CODE3",size=1.1,halign="end",valign="middle");
// &"D3" @WIRE(mode="straight",linecolor="#30485d",linewidth=0.16) {#XMUX3:2 (-10,-177)};
// (-10.4,-177) @TEXT("D3",size=1.1,halign="end",valign="middle");
// &"PHI_U" @WIRE(mode="straight",linecolor="#30485d",linewidth=0.16) {#XMUX3:3 (-10,-180.4)};
// (-10.4,-180.4) @TEXT("PHI_U",size=1.1,halign="end",valign="middle");
// &"VDD" @WIRE(mode="straight",linecolor="#30485d",linewidth=0.16) {#XMUX3:4 (0,-167)};
// (0,-166.6) @TEXT("VDD",size=1.1,halign="middle",valign="bottom");
// &"VSS" @WIRE(mode="straight",linecolor="#30485d",linewidth=0.16) {#XMUX3:5 (0,-187)};
// (0,-187.4) @TEXT("VSS",size=1.1,halign="middle",valign="top");
// &"TARGET3" @WIRE(mode="straight",linecolor="#30485d",linewidth=0.16) {#XMUX3:6 (10,-177)};
// (10.4,-177) @TEXT("TARGET3",size=1.1,halign="start",valign="middle");
// &"CODE2" @WIRE(mode="straight",linecolor="#30485d",linewidth=0.16) {#XMUX2:1 (-10,-211.6)};
// (-10.4,-211.6) @TEXT("CODE2",size=1.1,halign="end",valign="middle");
// &"D2" @WIRE(mode="straight",linecolor="#30485d",linewidth=0.16) {#XMUX2:2 (-10,-215)};
// (-10.4,-215) @TEXT("D2",size=1.1,halign="end",valign="middle");
// &"PHI_U" @WIRE(mode="straight",linecolor="#30485d",linewidth=0.16) {#XMUX2:3 (-10,-218.4)};
// (-10.4,-218.4) @TEXT("PHI_U",size=1.1,halign="end",valign="middle");
// &"VDD" @WIRE(mode="straight",linecolor="#30485d",linewidth=0.16) {#XMUX2:4 (0,-205)};
// (0,-204.6) @TEXT("VDD",size=1.1,halign="middle",valign="bottom");
// &"VSS" @WIRE(mode="straight",linecolor="#30485d",linewidth=0.16) {#XMUX2:5 (0,-225)};
// (0,-225.4) @TEXT("VSS",size=1.1,halign="middle",valign="top");
// &"TARGET2" @WIRE(mode="straight",linecolor="#30485d",linewidth=0.16) {#XMUX2:6 (10,-215)};
// (10.4,-215) @TEXT("TARGET2",size=1.1,halign="start",valign="middle");
// &"CODE1" @WIRE(mode="straight",linecolor="#30485d",linewidth=0.16) {#XMUX1:1 (-10,-249.6)};
// (-10.4,-249.6) @TEXT("CODE1",size=1.1,halign="end",valign="middle");
// &"D1" @WIRE(mode="straight",linecolor="#30485d",linewidth=0.16) {#XMUX1:2 (-10,-253)};
// (-10.4,-253) @TEXT("D1",size=1.1,halign="end",valign="middle");
// &"PHI_U" @WIRE(mode="straight",linecolor="#30485d",linewidth=0.16) {#XMUX1:3 (-10,-256.4)};
// (-10.4,-256.4) @TEXT("PHI_U",size=1.1,halign="end",valign="middle");
// &"VDD" @WIRE(mode="straight",linecolor="#30485d",linewidth=0.16) {#XMUX1:4 (0,-243)};
// (0,-242.6) @TEXT("VDD",size=1.1,halign="middle",valign="bottom");
// &"VSS" @WIRE(mode="straight",linecolor="#30485d",linewidth=0.16) {#XMUX1:5 (0,-263)};
// (0,-263.4) @TEXT("VSS",size=1.1,halign="middle",valign="top");
// &"TARGET1" @WIRE(mode="straight",linecolor="#30485d",linewidth=0.16) {#XMUX1:6 (10,-253)};
// (10.4,-253) @TEXT("TARGET1",size=1.1,halign="start",valign="middle");
// &"CODE0" @WIRE(mode="straight",linecolor="#30485d",linewidth=0.16) {#XMUX0:1 (-10,-287.6)};
// (-10.4,-287.6) @TEXT("CODE0",size=1.1,halign="end",valign="middle");
// &"D0" @WIRE(mode="straight",linecolor="#30485d",linewidth=0.16) {#XMUX0:2 (-10,-291)};
// (-10.4,-291) @TEXT("D0",size=1.1,halign="end",valign="middle");
// &"PHI_U" @WIRE(mode="straight",linecolor="#30485d",linewidth=0.16) {#XMUX0:3 (-10,-294.4)};
// (-10.4,-294.4) @TEXT("PHI_U",size=1.1,halign="end",valign="middle");
// &"VDD" @WIRE(mode="straight",linecolor="#30485d",linewidth=0.16) {#XMUX0:4 (0,-281)};
// (0,-280.6) @TEXT("VDD",size=1.1,halign="middle",valign="bottom");
// &"VSS" @WIRE(mode="straight",linecolor="#30485d",linewidth=0.16) {#XMUX0:5 (0,-301)};
// (0,-301.4) @TEXT("VSS",size=1.1,halign="middle",valign="top");
// &"TARGET0" @WIRE(mode="straight",linecolor="#30485d",linewidth=0.16) {#XMUX0:6 (10,-291)};
// (10.4,-291) @TEXT("TARGET0",size=1.1,halign="start",valign="middle");
// &"VDD" @WIRE(mode="straight",linecolor="#30485d",linewidth=0.16) {#X018:2 (118,-15)};
// (118,-14.6) @TEXT("VDD",size=1.1,halign="middle",valign="bottom");
// &"VSS" @WIRE(mode="straight",linecolor="#30485d",linewidth=0.16) {#X018:3 (118,-35)};
// (118,-35.4) @TEXT("VSS",size=1.1,halign="middle",valign="top");
// &"VDD" @WIRE(mode="straight",linecolor="#30485d",linewidth=0.16) {#X017:2 (43,-15)};
// (43,-14.6) @TEXT("VDD",size=1.1,halign="middle",valign="bottom");
// &"VSS" @WIRE(mode="straight",linecolor="#30485d",linewidth=0.16) {#X017:3 (43,-35)};
// (43,-35.4) @TEXT("VSS",size=1.1,halign="middle",valign="top");
// &"CAP_CLK" @WIRE(mode="straight",linecolor="#30485d",linewidth=0.16) {#XSTORE7:1 (76,-21.6)};
// (75.6,-21.6) @TEXT("CAP_CLK",size=1.1,halign="end",valign="middle");
// &"RST7" @WIRE(mode="straight",linecolor="#30485d",linewidth=0.16) {#XSTORE7:4 (76,-28.4)};
// (75.6,-28.4) @TEXT("RST7",size=1.1,halign="end",valign="middle");
// &"VDD" @WIRE(mode="straight",linecolor="#30485d",linewidth=0.16) {#XSTORE7:5 (86,-15)};
// (86,-14.6) @TEXT("VDD",size=1.1,halign="middle",valign="bottom");
// &"VSS" @WIRE(mode="straight",linecolor="#30485d",linewidth=0.16) {#XSTORE7:6 (86,-35)};
// (86,-35.4) @TEXT("VSS",size=1.1,halign="middle",valign="top");
// &"CAP_CLK" @WIRE(mode="straight",linecolor="#30485d",linewidth=0.16) {#XSTORE6:1 (76,-59.6)};
// (75.6,-59.6) @TEXT("CAP_CLK",size=1.1,halign="end",valign="middle");
// &"TARGET6" @WIRE(mode="straight",linecolor="#30485d",linewidth=0.16) {#XSTORE6:2 (76,-63)};
// (75.6,-63) @TEXT("TARGET6",size=1.1,halign="end",valign="middle");
// &"RST6" @WIRE(mode="straight",linecolor="#30485d",linewidth=0.16) {#XSTORE6:4 (76,-66.4)};
// (75.6,-66.4) @TEXT("RST6",size=1.1,halign="end",valign="middle");
// &"VDD" @WIRE(mode="straight",linecolor="#30485d",linewidth=0.16) {#XSTORE6:5 (86,-53)};
// (86,-52.6) @TEXT("VDD",size=1.1,halign="middle",valign="bottom");
// &"VSS" @WIRE(mode="straight",linecolor="#30485d",linewidth=0.16) {#XSTORE6:6 (86,-73)};
// (86,-73.4) @TEXT("VSS",size=1.1,halign="middle",valign="top");
// &"CAP_CLK" @WIRE(mode="straight",linecolor="#30485d",linewidth=0.16) {#XSTORE5:1 (76,-97.6)};
// (75.6,-97.6) @TEXT("CAP_CLK",size=1.1,halign="end",valign="middle");
// &"TARGET5" @WIRE(mode="straight",linecolor="#30485d",linewidth=0.16) {#XSTORE5:2 (76,-101)};
// (75.6,-101) @TEXT("TARGET5",size=1.1,halign="end",valign="middle");
// &"RST5" @WIRE(mode="straight",linecolor="#30485d",linewidth=0.16) {#XSTORE5:4 (76,-104.4)};
// (75.6,-104.4) @TEXT("RST5",size=1.1,halign="end",valign="middle");
// &"VDD" @WIRE(mode="straight",linecolor="#30485d",linewidth=0.16) {#XSTORE5:5 (86,-91)};
// (86,-90.6) @TEXT("VDD",size=1.1,halign="middle",valign="bottom");
// &"VSS" @WIRE(mode="straight",linecolor="#30485d",linewidth=0.16) {#XSTORE5:6 (86,-111)};
// (86,-111.4) @TEXT("VSS",size=1.1,halign="middle",valign="top");
// &"CAP_CLK" @WIRE(mode="straight",linecolor="#30485d",linewidth=0.16) {#XSTORE4:1 (76,-135.6)};
// (75.6,-135.6) @TEXT("CAP_CLK",size=1.1,halign="end",valign="middle");
// &"TARGET4" @WIRE(mode="straight",linecolor="#30485d",linewidth=0.16) {#XSTORE4:2 (76,-139)};
// (75.6,-139) @TEXT("TARGET4",size=1.1,halign="end",valign="middle");
// &"RST4" @WIRE(mode="straight",linecolor="#30485d",linewidth=0.16) {#XSTORE4:4 (76,-142.4)};
// (75.6,-142.4) @TEXT("RST4",size=1.1,halign="end",valign="middle");
// &"VDD" @WIRE(mode="straight",linecolor="#30485d",linewidth=0.16) {#XSTORE4:5 (86,-129)};
// (86,-128.6) @TEXT("VDD",size=1.1,halign="middle",valign="bottom");
// &"VSS" @WIRE(mode="straight",linecolor="#30485d",linewidth=0.16) {#XSTORE4:6 (86,-149)};
// (86,-149.4) @TEXT("VSS",size=1.1,halign="middle",valign="top");
// &"CAP_CLK" @WIRE(mode="straight",linecolor="#30485d",linewidth=0.16) {#XSTORE3:1 (76,-173.6)};
// (75.6,-173.6) @TEXT("CAP_CLK",size=1.1,halign="end",valign="middle");
// &"TARGET3" @WIRE(mode="straight",linecolor="#30485d",linewidth=0.16) {#XSTORE3:2 (76,-177)};
// (75.6,-177) @TEXT("TARGET3",size=1.1,halign="end",valign="middle");
// &"RST3" @WIRE(mode="straight",linecolor="#30485d",linewidth=0.16) {#XSTORE3:4 (76,-180.4)};
// (75.6,-180.4) @TEXT("RST3",size=1.1,halign="end",valign="middle");
// &"VDD" @WIRE(mode="straight",linecolor="#30485d",linewidth=0.16) {#XSTORE3:5 (86,-167)};
// (86,-166.6) @TEXT("VDD",size=1.1,halign="middle",valign="bottom");
// &"VSS" @WIRE(mode="straight",linecolor="#30485d",linewidth=0.16) {#XSTORE3:6 (86,-187)};
// (86,-187.4) @TEXT("VSS",size=1.1,halign="middle",valign="top");
// &"CAP_CLK" @WIRE(mode="straight",linecolor="#30485d",linewidth=0.16) {#XSTORE2:1 (76,-211.6)};
// (75.6,-211.6) @TEXT("CAP_CLK",size=1.1,halign="end",valign="middle");
// &"TARGET2" @WIRE(mode="straight",linecolor="#30485d",linewidth=0.16) {#XSTORE2:2 (76,-215)};
// (75.6,-215) @TEXT("TARGET2",size=1.1,halign="end",valign="middle");
// &"RST2" @WIRE(mode="straight",linecolor="#30485d",linewidth=0.16) {#XSTORE2:4 (76,-218.4)};
// (75.6,-218.4) @TEXT("RST2",size=1.1,halign="end",valign="middle");
// &"VDD" @WIRE(mode="straight",linecolor="#30485d",linewidth=0.16) {#XSTORE2:5 (86,-205)};
// (86,-204.6) @TEXT("VDD",size=1.1,halign="middle",valign="bottom");
// &"VSS" @WIRE(mode="straight",linecolor="#30485d",linewidth=0.16) {#XSTORE2:6 (86,-225)};
// (86,-225.4) @TEXT("VSS",size=1.1,halign="middle",valign="top");
// &"CAP_CLK" @WIRE(mode="straight",linecolor="#30485d",linewidth=0.16) {#XSTORE1:1 (76,-249.6)};
// (75.6,-249.6) @TEXT("CAP_CLK",size=1.1,halign="end",valign="middle");
// &"TARGET1" @WIRE(mode="straight",linecolor="#30485d",linewidth=0.16) {#XSTORE1:2 (76,-253)};
// (75.6,-253) @TEXT("TARGET1",size=1.1,halign="end",valign="middle");
// &"RST1" @WIRE(mode="straight",linecolor="#30485d",linewidth=0.16) {#XSTORE1:4 (76,-256.4)};
// (75.6,-256.4) @TEXT("RST1",size=1.1,halign="end",valign="middle");
// &"VDD" @WIRE(mode="straight",linecolor="#30485d",linewidth=0.16) {#XSTORE1:5 (86,-243)};
// (86,-242.6) @TEXT("VDD",size=1.1,halign="middle",valign="bottom");
// &"VSS" @WIRE(mode="straight",linecolor="#30485d",linewidth=0.16) {#XSTORE1:6 (86,-263)};
// (86,-263.4) @TEXT("VSS",size=1.1,halign="middle",valign="top");
// &"CAP_CLK" @WIRE(mode="straight",linecolor="#30485d",linewidth=0.16) {#XSTORE0:1 (76,-287.6)};
// (75.6,-287.6) @TEXT("CAP_CLK",size=1.1,halign="end",valign="middle");
// &"TARGET0" @WIRE(mode="straight",linecolor="#30485d",linewidth=0.16) {#XSTORE0:2 (76,-291)};
// (75.6,-291) @TEXT("TARGET0",size=1.1,halign="end",valign="middle");
// &"RST0" @WIRE(mode="straight",linecolor="#30485d",linewidth=0.16) {#XSTORE0:4 (76,-294.4)};
// (75.6,-294.4) @TEXT("RST0",size=1.1,halign="end",valign="middle");
// &"VDD" @WIRE(mode="straight",linecolor="#30485d",linewidth=0.16) {#XSTORE0:5 (86,-281)};
// (86,-280.6) @TEXT("VDD",size=1.1,halign="middle",valign="bottom");
// &"VSS" @WIRE(mode="straight",linecolor="#30485d",linewidth=0.16) {#XSTORE0:6 (86,-301)};
// (86,-301.4) @TEXT("VSS",size=1.1,halign="middle",valign="top");
// &"VDD" @WIRE(mode="straight",linecolor="#30485d",linewidth=0.16) {#XBBM7:4 (155,-14)};
// (155,-13.6) @TEXT("VDD",size=1.1,halign="middle",valign="bottom");
// &"VSS" @WIRE(mode="straight",linecolor="#30485d",linewidth=0.16) {#XBBM7:5 (155,-36)};
// (155,-36.4) @TEXT("VSS",size=1.1,halign="middle",valign="top");
// &"VDD" @WIRE(mode="straight",linecolor="#30485d",linewidth=0.16) {#XBBM6:4 (155,-52)};
// (155,-51.6) @TEXT("VDD",size=1.1,halign="middle",valign="bottom");
// &"VSS" @WIRE(mode="straight",linecolor="#30485d",linewidth=0.16) {#XBBM6:5 (155,-74)};
// (155,-74.4) @TEXT("VSS",size=1.1,halign="middle",valign="top");
// &"VDD" @WIRE(mode="straight",linecolor="#30485d",linewidth=0.16) {#XBBM5:4 (155,-90)};
// (155,-89.6) @TEXT("VDD",size=1.1,halign="middle",valign="bottom");
// &"VSS" @WIRE(mode="straight",linecolor="#30485d",linewidth=0.16) {#XBBM5:5 (155,-112)};
// (155,-112.4) @TEXT("VSS",size=1.1,halign="middle",valign="top");
// &"VDD" @WIRE(mode="straight",linecolor="#30485d",linewidth=0.16) {#XBBM4:4 (155,-128)};
// (155,-127.6) @TEXT("VDD",size=1.1,halign="middle",valign="bottom");
// &"VSS" @WIRE(mode="straight",linecolor="#30485d",linewidth=0.16) {#XBBM4:5 (155,-150)};
// (155,-150.4) @TEXT("VSS",size=1.1,halign="middle",valign="top");
// &"VDD" @WIRE(mode="straight",linecolor="#30485d",linewidth=0.16) {#XBBM3:4 (155,-166)};
// (155,-165.6) @TEXT("VDD",size=1.1,halign="middle",valign="bottom");
// &"VSS" @WIRE(mode="straight",linecolor="#30485d",linewidth=0.16) {#XBBM3:5 (155,-188)};
// (155,-188.4) @TEXT("VSS",size=1.1,halign="middle",valign="top");
// &"VDD" @WIRE(mode="straight",linecolor="#30485d",linewidth=0.16) {#XBBM2:4 (155,-204)};
// (155,-203.6) @TEXT("VDD",size=1.1,halign="middle",valign="bottom");
// &"VSS" @WIRE(mode="straight",linecolor="#30485d",linewidth=0.16) {#XBBM2:5 (155,-226)};
// (155,-226.4) @TEXT("VSS",size=1.1,halign="middle",valign="top");
// &"VDD" @WIRE(mode="straight",linecolor="#30485d",linewidth=0.16) {#XBBM1:4 (155,-242)};
// (155,-241.6) @TEXT("VDD",size=1.1,halign="middle",valign="bottom");
// &"VSS" @WIRE(mode="straight",linecolor="#30485d",linewidth=0.16) {#XBBM1:5 (155,-264)};
// (155,-264.4) @TEXT("VSS",size=1.1,halign="middle",valign="top");
// &"VDD" @WIRE(mode="straight",linecolor="#30485d",linewidth=0.16) {#XBBM0:4 (155,-280)};
// (155,-279.6) @TEXT("VDD",size=1.1,halign="middle",valign="bottom");
// &"VSS" @WIRE(mode="straight",linecolor="#30485d",linewidth=0.16) {#XBBM0:5 (155,-302)};
// (155,-302.4) @TEXT("VSS",size=1.1,halign="middle",valign="top");
// &"GNN0" @WIRE(mode="straight",linecolor="#30485d",linewidth=0.16) {#XDRV0:1 (234,-282.75)};
// (234.4,-282.75) @TEXT("GNN0",size=1.1,halign="start",valign="middle");
// &"GNP0" @WIRE(mode="straight",linecolor="#30485d",linewidth=0.16) {#XDRV0:2 (234,-286.05)};
// (234.4,-286.05) @TEXT("GNP0",size=1.1,halign="start",valign="middle");
// &"GPN0" @WIRE(mode="straight",linecolor="#30485d",linewidth=0.16) {#XDRV0:3 (234,-289.35)};
// (234.4,-289.35) @TEXT("GPN0",size=1.1,halign="start",valign="middle");
// &"GPP0" @WIRE(mode="straight",linecolor="#30485d",linewidth=0.16) {#XDRV0:4 (234,-292.65)};
// (234.4,-292.65) @TEXT("GPP0",size=1.1,halign="start",valign="middle");
// &"VDD" @WIRE(mode="straight",linecolor="#30485d",linewidth=0.16) {#XDRV0:7 (218,-274.45)};
// (218,-274.05) @TEXT("VDD",size=1.1,halign="middle",valign="bottom");
// &"VSS" @WIRE(mode="straight",linecolor="#30485d",linewidth=0.16) {#XDRV0:8 (218,-307.55)};
// (218,-307.95) @TEXT("VSS",size=1.1,halign="middle",valign="top");
// &"GNN1" @WIRE(mode="straight",linecolor="#30485d",linewidth=0.16) {#XDRV1:1 (234,-244.75)};
// (234.4,-244.75) @TEXT("GNN1",size=1.1,halign="start",valign="middle");
// &"GNP1" @WIRE(mode="straight",linecolor="#30485d",linewidth=0.16) {#XDRV1:2 (234,-248.05)};
// (234.4,-248.05) @TEXT("GNP1",size=1.1,halign="start",valign="middle");
// &"GPN1" @WIRE(mode="straight",linecolor="#30485d",linewidth=0.16) {#XDRV1:3 (234,-251.35)};
// (234.4,-251.35) @TEXT("GPN1",size=1.1,halign="start",valign="middle");
// &"GPP1" @WIRE(mode="straight",linecolor="#30485d",linewidth=0.16) {#XDRV1:4 (234,-254.65)};
// (234.4,-254.65) @TEXT("GPP1",size=1.1,halign="start",valign="middle");
// &"VDD" @WIRE(mode="straight",linecolor="#30485d",linewidth=0.16) {#XDRV1:7 (218,-236.45)};
// (218,-236.05) @TEXT("VDD",size=1.1,halign="middle",valign="bottom");
// &"VSS" @WIRE(mode="straight",linecolor="#30485d",linewidth=0.16) {#XDRV1:8 (218,-269.55)};
// (218,-269.95) @TEXT("VSS",size=1.1,halign="middle",valign="top");
// &"GNN2" @WIRE(mode="straight",linecolor="#30485d",linewidth=0.16) {#XDRV2:1 (234,-206.75)};
// (234.4,-206.75) @TEXT("GNN2",size=1.1,halign="start",valign="middle");
// &"GNP2" @WIRE(mode="straight",linecolor="#30485d",linewidth=0.16) {#XDRV2:2 (234,-210.05)};
// (234.4,-210.05) @TEXT("GNP2",size=1.1,halign="start",valign="middle");
// &"GPN2" @WIRE(mode="straight",linecolor="#30485d",linewidth=0.16) {#XDRV2:3 (234,-213.35)};
// (234.4,-213.35) @TEXT("GPN2",size=1.1,halign="start",valign="middle");
// &"GPP2" @WIRE(mode="straight",linecolor="#30485d",linewidth=0.16) {#XDRV2:4 (234,-216.65)};
// (234.4,-216.65) @TEXT("GPP2",size=1.1,halign="start",valign="middle");
// &"VDD" @WIRE(mode="straight",linecolor="#30485d",linewidth=0.16) {#XDRV2:7 (218,-198.45)};
// (218,-198.05) @TEXT("VDD",size=1.1,halign="middle",valign="bottom");
// &"VSS" @WIRE(mode="straight",linecolor="#30485d",linewidth=0.16) {#XDRV2:8 (218,-231.55)};
// (218,-231.95) @TEXT("VSS",size=1.1,halign="middle",valign="top");
// &"GNN3" @WIRE(mode="straight",linecolor="#30485d",linewidth=0.16) {#XDRV3:1 (234,-168.75)};
// (234.4,-168.75) @TEXT("GNN3",size=1.1,halign="start",valign="middle");
// &"GNP3" @WIRE(mode="straight",linecolor="#30485d",linewidth=0.16) {#XDRV3:2 (234,-172.05)};
// (234.4,-172.05) @TEXT("GNP3",size=1.1,halign="start",valign="middle");
// &"GPN3" @WIRE(mode="straight",linecolor="#30485d",linewidth=0.16) {#XDRV3:3 (234,-175.35)};
// (234.4,-175.35) @TEXT("GPN3",size=1.1,halign="start",valign="middle");
// &"GPP3" @WIRE(mode="straight",linecolor="#30485d",linewidth=0.16) {#XDRV3:4 (234,-178.65)};
// (234.4,-178.65) @TEXT("GPP3",size=1.1,halign="start",valign="middle");
// &"VDD" @WIRE(mode="straight",linecolor="#30485d",linewidth=0.16) {#XDRV3:7 (218,-160.45)};
// (218,-160.05) @TEXT("VDD",size=1.1,halign="middle",valign="bottom");
// &"VSS" @WIRE(mode="straight",linecolor="#30485d",linewidth=0.16) {#XDRV3:8 (218,-193.55)};
// (218,-193.95) @TEXT("VSS",size=1.1,halign="middle",valign="top");
// &"GNN4" @WIRE(mode="straight",linecolor="#30485d",linewidth=0.16) {#XDRV4:1 (234,-130.75)};
// (234.4,-130.75) @TEXT("GNN4",size=1.1,halign="start",valign="middle");
// &"GNP4" @WIRE(mode="straight",linecolor="#30485d",linewidth=0.16) {#XDRV4:2 (234,-134.05)};
// (234.4,-134.05) @TEXT("GNP4",size=1.1,halign="start",valign="middle");
// &"GPN4" @WIRE(mode="straight",linecolor="#30485d",linewidth=0.16) {#XDRV4:3 (234,-137.35)};
// (234.4,-137.35) @TEXT("GPN4",size=1.1,halign="start",valign="middle");
// &"GPP4" @WIRE(mode="straight",linecolor="#30485d",linewidth=0.16) {#XDRV4:4 (234,-140.65)};
// (234.4,-140.65) @TEXT("GPP4",size=1.1,halign="start",valign="middle");
// &"VDD" @WIRE(mode="straight",linecolor="#30485d",linewidth=0.16) {#XDRV4:7 (218,-122.45)};
// (218,-122.05) @TEXT("VDD",size=1.1,halign="middle",valign="bottom");
// &"VSS" @WIRE(mode="straight",linecolor="#30485d",linewidth=0.16) {#XDRV4:8 (218,-155.55)};
// (218,-155.95) @TEXT("VSS",size=1.1,halign="middle",valign="top");
// &"GNN5" @WIRE(mode="straight",linecolor="#30485d",linewidth=0.16) {#XDRV5:1 (234,-92.75)};
// (234.4,-92.75) @TEXT("GNN5",size=1.1,halign="start",valign="middle");
// &"GNP5" @WIRE(mode="straight",linecolor="#30485d",linewidth=0.16) {#XDRV5:2 (234,-96.05)};
// (234.4,-96.05) @TEXT("GNP5",size=1.1,halign="start",valign="middle");
// &"GPN5" @WIRE(mode="straight",linecolor="#30485d",linewidth=0.16) {#XDRV5:3 (234,-99.35)};
// (234.4,-99.35) @TEXT("GPN5",size=1.1,halign="start",valign="middle");
// &"GPP5" @WIRE(mode="straight",linecolor="#30485d",linewidth=0.16) {#XDRV5:4 (234,-102.65)};
// (234.4,-102.65) @TEXT("GPP5",size=1.1,halign="start",valign="middle");
// &"VDD" @WIRE(mode="straight",linecolor="#30485d",linewidth=0.16) {#XDRV5:7 (218,-84.45)};
// (218,-84.05) @TEXT("VDD",size=1.1,halign="middle",valign="bottom");
// &"VSS" @WIRE(mode="straight",linecolor="#30485d",linewidth=0.16) {#XDRV5:8 (218,-117.55)};
// (218,-117.95) @TEXT("VSS",size=1.1,halign="middle",valign="top");
// &"GNN6" @WIRE(mode="straight",linecolor="#30485d",linewidth=0.16) {#XDRV6:1 (234,-54.75)};
// (234.4,-54.75) @TEXT("GNN6",size=1.1,halign="start",valign="middle");
// &"GNP6" @WIRE(mode="straight",linecolor="#30485d",linewidth=0.16) {#XDRV6:2 (234,-58.05)};
// (234.4,-58.05) @TEXT("GNP6",size=1.1,halign="start",valign="middle");
// &"GPN6" @WIRE(mode="straight",linecolor="#30485d",linewidth=0.16) {#XDRV6:3 (234,-61.35)};
// (234.4,-61.35) @TEXT("GPN6",size=1.1,halign="start",valign="middle");
// &"GPP6" @WIRE(mode="straight",linecolor="#30485d",linewidth=0.16) {#XDRV6:4 (234,-64.65)};
// (234.4,-64.65) @TEXT("GPP6",size=1.1,halign="start",valign="middle");
// &"VDD" @WIRE(mode="straight",linecolor="#30485d",linewidth=0.16) {#XDRV6:7 (218,-46.45)};
// (218,-46.05) @TEXT("VDD",size=1.1,halign="middle",valign="bottom");
// &"VSS" @WIRE(mode="straight",linecolor="#30485d",linewidth=0.16) {#XDRV6:8 (218,-79.55)};
// (218,-79.95) @TEXT("VSS",size=1.1,halign="middle",valign="top");
// &"GNN7" @WIRE(mode="straight",linecolor="#30485d",linewidth=0.16) {#XDRV7:1 (234,-16.75)};
// (234.4,-16.75) @TEXT("GNN7",size=1.1,halign="start",valign="middle");
// &"GNP7" @WIRE(mode="straight",linecolor="#30485d",linewidth=0.16) {#XDRV7:2 (234,-20.05)};
// (234.4,-20.05) @TEXT("GNP7",size=1.1,halign="start",valign="middle");
// &"GPN7" @WIRE(mode="straight",linecolor="#30485d",linewidth=0.16) {#XDRV7:3 (234,-23.35)};
// (234.4,-23.35) @TEXT("GPN7",size=1.1,halign="start",valign="middle");
// &"GPP7" @WIRE(mode="straight",linecolor="#30485d",linewidth=0.16) {#XDRV7:4 (234,-26.65)};
// (234.4,-26.65) @TEXT("GPP7",size=1.1,halign="start",valign="middle");
// &"VDD" @WIRE(mode="straight",linecolor="#30485d",linewidth=0.16) {#XDRV7:7 (218,-8.45)};
// (218,-8.05) @TEXT("VDD",size=1.1,halign="middle",valign="bottom");
// &"VSS" @WIRE(mode="straight",linecolor="#30485d",linewidth=0.16) {#XDRV7:8 (218,-41.55)};
// (218,-41.95) @TEXT("VSS",size=1.1,halign="middle",valign="top");
// }
// END SARADC RNL
ends sar8s_refword

subckt sar8i_refword CODE0 CODE1 CODE2 CODE3 CODE4 CODE5 CODE6 CODE7 D0 D1  D2 D3 D4 D5 D6 D7 GNN0 GNN1 GNN2 GNN3 GNN4 GNN5 GNN6 GNN7 GNP0  GNP1 GNP2 GNP3 GNP4 GNP5 GNP6 GNP7 GPN0 GPN1 GPN2 GPN3 GPN4 GPN5  GPN6 GPN7 GPP0 GPP1 GPP2 GPP3 GPP4 GPP5 GPP6 GPP7 PHI_U SAMPLE VDD  VSS RST_DONE PRESET
    XRR7 (PRESET PRESET VDD VSS RST7) sar8p_and2
    XRSTEP1 (PRESET VDD VSS TAP1) sar8s_step
    XRR6 (PRESET TAP1 VDD VSS RST6) sar8p_and2
    XRSTEP2 (TAP1 VDD VSS TAP2) sar8s_step
    XRR5 (PRESET TAP2 VDD VSS RST5) sar8p_and2
    XRSTEP3 (TAP2 VDD VSS TAP3) sar8s_step
    XRR4 (PRESET TAP3 VDD VSS RST4) sar8p_and2
    XRSTEP4 (TAP3 VDD VSS TAP4) sar8s_step
    XRR3 (PRESET TAP4 VDD VSS RST3) sar8p_and2
    XRSTEP5 (TAP4 VDD VSS TAP5) sar8s_step
    XRR2 (PRESET TAP5 VDD VSS RST2) sar8p_and2
    XRSTEP6 (TAP5 VDD VSS TAP6) sar8s_step
    XRR1 (PRESET TAP6 VDD VSS RST1) sar8p_and2
    XRSTEP7 (TAP6 VDD VSS TAP7) sar8s_step
    XRR0 (PRESET TAP7 VDD VSS RST0) sar8p_and2
    XRDONE (RST0 VDD VSS RST_DONE) sar8p_buf
    X002 (FIRST1 VDD VSS FIRST2) sar8p_buf
    X001 (FIRST0 VDD VSS FIRST1) sar8p_buf
    X000 (PHI_U VDD VSS FIRST0) sar8p_buf
    X007 (FIRST2 LATE_CLK VDD VSS CAP_REQ) sar8p_or2
    X003 (SAMPLE ACK VDD VSS REQ_RESET) sar8p_or2
    XREQUEST (REQ_Q REQ_RESET PHI_U VDD VSS) sar8p_sr
    XD_LATE_CLK (REQ_Q VDD VSS LATE_CLK) sar8p_delay_capture
    XD_ACK (LATE_CLK VDD VSS ACK) sar8p_delay_valid
    X008 (CAP_REQ VDD VSS CAP_CLK) sar8p_clkbuf
    XMUX7 (CODE7 D7 PHI_U VDD VSS TARGET7) sar8p_mux2
    XMUX6 (CODE6 D6 PHI_U VDD VSS TARGET6) sar8p_mux2
    XMUX5 (CODE5 D5 PHI_U VDD VSS TARGET5) sar8p_mux2
    XMUX4 (CODE4 D4 PHI_U VDD VSS TARGET4) sar8p_mux2
    XMUX3 (CODE3 D3 PHI_U VDD VSS TARGET3) sar8p_mux2
    XMUX2 (CODE2 D2 PHI_U VDD VSS TARGET2) sar8p_mux2
    XMUX1 (CODE1 D1 PHI_U VDD VSS TARGET1) sar8p_mux2
    XMUX0 (CODE0 D0 PHI_U VDD VSS TARGET0) sar8p_mux2
    X018 (MSB_QN VDD VSS Q7) sar8p_inv
    X017 (TARGET7 VDD VSS MSB_DN) sar8p_inv
    XSTORE7 (CAP_CLK MSB_DN MSB_QN RST7 VDD VSS) sar8p_dffr
    XSTORE6 (CAP_CLK TARGET6 Q6 RST6 VDD VSS) sar8p_dffr
    XSTORE5 (CAP_CLK TARGET5 Q5 RST5 VDD VSS) sar8p_dffr
    XSTORE4 (CAP_CLK TARGET4 Q4 RST4 VDD VSS) sar8p_dffr
    XSTORE3 (CAP_CLK TARGET3 Q3 RST3 VDD VSS) sar8p_dffr
    XSTORE2 (CAP_CLK TARGET2 Q2 RST2 VDD VSS) sar8p_dffr
    XSTORE1 (CAP_CLK TARGET1 Q1 RST1 VDD VSS) sar8p_dffr
    XSTORE0 (CAP_CLK TARGET0 Q0 RST0 VDD VSS) sar8p_dffr
    XBBM7 (Q7 H7 L7 VDD VSS) sar8p_nonoverlap
    XBBM6 (Q6 H6 L6 VDD VSS) sar8p_nonoverlap
    XBBM5 (Q5 H5 L5 VDD VSS) sar8p_nonoverlap
    XBBM4 (Q4 H4 L4 VDD VSS) sar8p_nonoverlap
    XBBM3 (Q3 H3 L3 VDD VSS) sar8p_nonoverlap
    XBBM2 (Q2 H2 L2 VDD VSS) sar8p_nonoverlap
    XBBM1 (Q1 H1 L1 VDD VSS) sar8p_nonoverlap
    XBBM0 (Q0 H0 L0 VDD VSS) sar8p_nonoverlap
    XDRV0 (GNN0 GNP0 GPN0 GPP0 H0 L0 VDD VSS) sar8p_refdrv_b0
    XDRV1 (GNN1 GNP1 GPN1 GPP1 H1 L1 VDD VSS) sar8p_refdrv_b1
    XDRV2 (GNN2 GNP2 GPN2 GPP2 H2 L2 VDD VSS) sar8p_refdrv_b2
    XDRV3 (GNN3 GNP3 GPN3 GPP3 H3 L3 VDD VSS) sar8p_refdrv_b3
    XDRV4 (GNN4 GNP4 GPN4 GPP4 H4 L4 VDD VSS) sar8p_refdrv_b4
    XDRV5 (GNN5 GNP5 GPN5 GPP5 H5 L5 VDD VSS) sar8p_refdrv_b5
    XDRV6 (GNN6 GNP6 GPN6 GPP6 H6 L6 VDD VSS) sar8p_refdrv_b6
    XDRV7 (GNN7 GNP7 GPN7 GPP7 H7 L7 VDD VSS) sar8p_refdrv_b7
// BEGIN SARADC RNL
// @RNL(author="saradc topology") {
// (-24,205) @TEXT("sar8i_refword / capture, sequential reset, nonoverlap and gate drive",size=1.5,halign="start",textcolor="#223d52");
// (-24,187) @TEXT("Sequential preset / bit 7 -> bit 0",size=1.1,halign="start",textcolor="#223d52");
// #XRSTEP1 @SET-SYMBOL $S_sar8s_step;
// #XRSTEP1 @PLACE(43,160) => @ORIENT("R0");
// #XRSTEP2 @SET-SYMBOL $S_sar8s_step;
// #XRSTEP2 @PLACE(86,160) => @ORIENT("R0");
// #XRSTEP3 @SET-SYMBOL $S_sar8s_step;
// #XRSTEP3 @PLACE(129,160) => @ORIENT("R0");
// #XRSTEP4 @SET-SYMBOL $S_sar8s_step;
// #XRSTEP4 @PLACE(172,160) => @ORIENT("R0");
// #XRSTEP5 @SET-SYMBOL $S_sar8s_step;
// #XRSTEP5 @PLACE(215,160) => @ORIENT("R0");
// #XRSTEP6 @SET-SYMBOL $S_sar8s_step;
// #XRSTEP6 @PLACE(258,160) => @ORIENT("R0");
// #XRSTEP7 @SET-SYMBOL $S_sar8s_step;
// #XRSTEP7 @PLACE(301,160) => @ORIENT("R0");
// #XRR7 @SET-SYMBOL $S_sar8p_and2;
// #XRR7 @PLACE(0,125) => @ORIENT("R0");
// #XRR6 @SET-SYMBOL $S_sar8p_and2;
// #XRR6 @PLACE(43,125) => @ORIENT("R0");
// #XRR5 @SET-SYMBOL $S_sar8p_and2;
// #XRR5 @PLACE(86,125) => @ORIENT("R0");
// #XRR4 @SET-SYMBOL $S_sar8p_and2;
// #XRR4 @PLACE(129,125) => @ORIENT("R0");
// #XRR3 @SET-SYMBOL $S_sar8p_and2;
// #XRR3 @PLACE(172,125) => @ORIENT("R0");
// #XRR2 @SET-SYMBOL $S_sar8p_and2;
// #XRR2 @PLACE(215,125) => @ORIENT("R0");
// #XRR1 @SET-SYMBOL $S_sar8p_and2;
// #XRR1 @PLACE(258,125) => @ORIENT("R0");
// #XRR0 @SET-SYMBOL $S_sar8p_and2;
// #XRR0 @PLACE(301,125) => @ORIENT("R0");
// #XRDONE @SET-SYMBOL $S_sar8p_buf;
// #XRDONE @PLACE(344,125) => @ORIENT("R0");
// &"TAP1" @WIRE(mode="straight",linecolor="#30485d",linewidth=0.16) {(63,123.3) (63,160)};
// &"TAP1" @WIRE(mode="straight",linecolor="#30485d",linewidth=0.16) {#XRSTEP1:4 (63,160)};
// $JUNCTION @ATTACH (63,160);
// &"TAP1" @WIRE(mode="straight",linecolor="#30485d",linewidth=0.16) {#XRR6:2 (63,123.3)};
// $JUNCTION @ATTACH (63,123.3);
// &"TAP1" @WIRE(mode="straight",linecolor="#30485d",linewidth=0.16) {#XRSTEP2:1 (63,160)};
// $JUNCTION @ATTACH (63,160);
// &"TAP2" @WIRE(mode="straight",linecolor="#30485d",linewidth=0.16) {(106,123.3) (106,160)};
// &"TAP2" @WIRE(mode="straight",linecolor="#30485d",linewidth=0.16) {#XRSTEP2:4 (106,160)};
// $JUNCTION @ATTACH (106,160);
// &"TAP2" @WIRE(mode="straight",linecolor="#30485d",linewidth=0.16) {#XRR5:2 (106,123.3)};
// $JUNCTION @ATTACH (106,123.3);
// &"TAP2" @WIRE(mode="straight",linecolor="#30485d",linewidth=0.16) {#XRSTEP3:1 (106,160)};
// $JUNCTION @ATTACH (106,160);
// &"TAP3" @WIRE(mode="straight",linecolor="#30485d",linewidth=0.16) {(149,123.3) (149,160)};
// &"TAP3" @WIRE(mode="straight",linecolor="#30485d",linewidth=0.16) {#XRSTEP3:4 (149,160)};
// $JUNCTION @ATTACH (149,160);
// &"TAP3" @WIRE(mode="straight",linecolor="#30485d",linewidth=0.16) {#XRR4:2 (149,123.3)};
// $JUNCTION @ATTACH (149,123.3);
// &"TAP3" @WIRE(mode="straight",linecolor="#30485d",linewidth=0.16) {#XRSTEP4:1 (149,160)};
// $JUNCTION @ATTACH (149,160);
// &"TAP4" @WIRE(mode="straight",linecolor="#30485d",linewidth=0.16) {(192,123.3) (192,160)};
// &"TAP4" @WIRE(mode="straight",linecolor="#30485d",linewidth=0.16) {#XRSTEP4:4 (192,160)};
// $JUNCTION @ATTACH (192,160);
// &"TAP4" @WIRE(mode="straight",linecolor="#30485d",linewidth=0.16) {#XRR3:2 (192,123.3)};
// $JUNCTION @ATTACH (192,123.3);
// &"TAP4" @WIRE(mode="straight",linecolor="#30485d",linewidth=0.16) {#XRSTEP5:1 (192,160)};
// $JUNCTION @ATTACH (192,160);
// &"TAP5" @WIRE(mode="straight",linecolor="#30485d",linewidth=0.16) {(235,123.3) (235,160)};
// &"TAP5" @WIRE(mode="straight",linecolor="#30485d",linewidth=0.16) {#XRSTEP5:4 (235,160)};
// $JUNCTION @ATTACH (235,160);
// &"TAP5" @WIRE(mode="straight",linecolor="#30485d",linewidth=0.16) {#XRR2:2 (235,123.3)};
// $JUNCTION @ATTACH (235,123.3);
// &"TAP5" @WIRE(mode="straight",linecolor="#30485d",linewidth=0.16) {#XRSTEP6:1 (235,160)};
// $JUNCTION @ATTACH (235,160);
// &"TAP6" @WIRE(mode="straight",linecolor="#30485d",linewidth=0.16) {(278,123.3) (278,160)};
// &"TAP6" @WIRE(mode="straight",linecolor="#30485d",linewidth=0.16) {#XRSTEP6:4 (278,160)};
// $JUNCTION @ATTACH (278,160);
// &"TAP6" @WIRE(mode="straight",linecolor="#30485d",linewidth=0.16) {#XRR1:2 (278,123.3)};
// $JUNCTION @ATTACH (278,123.3);
// &"TAP6" @WIRE(mode="straight",linecolor="#30485d",linewidth=0.16) {#XRSTEP7:1 (278,160)};
// $JUNCTION @ATTACH (278,160);
// &"TAP7" @WIRE(mode="straight",linecolor="#30485d",linewidth=0.16) {(321,123.3) (321,160)};
// &"TAP7" @WIRE(mode="straight",linecolor="#30485d",linewidth=0.16) {#XRSTEP7:4 (321,160)};
// $JUNCTION @ATTACH (321,160);
// &"TAP7" @WIRE(mode="straight",linecolor="#30485d",linewidth=0.16) {#XRR0:2 (321,123.3)};
// $JUNCTION @ATTACH (321,123.3);
// (-24,90) @TEXT("Capture request / first and late clocks / acknowledge",size=1.1,halign="start",textcolor="#223d52");
// #X000 @SET-SYMBOL $S_sar8p_buf;
// #X000 @PLACE(0,65) => @ORIENT("R0");
// #X001 @SET-SYMBOL $S_sar8p_buf;
// #X001 @PLACE(43,65) => @ORIENT("R0");
// #X002 @SET-SYMBOL $S_sar8p_buf;
// #X002 @PLACE(86,65) => @ORIENT("R0");
// #X007 @SET-SYMBOL $S_sar8p_or2;
// #X007 @PLACE(171,65) => @ORIENT("R0");
// #X008 @SET-SYMBOL $S_sar8p_clkbuf;
// #X008 @PLACE(214,65) => @ORIENT("R0");
// #X003 @SET-SYMBOL $S_sar8p_or2;
// #X003 @PLACE(0,25) => @ORIENT("R0");
// #XREQUEST @SET-SYMBOL $S_sar8p_sr;
// #XREQUEST @PLACE(43,25) => @ORIENT("R0");
// #XD_LATE_CLK @SET-SYMBOL $S_sar8p_delay_capture;
// #XD_LATE_CLK @PLACE(86,25) => @ORIENT("R0");
// #XD_ACK @SET-SYMBOL $S_sar8p_delay_valid;
// #XD_ACK @PLACE(129,25) => @ORIENT("R0");
// #XMUX7 @SET-SYMBOL $S_sar8p_mux2;
// #XMUX7 @PLACE(0,-25) => @ORIENT("R0");
// #XSTORE7 @SET-SYMBOL $S_sar8p_dffr;
// #XSTORE7 @PLACE(86,-25) => @ORIENT("R0");
// #XBBM7 @SET-SYMBOL $S_sar8p_nonoverlap;
// #XBBM7 @PLACE(155,-25) => @ORIENT("R0");
// #XDRV7 @SET-SYMBOL $S_sar8p_refdrv_b7;
// #XDRV7 @PLACE(218,-25) => @ORIENT("R0");
// (-24,-11) @TEXT("bit 7",size=1,halign="start",textcolor="#223d52");
// #XMUX6 @SET-SYMBOL $S_sar8p_mux2;
// #XMUX6 @PLACE(0,-63) => @ORIENT("R0");
// #XSTORE6 @SET-SYMBOL $S_sar8p_dffr;
// #XSTORE6 @PLACE(86,-63) => @ORIENT("R0");
// #XBBM6 @SET-SYMBOL $S_sar8p_nonoverlap;
// #XBBM6 @PLACE(155,-63) => @ORIENT("R0");
// #XDRV6 @SET-SYMBOL $S_sar8p_refdrv_b6;
// #XDRV6 @PLACE(218,-63) => @ORIENT("R0");
// (-24,-49) @TEXT("bit 6",size=1,halign="start",textcolor="#223d52");
// #XMUX5 @SET-SYMBOL $S_sar8p_mux2;
// #XMUX5 @PLACE(0,-101) => @ORIENT("R0");
// #XSTORE5 @SET-SYMBOL $S_sar8p_dffr;
// #XSTORE5 @PLACE(86,-101) => @ORIENT("R0");
// #XBBM5 @SET-SYMBOL $S_sar8p_nonoverlap;
// #XBBM5 @PLACE(155,-101) => @ORIENT("R0");
// #XDRV5 @SET-SYMBOL $S_sar8p_refdrv_b5;
// #XDRV5 @PLACE(218,-101) => @ORIENT("R0");
// (-24,-87) @TEXT("bit 5",size=1,halign="start",textcolor="#223d52");
// #XMUX4 @SET-SYMBOL $S_sar8p_mux2;
// #XMUX4 @PLACE(0,-139) => @ORIENT("R0");
// #XSTORE4 @SET-SYMBOL $S_sar8p_dffr;
// #XSTORE4 @PLACE(86,-139) => @ORIENT("R0");
// #XBBM4 @SET-SYMBOL $S_sar8p_nonoverlap;
// #XBBM4 @PLACE(155,-139) => @ORIENT("R0");
// #XDRV4 @SET-SYMBOL $S_sar8p_refdrv_b4;
// #XDRV4 @PLACE(218,-139) => @ORIENT("R0");
// (-24,-125) @TEXT("bit 4",size=1,halign="start",textcolor="#223d52");
// #XMUX3 @SET-SYMBOL $S_sar8p_mux2;
// #XMUX3 @PLACE(0,-177) => @ORIENT("R0");
// #XSTORE3 @SET-SYMBOL $S_sar8p_dffr;
// #XSTORE3 @PLACE(86,-177) => @ORIENT("R0");
// #XBBM3 @SET-SYMBOL $S_sar8p_nonoverlap;
// #XBBM3 @PLACE(155,-177) => @ORIENT("R0");
// #XDRV3 @SET-SYMBOL $S_sar8p_refdrv_b3;
// #XDRV3 @PLACE(218,-177) => @ORIENT("R0");
// (-24,-163) @TEXT("bit 3",size=1,halign="start",textcolor="#223d52");
// #XMUX2 @SET-SYMBOL $S_sar8p_mux2;
// #XMUX2 @PLACE(0,-215) => @ORIENT("R0");
// #XSTORE2 @SET-SYMBOL $S_sar8p_dffr;
// #XSTORE2 @PLACE(86,-215) => @ORIENT("R0");
// #XBBM2 @SET-SYMBOL $S_sar8p_nonoverlap;
// #XBBM2 @PLACE(155,-215) => @ORIENT("R0");
// #XDRV2 @SET-SYMBOL $S_sar8p_refdrv_b2;
// #XDRV2 @PLACE(218,-215) => @ORIENT("R0");
// (-24,-201) @TEXT("bit 2",size=1,halign="start",textcolor="#223d52");
// #XMUX1 @SET-SYMBOL $S_sar8p_mux2;
// #XMUX1 @PLACE(0,-253) => @ORIENT("R0");
// #XSTORE1 @SET-SYMBOL $S_sar8p_dffr;
// #XSTORE1 @PLACE(86,-253) => @ORIENT("R0");
// #XBBM1 @SET-SYMBOL $S_sar8p_nonoverlap;
// #XBBM1 @PLACE(155,-253) => @ORIENT("R0");
// #XDRV1 @SET-SYMBOL $S_sar8p_refdrv_b1;
// #XDRV1 @PLACE(218,-253) => @ORIENT("R0");
// (-24,-239) @TEXT("bit 1",size=1,halign="start",textcolor="#223d52");
// #XMUX0 @SET-SYMBOL $S_sar8p_mux2;
// #XMUX0 @PLACE(0,-291) => @ORIENT("R0");
// #XSTORE0 @SET-SYMBOL $S_sar8p_dffr;
// #XSTORE0 @PLACE(86,-291) => @ORIENT("R0");
// #XBBM0 @SET-SYMBOL $S_sar8p_nonoverlap;
// #XBBM0 @PLACE(155,-291) => @ORIENT("R0");
// #XDRV0 @SET-SYMBOL $S_sar8p_refdrv_b0;
// #XDRV0 @PLACE(218,-291) => @ORIENT("R0");
// (-24,-277) @TEXT("bit 0",size=1,halign="start",textcolor="#223d52");
// #X017 @SET-SYMBOL $S_sar8p_inv;
// #X017 @PLACE(43,-25) => @ORIENT("R0");
// #X018 @SET-SYMBOL $S_sar8p_inv;
// #X018 @PLACE(118,-25) => @ORIENT("R0");
// &"FIRST1" @WIRE(mode="straight",linecolor="#30485d",linewidth=0.16) {#X002:1 (64.5,65) (64.5,65) #X001:4};
// &"FIRST0" @WIRE(mode="straight",linecolor="#30485d",linewidth=0.16) {#X001:1 (21.5,65) (21.5,65) #X000:4};
// &"REQ_RESET" @WIRE(mode="straight",linecolor="#30485d",linewidth=0.16) {#X003:5 (18.5,25) (18.5,26.65) #XREQUEST:2};
// &"REQ_Q" @WIRE(mode="straight",linecolor="#30485d",linewidth=0.16) {#XREQUEST:1 (64.5,25) (64.5,25) #XD_LATE_CLK:1};
// &"TARGET7" @WIRE(mode="straight",linecolor="#30485d",linewidth=0.16) {#XMUX7:6 (21.5,-25) (21.5,-25) #X017:1};
// &"MSB_QN" @WIRE(mode="straight",linecolor="#30485d",linewidth=0.16) {#X018:1 (102,-25) (102,-25) #XSTORE7:3};
// &"Q7" @WIRE(mode="straight",linecolor="#30485d",linewidth=0.16) {#X018:4 (133.5,-25) (133.5,-25) #XBBM7:1};
// &"MSB_DN" @WIRE(mode="straight",linecolor="#30485d",linewidth=0.16) {#X017:4 (64.5,-25) (64.5,-25) #XSTORE7:2};
// &"Q6" @WIRE(mode="straight",linecolor="#30485d",linewidth=0.16) {#XSTORE6:3 (117.5,-63) (117.5,-63) #XBBM6:1};
// &"Q5" @WIRE(mode="straight",linecolor="#30485d",linewidth=0.16) {#XSTORE5:3 (117.5,-101) (117.5,-101) #XBBM5:1};
// &"Q4" @WIRE(mode="straight",linecolor="#30485d",linewidth=0.16) {#XSTORE4:3 (117.5,-139) (117.5,-139) #XBBM4:1};
// &"Q3" @WIRE(mode="straight",linecolor="#30485d",linewidth=0.16) {#XSTORE3:3 (117.5,-177) (117.5,-177) #XBBM3:1};
// &"Q2" @WIRE(mode="straight",linecolor="#30485d",linewidth=0.16) {#XSTORE2:3 (117.5,-215) (117.5,-215) #XBBM2:1};
// &"Q1" @WIRE(mode="straight",linecolor="#30485d",linewidth=0.16) {#XSTORE1:3 (117.5,-253) (117.5,-253) #XBBM1:1};
// &"Q0" @WIRE(mode="straight",linecolor="#30485d",linewidth=0.16) {#XSTORE0:3 (117.5,-291) (117.5,-291) #XBBM0:1};
// &"H7" @WIRE(mode="straight",linecolor="#30485d",linewidth=0.16) {#XBBM7:2 (199.5,-23.35) (199.5,-29.95) #XDRV7:5};
// &"L7" @WIRE(mode="straight",linecolor="#30485d",linewidth=0.16) {#XBBM7:3 (199.5,-26.65) (199.5,-33.25) #XDRV7:6};
// &"H6" @WIRE(mode="straight",linecolor="#30485d",linewidth=0.16) {#XBBM6:2 (199.5,-61.35) (199.5,-67.95) #XDRV6:5};
// &"L6" @WIRE(mode="straight",linecolor="#30485d",linewidth=0.16) {#XBBM6:3 (199.5,-64.65) (199.5,-71.25) #XDRV6:6};
// &"H5" @WIRE(mode="straight",linecolor="#30485d",linewidth=0.16) {#XBBM5:2 (199.5,-99.35) (199.5,-105.95) #XDRV5:5};
// &"L5" @WIRE(mode="straight",linecolor="#30485d",linewidth=0.16) {#XBBM5:3 (199.5,-102.65) (199.5,-109.25) #XDRV5:6};
// &"H4" @WIRE(mode="straight",linecolor="#30485d",linewidth=0.16) {#XBBM4:2 (199.5,-137.35) (199.5,-143.95) #XDRV4:5};
// &"L4" @WIRE(mode="straight",linecolor="#30485d",linewidth=0.16) {#XBBM4:3 (199.5,-140.65) (199.5,-147.25) #XDRV4:6};
// &"H3" @WIRE(mode="straight",linecolor="#30485d",linewidth=0.16) {#XBBM3:2 (199.5,-175.35) (199.5,-181.95) #XDRV3:5};
// &"L3" @WIRE(mode="straight",linecolor="#30485d",linewidth=0.16) {#XBBM3:3 (199.5,-178.65) (199.5,-185.25) #XDRV3:6};
// &"H2" @WIRE(mode="straight",linecolor="#30485d",linewidth=0.16) {#XBBM2:2 (199.5,-213.35) (199.5,-219.95) #XDRV2:5};
// &"L2" @WIRE(mode="straight",linecolor="#30485d",linewidth=0.16) {#XBBM2:3 (199.5,-216.65) (199.5,-223.25) #XDRV2:6};
// &"H1" @WIRE(mode="straight",linecolor="#30485d",linewidth=0.16) {#XBBM1:2 (199.5,-251.35) (199.5,-257.95) #XDRV1:5};
// &"L1" @WIRE(mode="straight",linecolor="#30485d",linewidth=0.16) {#XBBM1:3 (199.5,-254.65) (199.5,-261.25) #XDRV1:6};
// &"H0" @WIRE(mode="straight",linecolor="#30485d",linewidth=0.16) {#XBBM0:2 (199.5,-289.35) (199.5,-295.95) #XDRV0:5};
// &"L0" @WIRE(mode="straight",linecolor="#30485d",linewidth=0.16) {#XBBM0:3 (199.5,-292.65) (199.5,-299.25) #XDRV0:6};
// (-24,-318) @TEXT("CODE / D -> MUX -> resettable storage -> break-before-make -> physical GP/GN drivers",size=1.1,halign="start",textcolor="#223d52");
// &"PRESET" @WIRE(mode="straight",linecolor="#30485d",linewidth=0.16) {#XRR7:1 (-10,126.7)};
// (-10.4,126.7) @TEXT("PRESET",size=1.1,halign="end",valign="middle");
// &"PRESET" @WIRE(mode="straight",linecolor="#30485d",linewidth=0.16) {#XRR7:2 (-10,123.3)};
// (-10.4,123.3) @TEXT("PRESET",size=1.1,halign="end",valign="middle");
// &"VDD" @WIRE(mode="straight",linecolor="#30485d",linewidth=0.16) {#XRR7:3 (0,135)};
// (0,135.4) @TEXT("VDD",size=1.1,halign="middle",valign="bottom");
// &"VSS" @WIRE(mode="straight",linecolor="#30485d",linewidth=0.16) {#XRR7:4 (0,115)};
// (0,114.6) @TEXT("VSS",size=1.1,halign="middle",valign="top");
// &"RST7" @WIRE(mode="straight",linecolor="#30485d",linewidth=0.16) {#XRR7:5 (10,125)};
// (10.4,125) @TEXT("RST7",size=1.1,halign="start",valign="middle");
// &"PRESET" @WIRE(mode="straight",linecolor="#30485d",linewidth=0.16) {#XRSTEP1:1 (27,160)};
// (26.6,160) @TEXT("PRESET",size=1.1,halign="end",valign="middle");
// &"VDD" @WIRE(mode="straight",linecolor="#30485d",linewidth=0.16) {#XRSTEP1:2 (43,171)};
// (43,171.4) @TEXT("VDD",size=1.1,halign="middle",valign="bottom");
// &"VSS" @WIRE(mode="straight",linecolor="#30485d",linewidth=0.16) {#XRSTEP1:3 (43,149)};
// (43,148.6) @TEXT("VSS",size=1.1,halign="middle",valign="top");
// &"PRESET" @WIRE(mode="straight",linecolor="#30485d",linewidth=0.16) {#XRR6:1 (33,126.7)};
// (32.6,126.7) @TEXT("PRESET",size=1.1,halign="end",valign="middle");
// &"VDD" @WIRE(mode="straight",linecolor="#30485d",linewidth=0.16) {#XRR6:3 (43,135)};
// (43,135.4) @TEXT("VDD",size=1.1,halign="middle",valign="bottom");
// &"VSS" @WIRE(mode="straight",linecolor="#30485d",linewidth=0.16) {#XRR6:4 (43,115)};
// (43,114.6) @TEXT("VSS",size=1.1,halign="middle",valign="top");
// &"RST6" @WIRE(mode="straight",linecolor="#30485d",linewidth=0.16) {#XRR6:5 (53,125)};
// (53.4,125) @TEXT("RST6",size=1.1,halign="start",valign="middle");
// &"VDD" @WIRE(mode="straight",linecolor="#30485d",linewidth=0.16) {#XRSTEP2:2 (86,171)};
// (86,171.4) @TEXT("VDD",size=1.1,halign="middle",valign="bottom");
// &"VSS" @WIRE(mode="straight",linecolor="#30485d",linewidth=0.16) {#XRSTEP2:3 (86,149)};
// (86,148.6) @TEXT("VSS",size=1.1,halign="middle",valign="top");
// &"PRESET" @WIRE(mode="straight",linecolor="#30485d",linewidth=0.16) {#XRR5:1 (76,126.7)};
// (75.6,126.7) @TEXT("PRESET",size=1.1,halign="end",valign="middle");
// &"VDD" @WIRE(mode="straight",linecolor="#30485d",linewidth=0.16) {#XRR5:3 (86,135)};
// (86,135.4) @TEXT("VDD",size=1.1,halign="middle",valign="bottom");
// &"VSS" @WIRE(mode="straight",linecolor="#30485d",linewidth=0.16) {#XRR5:4 (86,115)};
// (86,114.6) @TEXT("VSS",size=1.1,halign="middle",valign="top");
// &"RST5" @WIRE(mode="straight",linecolor="#30485d",linewidth=0.16) {#XRR5:5 (96,125)};
// (96.4,125) @TEXT("RST5",size=1.1,halign="start",valign="middle");
// &"VDD" @WIRE(mode="straight",linecolor="#30485d",linewidth=0.16) {#XRSTEP3:2 (129,171)};
// (129,171.4) @TEXT("VDD",size=1.1,halign="middle",valign="bottom");
// &"VSS" @WIRE(mode="straight",linecolor="#30485d",linewidth=0.16) {#XRSTEP3:3 (129,149)};
// (129,148.6) @TEXT("VSS",size=1.1,halign="middle",valign="top");
// &"PRESET" @WIRE(mode="straight",linecolor="#30485d",linewidth=0.16) {#XRR4:1 (119,126.7)};
// (118.6,126.7) @TEXT("PRESET",size=1.1,halign="end",valign="middle");
// &"VDD" @WIRE(mode="straight",linecolor="#30485d",linewidth=0.16) {#XRR4:3 (129,135)};
// (129,135.4) @TEXT("VDD",size=1.1,halign="middle",valign="bottom");
// &"VSS" @WIRE(mode="straight",linecolor="#30485d",linewidth=0.16) {#XRR4:4 (129,115)};
// (129,114.6) @TEXT("VSS",size=1.1,halign="middle",valign="top");
// &"RST4" @WIRE(mode="straight",linecolor="#30485d",linewidth=0.16) {#XRR4:5 (139,125)};
// (139.4,125) @TEXT("RST4",size=1.1,halign="start",valign="middle");
// &"VDD" @WIRE(mode="straight",linecolor="#30485d",linewidth=0.16) {#XRSTEP4:2 (172,171)};
// (172,171.4) @TEXT("VDD",size=1.1,halign="middle",valign="bottom");
// &"VSS" @WIRE(mode="straight",linecolor="#30485d",linewidth=0.16) {#XRSTEP4:3 (172,149)};
// (172,148.6) @TEXT("VSS",size=1.1,halign="middle",valign="top");
// &"PRESET" @WIRE(mode="straight",linecolor="#30485d",linewidth=0.16) {#XRR3:1 (162,126.7)};
// (161.6,126.7) @TEXT("PRESET",size=1.1,halign="end",valign="middle");
// &"VDD" @WIRE(mode="straight",linecolor="#30485d",linewidth=0.16) {#XRR3:3 (172,135)};
// (172,135.4) @TEXT("VDD",size=1.1,halign="middle",valign="bottom");
// &"VSS" @WIRE(mode="straight",linecolor="#30485d",linewidth=0.16) {#XRR3:4 (172,115)};
// (172,114.6) @TEXT("VSS",size=1.1,halign="middle",valign="top");
// &"RST3" @WIRE(mode="straight",linecolor="#30485d",linewidth=0.16) {#XRR3:5 (182,125)};
// (182.4,125) @TEXT("RST3",size=1.1,halign="start",valign="middle");
// &"VDD" @WIRE(mode="straight",linecolor="#30485d",linewidth=0.16) {#XRSTEP5:2 (215,171)};
// (215,171.4) @TEXT("VDD",size=1.1,halign="middle",valign="bottom");
// &"VSS" @WIRE(mode="straight",linecolor="#30485d",linewidth=0.16) {#XRSTEP5:3 (215,149)};
// (215,148.6) @TEXT("VSS",size=1.1,halign="middle",valign="top");
// &"PRESET" @WIRE(mode="straight",linecolor="#30485d",linewidth=0.16) {#XRR2:1 (205,126.7)};
// (204.6,126.7) @TEXT("PRESET",size=1.1,halign="end",valign="middle");
// &"VDD" @WIRE(mode="straight",linecolor="#30485d",linewidth=0.16) {#XRR2:3 (215,135)};
// (215,135.4) @TEXT("VDD",size=1.1,halign="middle",valign="bottom");
// &"VSS" @WIRE(mode="straight",linecolor="#30485d",linewidth=0.16) {#XRR2:4 (215,115)};
// (215,114.6) @TEXT("VSS",size=1.1,halign="middle",valign="top");
// &"RST2" @WIRE(mode="straight",linecolor="#30485d",linewidth=0.16) {#XRR2:5 (225,125)};
// (225.4,125) @TEXT("RST2",size=1.1,halign="start",valign="middle");
// &"VDD" @WIRE(mode="straight",linecolor="#30485d",linewidth=0.16) {#XRSTEP6:2 (258,171)};
// (258,171.4) @TEXT("VDD",size=1.1,halign="middle",valign="bottom");
// &"VSS" @WIRE(mode="straight",linecolor="#30485d",linewidth=0.16) {#XRSTEP6:3 (258,149)};
// (258,148.6) @TEXT("VSS",size=1.1,halign="middle",valign="top");
// &"PRESET" @WIRE(mode="straight",linecolor="#30485d",linewidth=0.16) {#XRR1:1 (248,126.7)};
// (247.6,126.7) @TEXT("PRESET",size=1.1,halign="end",valign="middle");
// &"VDD" @WIRE(mode="straight",linecolor="#30485d",linewidth=0.16) {#XRR1:3 (258,135)};
// (258,135.4) @TEXT("VDD",size=1.1,halign="middle",valign="bottom");
// &"VSS" @WIRE(mode="straight",linecolor="#30485d",linewidth=0.16) {#XRR1:4 (258,115)};
// (258,114.6) @TEXT("VSS",size=1.1,halign="middle",valign="top");
// &"RST1" @WIRE(mode="straight",linecolor="#30485d",linewidth=0.16) {#XRR1:5 (268,125)};
// (268.4,125) @TEXT("RST1",size=1.1,halign="start",valign="middle");
// &"VDD" @WIRE(mode="straight",linecolor="#30485d",linewidth=0.16) {#XRSTEP7:2 (301,171)};
// (301,171.4) @TEXT("VDD",size=1.1,halign="middle",valign="bottom");
// &"VSS" @WIRE(mode="straight",linecolor="#30485d",linewidth=0.16) {#XRSTEP7:3 (301,149)};
// (301,148.6) @TEXT("VSS",size=1.1,halign="middle",valign="top");
// &"PRESET" @WIRE(mode="straight",linecolor="#30485d",linewidth=0.16) {#XRR0:1 (291,126.7)};
// (290.6,126.7) @TEXT("PRESET",size=1.1,halign="end",valign="middle");
// &"VDD" @WIRE(mode="straight",linecolor="#30485d",linewidth=0.16) {#XRR0:3 (301,135)};
// (301,135.4) @TEXT("VDD",size=1.1,halign="middle",valign="bottom");
// &"VSS" @WIRE(mode="straight",linecolor="#30485d",linewidth=0.16) {#XRR0:4 (301,115)};
// (301,114.6) @TEXT("VSS",size=1.1,halign="middle",valign="top");
// &"RST0" @WIRE(mode="straight",linecolor="#30485d",linewidth=0.16) {#XRR0:5 (311,125)};
// (311.4,125) @TEXT("RST0",size=1.1,halign="start",valign="middle");
// &"RST0" @WIRE(mode="straight",linecolor="#30485d",linewidth=0.16) {#XRDONE:1 (334,125)};
// (333.6,125) @TEXT("RST0",size=1.1,halign="end",valign="middle");
// &"VDD" @WIRE(mode="straight",linecolor="#30485d",linewidth=0.16) {#XRDONE:2 (344,135)};
// (344,135.4) @TEXT("VDD",size=1.1,halign="middle",valign="bottom");
// &"VSS" @WIRE(mode="straight",linecolor="#30485d",linewidth=0.16) {#XRDONE:3 (344,115)};
// (344,114.6) @TEXT("VSS",size=1.1,halign="middle",valign="top");
// &"RST_DONE" @WIRE(mode="straight",linecolor="#30485d",linewidth=0.16) {#XRDONE:4 (354,125)};
// (354.4,125) @TEXT("RST_DONE",size=1.1,halign="start",valign="middle");
// &"VDD" @WIRE(mode="straight",linecolor="#30485d",linewidth=0.16) {#X002:2 (86,75)};
// (86,75.4) @TEXT("VDD",size=1.1,halign="middle",valign="bottom");
// &"VSS" @WIRE(mode="straight",linecolor="#30485d",linewidth=0.16) {#X002:3 (86,55)};
// (86,54.6) @TEXT("VSS",size=1.1,halign="middle",valign="top");
// &"FIRST2" @WIRE(mode="straight",linecolor="#30485d",linewidth=0.16) {#X002:4 (96,65)};
// (96.4,65) @TEXT("FIRST2",size=1.1,halign="start",valign="middle");
// &"VDD" @WIRE(mode="straight",linecolor="#30485d",linewidth=0.16) {#X001:2 (43,75)};
// (43,75.4) @TEXT("VDD",size=1.1,halign="middle",valign="bottom");
// &"VSS" @WIRE(mode="straight",linecolor="#30485d",linewidth=0.16) {#X001:3 (43,55)};
// (43,54.6) @TEXT("VSS",size=1.1,halign="middle",valign="top");
// &"PHI_U" @WIRE(mode="straight",linecolor="#30485d",linewidth=0.16) {#X000:1 (-10,65)};
// (-10.4,65) @TEXT("PHI_U",size=1.1,halign="end",valign="middle");
// &"VDD" @WIRE(mode="straight",linecolor="#30485d",linewidth=0.16) {#X000:2 (0,75)};
// (0,75.4) @TEXT("VDD",size=1.1,halign="middle",valign="bottom");
// &"VSS" @WIRE(mode="straight",linecolor="#30485d",linewidth=0.16) {#X000:3 (0,55)};
// (0,54.6) @TEXT("VSS",size=1.1,halign="middle",valign="top");
// &"FIRST2" @WIRE(mode="straight",linecolor="#30485d",linewidth=0.16) {#X007:1 (161,66.7)};
// (160.6,66.7) @TEXT("FIRST2",size=1.1,halign="end",valign="middle");
// &"LATE_CLK" @WIRE(mode="straight",linecolor="#30485d",linewidth=0.16) {#X007:2 (161,63.3)};
// (160.6,63.3) @TEXT("LATE_CLK",size=1.1,halign="end",valign="middle");
// &"VDD" @WIRE(mode="straight",linecolor="#30485d",linewidth=0.16) {#X007:3 (171,75)};
// (171,75.4) @TEXT("VDD",size=1.1,halign="middle",valign="bottom");
// &"VSS" @WIRE(mode="straight",linecolor="#30485d",linewidth=0.16) {#X007:4 (171,55)};
// (171,54.6) @TEXT("VSS",size=1.1,halign="middle",valign="top");
// &"CAP_REQ" @WIRE(mode="straight",linecolor="#30485d",linewidth=0.16) {#X007:5 (181,65)};
// (181.4,65) @TEXT("CAP_REQ",size=1.1,halign="start",valign="middle");
// &"SAMPLE" @WIRE(mode="straight",linecolor="#30485d",linewidth=0.16) {#X003:1 (-10,26.7)};
// (-10.4,26.7) @TEXT("SAMPLE",size=1.1,halign="end",valign="middle");
// &"ACK" @WIRE(mode="straight",linecolor="#30485d",linewidth=0.16) {#X003:2 (-10,23.3)};
// (-10.4,23.3) @TEXT("ACK",size=1.1,halign="end",valign="middle");
// &"VDD" @WIRE(mode="straight",linecolor="#30485d",linewidth=0.16) {#X003:3 (0,35)};
// (0,35.4) @TEXT("VDD",size=1.1,halign="middle",valign="bottom");
// &"VSS" @WIRE(mode="straight",linecolor="#30485d",linewidth=0.16) {#X003:4 (0,15)};
// (0,14.6) @TEXT("VSS",size=1.1,halign="middle",valign="top");
// &"PHI_U" @WIRE(mode="straight",linecolor="#30485d",linewidth=0.16) {#XREQUEST:3 (27,23.35)};
// (26.6,23.35) @TEXT("PHI_U",size=1.1,halign="end",valign="middle");
// &"VDD" @WIRE(mode="straight",linecolor="#30485d",linewidth=0.16) {#XREQUEST:4 (43,36)};
// (43,36.4) @TEXT("VDD",size=1.1,halign="middle",valign="bottom");
// &"VSS" @WIRE(mode="straight",linecolor="#30485d",linewidth=0.16) {#XREQUEST:5 (43,14)};
// (43,13.6) @TEXT("VSS",size=1.1,halign="middle",valign="top");
// &"VDD" @WIRE(mode="straight",linecolor="#30485d",linewidth=0.16) {#XD_LATE_CLK:2 (86,36)};
// (86,36.4) @TEXT("VDD",size=1.1,halign="middle",valign="bottom");
// &"VSS" @WIRE(mode="straight",linecolor="#30485d",linewidth=0.16) {#XD_LATE_CLK:3 (86,14)};
// (86,13.6) @TEXT("VSS",size=1.1,halign="middle",valign="top");
// &"LATE_CLK" @WIRE(mode="straight",linecolor="#30485d",linewidth=0.16) {#XD_LATE_CLK:4 (102,25)};
// (102.4,25) @TEXT("LATE_CLK",size=1.1,halign="start",valign="middle");
// &"LATE_CLK" @WIRE(mode="straight",linecolor="#30485d",linewidth=0.16) {#XD_ACK:1 (113,25)};
// (112.6,25) @TEXT("LATE_CLK",size=1.1,halign="end",valign="middle");
// &"VDD" @WIRE(mode="straight",linecolor="#30485d",linewidth=0.16) {#XD_ACK:2 (129,36)};
// (129,36.4) @TEXT("VDD",size=1.1,halign="middle",valign="bottom");
// &"VSS" @WIRE(mode="straight",linecolor="#30485d",linewidth=0.16) {#XD_ACK:3 (129,14)};
// (129,13.6) @TEXT("VSS",size=1.1,halign="middle",valign="top");
// &"ACK" @WIRE(mode="straight",linecolor="#30485d",linewidth=0.16) {#XD_ACK:4 (145,25)};
// (145.4,25) @TEXT("ACK",size=1.1,halign="start",valign="middle");
// &"CAP_REQ" @WIRE(mode="straight",linecolor="#30485d",linewidth=0.16) {#X008:1 (204,65)};
// (203.6,65) @TEXT("CAP_REQ",size=1.1,halign="end",valign="middle");
// &"VDD" @WIRE(mode="straight",linecolor="#30485d",linewidth=0.16) {#X008:2 (214,75)};
// (214,75.4) @TEXT("VDD",size=1.1,halign="middle",valign="bottom");
// &"VSS" @WIRE(mode="straight",linecolor="#30485d",linewidth=0.16) {#X008:3 (214,55)};
// (214,54.6) @TEXT("VSS",size=1.1,halign="middle",valign="top");
// &"CAP_CLK" @WIRE(mode="straight",linecolor="#30485d",linewidth=0.16) {#X008:4 (224,65)};
// (224.4,65) @TEXT("CAP_CLK",size=1.1,halign="start",valign="middle");
// &"CODE7" @WIRE(mode="straight",linecolor="#30485d",linewidth=0.16) {#XMUX7:1 (-10,-21.6)};
// (-10.4,-21.6) @TEXT("CODE7",size=1.1,halign="end",valign="middle");
// &"D7" @WIRE(mode="straight",linecolor="#30485d",linewidth=0.16) {#XMUX7:2 (-10,-25)};
// (-10.4,-25) @TEXT("D7",size=1.1,halign="end",valign="middle");
// &"PHI_U" @WIRE(mode="straight",linecolor="#30485d",linewidth=0.16) {#XMUX7:3 (-10,-28.4)};
// (-10.4,-28.4) @TEXT("PHI_U",size=1.1,halign="end",valign="middle");
// &"VDD" @WIRE(mode="straight",linecolor="#30485d",linewidth=0.16) {#XMUX7:4 (0,-15)};
// (0,-14.6) @TEXT("VDD",size=1.1,halign="middle",valign="bottom");
// &"VSS" @WIRE(mode="straight",linecolor="#30485d",linewidth=0.16) {#XMUX7:5 (0,-35)};
// (0,-35.4) @TEXT("VSS",size=1.1,halign="middle",valign="top");
// &"CODE6" @WIRE(mode="straight",linecolor="#30485d",linewidth=0.16) {#XMUX6:1 (-10,-59.6)};
// (-10.4,-59.6) @TEXT("CODE6",size=1.1,halign="end",valign="middle");
// &"D6" @WIRE(mode="straight",linecolor="#30485d",linewidth=0.16) {#XMUX6:2 (-10,-63)};
// (-10.4,-63) @TEXT("D6",size=1.1,halign="end",valign="middle");
// &"PHI_U" @WIRE(mode="straight",linecolor="#30485d",linewidth=0.16) {#XMUX6:3 (-10,-66.4)};
// (-10.4,-66.4) @TEXT("PHI_U",size=1.1,halign="end",valign="middle");
// &"VDD" @WIRE(mode="straight",linecolor="#30485d",linewidth=0.16) {#XMUX6:4 (0,-53)};
// (0,-52.6) @TEXT("VDD",size=1.1,halign="middle",valign="bottom");
// &"VSS" @WIRE(mode="straight",linecolor="#30485d",linewidth=0.16) {#XMUX6:5 (0,-73)};
// (0,-73.4) @TEXT("VSS",size=1.1,halign="middle",valign="top");
// &"TARGET6" @WIRE(mode="straight",linecolor="#30485d",linewidth=0.16) {#XMUX6:6 (10,-63)};
// (10.4,-63) @TEXT("TARGET6",size=1.1,halign="start",valign="middle");
// &"CODE5" @WIRE(mode="straight",linecolor="#30485d",linewidth=0.16) {#XMUX5:1 (-10,-97.6)};
// (-10.4,-97.6) @TEXT("CODE5",size=1.1,halign="end",valign="middle");
// &"D5" @WIRE(mode="straight",linecolor="#30485d",linewidth=0.16) {#XMUX5:2 (-10,-101)};
// (-10.4,-101) @TEXT("D5",size=1.1,halign="end",valign="middle");
// &"PHI_U" @WIRE(mode="straight",linecolor="#30485d",linewidth=0.16) {#XMUX5:3 (-10,-104.4)};
// (-10.4,-104.4) @TEXT("PHI_U",size=1.1,halign="end",valign="middle");
// &"VDD" @WIRE(mode="straight",linecolor="#30485d",linewidth=0.16) {#XMUX5:4 (0,-91)};
// (0,-90.6) @TEXT("VDD",size=1.1,halign="middle",valign="bottom");
// &"VSS" @WIRE(mode="straight",linecolor="#30485d",linewidth=0.16) {#XMUX5:5 (0,-111)};
// (0,-111.4) @TEXT("VSS",size=1.1,halign="middle",valign="top");
// &"TARGET5" @WIRE(mode="straight",linecolor="#30485d",linewidth=0.16) {#XMUX5:6 (10,-101)};
// (10.4,-101) @TEXT("TARGET5",size=1.1,halign="start",valign="middle");
// &"CODE4" @WIRE(mode="straight",linecolor="#30485d",linewidth=0.16) {#XMUX4:1 (-10,-135.6)};
// (-10.4,-135.6) @TEXT("CODE4",size=1.1,halign="end",valign="middle");
// &"D4" @WIRE(mode="straight",linecolor="#30485d",linewidth=0.16) {#XMUX4:2 (-10,-139)};
// (-10.4,-139) @TEXT("D4",size=1.1,halign="end",valign="middle");
// &"PHI_U" @WIRE(mode="straight",linecolor="#30485d",linewidth=0.16) {#XMUX4:3 (-10,-142.4)};
// (-10.4,-142.4) @TEXT("PHI_U",size=1.1,halign="end",valign="middle");
// &"VDD" @WIRE(mode="straight",linecolor="#30485d",linewidth=0.16) {#XMUX4:4 (0,-129)};
// (0,-128.6) @TEXT("VDD",size=1.1,halign="middle",valign="bottom");
// &"VSS" @WIRE(mode="straight",linecolor="#30485d",linewidth=0.16) {#XMUX4:5 (0,-149)};
// (0,-149.4) @TEXT("VSS",size=1.1,halign="middle",valign="top");
// &"TARGET4" @WIRE(mode="straight",linecolor="#30485d",linewidth=0.16) {#XMUX4:6 (10,-139)};
// (10.4,-139) @TEXT("TARGET4",size=1.1,halign="start",valign="middle");
// &"CODE3" @WIRE(mode="straight",linecolor="#30485d",linewidth=0.16) {#XMUX3:1 (-10,-173.6)};
// (-10.4,-173.6) @TEXT("CODE3",size=1.1,halign="end",valign="middle");
// &"D3" @WIRE(mode="straight",linecolor="#30485d",linewidth=0.16) {#XMUX3:2 (-10,-177)};
// (-10.4,-177) @TEXT("D3",size=1.1,halign="end",valign="middle");
// &"PHI_U" @WIRE(mode="straight",linecolor="#30485d",linewidth=0.16) {#XMUX3:3 (-10,-180.4)};
// (-10.4,-180.4) @TEXT("PHI_U",size=1.1,halign="end",valign="middle");
// &"VDD" @WIRE(mode="straight",linecolor="#30485d",linewidth=0.16) {#XMUX3:4 (0,-167)};
// (0,-166.6) @TEXT("VDD",size=1.1,halign="middle",valign="bottom");
// &"VSS" @WIRE(mode="straight",linecolor="#30485d",linewidth=0.16) {#XMUX3:5 (0,-187)};
// (0,-187.4) @TEXT("VSS",size=1.1,halign="middle",valign="top");
// &"TARGET3" @WIRE(mode="straight",linecolor="#30485d",linewidth=0.16) {#XMUX3:6 (10,-177)};
// (10.4,-177) @TEXT("TARGET3",size=1.1,halign="start",valign="middle");
// &"CODE2" @WIRE(mode="straight",linecolor="#30485d",linewidth=0.16) {#XMUX2:1 (-10,-211.6)};
// (-10.4,-211.6) @TEXT("CODE2",size=1.1,halign="end",valign="middle");
// &"D2" @WIRE(mode="straight",linecolor="#30485d",linewidth=0.16) {#XMUX2:2 (-10,-215)};
// (-10.4,-215) @TEXT("D2",size=1.1,halign="end",valign="middle");
// &"PHI_U" @WIRE(mode="straight",linecolor="#30485d",linewidth=0.16) {#XMUX2:3 (-10,-218.4)};
// (-10.4,-218.4) @TEXT("PHI_U",size=1.1,halign="end",valign="middle");
// &"VDD" @WIRE(mode="straight",linecolor="#30485d",linewidth=0.16) {#XMUX2:4 (0,-205)};
// (0,-204.6) @TEXT("VDD",size=1.1,halign="middle",valign="bottom");
// &"VSS" @WIRE(mode="straight",linecolor="#30485d",linewidth=0.16) {#XMUX2:5 (0,-225)};
// (0,-225.4) @TEXT("VSS",size=1.1,halign="middle",valign="top");
// &"TARGET2" @WIRE(mode="straight",linecolor="#30485d",linewidth=0.16) {#XMUX2:6 (10,-215)};
// (10.4,-215) @TEXT("TARGET2",size=1.1,halign="start",valign="middle");
// &"CODE1" @WIRE(mode="straight",linecolor="#30485d",linewidth=0.16) {#XMUX1:1 (-10,-249.6)};
// (-10.4,-249.6) @TEXT("CODE1",size=1.1,halign="end",valign="middle");
// &"D1" @WIRE(mode="straight",linecolor="#30485d",linewidth=0.16) {#XMUX1:2 (-10,-253)};
// (-10.4,-253) @TEXT("D1",size=1.1,halign="end",valign="middle");
// &"PHI_U" @WIRE(mode="straight",linecolor="#30485d",linewidth=0.16) {#XMUX1:3 (-10,-256.4)};
// (-10.4,-256.4) @TEXT("PHI_U",size=1.1,halign="end",valign="middle");
// &"VDD" @WIRE(mode="straight",linecolor="#30485d",linewidth=0.16) {#XMUX1:4 (0,-243)};
// (0,-242.6) @TEXT("VDD",size=1.1,halign="middle",valign="bottom");
// &"VSS" @WIRE(mode="straight",linecolor="#30485d",linewidth=0.16) {#XMUX1:5 (0,-263)};
// (0,-263.4) @TEXT("VSS",size=1.1,halign="middle",valign="top");
// &"TARGET1" @WIRE(mode="straight",linecolor="#30485d",linewidth=0.16) {#XMUX1:6 (10,-253)};
// (10.4,-253) @TEXT("TARGET1",size=1.1,halign="start",valign="middle");
// &"CODE0" @WIRE(mode="straight",linecolor="#30485d",linewidth=0.16) {#XMUX0:1 (-10,-287.6)};
// (-10.4,-287.6) @TEXT("CODE0",size=1.1,halign="end",valign="middle");
// &"D0" @WIRE(mode="straight",linecolor="#30485d",linewidth=0.16) {#XMUX0:2 (-10,-291)};
// (-10.4,-291) @TEXT("D0",size=1.1,halign="end",valign="middle");
// &"PHI_U" @WIRE(mode="straight",linecolor="#30485d",linewidth=0.16) {#XMUX0:3 (-10,-294.4)};
// (-10.4,-294.4) @TEXT("PHI_U",size=1.1,halign="end",valign="middle");
// &"VDD" @WIRE(mode="straight",linecolor="#30485d",linewidth=0.16) {#XMUX0:4 (0,-281)};
// (0,-280.6) @TEXT("VDD",size=1.1,halign="middle",valign="bottom");
// &"VSS" @WIRE(mode="straight",linecolor="#30485d",linewidth=0.16) {#XMUX0:5 (0,-301)};
// (0,-301.4) @TEXT("VSS",size=1.1,halign="middle",valign="top");
// &"TARGET0" @WIRE(mode="straight",linecolor="#30485d",linewidth=0.16) {#XMUX0:6 (10,-291)};
// (10.4,-291) @TEXT("TARGET0",size=1.1,halign="start",valign="middle");
// &"VDD" @WIRE(mode="straight",linecolor="#30485d",linewidth=0.16) {#X018:2 (118,-15)};
// (118,-14.6) @TEXT("VDD",size=1.1,halign="middle",valign="bottom");
// &"VSS" @WIRE(mode="straight",linecolor="#30485d",linewidth=0.16) {#X018:3 (118,-35)};
// (118,-35.4) @TEXT("VSS",size=1.1,halign="middle",valign="top");
// &"VDD" @WIRE(mode="straight",linecolor="#30485d",linewidth=0.16) {#X017:2 (43,-15)};
// (43,-14.6) @TEXT("VDD",size=1.1,halign="middle",valign="bottom");
// &"VSS" @WIRE(mode="straight",linecolor="#30485d",linewidth=0.16) {#X017:3 (43,-35)};
// (43,-35.4) @TEXT("VSS",size=1.1,halign="middle",valign="top");
// &"CAP_CLK" @WIRE(mode="straight",linecolor="#30485d",linewidth=0.16) {#XSTORE7:1 (76,-21.6)};
// (75.6,-21.6) @TEXT("CAP_CLK",size=1.1,halign="end",valign="middle");
// &"RST7" @WIRE(mode="straight",linecolor="#30485d",linewidth=0.16) {#XSTORE7:4 (76,-28.4)};
// (75.6,-28.4) @TEXT("RST7",size=1.1,halign="end",valign="middle");
// &"VDD" @WIRE(mode="straight",linecolor="#30485d",linewidth=0.16) {#XSTORE7:5 (86,-15)};
// (86,-14.6) @TEXT("VDD",size=1.1,halign="middle",valign="bottom");
// &"VSS" @WIRE(mode="straight",linecolor="#30485d",linewidth=0.16) {#XSTORE7:6 (86,-35)};
// (86,-35.4) @TEXT("VSS",size=1.1,halign="middle",valign="top");
// &"CAP_CLK" @WIRE(mode="straight",linecolor="#30485d",linewidth=0.16) {#XSTORE6:1 (76,-59.6)};
// (75.6,-59.6) @TEXT("CAP_CLK",size=1.1,halign="end",valign="middle");
// &"TARGET6" @WIRE(mode="straight",linecolor="#30485d",linewidth=0.16) {#XSTORE6:2 (76,-63)};
// (75.6,-63) @TEXT("TARGET6",size=1.1,halign="end",valign="middle");
// &"RST6" @WIRE(mode="straight",linecolor="#30485d",linewidth=0.16) {#XSTORE6:4 (76,-66.4)};
// (75.6,-66.4) @TEXT("RST6",size=1.1,halign="end",valign="middle");
// &"VDD" @WIRE(mode="straight",linecolor="#30485d",linewidth=0.16) {#XSTORE6:5 (86,-53)};
// (86,-52.6) @TEXT("VDD",size=1.1,halign="middle",valign="bottom");
// &"VSS" @WIRE(mode="straight",linecolor="#30485d",linewidth=0.16) {#XSTORE6:6 (86,-73)};
// (86,-73.4) @TEXT("VSS",size=1.1,halign="middle",valign="top");
// &"CAP_CLK" @WIRE(mode="straight",linecolor="#30485d",linewidth=0.16) {#XSTORE5:1 (76,-97.6)};
// (75.6,-97.6) @TEXT("CAP_CLK",size=1.1,halign="end",valign="middle");
// &"TARGET5" @WIRE(mode="straight",linecolor="#30485d",linewidth=0.16) {#XSTORE5:2 (76,-101)};
// (75.6,-101) @TEXT("TARGET5",size=1.1,halign="end",valign="middle");
// &"RST5" @WIRE(mode="straight",linecolor="#30485d",linewidth=0.16) {#XSTORE5:4 (76,-104.4)};
// (75.6,-104.4) @TEXT("RST5",size=1.1,halign="end",valign="middle");
// &"VDD" @WIRE(mode="straight",linecolor="#30485d",linewidth=0.16) {#XSTORE5:5 (86,-91)};
// (86,-90.6) @TEXT("VDD",size=1.1,halign="middle",valign="bottom");
// &"VSS" @WIRE(mode="straight",linecolor="#30485d",linewidth=0.16) {#XSTORE5:6 (86,-111)};
// (86,-111.4) @TEXT("VSS",size=1.1,halign="middle",valign="top");
// &"CAP_CLK" @WIRE(mode="straight",linecolor="#30485d",linewidth=0.16) {#XSTORE4:1 (76,-135.6)};
// (75.6,-135.6) @TEXT("CAP_CLK",size=1.1,halign="end",valign="middle");
// &"TARGET4" @WIRE(mode="straight",linecolor="#30485d",linewidth=0.16) {#XSTORE4:2 (76,-139)};
// (75.6,-139) @TEXT("TARGET4",size=1.1,halign="end",valign="middle");
// &"RST4" @WIRE(mode="straight",linecolor="#30485d",linewidth=0.16) {#XSTORE4:4 (76,-142.4)};
// (75.6,-142.4) @TEXT("RST4",size=1.1,halign="end",valign="middle");
// &"VDD" @WIRE(mode="straight",linecolor="#30485d",linewidth=0.16) {#XSTORE4:5 (86,-129)};
// (86,-128.6) @TEXT("VDD",size=1.1,halign="middle",valign="bottom");
// &"VSS" @WIRE(mode="straight",linecolor="#30485d",linewidth=0.16) {#XSTORE4:6 (86,-149)};
// (86,-149.4) @TEXT("VSS",size=1.1,halign="middle",valign="top");
// &"CAP_CLK" @WIRE(mode="straight",linecolor="#30485d",linewidth=0.16) {#XSTORE3:1 (76,-173.6)};
// (75.6,-173.6) @TEXT("CAP_CLK",size=1.1,halign="end",valign="middle");
// &"TARGET3" @WIRE(mode="straight",linecolor="#30485d",linewidth=0.16) {#XSTORE3:2 (76,-177)};
// (75.6,-177) @TEXT("TARGET3",size=1.1,halign="end",valign="middle");
// &"RST3" @WIRE(mode="straight",linecolor="#30485d",linewidth=0.16) {#XSTORE3:4 (76,-180.4)};
// (75.6,-180.4) @TEXT("RST3",size=1.1,halign="end",valign="middle");
// &"VDD" @WIRE(mode="straight",linecolor="#30485d",linewidth=0.16) {#XSTORE3:5 (86,-167)};
// (86,-166.6) @TEXT("VDD",size=1.1,halign="middle",valign="bottom");
// &"VSS" @WIRE(mode="straight",linecolor="#30485d",linewidth=0.16) {#XSTORE3:6 (86,-187)};
// (86,-187.4) @TEXT("VSS",size=1.1,halign="middle",valign="top");
// &"CAP_CLK" @WIRE(mode="straight",linecolor="#30485d",linewidth=0.16) {#XSTORE2:1 (76,-211.6)};
// (75.6,-211.6) @TEXT("CAP_CLK",size=1.1,halign="end",valign="middle");
// &"TARGET2" @WIRE(mode="straight",linecolor="#30485d",linewidth=0.16) {#XSTORE2:2 (76,-215)};
// (75.6,-215) @TEXT("TARGET2",size=1.1,halign="end",valign="middle");
// &"RST2" @WIRE(mode="straight",linecolor="#30485d",linewidth=0.16) {#XSTORE2:4 (76,-218.4)};
// (75.6,-218.4) @TEXT("RST2",size=1.1,halign="end",valign="middle");
// &"VDD" @WIRE(mode="straight",linecolor="#30485d",linewidth=0.16) {#XSTORE2:5 (86,-205)};
// (86,-204.6) @TEXT("VDD",size=1.1,halign="middle",valign="bottom");
// &"VSS" @WIRE(mode="straight",linecolor="#30485d",linewidth=0.16) {#XSTORE2:6 (86,-225)};
// (86,-225.4) @TEXT("VSS",size=1.1,halign="middle",valign="top");
// &"CAP_CLK" @WIRE(mode="straight",linecolor="#30485d",linewidth=0.16) {#XSTORE1:1 (76,-249.6)};
// (75.6,-249.6) @TEXT("CAP_CLK",size=1.1,halign="end",valign="middle");
// &"TARGET1" @WIRE(mode="straight",linecolor="#30485d",linewidth=0.16) {#XSTORE1:2 (76,-253)};
// (75.6,-253) @TEXT("TARGET1",size=1.1,halign="end",valign="middle");
// &"RST1" @WIRE(mode="straight",linecolor="#30485d",linewidth=0.16) {#XSTORE1:4 (76,-256.4)};
// (75.6,-256.4) @TEXT("RST1",size=1.1,halign="end",valign="middle");
// &"VDD" @WIRE(mode="straight",linecolor="#30485d",linewidth=0.16) {#XSTORE1:5 (86,-243)};
// (86,-242.6) @TEXT("VDD",size=1.1,halign="middle",valign="bottom");
// &"VSS" @WIRE(mode="straight",linecolor="#30485d",linewidth=0.16) {#XSTORE1:6 (86,-263)};
// (86,-263.4) @TEXT("VSS",size=1.1,halign="middle",valign="top");
// &"CAP_CLK" @WIRE(mode="straight",linecolor="#30485d",linewidth=0.16) {#XSTORE0:1 (76,-287.6)};
// (75.6,-287.6) @TEXT("CAP_CLK",size=1.1,halign="end",valign="middle");
// &"TARGET0" @WIRE(mode="straight",linecolor="#30485d",linewidth=0.16) {#XSTORE0:2 (76,-291)};
// (75.6,-291) @TEXT("TARGET0",size=1.1,halign="end",valign="middle");
// &"RST0" @WIRE(mode="straight",linecolor="#30485d",linewidth=0.16) {#XSTORE0:4 (76,-294.4)};
// (75.6,-294.4) @TEXT("RST0",size=1.1,halign="end",valign="middle");
// &"VDD" @WIRE(mode="straight",linecolor="#30485d",linewidth=0.16) {#XSTORE0:5 (86,-281)};
// (86,-280.6) @TEXT("VDD",size=1.1,halign="middle",valign="bottom");
// &"VSS" @WIRE(mode="straight",linecolor="#30485d",linewidth=0.16) {#XSTORE0:6 (86,-301)};
// (86,-301.4) @TEXT("VSS",size=1.1,halign="middle",valign="top");
// &"VDD" @WIRE(mode="straight",linecolor="#30485d",linewidth=0.16) {#XBBM7:4 (155,-14)};
// (155,-13.6) @TEXT("VDD",size=1.1,halign="middle",valign="bottom");
// &"VSS" @WIRE(mode="straight",linecolor="#30485d",linewidth=0.16) {#XBBM7:5 (155,-36)};
// (155,-36.4) @TEXT("VSS",size=1.1,halign="middle",valign="top");
// &"VDD" @WIRE(mode="straight",linecolor="#30485d",linewidth=0.16) {#XBBM6:4 (155,-52)};
// (155,-51.6) @TEXT("VDD",size=1.1,halign="middle",valign="bottom");
// &"VSS" @WIRE(mode="straight",linecolor="#30485d",linewidth=0.16) {#XBBM6:5 (155,-74)};
// (155,-74.4) @TEXT("VSS",size=1.1,halign="middle",valign="top");
// &"VDD" @WIRE(mode="straight",linecolor="#30485d",linewidth=0.16) {#XBBM5:4 (155,-90)};
// (155,-89.6) @TEXT("VDD",size=1.1,halign="middle",valign="bottom");
// &"VSS" @WIRE(mode="straight",linecolor="#30485d",linewidth=0.16) {#XBBM5:5 (155,-112)};
// (155,-112.4) @TEXT("VSS",size=1.1,halign="middle",valign="top");
// &"VDD" @WIRE(mode="straight",linecolor="#30485d",linewidth=0.16) {#XBBM4:4 (155,-128)};
// (155,-127.6) @TEXT("VDD",size=1.1,halign="middle",valign="bottom");
// &"VSS" @WIRE(mode="straight",linecolor="#30485d",linewidth=0.16) {#XBBM4:5 (155,-150)};
// (155,-150.4) @TEXT("VSS",size=1.1,halign="middle",valign="top");
// &"VDD" @WIRE(mode="straight",linecolor="#30485d",linewidth=0.16) {#XBBM3:4 (155,-166)};
// (155,-165.6) @TEXT("VDD",size=1.1,halign="middle",valign="bottom");
// &"VSS" @WIRE(mode="straight",linecolor="#30485d",linewidth=0.16) {#XBBM3:5 (155,-188)};
// (155,-188.4) @TEXT("VSS",size=1.1,halign="middle",valign="top");
// &"VDD" @WIRE(mode="straight",linecolor="#30485d",linewidth=0.16) {#XBBM2:4 (155,-204)};
// (155,-203.6) @TEXT("VDD",size=1.1,halign="middle",valign="bottom");
// &"VSS" @WIRE(mode="straight",linecolor="#30485d",linewidth=0.16) {#XBBM2:5 (155,-226)};
// (155,-226.4) @TEXT("VSS",size=1.1,halign="middle",valign="top");
// &"VDD" @WIRE(mode="straight",linecolor="#30485d",linewidth=0.16) {#XBBM1:4 (155,-242)};
// (155,-241.6) @TEXT("VDD",size=1.1,halign="middle",valign="bottom");
// &"VSS" @WIRE(mode="straight",linecolor="#30485d",linewidth=0.16) {#XBBM1:5 (155,-264)};
// (155,-264.4) @TEXT("VSS",size=1.1,halign="middle",valign="top");
// &"VDD" @WIRE(mode="straight",linecolor="#30485d",linewidth=0.16) {#XBBM0:4 (155,-280)};
// (155,-279.6) @TEXT("VDD",size=1.1,halign="middle",valign="bottom");
// &"VSS" @WIRE(mode="straight",linecolor="#30485d",linewidth=0.16) {#XBBM0:5 (155,-302)};
// (155,-302.4) @TEXT("VSS",size=1.1,halign="middle",valign="top");
// &"GNN0" @WIRE(mode="straight",linecolor="#30485d",linewidth=0.16) {#XDRV0:1 (234,-282.75)};
// (234.4,-282.75) @TEXT("GNN0",size=1.1,halign="start",valign="middle");
// &"GNP0" @WIRE(mode="straight",linecolor="#30485d",linewidth=0.16) {#XDRV0:2 (234,-286.05)};
// (234.4,-286.05) @TEXT("GNP0",size=1.1,halign="start",valign="middle");
// &"GPN0" @WIRE(mode="straight",linecolor="#30485d",linewidth=0.16) {#XDRV0:3 (234,-289.35)};
// (234.4,-289.35) @TEXT("GPN0",size=1.1,halign="start",valign="middle");
// &"GPP0" @WIRE(mode="straight",linecolor="#30485d",linewidth=0.16) {#XDRV0:4 (234,-292.65)};
// (234.4,-292.65) @TEXT("GPP0",size=1.1,halign="start",valign="middle");
// &"VDD" @WIRE(mode="straight",linecolor="#30485d",linewidth=0.16) {#XDRV0:7 (218,-274.45)};
// (218,-274.05) @TEXT("VDD",size=1.1,halign="middle",valign="bottom");
// &"VSS" @WIRE(mode="straight",linecolor="#30485d",linewidth=0.16) {#XDRV0:8 (218,-307.55)};
// (218,-307.95) @TEXT("VSS",size=1.1,halign="middle",valign="top");
// &"GNN1" @WIRE(mode="straight",linecolor="#30485d",linewidth=0.16) {#XDRV1:1 (234,-244.75)};
// (234.4,-244.75) @TEXT("GNN1",size=1.1,halign="start",valign="middle");
// &"GNP1" @WIRE(mode="straight",linecolor="#30485d",linewidth=0.16) {#XDRV1:2 (234,-248.05)};
// (234.4,-248.05) @TEXT("GNP1",size=1.1,halign="start",valign="middle");
// &"GPN1" @WIRE(mode="straight",linecolor="#30485d",linewidth=0.16) {#XDRV1:3 (234,-251.35)};
// (234.4,-251.35) @TEXT("GPN1",size=1.1,halign="start",valign="middle");
// &"GPP1" @WIRE(mode="straight",linecolor="#30485d",linewidth=0.16) {#XDRV1:4 (234,-254.65)};
// (234.4,-254.65) @TEXT("GPP1",size=1.1,halign="start",valign="middle");
// &"VDD" @WIRE(mode="straight",linecolor="#30485d",linewidth=0.16) {#XDRV1:7 (218,-236.45)};
// (218,-236.05) @TEXT("VDD",size=1.1,halign="middle",valign="bottom");
// &"VSS" @WIRE(mode="straight",linecolor="#30485d",linewidth=0.16) {#XDRV1:8 (218,-269.55)};
// (218,-269.95) @TEXT("VSS",size=1.1,halign="middle",valign="top");
// &"GNN2" @WIRE(mode="straight",linecolor="#30485d",linewidth=0.16) {#XDRV2:1 (234,-206.75)};
// (234.4,-206.75) @TEXT("GNN2",size=1.1,halign="start",valign="middle");
// &"GNP2" @WIRE(mode="straight",linecolor="#30485d",linewidth=0.16) {#XDRV2:2 (234,-210.05)};
// (234.4,-210.05) @TEXT("GNP2",size=1.1,halign="start",valign="middle");
// &"GPN2" @WIRE(mode="straight",linecolor="#30485d",linewidth=0.16) {#XDRV2:3 (234,-213.35)};
// (234.4,-213.35) @TEXT("GPN2",size=1.1,halign="start",valign="middle");
// &"GPP2" @WIRE(mode="straight",linecolor="#30485d",linewidth=0.16) {#XDRV2:4 (234,-216.65)};
// (234.4,-216.65) @TEXT("GPP2",size=1.1,halign="start",valign="middle");
// &"VDD" @WIRE(mode="straight",linecolor="#30485d",linewidth=0.16) {#XDRV2:7 (218,-198.45)};
// (218,-198.05) @TEXT("VDD",size=1.1,halign="middle",valign="bottom");
// &"VSS" @WIRE(mode="straight",linecolor="#30485d",linewidth=0.16) {#XDRV2:8 (218,-231.55)};
// (218,-231.95) @TEXT("VSS",size=1.1,halign="middle",valign="top");
// &"GNN3" @WIRE(mode="straight",linecolor="#30485d",linewidth=0.16) {#XDRV3:1 (234,-168.75)};
// (234.4,-168.75) @TEXT("GNN3",size=1.1,halign="start",valign="middle");
// &"GNP3" @WIRE(mode="straight",linecolor="#30485d",linewidth=0.16) {#XDRV3:2 (234,-172.05)};
// (234.4,-172.05) @TEXT("GNP3",size=1.1,halign="start",valign="middle");
// &"GPN3" @WIRE(mode="straight",linecolor="#30485d",linewidth=0.16) {#XDRV3:3 (234,-175.35)};
// (234.4,-175.35) @TEXT("GPN3",size=1.1,halign="start",valign="middle");
// &"GPP3" @WIRE(mode="straight",linecolor="#30485d",linewidth=0.16) {#XDRV3:4 (234,-178.65)};
// (234.4,-178.65) @TEXT("GPP3",size=1.1,halign="start",valign="middle");
// &"VDD" @WIRE(mode="straight",linecolor="#30485d",linewidth=0.16) {#XDRV3:7 (218,-160.45)};
// (218,-160.05) @TEXT("VDD",size=1.1,halign="middle",valign="bottom");
// &"VSS" @WIRE(mode="straight",linecolor="#30485d",linewidth=0.16) {#XDRV3:8 (218,-193.55)};
// (218,-193.95) @TEXT("VSS",size=1.1,halign="middle",valign="top");
// &"GNN4" @WIRE(mode="straight",linecolor="#30485d",linewidth=0.16) {#XDRV4:1 (234,-130.75)};
// (234.4,-130.75) @TEXT("GNN4",size=1.1,halign="start",valign="middle");
// &"GNP4" @WIRE(mode="straight",linecolor="#30485d",linewidth=0.16) {#XDRV4:2 (234,-134.05)};
// (234.4,-134.05) @TEXT("GNP4",size=1.1,halign="start",valign="middle");
// &"GPN4" @WIRE(mode="straight",linecolor="#30485d",linewidth=0.16) {#XDRV4:3 (234,-137.35)};
// (234.4,-137.35) @TEXT("GPN4",size=1.1,halign="start",valign="middle");
// &"GPP4" @WIRE(mode="straight",linecolor="#30485d",linewidth=0.16) {#XDRV4:4 (234,-140.65)};
// (234.4,-140.65) @TEXT("GPP4",size=1.1,halign="start",valign="middle");
// &"VDD" @WIRE(mode="straight",linecolor="#30485d",linewidth=0.16) {#XDRV4:7 (218,-122.45)};
// (218,-122.05) @TEXT("VDD",size=1.1,halign="middle",valign="bottom");
// &"VSS" @WIRE(mode="straight",linecolor="#30485d",linewidth=0.16) {#XDRV4:8 (218,-155.55)};
// (218,-155.95) @TEXT("VSS",size=1.1,halign="middle",valign="top");
// &"GNN5" @WIRE(mode="straight",linecolor="#30485d",linewidth=0.16) {#XDRV5:1 (234,-92.75)};
// (234.4,-92.75) @TEXT("GNN5",size=1.1,halign="start",valign="middle");
// &"GNP5" @WIRE(mode="straight",linecolor="#30485d",linewidth=0.16) {#XDRV5:2 (234,-96.05)};
// (234.4,-96.05) @TEXT("GNP5",size=1.1,halign="start",valign="middle");
// &"GPN5" @WIRE(mode="straight",linecolor="#30485d",linewidth=0.16) {#XDRV5:3 (234,-99.35)};
// (234.4,-99.35) @TEXT("GPN5",size=1.1,halign="start",valign="middle");
// &"GPP5" @WIRE(mode="straight",linecolor="#30485d",linewidth=0.16) {#XDRV5:4 (234,-102.65)};
// (234.4,-102.65) @TEXT("GPP5",size=1.1,halign="start",valign="middle");
// &"VDD" @WIRE(mode="straight",linecolor="#30485d",linewidth=0.16) {#XDRV5:7 (218,-84.45)};
// (218,-84.05) @TEXT("VDD",size=1.1,halign="middle",valign="bottom");
// &"VSS" @WIRE(mode="straight",linecolor="#30485d",linewidth=0.16) {#XDRV5:8 (218,-117.55)};
// (218,-117.95) @TEXT("VSS",size=1.1,halign="middle",valign="top");
// &"GNN6" @WIRE(mode="straight",linecolor="#30485d",linewidth=0.16) {#XDRV6:1 (234,-54.75)};
// (234.4,-54.75) @TEXT("GNN6",size=1.1,halign="start",valign="middle");
// &"GNP6" @WIRE(mode="straight",linecolor="#30485d",linewidth=0.16) {#XDRV6:2 (234,-58.05)};
// (234.4,-58.05) @TEXT("GNP6",size=1.1,halign="start",valign="middle");
// &"GPN6" @WIRE(mode="straight",linecolor="#30485d",linewidth=0.16) {#XDRV6:3 (234,-61.35)};
// (234.4,-61.35) @TEXT("GPN6",size=1.1,halign="start",valign="middle");
// &"GPP6" @WIRE(mode="straight",linecolor="#30485d",linewidth=0.16) {#XDRV6:4 (234,-64.65)};
// (234.4,-64.65) @TEXT("GPP6",size=1.1,halign="start",valign="middle");
// &"VDD" @WIRE(mode="straight",linecolor="#30485d",linewidth=0.16) {#XDRV6:7 (218,-46.45)};
// (218,-46.05) @TEXT("VDD",size=1.1,halign="middle",valign="bottom");
// &"VSS" @WIRE(mode="straight",linecolor="#30485d",linewidth=0.16) {#XDRV6:8 (218,-79.55)};
// (218,-79.95) @TEXT("VSS",size=1.1,halign="middle",valign="top");
// &"GNN7" @WIRE(mode="straight",linecolor="#30485d",linewidth=0.16) {#XDRV7:1 (234,-16.75)};
// (234.4,-16.75) @TEXT("GNN7",size=1.1,halign="start",valign="middle");
// &"GNP7" @WIRE(mode="straight",linecolor="#30485d",linewidth=0.16) {#XDRV7:2 (234,-20.05)};
// (234.4,-20.05) @TEXT("GNP7",size=1.1,halign="start",valign="middle");
// &"GPN7" @WIRE(mode="straight",linecolor="#30485d",linewidth=0.16) {#XDRV7:3 (234,-23.35)};
// (234.4,-23.35) @TEXT("GPN7",size=1.1,halign="start",valign="middle");
// &"GPP7" @WIRE(mode="straight",linecolor="#30485d",linewidth=0.16) {#XDRV7:4 (234,-26.65)};
// (234.4,-26.65) @TEXT("GPP7",size=1.1,halign="start",valign="middle");
// &"VDD" @WIRE(mode="straight",linecolor="#30485d",linewidth=0.16) {#XDRV7:7 (218,-8.45)};
// (218,-8.05) @TEXT("VDD",size=1.1,halign="middle",valign="bottom");
// &"VSS" @WIRE(mode="straight",linecolor="#30485d",linewidth=0.16) {#XDRV7:8 (218,-41.55)};
// (218,-41.95) @TEXT("VSS",size=1.1,halign="middle",valign="top");
// }
// END SARADC RNL
ends sar8i_refword

subckt sar8i_idle ACTIVE SAMPLE VDD VSS PRESET SAMPLE_MATCH
    XN (ACTIVE VDD VSS IDLE) sar8p_inv
    XD (IDLE VDD VSS IDLE_D) sar8i_guard
    XP (SAMPLE IDLE_D VDD VSS PRESET) sar8p_or2
    XA (SAMPLE SAMPLE VDD VSS SAMPLE_AND) sar8p_and2
    XB (SAMPLE_AND VDD VSS SAMPLE_MATCH) sar8p_buf
// BEGIN SARADC RNL
// @RNL(author="saradc topology") {
// #XN @SET-SYMBOL $S_sar8p_inv;
// #XN @PLACE(0,18) => @ORIENT("R0");
// #XD @SET-SYMBOL $S_sar8i_guard;
// #XD @PLACE(42,18) => @ORIENT("R0");
// #XP @SET-SYMBOL $S_sar8p_or2;
// #XP @PLACE(84,18) => @ORIENT("R0");
// #XA @SET-SYMBOL $S_sar8p_and2;
// #XA @PLACE(0,-24) => @ORIENT("R0");
// #XB @SET-SYMBOL $S_sar8p_buf;
// #XB @PLACE(42,-24) => @ORIENT("R0");
// &"IDLE" @WIRE(mode="straight",linecolor="#30485d",linewidth=0.16) {#XN:4 (18,18) (18,18) #XD:1};
// &"IDLE_D" @WIRE(mode="straight",linecolor="#30485d",linewidth=0.16) {#XD:4 (66,18) (66,16.3) #XP:2};
// &"SAMPLE_AND" @WIRE(mode="straight",linecolor="#30485d",linewidth=0.16) {#XA:5 (21,-24) (21,-24) #XB:1};
// &"SAMPLE" @WIRE(mode="straight",linecolor="#30485d",linewidth=0.16) {(-12,-25.7) (-12,-22.3) (-12,19.7)};
// &"SAMPLE" @WIRE(mode="straight",linecolor="#30485d",linewidth=0.16) {#XP:1 (-12,19.7)};
// $JUNCTION @ATTACH (-12,19.7);
// &"SAMPLE" @WIRE(mode="straight",linecolor="#30485d",linewidth=0.16) {#XA:1 (-12,-22.3)};
// $JUNCTION @ATTACH (-12,-22.3);
// &"SAMPLE" @WIRE(mode="straight",linecolor="#30485d",linewidth=0.16) {#XA:2 (-12,-25.7)};
// $JUNCTION @ATTACH (-12,-25.7);
// (-16,46) @TEXT("sar8i_idle / native standard-cell composition",size=1.3,halign="start",textcolor="#223d52");
// &"ACTIVE" @WIRE(mode="straight",linecolor="#30485d",linewidth=0.16) {#XN:1 (-10,18)};
// (-10.4,18) @TEXT("ACTIVE",size=1.1,halign="end",valign="middle");
// &"VDD" @WIRE(mode="straight",linecolor="#30485d",linewidth=0.16) {#XN:2 (0,28)};
// (0,28.4) @TEXT("VDD",size=1.1,halign="middle",valign="bottom");
// &"VSS" @WIRE(mode="straight",linecolor="#30485d",linewidth=0.16) {#XN:3 (0,8)};
// (0,7.6) @TEXT("VSS",size=1.1,halign="middle",valign="top");
// &"VDD" @WIRE(mode="straight",linecolor="#30485d",linewidth=0.16) {#XD:2 (42,29)};
// (42,29.4) @TEXT("VDD",size=1.1,halign="middle",valign="bottom");
// &"VSS" @WIRE(mode="straight",linecolor="#30485d",linewidth=0.16) {#XD:3 (42,7)};
// (42,6.6) @TEXT("VSS",size=1.1,halign="middle",valign="top");
// &"VDD" @WIRE(mode="straight",linecolor="#30485d",linewidth=0.16) {#XP:3 (84,28)};
// (84,28.4) @TEXT("VDD",size=1.1,halign="middle",valign="bottom");
// &"VSS" @WIRE(mode="straight",linecolor="#30485d",linewidth=0.16) {#XP:4 (84,8)};
// (84,7.6) @TEXT("VSS",size=1.1,halign="middle",valign="top");
// &"PRESET" @WIRE(mode="straight",linecolor="#30485d",linewidth=0.16) {#XP:5 (94,18)};
// (94.4,18) @TEXT("PRESET",size=1.1,halign="start",valign="middle");
// &"VDD" @WIRE(mode="straight",linecolor="#30485d",linewidth=0.16) {#XA:3 (0,-14)};
// (0,-13.6) @TEXT("VDD",size=1.1,halign="middle",valign="bottom");
// &"VSS" @WIRE(mode="straight",linecolor="#30485d",linewidth=0.16) {#XA:4 (0,-34)};
// (0,-34.4) @TEXT("VSS",size=1.1,halign="middle",valign="top");
// &"VDD" @WIRE(mode="straight",linecolor="#30485d",linewidth=0.16) {#XB:2 (42,-14)};
// (42,-13.6) @TEXT("VDD",size=1.1,halign="middle",valign="bottom");
// &"VSS" @WIRE(mode="straight",linecolor="#30485d",linewidth=0.16) {#XB:3 (42,-34)};
// (42,-34.4) @TEXT("VSS",size=1.1,halign="middle",valign="top");
// &"SAMPLE_MATCH" @WIRE(mode="straight",linecolor="#30485d",linewidth=0.16) {#XB:4 (52,-24)};
// (52.4,-24) @TEXT("SAMPLE_MATCH",size=1.1,halign="start",valign="middle");
// }
// END SARADC RNL
ends sar8i_idle
