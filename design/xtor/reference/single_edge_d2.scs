// Native-cell reference decoding and shared per-side selects for the single-edge top.
// BEGIN SARADC RNL
// @RNL(type="header") { @VERSION("0.3");
// @USE-PACKAGE(name="sar8",version="0.1",path="../../rnl/sar8.rnl");
// @USE-PACKAGE(name="rnl-std-fill") {}; }
// END SARADC RNL
subckt sar8i_refword CODE0 CODE1 CODE2 CODE3 CODE4 CODE5 CODE6 CODE7 REFSEL_N0 REFSEL_N1 REFSEL_N2 REFSEL_N3 REFSEL_N4 REFSEL_N5 REFSEL_N6 REFSEL_N7 REFSEL_P0 REFSEL_P1 REFSEL_P2 REFSEL_P3 REFSEL_P4 REFSEL_P5 REFSEL_P6 REFSEL_P7 VDD VSS PRESET
XPRESET_N (PRESET RUN VDD VSS) INVD1BWP12T30P140
XINITIAL0 (CODE0 RUN QN0 VDD VSS) ND2D1BWP12T30P140
XPN0 (QN0 REFSEL_P0 VDD VSS) INVD1BWP12T30P140
XNN0 (QN0 REFSEL_N0 VDD VSS) BUFFD1BWP12T30P140
XINITIAL1 (CODE1 RUN QN1 VDD VSS) ND2D1BWP12T30P140
XPN1 (QN1 REFSEL_P1 VDD VSS) INVD1BWP12T30P140
XNN1 (QN1 REFSEL_N1 VDD VSS) BUFFD1BWP12T30P140
XINITIAL2 (CODE2 RUN QN2 VDD VSS) ND2D1BWP12T30P140
XPN2 (QN2 REFSEL_P2 VDD VSS) INVD1BWP12T30P140
XNN2 (QN2 REFSEL_N2 VDD VSS) BUFFD1BWP12T30P140
XINITIAL3 (CODE3 RUN QN3 VDD VSS) ND2D1BWP12T30P140
XPN3 (QN3 REFSEL_P3 VDD VSS) INVD1BWP12T30P140
XNN3 (QN3 REFSEL_N3 VDD VSS) BUFFD1BWP12T30P140
XINITIAL4 (CODE4 RUN QN4 VDD VSS) ND2D1BWP12T30P140
XPN4 (QN4 REFSEL_P4 VDD VSS) INVD1BWP12T30P140
XNN4 (QN4 REFSEL_N4 VDD VSS) BUFFD1BWP12T30P140
XINITIAL5 (CODE5 RUN QN5 VDD VSS) ND2D1BWP12T30P140
XPN5 (QN5 REFSEL_P5 VDD VSS) INVD1BWP12T30P140
XNN5 (QN5 REFSEL_N5 VDD VSS) BUFFD1BWP12T30P140
XINITIAL6 (CODE6 RUN QN6 VDD VSS) ND2D1BWP12T30P140
XPN6 (QN6 REFSEL_P6 VDD VSS) INVD1BWP12T30P140
XNN6 (QN6 REFSEL_N6 VDD VSS) BUFFD1BWP12T30P140
// PRESET rises with CODE7 high at the end of every MSB-1 conversion. The INV+INV+ND2 form keeps
// the stacked node within the terminal-voltage rule (native OR2D1 reached 1.124 V).
XINITIAL7_A (CODE7 CODE7_B VDD VSS) INVD1BWP12T30P140
XINITIAL7_B (PRESET PRESET_B VDD VSS) INVD1BWP12T30P140
XINITIAL7 (CODE7_B PRESET_B Q7 VDD VSS) ND2D1BWP12T30P140
XINV7 (Q7 QN7 VDD VSS) INVD1BWP12T30P140
XPN7 (QN7 REFSEL_P7 VDD VSS) INVD2BWP12T30P140
XNN7 (QN7 REFSEL_N7 VDD VSS) BUFFD2BWP12T30P140
// BEGIN SARADC RNL
// @RNL(author="saradc topology") {
// (-24,91) @TEXT("Reference drive",size=2.55,halign="start",textcolor="#223d52");
// #XPRESET_N @SET-SYMBOL $S_INVD1BWP12T30P140;
// #XPRESET_N @PLACE(2,71) => @ORIENT("R0");
// #XPRESET_N @TEXT("",key="name",size=1.65,halign="middle",textcolor="#223d52") => @PLACE(2,71);
// #XPRESET_N @TEXT("",key="model");
// %sar_port1 = $IO_PORT @ATTACH &"PRESET" => @PLACE(-15,71);
// &"PRESET" @WIRE(mode="straight",linecolor="#94601a",linewidth=0.16) {%sar_port1:p #XPRESET_N:1};
// #XINITIAL0 @SET-SYMBOL $S_ND2D1BWP12T30P140;
// #XINITIAL0 @PLACE(0,43) => @ORIENT("R0");
// #XINITIAL0 @TEXT("",key="name",size=1.65,halign="middle",textcolor="#223d52") => @PLACE(0,43);
// #XINITIAL0 @TEXT("",key="model");
// #XNN0 @SET-SYMBOL $S_BUFFD1BWP12T30P140;
// #XNN0 @PLACE(30,49) => @ORIENT("R0");
// #XNN0 @TEXT("",key="name",size=1.65,halign="middle",textcolor="#223d52") => @PLACE(30,49);
// #XNN0 @TEXT("",key="model");
// #XPN0 @SET-SYMBOL $S_INVD1BWP12T30P140;
// #XPN0 @PLACE(54,38) => @ORIENT("R0");
// #XPN0 @TEXT("",key="name",size=1.65,halign="middle",textcolor="#223d52") => @PLACE(54,38);
// #XPN0 @TEXT("",key="model");
// (-22,43) @TEXT("B0",size=1.15,halign="start",textcolor="#223d52");
// %sar_junction2 = (14,43);
// %sar_junction2 @CIRCLE(radius=0.34,linecolor="#30485d",fill="fillcolor",fillcolor="#30485d") => @LAYER("top");
// &"QN0" @WIRE(mode="straight",linecolor="#30485d",linewidth=0.16) {#XINITIAL0:3 %sar_junction2};
// &"QN0" @WIRE(mode="straight",linecolor="#30485d",linewidth=0.16) {%sar_junction2 (14,49) #XNN0:1};
// &"QN0" @WIRE(mode="straight",linecolor="#30485d",linewidth=0.16) {%sar_junction2 (14,38) #XPN0:1};
// #XINITIAL1 @SET-SYMBOL $S_ND2D1BWP12T30P140;
// #XINITIAL1 @PLACE(0,19) => @ORIENT("R0");
// #XINITIAL1 @TEXT("",key="name",size=1.65,halign="middle",textcolor="#223d52") => @PLACE(0,19);
// #XINITIAL1 @TEXT("",key="model");
// #XNN1 @SET-SYMBOL $S_BUFFD1BWP12T30P140;
// #XNN1 @PLACE(30,25) => @ORIENT("R0");
// #XNN1 @TEXT("",key="name",size=1.65,halign="middle",textcolor="#223d52") => @PLACE(30,25);
// #XNN1 @TEXT("",key="model");
// #XPN1 @SET-SYMBOL $S_INVD1BWP12T30P140;
// #XPN1 @PLACE(54,14) => @ORIENT("R0");
// #XPN1 @TEXT("",key="name",size=1.65,halign="middle",textcolor="#223d52") => @PLACE(54,14);
// #XPN1 @TEXT("",key="model");
// (-22,19) @TEXT("B1",size=1.15,halign="start",textcolor="#223d52");
// %sar_junction3 = (14,19);
// %sar_junction3 @CIRCLE(radius=0.34,linecolor="#30485d",fill="fillcolor",fillcolor="#30485d") => @LAYER("top");
// &"QN1" @WIRE(mode="straight",linecolor="#30485d",linewidth=0.16) {#XINITIAL1:3 %sar_junction3};
// &"QN1" @WIRE(mode="straight",linecolor="#30485d",linewidth=0.16) {%sar_junction3 (14,25) #XNN1:1};
// &"QN1" @WIRE(mode="straight",linecolor="#30485d",linewidth=0.16) {%sar_junction3 (14,14) #XPN1:1};
// #XINITIAL2 @SET-SYMBOL $S_ND2D1BWP12T30P140;
// #XINITIAL2 @PLACE(0,-5) => @ORIENT("R0");
// #XINITIAL2 @TEXT("",key="name",size=1.65,halign="middle",textcolor="#223d52") => @PLACE(0,-5);
// #XINITIAL2 @TEXT("",key="model");
// #XNN2 @SET-SYMBOL $S_BUFFD1BWP12T30P140;
// #XNN2 @PLACE(30,1) => @ORIENT("R0");
// #XNN2 @TEXT("",key="name",size=1.65,halign="middle",textcolor="#223d52") => @PLACE(30,1);
// #XNN2 @TEXT("",key="model");
// #XPN2 @SET-SYMBOL $S_INVD1BWP12T30P140;
// #XPN2 @PLACE(54,-10) => @ORIENT("R0");
// #XPN2 @TEXT("",key="name",size=1.65,halign="middle",textcolor="#223d52") => @PLACE(54,-10);
// #XPN2 @TEXT("",key="model");
// (-22,-5) @TEXT("B2",size=1.15,halign="start",textcolor="#223d52");
// %sar_junction4 = (14,-5);
// %sar_junction4 @CIRCLE(radius=0.34,linecolor="#30485d",fill="fillcolor",fillcolor="#30485d") => @LAYER("top");
// &"QN2" @WIRE(mode="straight",linecolor="#30485d",linewidth=0.16) {#XINITIAL2:3 %sar_junction4};
// &"QN2" @WIRE(mode="straight",linecolor="#30485d",linewidth=0.16) {%sar_junction4 (14,1) #XNN2:1};
// &"QN2" @WIRE(mode="straight",linecolor="#30485d",linewidth=0.16) {%sar_junction4 (14,-10) #XPN2:1};
// #XINITIAL3 @SET-SYMBOL $S_ND2D1BWP12T30P140;
// #XINITIAL3 @PLACE(0,-29) => @ORIENT("R0");
// #XINITIAL3 @TEXT("",key="name",size=1.65,halign="middle",textcolor="#223d52") => @PLACE(0,-29);
// #XINITIAL3 @TEXT("",key="model");
// #XNN3 @SET-SYMBOL $S_BUFFD1BWP12T30P140;
// #XNN3 @PLACE(30,-23) => @ORIENT("R0");
// #XNN3 @TEXT("",key="name",size=1.65,halign="middle",textcolor="#223d52") => @PLACE(30,-23);
// #XNN3 @TEXT("",key="model");
// #XPN3 @SET-SYMBOL $S_INVD1BWP12T30P140;
// #XPN3 @PLACE(54,-34) => @ORIENT("R0");
// #XPN3 @TEXT("",key="name",size=1.65,halign="middle",textcolor="#223d52") => @PLACE(54,-34);
// #XPN3 @TEXT("",key="model");
// (-22,-29) @TEXT("B3",size=1.15,halign="start",textcolor="#223d52");
// %sar_junction5 = (14,-29);
// %sar_junction5 @CIRCLE(radius=0.34,linecolor="#30485d",fill="fillcolor",fillcolor="#30485d") => @LAYER("top");
// &"QN3" @WIRE(mode="straight",linecolor="#30485d",linewidth=0.16) {#XINITIAL3:3 %sar_junction5};
// &"QN3" @WIRE(mode="straight",linecolor="#30485d",linewidth=0.16) {%sar_junction5 (14,-23) #XNN3:1};
// &"QN3" @WIRE(mode="straight",linecolor="#30485d",linewidth=0.16) {%sar_junction5 (14,-34) #XPN3:1};
// &"VDD" @WIRE(mode="straight",linecolor="#647584",linewidth=0.16) {#XINITIAL0:4 (0,51.45)};
// (0,51.77) @TEXT("VDD",size=0.98,halign="middle",valign="bottom");
// &"VSS" @WIRE(mode="straight",linecolor="#647584",linewidth=0.16) {#XINITIAL0:5 (0,34.55)};
// (0,34.23) @TEXT("VSS",size=0.98,halign="middle",valign="top");
// &"VDD" @WIRE(mode="straight",linecolor="#647584",linewidth=0.16) {#XNN0:3 (30,57.45)};
// (30,57.77) @TEXT("VDD",size=0.98,halign="middle",valign="bottom");
// &"VSS" @WIRE(mode="straight",linecolor="#647584",linewidth=0.16) {#XNN0:4 (30,40.55)};
// (30,40.23) @TEXT("VSS",size=0.98,halign="middle",valign="top");
// &"VDD" @WIRE(mode="straight",linecolor="#647584",linewidth=0.16) {#XPN0:3 (54,46.45)};
// (54,46.77) @TEXT("VDD",size=0.98,halign="middle",valign="bottom");
// &"VSS" @WIRE(mode="straight",linecolor="#647584",linewidth=0.16) {#XPN0:4 (54,29.55)};
// (54,29.23) @TEXT("VSS",size=0.98,halign="middle",valign="top");
// &"VDD" @WIRE(mode="straight",linecolor="#647584",linewidth=0.16) {#XINITIAL1:4 (0,27.45)};
// (0,27.77) @TEXT("VDD",size=0.98,halign="middle",valign="bottom");
// &"VSS" @WIRE(mode="straight",linecolor="#647584",linewidth=0.16) {#XINITIAL1:5 (0,10.55)};
// (0,10.23) @TEXT("VSS",size=0.98,halign="middle",valign="top");
// &"VDD" @WIRE(mode="straight",linecolor="#647584",linewidth=0.16) {#XNN1:3 (30,33.45)};
// (30,33.77) @TEXT("VDD",size=0.98,halign="middle",valign="bottom");
// &"VSS" @WIRE(mode="straight",linecolor="#647584",linewidth=0.16) {#XNN1:4 (30,16.55)};
// (30,16.23) @TEXT("VSS",size=0.98,halign="middle",valign="top");
// &"VDD" @WIRE(mode="straight",linecolor="#647584",linewidth=0.16) {#XPN1:3 (54,22.45)};
// (54,22.77) @TEXT("VDD",size=0.98,halign="middle",valign="bottom");
// &"VSS" @WIRE(mode="straight",linecolor="#647584",linewidth=0.16) {#XPN1:4 (54,5.55)};
// (54,5.23) @TEXT("VSS",size=0.98,halign="middle",valign="top");
// &"VDD" @WIRE(mode="straight",linecolor="#647584",linewidth=0.16) {#XINITIAL2:4 (0,3.45)};
// (0,3.77) @TEXT("VDD",size=0.98,halign="middle",valign="bottom");
// &"VSS" @WIRE(mode="straight",linecolor="#647584",linewidth=0.16) {#XINITIAL2:5 (0,-13.45)};
// (0,-13.77) @TEXT("VSS",size=0.98,halign="middle",valign="top");
// &"VDD" @WIRE(mode="straight",linecolor="#647584",linewidth=0.16) {#XNN2:3 (30,9.45)};
// (30,9.77) @TEXT("VDD",size=0.98,halign="middle",valign="bottom");
// &"VSS" @WIRE(mode="straight",linecolor="#647584",linewidth=0.16) {#XNN2:4 (30,-7.45)};
// (30,-7.77) @TEXT("VSS",size=0.98,halign="middle",valign="top");
// &"VDD" @WIRE(mode="straight",linecolor="#647584",linewidth=0.16) {#XPN2:3 (54,-1.55)};
// (54,-1.23) @TEXT("VDD",size=0.98,halign="middle",valign="bottom");
// &"VSS" @WIRE(mode="straight",linecolor="#647584",linewidth=0.16) {#XPN2:4 (54,-18.45)};
// (54,-18.77) @TEXT("VSS",size=0.98,halign="middle",valign="top");
// &"VDD" @WIRE(mode="straight",linecolor="#647584",linewidth=0.16) {#XINITIAL3:4 (0,-20.55)};
// (0,-20.23) @TEXT("VDD",size=0.98,halign="middle",valign="bottom");
// &"VSS" @WIRE(mode="straight",linecolor="#647584",linewidth=0.16) {#XINITIAL3:5 (0,-37.45)};
// (0,-37.77) @TEXT("VSS",size=0.98,halign="middle",valign="top");
// &"VDD" @WIRE(mode="straight",linecolor="#647584",linewidth=0.16) {#XNN3:3 (30,-14.55)};
// (30,-14.23) @TEXT("VDD",size=0.98,halign="middle",valign="bottom");
// &"VSS" @WIRE(mode="straight",linecolor="#647584",linewidth=0.16) {#XNN3:4 (30,-31.45)};
// (30,-31.77) @TEXT("VSS",size=0.98,halign="middle",valign="top");
// &"VDD" @WIRE(mode="straight",linecolor="#647584",linewidth=0.16) {#XPN3:3 (54,-25.55)};
// (54,-25.23) @TEXT("VDD",size=0.98,halign="middle",valign="bottom");
// &"VSS" @WIRE(mode="straight",linecolor="#647584",linewidth=0.16) {#XPN3:4 (54,-42.45)};
// (54,-42.77) @TEXT("VSS",size=0.98,halign="middle",valign="top");
// {#XINITIAL0 #XNN0 #XPN0 #XINITIAL1 #XNN1 #XPN1 #XINITIAL2 #XNN2 #XPN2 #XINITIAL3 #XNN3 #XPN3} @GROUP;
// @RECTANGLE(linecolor="#a9b8c5",linewidth=0.16,fill="fillcolor",fillcolor="#f7f9fc") {(-24,-46) (83,60)} => @LAYER("bottom");
// (-21,56) @TEXT("Bits 0-3",size=1.95,halign="start",textcolor="#223d52");
// #XINITIAL4 @SET-SYMBOL $S_ND2D1BWP12T30P140;
// #XINITIAL4 @PLACE(110,43) => @ORIENT("R0");
// #XINITIAL4 @TEXT("",key="name",size=1.65,halign="middle",textcolor="#223d52") => @PLACE(110,43);
// #XINITIAL4 @TEXT("",key="model");
// #XNN4 @SET-SYMBOL $S_BUFFD1BWP12T30P140;
// #XNN4 @PLACE(140,49) => @ORIENT("R0");
// #XNN4 @TEXT("",key="name",size=1.65,halign="middle",textcolor="#223d52") => @PLACE(140,49);
// #XNN4 @TEXT("",key="model");
// #XPN4 @SET-SYMBOL $S_INVD1BWP12T30P140;
// #XPN4 @PLACE(164,38) => @ORIENT("R0");
// #XPN4 @TEXT("",key="name",size=1.65,halign="middle",textcolor="#223d52") => @PLACE(164,38);
// #XPN4 @TEXT("",key="model");
// (88,43) @TEXT("B4",size=1.15,halign="start",textcolor="#223d52");
// %sar_junction6 = (124,43);
// %sar_junction6 @CIRCLE(radius=0.34,linecolor="#30485d",fill="fillcolor",fillcolor="#30485d") => @LAYER("top");
// &"QN4" @WIRE(mode="straight",linecolor="#30485d",linewidth=0.16) {#XINITIAL4:3 %sar_junction6};
// &"QN4" @WIRE(mode="straight",linecolor="#30485d",linewidth=0.16) {%sar_junction6 (124,49) #XNN4:1};
// &"QN4" @WIRE(mode="straight",linecolor="#30485d",linewidth=0.16) {%sar_junction6 (124,38) #XPN4:1};
// #XINITIAL5 @SET-SYMBOL $S_ND2D1BWP12T30P140;
// #XINITIAL5 @PLACE(110,19) => @ORIENT("R0");
// #XINITIAL5 @TEXT("",key="name",size=1.65,halign="middle",textcolor="#223d52") => @PLACE(110,19);
// #XINITIAL5 @TEXT("",key="model");
// #XNN5 @SET-SYMBOL $S_BUFFD1BWP12T30P140;
// #XNN5 @PLACE(140,25) => @ORIENT("R0");
// #XNN5 @TEXT("",key="name",size=1.65,halign="middle",textcolor="#223d52") => @PLACE(140,25);
// #XNN5 @TEXT("",key="model");
// #XPN5 @SET-SYMBOL $S_INVD1BWP12T30P140;
// #XPN5 @PLACE(164,14) => @ORIENT("R0");
// #XPN5 @TEXT("",key="name",size=1.65,halign="middle",textcolor="#223d52") => @PLACE(164,14);
// #XPN5 @TEXT("",key="model");
// (88,19) @TEXT("B5",size=1.15,halign="start",textcolor="#223d52");
// %sar_junction7 = (124,19);
// %sar_junction7 @CIRCLE(radius=0.34,linecolor="#30485d",fill="fillcolor",fillcolor="#30485d") => @LAYER("top");
// &"QN5" @WIRE(mode="straight",linecolor="#30485d",linewidth=0.16) {#XINITIAL5:3 %sar_junction7};
// &"QN5" @WIRE(mode="straight",linecolor="#30485d",linewidth=0.16) {%sar_junction7 (124,25) #XNN5:1};
// &"QN5" @WIRE(mode="straight",linecolor="#30485d",linewidth=0.16) {%sar_junction7 (124,14) #XPN5:1};
// #XINITIAL6 @SET-SYMBOL $S_ND2D1BWP12T30P140;
// #XINITIAL6 @PLACE(110,-5) => @ORIENT("R0");
// #XINITIAL6 @TEXT("",key="name",size=1.65,halign="middle",textcolor="#223d52") => @PLACE(110,-5);
// #XINITIAL6 @TEXT("",key="model");
// #XNN6 @SET-SYMBOL $S_BUFFD1BWP12T30P140;
// #XNN6 @PLACE(140,1) => @ORIENT("R0");
// #XNN6 @TEXT("",key="name",size=1.65,halign="middle",textcolor="#223d52") => @PLACE(140,1);
// #XNN6 @TEXT("",key="model");
// #XPN6 @SET-SYMBOL $S_INVD1BWP12T30P140;
// #XPN6 @PLACE(164,-10) => @ORIENT("R0");
// #XPN6 @TEXT("",key="name",size=1.65,halign="middle",textcolor="#223d52") => @PLACE(164,-10);
// #XPN6 @TEXT("",key="model");
// (88,-5) @TEXT("B6",size=1.15,halign="start",textcolor="#223d52");
// %sar_junction8 = (124,-5);
// %sar_junction8 @CIRCLE(radius=0.34,linecolor="#30485d",fill="fillcolor",fillcolor="#30485d") => @LAYER("top");
// &"QN6" @WIRE(mode="straight",linecolor="#30485d",linewidth=0.16) {#XINITIAL6:3 %sar_junction8};
// &"QN6" @WIRE(mode="straight",linecolor="#30485d",linewidth=0.16) {%sar_junction8 (124,1) #XNN6:1};
// &"QN6" @WIRE(mode="straight",linecolor="#30485d",linewidth=0.16) {%sar_junction8 (124,-10) #XPN6:1};
// &"VDD" @WIRE(mode="straight",linecolor="#647584",linewidth=0.16) {#XINITIAL4:4 (110,51.45)};
// (110,51.77) @TEXT("VDD",size=0.98,halign="middle",valign="bottom");
// &"VSS" @WIRE(mode="straight",linecolor="#647584",linewidth=0.16) {#XINITIAL4:5 (110,34.55)};
// (110,34.23) @TEXT("VSS",size=0.98,halign="middle",valign="top");
// &"VDD" @WIRE(mode="straight",linecolor="#647584",linewidth=0.16) {#XNN4:3 (140,57.45)};
// (140,57.77) @TEXT("VDD",size=0.98,halign="middle",valign="bottom");
// &"VSS" @WIRE(mode="straight",linecolor="#647584",linewidth=0.16) {#XNN4:4 (140,40.55)};
// (140,40.23) @TEXT("VSS",size=0.98,halign="middle",valign="top");
// &"VDD" @WIRE(mode="straight",linecolor="#647584",linewidth=0.16) {#XPN4:3 (164,46.45)};
// (164,46.77) @TEXT("VDD",size=0.98,halign="middle",valign="bottom");
// &"VSS" @WIRE(mode="straight",linecolor="#647584",linewidth=0.16) {#XPN4:4 (164,29.55)};
// (164,29.23) @TEXT("VSS",size=0.98,halign="middle",valign="top");
// &"VDD" @WIRE(mode="straight",linecolor="#647584",linewidth=0.16) {#XINITIAL5:4 (110,27.45)};
// (110,27.77) @TEXT("VDD",size=0.98,halign="middle",valign="bottom");
// &"VSS" @WIRE(mode="straight",linecolor="#647584",linewidth=0.16) {#XINITIAL5:5 (110,10.55)};
// (110,10.23) @TEXT("VSS",size=0.98,halign="middle",valign="top");
// &"VDD" @WIRE(mode="straight",linecolor="#647584",linewidth=0.16) {#XNN5:3 (140,33.45)};
// (140,33.77) @TEXT("VDD",size=0.98,halign="middle",valign="bottom");
// &"VSS" @WIRE(mode="straight",linecolor="#647584",linewidth=0.16) {#XNN5:4 (140,16.55)};
// (140,16.23) @TEXT("VSS",size=0.98,halign="middle",valign="top");
// &"VDD" @WIRE(mode="straight",linecolor="#647584",linewidth=0.16) {#XPN5:3 (164,22.45)};
// (164,22.77) @TEXT("VDD",size=0.98,halign="middle",valign="bottom");
// &"VSS" @WIRE(mode="straight",linecolor="#647584",linewidth=0.16) {#XPN5:4 (164,5.55)};
// (164,5.23) @TEXT("VSS",size=0.98,halign="middle",valign="top");
// &"VDD" @WIRE(mode="straight",linecolor="#647584",linewidth=0.16) {#XINITIAL6:4 (110,3.45)};
// (110,3.77) @TEXT("VDD",size=0.98,halign="middle",valign="bottom");
// &"VSS" @WIRE(mode="straight",linecolor="#647584",linewidth=0.16) {#XINITIAL6:5 (110,-13.45)};
// (110,-13.77) @TEXT("VSS",size=0.98,halign="middle",valign="top");
// &"VDD" @WIRE(mode="straight",linecolor="#647584",linewidth=0.16) {#XNN6:3 (140,9.45)};
// (140,9.77) @TEXT("VDD",size=0.98,halign="middle",valign="bottom");
// &"VSS" @WIRE(mode="straight",linecolor="#647584",linewidth=0.16) {#XNN6:4 (140,-7.45)};
// (140,-7.77) @TEXT("VSS",size=0.98,halign="middle",valign="top");
// &"VDD" @WIRE(mode="straight",linecolor="#647584",linewidth=0.16) {#XPN6:3 (164,-1.55)};
// (164,-1.23) @TEXT("VDD",size=0.98,halign="middle",valign="bottom");
// &"VSS" @WIRE(mode="straight",linecolor="#647584",linewidth=0.16) {#XPN6:4 (164,-18.45)};
// (164,-18.77) @TEXT("VSS",size=0.98,halign="middle",valign="top");
// {#XINITIAL4 #XNN4 #XPN4 #XINITIAL5 #XNN5 #XPN5 #XINITIAL6 #XNN6 #XPN6} @GROUP;
// @RECTANGLE(linecolor="#a9b8c5",linewidth=0.16,fill="fillcolor",fillcolor="#f7f9fc") {(86,-22) (193,60)} => @LAYER("bottom");
// (89,56) @TEXT("Bits 4-6",size=1.95,halign="start",textcolor="#223d52");
// #XINITIAL7_A @SET-SYMBOL $S_INVD1BWP12T30P140;
// #XINITIAL7_A @PLACE(-2,-67) => @ORIENT("R0");
// #XINITIAL7_A @TEXT("",key="name",size=1.65,halign="middle",textcolor="#223d52") => @PLACE(-2,-67);
// #XINITIAL7_A @TEXT("",key="model");
// #XINITIAL7_B @SET-SYMBOL $S_INVD1BWP12T30P140;
// #XINITIAL7_B @PLACE(2,-87) => @ORIENT("R0");
// #XINITIAL7_B @TEXT("",key="name",size=1.65,halign="middle",textcolor="#223d52") => @PLACE(2,-87);
// #XINITIAL7_B @TEXT("",key="model");
// #XINITIAL7 @SET-SYMBOL $S_ND2D1BWP12T30P140;
// #XINITIAL7 @PLACE(31,-77) => @ORIENT("R0");
// #XINITIAL7 @TEXT("",key="name",size=1.65,halign="middle",textcolor="#223d52") => @PLACE(31,-77);
// #XINITIAL7 @TEXT("",key="model");
// #XINV7 @SET-SYMBOL $S_INVD1BWP12T30P140;
// #XINV7 @PLACE(57,-77) => @ORIENT("R0");
// #XINV7 @TEXT("",key="name",size=1.65,halign="middle",textcolor="#223d52") => @PLACE(57,-77);
// #XINV7 @TEXT("",key="model");
// #XNN7 @SET-SYMBOL $S_BUFFD2BWP12T30P140;
// #XNN7 @PLACE(90,-71) => @ORIENT("R0");
// #XNN7 @TEXT("",key="name",size=1.65,halign="middle",textcolor="#223d52") => @PLACE(90,-71);
// #XNN7 @TEXT("",key="model");
// #XPN7 @SET-SYMBOL $S_INVD2BWP12T30P140;
// #XPN7 @PLACE(114,-82) => @ORIENT("R0");
// #XPN7 @TEXT("",key="name",size=1.65,halign="middle",textcolor="#223d52") => @PLACE(114,-82);
// #XPN7 @TEXT("",key="model");
// &"VDD" @WIRE(mode="straight",linecolor="#647584",linewidth=0.16) {#XINITIAL7_A:3 (-2,-58.55)};
// (-2,-58.23) @TEXT("VDD",size=0.98,halign="middle",valign="bottom");
// &"VSS" @WIRE(mode="straight",linecolor="#647584",linewidth=0.16) {#XINITIAL7_A:4 (-2,-75.45)};
// (-2,-75.77) @TEXT("VSS",size=0.98,halign="middle",valign="top");
// &"VDD" @WIRE(mode="straight",linecolor="#647584",linewidth=0.16) {#XINITIAL7_B:3 (2,-78.55)};
// (2,-78.23) @TEXT("VDD",size=0.98,halign="middle",valign="bottom");
// &"VSS" @WIRE(mode="straight",linecolor="#647584",linewidth=0.16) {#XINITIAL7_B:4 (2,-95.45)};
// (2,-95.77) @TEXT("VSS",size=0.98,halign="middle",valign="top");
// &"VDD" @WIRE(mode="straight",linecolor="#647584",linewidth=0.16) {#XINITIAL7:4 (31,-68.55)};
// (31,-68.23) @TEXT("VDD",size=0.98,halign="middle",valign="bottom");
// &"VSS" @WIRE(mode="straight",linecolor="#647584",linewidth=0.16) {#XINITIAL7:5 (31,-85.45)};
// (31,-85.77) @TEXT("VSS",size=0.98,halign="middle",valign="top");
// &"VDD" @WIRE(mode="straight",linecolor="#647584",linewidth=0.16) {#XINV7:3 (57,-68.55)};
// (57,-68.23) @TEXT("VDD",size=0.98,halign="middle",valign="bottom");
// &"VSS" @WIRE(mode="straight",linecolor="#647584",linewidth=0.16) {#XINV7:4 (57,-85.45)};
// (57,-85.77) @TEXT("VSS",size=0.98,halign="middle",valign="top");
// &"VDD" @WIRE(mode="straight",linecolor="#647584",linewidth=0.16) {#XNN7:3 (90,-62.55)};
// (90,-62.23) @TEXT("VDD",size=0.98,halign="middle",valign="bottom");
// &"VSS" @WIRE(mode="straight",linecolor="#647584",linewidth=0.16) {#XNN7:4 (90,-79.45)};
// (90,-79.77) @TEXT("VSS",size=0.98,halign="middle",valign="top");
// &"VDD" @WIRE(mode="straight",linecolor="#647584",linewidth=0.16) {#XPN7:3 (114,-73.55)};
// (114,-73.23) @TEXT("VDD",size=0.98,halign="middle",valign="bottom");
// &"VSS" @WIRE(mode="straight",linecolor="#647584",linewidth=0.16) {#XPN7:4 (114,-90.45)};
// (114,-90.77) @TEXT("VSS",size=0.98,halign="middle",valign="top");
// {#XINITIAL7_A #XINITIAL7_B #XINITIAL7 #XINV7 #XNN7 #XPN7} @GROUP;
// @RECTANGLE(linecolor="#a9b8c5",linewidth=0.16,fill="fillcolor",fillcolor="#f7f9fc") {(-24,-99) (151,-51)} => @LAYER("bottom");
// (-21,-55) @TEXT("Bit 7 / MSB",size=1.95,halign="start",textcolor="#223d52");
// (-21,-58.5) @TEXT("PRESET selects the 0x80 startup word.",size=1.26,halign="start",textcolor="#223d52");
// &"CODE7_B" @WIRE(mode="straight",linecolor="#30485d",linewidth=0.16) {#XINITIAL7_A:2 (14.5,-67) (14.5,-75.3) #XINITIAL7:1};
// &"PRESET_B" @WIRE(mode="straight",linecolor="#30485d",linewidth=0.16) {#XINITIAL7_B:2 (16.5,-87) (16.5,-78.7) #XINITIAL7:2};
// &"Q7" @WIRE(mode="straight",linecolor="#30485d",linewidth=0.16) {#XINITIAL7:3 (44,-77) (44,-77) #XINV7:1};
// %sar_junction9 = (72,-77);
// %sar_junction9 @CIRCLE(radius=0.34,linecolor="#30485d",fill="fillcolor",fillcolor="#30485d") => @LAYER("top");
// &"QN7" @WIRE(mode="straight",linecolor="#30485d",linewidth=0.16) {#XINV7:2 %sar_junction9};
// &"QN7" @WIRE(mode="straight",linecolor="#30485d",linewidth=0.16) {%sar_junction9 (72,-71) #XNN7:1};
// &"QN7" @WIRE(mode="straight",linecolor="#30485d",linewidth=0.16) {%sar_junction9 (72,-82) #XPN7:1};
// &"RUN" @WIRE(mode="straight",linecolor="#30485d",linewidth=0.16) {#XPRESET_N:2 (12,71)};
// (12.4,71) @TEXT("RUN",size=1.1,halign="start",valign="middle");
// &"VDD" @WIRE(mode="straight",linecolor="#30485d",linewidth=0.16) {#XPRESET_N:3 (2,81)};
// (2,81.4) @TEXT("VDD",size=1.1,halign="middle",valign="bottom");
// &"VSS" @WIRE(mode="straight",linecolor="#30485d",linewidth=0.16) {#XPRESET_N:4 (2,61)};
// (2,60.6) @TEXT("VSS",size=1.1,halign="middle",valign="top");
// &"CODE0" @WIRE(mode="straight",linecolor="#30485d",linewidth=0.16) {#XINITIAL0:1 (-10,44.7)};
// (-10.4,44.7) @TEXT("CODE0",size=1.1,halign="end",valign="middle");
// &"RUN" @WIRE(mode="straight",linecolor="#30485d",linewidth=0.16) {#XINITIAL0:2 (-10,41.3)};
// (-10.4,41.3) @TEXT("RUN",size=1.1,halign="end",valign="middle");
// &"REFSEL_P0" @WIRE(mode="straight",linecolor="#30485d",linewidth=0.16) {#XPN0:2 (64,38)};
// (64.4,38) @TEXT("REFSEL_P0",size=1.1,halign="start",valign="middle");
// &"REFSEL_N0" @WIRE(mode="straight",linecolor="#30485d",linewidth=0.16) {#XNN0:2 (40,49)};
// (40.4,49) @TEXT("REFSEL_N0",size=1.1,halign="start",valign="middle");
// &"CODE1" @WIRE(mode="straight",linecolor="#30485d",linewidth=0.16) {#XINITIAL1:1 (-10,20.7)};
// (-10.4,20.7) @TEXT("CODE1",size=1.1,halign="end",valign="middle");
// &"RUN" @WIRE(mode="straight",linecolor="#30485d",linewidth=0.16) {#XINITIAL1:2 (-10,17.3)};
// (-10.4,17.3) @TEXT("RUN",size=1.1,halign="end",valign="middle");
// &"REFSEL_P1" @WIRE(mode="straight",linecolor="#30485d",linewidth=0.16) {#XPN1:2 (64,14)};
// (64.4,14) @TEXT("REFSEL_P1",size=1.1,halign="start",valign="middle");
// &"REFSEL_N1" @WIRE(mode="straight",linecolor="#30485d",linewidth=0.16) {#XNN1:2 (40,25)};
// (40.4,25) @TEXT("REFSEL_N1",size=1.1,halign="start",valign="middle");
// &"CODE2" @WIRE(mode="straight",linecolor="#30485d",linewidth=0.16) {#XINITIAL2:1 (-10,-3.3)};
// (-10.4,-3.3) @TEXT("CODE2",size=1.1,halign="end",valign="middle");
// &"RUN" @WIRE(mode="straight",linecolor="#30485d",linewidth=0.16) {#XINITIAL2:2 (-10,-6.7)};
// (-10.4,-6.7) @TEXT("RUN",size=1.1,halign="end",valign="middle");
// &"REFSEL_P2" @WIRE(mode="straight",linecolor="#30485d",linewidth=0.16) {#XPN2:2 (64,-10)};
// (64.4,-10) @TEXT("REFSEL_P2",size=1.1,halign="start",valign="middle");
// &"REFSEL_N2" @WIRE(mode="straight",linecolor="#30485d",linewidth=0.16) {#XNN2:2 (40,1)};
// (40.4,1) @TEXT("REFSEL_N2",size=1.1,halign="start",valign="middle");
// &"CODE3" @WIRE(mode="straight",linecolor="#30485d",linewidth=0.16) {#XINITIAL3:1 (-10,-27.3)};
// (-10.4,-27.3) @TEXT("CODE3",size=1.1,halign="end",valign="middle");
// &"RUN" @WIRE(mode="straight",linecolor="#30485d",linewidth=0.16) {#XINITIAL3:2 (-10,-30.7)};
// (-10.4,-30.7) @TEXT("RUN",size=1.1,halign="end",valign="middle");
// &"REFSEL_P3" @WIRE(mode="straight",linecolor="#30485d",linewidth=0.16) {#XPN3:2 (64,-34)};
// (64.4,-34) @TEXT("REFSEL_P3",size=1.1,halign="start",valign="middle");
// &"REFSEL_N3" @WIRE(mode="straight",linecolor="#30485d",linewidth=0.16) {#XNN3:2 (40,-23)};
// (40.4,-23) @TEXT("REFSEL_N3",size=1.1,halign="start",valign="middle");
// &"CODE4" @WIRE(mode="straight",linecolor="#30485d",linewidth=0.16) {#XINITIAL4:1 (100,44.7)};
// (99.6,44.7) @TEXT("CODE4",size=1.1,halign="end",valign="middle");
// &"RUN" @WIRE(mode="straight",linecolor="#30485d",linewidth=0.16) {#XINITIAL4:2 (100,41.3)};
// (99.6,41.3) @TEXT("RUN",size=1.1,halign="end",valign="middle");
// &"REFSEL_P4" @WIRE(mode="straight",linecolor="#30485d",linewidth=0.16) {#XPN4:2 (174,38)};
// (174.4,38) @TEXT("REFSEL_P4",size=1.1,halign="start",valign="middle");
// &"REFSEL_N4" @WIRE(mode="straight",linecolor="#30485d",linewidth=0.16) {#XNN4:2 (150,49)};
// (150.4,49) @TEXT("REFSEL_N4",size=1.1,halign="start",valign="middle");
// &"CODE5" @WIRE(mode="straight",linecolor="#30485d",linewidth=0.16) {#XINITIAL5:1 (100,20.7)};
// (99.6,20.7) @TEXT("CODE5",size=1.1,halign="end",valign="middle");
// &"RUN" @WIRE(mode="straight",linecolor="#30485d",linewidth=0.16) {#XINITIAL5:2 (100,17.3)};
// (99.6,17.3) @TEXT("RUN",size=1.1,halign="end",valign="middle");
// &"REFSEL_P5" @WIRE(mode="straight",linecolor="#30485d",linewidth=0.16) {#XPN5:2 (174,14)};
// (174.4,14) @TEXT("REFSEL_P5",size=1.1,halign="start",valign="middle");
// &"REFSEL_N5" @WIRE(mode="straight",linecolor="#30485d",linewidth=0.16) {#XNN5:2 (150,25)};
// (150.4,25) @TEXT("REFSEL_N5",size=1.1,halign="start",valign="middle");
// &"CODE6" @WIRE(mode="straight",linecolor="#30485d",linewidth=0.16) {#XINITIAL6:1 (100,-3.3)};
// (99.6,-3.3) @TEXT("CODE6",size=1.1,halign="end",valign="middle");
// &"RUN" @WIRE(mode="straight",linecolor="#30485d",linewidth=0.16) {#XINITIAL6:2 (100,-6.7)};
// (99.6,-6.7) @TEXT("RUN",size=1.1,halign="end",valign="middle");
// &"REFSEL_P6" @WIRE(mode="straight",linecolor="#30485d",linewidth=0.16) {#XPN6:2 (174,-10)};
// (174.4,-10) @TEXT("REFSEL_P6",size=1.1,halign="start",valign="middle");
// &"REFSEL_N6" @WIRE(mode="straight",linecolor="#30485d",linewidth=0.16) {#XNN6:2 (150,1)};
// (150.4,1) @TEXT("REFSEL_N6",size=1.1,halign="start",valign="middle");
// &"CODE7" @WIRE(mode="straight",linecolor="#30485d",linewidth=0.16) {#XINITIAL7_A:1 (-12,-67)};
// (-12.4,-67) @TEXT("CODE7",size=1.1,halign="end",valign="middle");
// &"PRESET" @WIRE(mode="straight",linecolor="#30485d",linewidth=0.16) {#XINITIAL7_B:1 (-8,-87)};
// (-8.4,-87) @TEXT("PRESET",size=1.1,halign="end",valign="middle");
// &"REFSEL_P7" @WIRE(mode="straight",linecolor="#30485d",linewidth=0.16) {#XPN7:2 (124,-82)};
// (124.4,-82) @TEXT("REFSEL_P7",size=1.1,halign="start",valign="middle");
// &"REFSEL_N7" @WIRE(mode="straight",linecolor="#30485d",linewidth=0.16) {#XNN7:2 (100,-71)};
// (100.4,-71) @TEXT("REFSEL_N7",size=1.1,halign="start",valign="middle");
// }
// END SARADC RNL
ends sar8i_refword
