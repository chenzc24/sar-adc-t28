// Native-cell reference decoding and complementary gate drives for the single-edge top.
// BEGIN SARADC RNL
// @RNL(type="header") { @VERSION("0.3");
// @USE-PACKAGE(name="sar8",version="0.1",path="../../rnl/sar8.rnl");
// @USE-PACKAGE(name="rnl-std-fill") {}; }
// END SARADC RNL
subckt sar8i_refword CODE0 CODE1 CODE2 CODE3 CODE4 CODE5 CODE6 CODE7 D0 D1  D2 D3 D4 D5 D6 D7 GNN0 GNN1 GNN2 GNN3 GNN4 GNN5 GNN6 GNN7 GNP0  GNP1 GNP2 GNP3 GNP4 GNP5 GNP6 GNP7 GPN0 GPN1 GPN2 GPN3 GPN4 GPN5  GPN6 GPN7 GPP0 GPP1 GPP2 GPP3 GPP4 GPP5 GPP6 GPP7 PHI_U SAMPLE VDD  VSS RST_DONE PRESET
XPRESET_N (PRESET RUN VDD VSS) INVD1BWP12T30P140
XINITIAL0 (CODE0 RUN QN0 VDD VSS) ND2D1BWP12T30P140
XPN0 (QN0 GPN0 VDD VSS) INVD1BWP12T30P140
XNN0 (QN0 GNN0 VDD VSS) BUFFD1BWP12T30P140
WNP0 (GNN0 GNP0) iprobe
WPP0 (GPN0 GPP0) iprobe
XINITIAL1 (CODE1 RUN QN1 VDD VSS) ND2D1BWP12T30P140
XPN1 (QN1 GPN1 VDD VSS) INVD1BWP12T30P140
XNN1 (QN1 GNN1 VDD VSS) BUFFD1BWP12T30P140
WNP1 (GNN1 GNP1) iprobe
WPP1 (GPN1 GPP1) iprobe
XINITIAL2 (CODE2 RUN QN2 VDD VSS) ND2D1BWP12T30P140
XPN2 (QN2 GPN2 VDD VSS) INVD1BWP12T30P140
XNN2 (QN2 GNN2 VDD VSS) BUFFD1BWP12T30P140
WNP2 (GNN2 GNP2) iprobe
WPP2 (GPN2 GPP2) iprobe
XINITIAL3 (CODE3 RUN QN3 VDD VSS) ND2D1BWP12T30P140
XPN3 (QN3 GPN3 VDD VSS) INVD1BWP12T30P140
XNN3 (QN3 GNN3 VDD VSS) BUFFD1BWP12T30P140
WNP3 (GNN3 GNP3) iprobe
WPP3 (GPN3 GPP3) iprobe
XINITIAL4 (CODE4 RUN QN4 VDD VSS) ND2D1BWP12T30P140
XPN4 (QN4 GPN4 VDD VSS) INVD1BWP12T30P140
XNN4 (QN4 GNN4 VDD VSS) BUFFD1BWP12T30P140
WNP4 (GNN4 GNP4) iprobe
WPP4 (GPN4 GPP4) iprobe
XINITIAL5 (CODE5 RUN QN5 VDD VSS) ND2D1BWP12T30P140
XPN5 (QN5 GPN5 VDD VSS) INVD1BWP12T30P140
XNN5 (QN5 GNN5 VDD VSS) BUFFD1BWP12T30P140
WNP5 (GNN5 GNP5) iprobe
WPP5 (GPN5 GPP5) iprobe
XINITIAL6 (CODE6 RUN QN6 VDD VSS) ND2D1BWP12T30P140
XPN6 (QN6 GPN6 VDD VSS) INVD1BWP12T30P140
XNN6 (QN6 GNN6 VDD VSS) BUFFD1BWP12T30P140
WNP6 (GNN6 GNP6) iprobe
WPP6 (GPN6 GPP6) iprobe
// PRESET rises with CODE7 high at the end of every MSB-1 conversion. The INV+INV+ND2 form keeps
// the stacked node within the terminal-voltage rule (native OR2D1 reached 1.124 V).
XINITIAL7_A (CODE7 CODE7_B VDD VSS) INVD1BWP12T30P140
XINITIAL7_B (PRESET PRESET_B VDD VSS) INVD1BWP12T30P140
XINITIAL7 (CODE7_B PRESET_B Q7 VDD VSS) ND2D1BWP12T30P140
XINV7 (Q7 QN7 VDD VSS) INVD1BWP12T30P140
XPN7 (QN7 GPN7 VDD VSS) INVD2BWP12T30P140
XNN7 (QN7 GNN7 VDD VSS) BUFFD2BWP12T30P140
WNP7 (GNN7 GNP7) iprobe
WPP7 (GPN7 GPP7) iprobe
WUNUSED (RST_DONE VSS) iprobe
// BEGIN SARADC RNL
// @RNL(author="saradc topology") {
// (-17,70) @TEXT("Single-edge reference decode and switch drive",size=2,halign="start",textcolor="#223d52");
// #XPRESET_N @SET-SYMBOL $S_INVD1BWP12T30P140;
// #XPRESET_N @PLACE(0,42) => @ORIENT("R0");
// #WUNUSED @SET-SYMBOL $S_iprobe;
// #WUNUSED @PLACE(34,42) => @ORIENT("R0");
// (-18,17) @TEXT("Bit 0",size=1.2,halign="start",textcolor="#223d52");
// #XINITIAL0 @SET-SYMBOL $S_ND2D1BWP12T30P140;
// #XINITIAL0 @PLACE(0,9) => @ORIENT("R0");
// #XPN0 @SET-SYMBOL $S_INVD1BWP12T30P140;
// #XPN0 @PLACE(34,9) => @ORIENT("R0");
// #XNN0 @SET-SYMBOL $S_BUFFD1BWP12T30P140;
// #XNN0 @PLACE(68,9) => @ORIENT("R0");
// #WNP0 @SET-SYMBOL $S_iprobe;
// #WNP0 @PLACE(102,9) => @ORIENT("R0");
// #WPP0 @SET-SYMBOL $S_iprobe;
// #WPP0 @PLACE(136,9) => @ORIENT("R0");
// (-18,-13) @TEXT("Bit 1",size=1.2,halign="start",textcolor="#223d52");
// #XINITIAL1 @SET-SYMBOL $S_ND2D1BWP12T30P140;
// #XINITIAL1 @PLACE(0,-21) => @ORIENT("R0");
// #XPN1 @SET-SYMBOL $S_INVD1BWP12T30P140;
// #XPN1 @PLACE(34,-21) => @ORIENT("R0");
// #XNN1 @SET-SYMBOL $S_BUFFD1BWP12T30P140;
// #XNN1 @PLACE(68,-21) => @ORIENT("R0");
// #WNP1 @SET-SYMBOL $S_iprobe;
// #WNP1 @PLACE(102,-21) => @ORIENT("R0");
// #WPP1 @SET-SYMBOL $S_iprobe;
// #WPP1 @PLACE(136,-21) => @ORIENT("R0");
// (-18,-43) @TEXT("Bit 2",size=1.2,halign="start",textcolor="#223d52");
// #XINITIAL2 @SET-SYMBOL $S_ND2D1BWP12T30P140;
// #XINITIAL2 @PLACE(0,-51) => @ORIENT("R0");
// #XPN2 @SET-SYMBOL $S_INVD1BWP12T30P140;
// #XPN2 @PLACE(34,-51) => @ORIENT("R0");
// #XNN2 @SET-SYMBOL $S_BUFFD1BWP12T30P140;
// #XNN2 @PLACE(68,-51) => @ORIENT("R0");
// #WNP2 @SET-SYMBOL $S_iprobe;
// #WNP2 @PLACE(102,-51) => @ORIENT("R0");
// #WPP2 @SET-SYMBOL $S_iprobe;
// #WPP2 @PLACE(136,-51) => @ORIENT("R0");
// (-18,-73) @TEXT("Bit 3",size=1.2,halign="start",textcolor="#223d52");
// #XINITIAL3 @SET-SYMBOL $S_ND2D1BWP12T30P140;
// #XINITIAL3 @PLACE(0,-81) => @ORIENT("R0");
// #XPN3 @SET-SYMBOL $S_INVD1BWP12T30P140;
// #XPN3 @PLACE(34,-81) => @ORIENT("R0");
// #XNN3 @SET-SYMBOL $S_BUFFD1BWP12T30P140;
// #XNN3 @PLACE(68,-81) => @ORIENT("R0");
// #WNP3 @SET-SYMBOL $S_iprobe;
// #WNP3 @PLACE(102,-81) => @ORIENT("R0");
// #WPP3 @SET-SYMBOL $S_iprobe;
// #WPP3 @PLACE(136,-81) => @ORIENT("R0");
// (-18,-103) @TEXT("Bit 4",size=1.2,halign="start",textcolor="#223d52");
// #XINITIAL4 @SET-SYMBOL $S_ND2D1BWP12T30P140;
// #XINITIAL4 @PLACE(0,-111) => @ORIENT("R0");
// #XPN4 @SET-SYMBOL $S_INVD1BWP12T30P140;
// #XPN4 @PLACE(34,-111) => @ORIENT("R0");
// #XNN4 @SET-SYMBOL $S_BUFFD1BWP12T30P140;
// #XNN4 @PLACE(68,-111) => @ORIENT("R0");
// #WNP4 @SET-SYMBOL $S_iprobe;
// #WNP4 @PLACE(102,-111) => @ORIENT("R0");
// #WPP4 @SET-SYMBOL $S_iprobe;
// #WPP4 @PLACE(136,-111) => @ORIENT("R0");
// (-18,-133) @TEXT("Bit 5",size=1.2,halign="start",textcolor="#223d52");
// #XINITIAL5 @SET-SYMBOL $S_ND2D1BWP12T30P140;
// #XINITIAL5 @PLACE(0,-141) => @ORIENT("R0");
// #XPN5 @SET-SYMBOL $S_INVD1BWP12T30P140;
// #XPN5 @PLACE(34,-141) => @ORIENT("R0");
// #XNN5 @SET-SYMBOL $S_BUFFD1BWP12T30P140;
// #XNN5 @PLACE(68,-141) => @ORIENT("R0");
// #WNP5 @SET-SYMBOL $S_iprobe;
// #WNP5 @PLACE(102,-141) => @ORIENT("R0");
// #WPP5 @SET-SYMBOL $S_iprobe;
// #WPP5 @PLACE(136,-141) => @ORIENT("R0");
// (-18,-163) @TEXT("Bit 6",size=1.2,halign="start",textcolor="#223d52");
// #XINITIAL6 @SET-SYMBOL $S_ND2D1BWP12T30P140;
// #XINITIAL6 @PLACE(0,-171) => @ORIENT("R0");
// #XPN6 @SET-SYMBOL $S_INVD1BWP12T30P140;
// #XPN6 @PLACE(34,-171) => @ORIENT("R0");
// #XNN6 @SET-SYMBOL $S_BUFFD1BWP12T30P140;
// #XNN6 @PLACE(68,-171) => @ORIENT("R0");
// #WNP6 @SET-SYMBOL $S_iprobe;
// #WNP6 @PLACE(102,-171) => @ORIENT("R0");
// #WPP6 @SET-SYMBOL $S_iprobe;
// #WPP6 @PLACE(136,-171) => @ORIENT("R0");
// (-18,-193) @TEXT("Bit 7",size=1.2,halign="start",textcolor="#223d52");
// #XINITIAL7_A @SET-SYMBOL $S_INVD1BWP12T30P140;
// #XINITIAL7_A @PLACE(0,-201) => @ORIENT("R0");
// #XINITIAL7_B @SET-SYMBOL $S_INVD1BWP12T30P140;
// #XINITIAL7_B @PLACE(34,-201) => @ORIENT("R0");
// #XINITIAL7 @SET-SYMBOL $S_ND2D1BWP12T30P140;
// #XINITIAL7 @PLACE(68,-201) => @ORIENT("R0");
// #XINV7 @SET-SYMBOL $S_INVD1BWP12T30P140;
// #XINV7 @PLACE(102,-201) => @ORIENT("R0");
// #XPN7 @SET-SYMBOL $S_INVD2BWP12T30P140;
// #XPN7 @PLACE(136,-201) => @ORIENT("R0");
// #XNN7 @SET-SYMBOL $S_BUFFD2BWP12T30P140;
// #XNN7 @PLACE(170,-201) => @ORIENT("R0");
// #WNP7 @SET-SYMBOL $S_iprobe;
// #WNP7 @PLACE(204,-201) => @ORIENT("R0");
// #WPP7 @SET-SYMBOL $S_iprobe;
// #WPP7 @PLACE(238,-201) => @ORIENT("R0");
// &"GNN0" @WIRE(mode="straight",linecolor="#30485d",linewidth=0.16) {#XNN0:2 (85,9) (85,10.65) #WNP0:1};
// &"GNN1" @WIRE(mode="straight",linecolor="#30485d",linewidth=0.16) {#XNN1:2 (85,-21) (85,-19.35) #WNP1:1};
// &"GNN2" @WIRE(mode="straight",linecolor="#30485d",linewidth=0.16) {#XNN2:2 (85,-51) (85,-49.35) #WNP2:1};
// &"GNN3" @WIRE(mode="straight",linecolor="#30485d",linewidth=0.16) {#XNN3:2 (85,-81) (85,-79.35) #WNP3:1};
// &"GNN4" @WIRE(mode="straight",linecolor="#30485d",linewidth=0.16) {#XNN4:2 (85,-111) (85,-109.35) #WNP4:1};
// &"GNN5" @WIRE(mode="straight",linecolor="#30485d",linewidth=0.16) {#XNN5:2 (85,-141) (85,-139.35) #WNP5:1};
// &"GNN6" @WIRE(mode="straight",linecolor="#30485d",linewidth=0.16) {#XNN6:2 (85,-171) (85,-169.35) #WNP6:1};
// &"PRESET_B" @WIRE(mode="straight",linecolor="#30485d",linewidth=0.16) {#XINITIAL7_B:2 (51,-201) (51,-202.7) #XINITIAL7:2};
// &"Q7" @WIRE(mode="straight",linecolor="#30485d",linewidth=0.16) {#XINITIAL7:3 (85,-201) (85,-201) #XINV7:1};
// &"GNN7" @WIRE(mode="straight",linecolor="#30485d",linewidth=0.16) {#XNN7:2 (187,-201) (187,-199.35) #WNP7:1};
// &"PRESET" @WIRE(mode="straight",linecolor="#30485d",linewidth=0.16) {#XPRESET_N:1 (-10,42)};
// (-10.4,42) @TEXT("PRESET",size=1.1,halign="end",valign="middle");
// &"RUN" @WIRE(mode="straight",linecolor="#30485d",linewidth=0.16) {#XPRESET_N:2 (10,42)};
// (10.4,42) @TEXT("RUN",size=1.1,halign="start",valign="middle");
// &"VDD" @WIRE(mode="straight",linecolor="#30485d",linewidth=0.16) {#XPRESET_N:3 (0,52)};
// (0,52.4) @TEXT("VDD",size=1.1,halign="middle",valign="bottom");
// &"VSS" @WIRE(mode="straight",linecolor="#30485d",linewidth=0.16) {#XPRESET_N:4 (0,32)};
// (0,31.6) @TEXT("VSS",size=1.1,halign="middle",valign="top");
// &"CODE0" @WIRE(mode="straight",linecolor="#30485d",linewidth=0.16) {#XINITIAL0:1 (-10,10.7)};
// (-10.4,10.7) @TEXT("CODE0",size=1.1,halign="end",valign="middle");
// &"RUN" @WIRE(mode="straight",linecolor="#30485d",linewidth=0.16) {#XINITIAL0:2 (-10,7.3)};
// (-10.4,7.3) @TEXT("RUN",size=1.1,halign="end",valign="middle");
// &"QN0" @WIRE(mode="straight",linecolor="#30485d",linewidth=0.16) {#XINITIAL0:3 (10,9)};
// (10.4,9) @TEXT("QN0",size=1.1,halign="start",valign="middle");
// &"VDD" @WIRE(mode="straight",linecolor="#30485d",linewidth=0.16) {#XINITIAL0:4 (0,19)};
// (0,19.4) @TEXT("VDD",size=1.1,halign="middle",valign="bottom");
// &"VSS" @WIRE(mode="straight",linecolor="#30485d",linewidth=0.16) {#XINITIAL0:5 (0,-1)};
// (0,-1.4) @TEXT("VSS",size=1.1,halign="middle",valign="top");
// &"QN0" @WIRE(mode="straight",linecolor="#30485d",linewidth=0.16) {#XPN0:1 (24,9)};
// (23.6,9) @TEXT("QN0",size=1.1,halign="end",valign="middle");
// &"GPN0" @WIRE(mode="straight",linecolor="#30485d",linewidth=0.16) {#XPN0:2 (44,9)};
// (44.4,9) @TEXT("GPN0",size=1.1,halign="start",valign="middle");
// &"VDD" @WIRE(mode="straight",linecolor="#30485d",linewidth=0.16) {#XPN0:3 (34,19)};
// (34,19.4) @TEXT("VDD",size=1.1,halign="middle",valign="bottom");
// &"VSS" @WIRE(mode="straight",linecolor="#30485d",linewidth=0.16) {#XPN0:4 (34,-1)};
// (34,-1.4) @TEXT("VSS",size=1.1,halign="middle",valign="top");
// &"QN0" @WIRE(mode="straight",linecolor="#30485d",linewidth=0.16) {#XNN0:1 (52,9)};
// (51.6,9) @TEXT("QN0",size=1.1,halign="end",valign="middle");
// &"VDD" @WIRE(mode="straight",linecolor="#30485d",linewidth=0.16) {#XNN0:3 (68,20)};
// (68,20.4) @TEXT("VDD",size=1.1,halign="middle",valign="bottom");
// &"VSS" @WIRE(mode="straight",linecolor="#30485d",linewidth=0.16) {#XNN0:4 (68,-2)};
// (68,-2.4) @TEXT("VSS",size=1.1,halign="middle",valign="top");
// &"GNP0" @WIRE(mode="straight",linecolor="#30485d",linewidth=0.16) {#WNP0:2 (86,7.35)};
// (85.6,7.35) @TEXT("GNP0",size=1.1,halign="end",valign="middle");
// &"GPN0" @WIRE(mode="straight",linecolor="#30485d",linewidth=0.16) {#WPP0:1 (120,10.65)};
// (119.6,10.65) @TEXT("GPN0",size=1.1,halign="end",valign="middle");
// &"GPP0" @WIRE(mode="straight",linecolor="#30485d",linewidth=0.16) {#WPP0:2 (120,7.35)};
// (119.6,7.35) @TEXT("GPP0",size=1.1,halign="end",valign="middle");
// &"CODE1" @WIRE(mode="straight",linecolor="#30485d",linewidth=0.16) {#XINITIAL1:1 (-10,-19.3)};
// (-10.4,-19.3) @TEXT("CODE1",size=1.1,halign="end",valign="middle");
// &"RUN" @WIRE(mode="straight",linecolor="#30485d",linewidth=0.16) {#XINITIAL1:2 (-10,-22.7)};
// (-10.4,-22.7) @TEXT("RUN",size=1.1,halign="end",valign="middle");
// &"QN1" @WIRE(mode="straight",linecolor="#30485d",linewidth=0.16) {#XINITIAL1:3 (10,-21)};
// (10.4,-21) @TEXT("QN1",size=1.1,halign="start",valign="middle");
// &"VDD" @WIRE(mode="straight",linecolor="#30485d",linewidth=0.16) {#XINITIAL1:4 (0,-11)};
// (0,-10.6) @TEXT("VDD",size=1.1,halign="middle",valign="bottom");
// &"VSS" @WIRE(mode="straight",linecolor="#30485d",linewidth=0.16) {#XINITIAL1:5 (0,-31)};
// (0,-31.4) @TEXT("VSS",size=1.1,halign="middle",valign="top");
// &"QN1" @WIRE(mode="straight",linecolor="#30485d",linewidth=0.16) {#XPN1:1 (24,-21)};
// (23.6,-21) @TEXT("QN1",size=1.1,halign="end",valign="middle");
// &"GPN1" @WIRE(mode="straight",linecolor="#30485d",linewidth=0.16) {#XPN1:2 (44,-21)};
// (44.4,-21) @TEXT("GPN1",size=1.1,halign="start",valign="middle");
// &"VDD" @WIRE(mode="straight",linecolor="#30485d",linewidth=0.16) {#XPN1:3 (34,-11)};
// (34,-10.6) @TEXT("VDD",size=1.1,halign="middle",valign="bottom");
// &"VSS" @WIRE(mode="straight",linecolor="#30485d",linewidth=0.16) {#XPN1:4 (34,-31)};
// (34,-31.4) @TEXT("VSS",size=1.1,halign="middle",valign="top");
// &"QN1" @WIRE(mode="straight",linecolor="#30485d",linewidth=0.16) {#XNN1:1 (52,-21)};
// (51.6,-21) @TEXT("QN1",size=1.1,halign="end",valign="middle");
// &"VDD" @WIRE(mode="straight",linecolor="#30485d",linewidth=0.16) {#XNN1:3 (68,-10)};
// (68,-9.6) @TEXT("VDD",size=1.1,halign="middle",valign="bottom");
// &"VSS" @WIRE(mode="straight",linecolor="#30485d",linewidth=0.16) {#XNN1:4 (68,-32)};
// (68,-32.4) @TEXT("VSS",size=1.1,halign="middle",valign="top");
// &"GNP1" @WIRE(mode="straight",linecolor="#30485d",linewidth=0.16) {#WNP1:2 (86,-22.65)};
// (85.6,-22.65) @TEXT("GNP1",size=1.1,halign="end",valign="middle");
// &"GPN1" @WIRE(mode="straight",linecolor="#30485d",linewidth=0.16) {#WPP1:1 (120,-19.35)};
// (119.6,-19.35) @TEXT("GPN1",size=1.1,halign="end",valign="middle");
// &"GPP1" @WIRE(mode="straight",linecolor="#30485d",linewidth=0.16) {#WPP1:2 (120,-22.65)};
// (119.6,-22.65) @TEXT("GPP1",size=1.1,halign="end",valign="middle");
// &"CODE2" @WIRE(mode="straight",linecolor="#30485d",linewidth=0.16) {#XINITIAL2:1 (-10,-49.3)};
// (-10.4,-49.3) @TEXT("CODE2",size=1.1,halign="end",valign="middle");
// &"RUN" @WIRE(mode="straight",linecolor="#30485d",linewidth=0.16) {#XINITIAL2:2 (-10,-52.7)};
// (-10.4,-52.7) @TEXT("RUN",size=1.1,halign="end",valign="middle");
// &"QN2" @WIRE(mode="straight",linecolor="#30485d",linewidth=0.16) {#XINITIAL2:3 (10,-51)};
// (10.4,-51) @TEXT("QN2",size=1.1,halign="start",valign="middle");
// &"VDD" @WIRE(mode="straight",linecolor="#30485d",linewidth=0.16) {#XINITIAL2:4 (0,-41)};
// (0,-40.6) @TEXT("VDD",size=1.1,halign="middle",valign="bottom");
// &"VSS" @WIRE(mode="straight",linecolor="#30485d",linewidth=0.16) {#XINITIAL2:5 (0,-61)};
// (0,-61.4) @TEXT("VSS",size=1.1,halign="middle",valign="top");
// &"QN2" @WIRE(mode="straight",linecolor="#30485d",linewidth=0.16) {#XPN2:1 (24,-51)};
// (23.6,-51) @TEXT("QN2",size=1.1,halign="end",valign="middle");
// &"GPN2" @WIRE(mode="straight",linecolor="#30485d",linewidth=0.16) {#XPN2:2 (44,-51)};
// (44.4,-51) @TEXT("GPN2",size=1.1,halign="start",valign="middle");
// &"VDD" @WIRE(mode="straight",linecolor="#30485d",linewidth=0.16) {#XPN2:3 (34,-41)};
// (34,-40.6) @TEXT("VDD",size=1.1,halign="middle",valign="bottom");
// &"VSS" @WIRE(mode="straight",linecolor="#30485d",linewidth=0.16) {#XPN2:4 (34,-61)};
// (34,-61.4) @TEXT("VSS",size=1.1,halign="middle",valign="top");
// &"QN2" @WIRE(mode="straight",linecolor="#30485d",linewidth=0.16) {#XNN2:1 (52,-51)};
// (51.6,-51) @TEXT("QN2",size=1.1,halign="end",valign="middle");
// &"VDD" @WIRE(mode="straight",linecolor="#30485d",linewidth=0.16) {#XNN2:3 (68,-40)};
// (68,-39.6) @TEXT("VDD",size=1.1,halign="middle",valign="bottom");
// &"VSS" @WIRE(mode="straight",linecolor="#30485d",linewidth=0.16) {#XNN2:4 (68,-62)};
// (68,-62.4) @TEXT("VSS",size=1.1,halign="middle",valign="top");
// &"GNP2" @WIRE(mode="straight",linecolor="#30485d",linewidth=0.16) {#WNP2:2 (86,-52.65)};
// (85.6,-52.65) @TEXT("GNP2",size=1.1,halign="end",valign="middle");
// &"GPN2" @WIRE(mode="straight",linecolor="#30485d",linewidth=0.16) {#WPP2:1 (120,-49.35)};
// (119.6,-49.35) @TEXT("GPN2",size=1.1,halign="end",valign="middle");
// &"GPP2" @WIRE(mode="straight",linecolor="#30485d",linewidth=0.16) {#WPP2:2 (120,-52.65)};
// (119.6,-52.65) @TEXT("GPP2",size=1.1,halign="end",valign="middle");
// &"CODE3" @WIRE(mode="straight",linecolor="#30485d",linewidth=0.16) {#XINITIAL3:1 (-10,-79.3)};
// (-10.4,-79.3) @TEXT("CODE3",size=1.1,halign="end",valign="middle");
// &"RUN" @WIRE(mode="straight",linecolor="#30485d",linewidth=0.16) {#XINITIAL3:2 (-10,-82.7)};
// (-10.4,-82.7) @TEXT("RUN",size=1.1,halign="end",valign="middle");
// &"QN3" @WIRE(mode="straight",linecolor="#30485d",linewidth=0.16) {#XINITIAL3:3 (10,-81)};
// (10.4,-81) @TEXT("QN3",size=1.1,halign="start",valign="middle");
// &"VDD" @WIRE(mode="straight",linecolor="#30485d",linewidth=0.16) {#XINITIAL3:4 (0,-71)};
// (0,-70.6) @TEXT("VDD",size=1.1,halign="middle",valign="bottom");
// &"VSS" @WIRE(mode="straight",linecolor="#30485d",linewidth=0.16) {#XINITIAL3:5 (0,-91)};
// (0,-91.4) @TEXT("VSS",size=1.1,halign="middle",valign="top");
// &"QN3" @WIRE(mode="straight",linecolor="#30485d",linewidth=0.16) {#XPN3:1 (24,-81)};
// (23.6,-81) @TEXT("QN3",size=1.1,halign="end",valign="middle");
// &"GPN3" @WIRE(mode="straight",linecolor="#30485d",linewidth=0.16) {#XPN3:2 (44,-81)};
// (44.4,-81) @TEXT("GPN3",size=1.1,halign="start",valign="middle");
// &"VDD" @WIRE(mode="straight",linecolor="#30485d",linewidth=0.16) {#XPN3:3 (34,-71)};
// (34,-70.6) @TEXT("VDD",size=1.1,halign="middle",valign="bottom");
// &"VSS" @WIRE(mode="straight",linecolor="#30485d",linewidth=0.16) {#XPN3:4 (34,-91)};
// (34,-91.4) @TEXT("VSS",size=1.1,halign="middle",valign="top");
// &"QN3" @WIRE(mode="straight",linecolor="#30485d",linewidth=0.16) {#XNN3:1 (52,-81)};
// (51.6,-81) @TEXT("QN3",size=1.1,halign="end",valign="middle");
// &"VDD" @WIRE(mode="straight",linecolor="#30485d",linewidth=0.16) {#XNN3:3 (68,-70)};
// (68,-69.6) @TEXT("VDD",size=1.1,halign="middle",valign="bottom");
// &"VSS" @WIRE(mode="straight",linecolor="#30485d",linewidth=0.16) {#XNN3:4 (68,-92)};
// (68,-92.4) @TEXT("VSS",size=1.1,halign="middle",valign="top");
// &"GNP3" @WIRE(mode="straight",linecolor="#30485d",linewidth=0.16) {#WNP3:2 (86,-82.65)};
// (85.6,-82.65) @TEXT("GNP3",size=1.1,halign="end",valign="middle");
// &"GPN3" @WIRE(mode="straight",linecolor="#30485d",linewidth=0.16) {#WPP3:1 (120,-79.35)};
// (119.6,-79.35) @TEXT("GPN3",size=1.1,halign="end",valign="middle");
// &"GPP3" @WIRE(mode="straight",linecolor="#30485d",linewidth=0.16) {#WPP3:2 (120,-82.65)};
// (119.6,-82.65) @TEXT("GPP3",size=1.1,halign="end",valign="middle");
// &"CODE4" @WIRE(mode="straight",linecolor="#30485d",linewidth=0.16) {#XINITIAL4:1 (-10,-109.3)};
// (-10.4,-109.3) @TEXT("CODE4",size=1.1,halign="end",valign="middle");
// &"RUN" @WIRE(mode="straight",linecolor="#30485d",linewidth=0.16) {#XINITIAL4:2 (-10,-112.7)};
// (-10.4,-112.7) @TEXT("RUN",size=1.1,halign="end",valign="middle");
// &"QN4" @WIRE(mode="straight",linecolor="#30485d",linewidth=0.16) {#XINITIAL4:3 (10,-111)};
// (10.4,-111) @TEXT("QN4",size=1.1,halign="start",valign="middle");
// &"VDD" @WIRE(mode="straight",linecolor="#30485d",linewidth=0.16) {#XINITIAL4:4 (0,-101)};
// (0,-100.6) @TEXT("VDD",size=1.1,halign="middle",valign="bottom");
// &"VSS" @WIRE(mode="straight",linecolor="#30485d",linewidth=0.16) {#XINITIAL4:5 (0,-121)};
// (0,-121.4) @TEXT("VSS",size=1.1,halign="middle",valign="top");
// &"QN4" @WIRE(mode="straight",linecolor="#30485d",linewidth=0.16) {#XPN4:1 (24,-111)};
// (23.6,-111) @TEXT("QN4",size=1.1,halign="end",valign="middle");
// &"GPN4" @WIRE(mode="straight",linecolor="#30485d",linewidth=0.16) {#XPN4:2 (44,-111)};
// (44.4,-111) @TEXT("GPN4",size=1.1,halign="start",valign="middle");
// &"VDD" @WIRE(mode="straight",linecolor="#30485d",linewidth=0.16) {#XPN4:3 (34,-101)};
// (34,-100.6) @TEXT("VDD",size=1.1,halign="middle",valign="bottom");
// &"VSS" @WIRE(mode="straight",linecolor="#30485d",linewidth=0.16) {#XPN4:4 (34,-121)};
// (34,-121.4) @TEXT("VSS",size=1.1,halign="middle",valign="top");
// &"QN4" @WIRE(mode="straight",linecolor="#30485d",linewidth=0.16) {#XNN4:1 (52,-111)};
// (51.6,-111) @TEXT("QN4",size=1.1,halign="end",valign="middle");
// &"VDD" @WIRE(mode="straight",linecolor="#30485d",linewidth=0.16) {#XNN4:3 (68,-100)};
// (68,-99.6) @TEXT("VDD",size=1.1,halign="middle",valign="bottom");
// &"VSS" @WIRE(mode="straight",linecolor="#30485d",linewidth=0.16) {#XNN4:4 (68,-122)};
// (68,-122.4) @TEXT("VSS",size=1.1,halign="middle",valign="top");
// &"GNP4" @WIRE(mode="straight",linecolor="#30485d",linewidth=0.16) {#WNP4:2 (86,-112.65)};
// (85.6,-112.65) @TEXT("GNP4",size=1.1,halign="end",valign="middle");
// &"GPN4" @WIRE(mode="straight",linecolor="#30485d",linewidth=0.16) {#WPP4:1 (120,-109.35)};
// (119.6,-109.35) @TEXT("GPN4",size=1.1,halign="end",valign="middle");
// &"GPP4" @WIRE(mode="straight",linecolor="#30485d",linewidth=0.16) {#WPP4:2 (120,-112.65)};
// (119.6,-112.65) @TEXT("GPP4",size=1.1,halign="end",valign="middle");
// &"CODE5" @WIRE(mode="straight",linecolor="#30485d",linewidth=0.16) {#XINITIAL5:1 (-10,-139.3)};
// (-10.4,-139.3) @TEXT("CODE5",size=1.1,halign="end",valign="middle");
// &"RUN" @WIRE(mode="straight",linecolor="#30485d",linewidth=0.16) {#XINITIAL5:2 (-10,-142.7)};
// (-10.4,-142.7) @TEXT("RUN",size=1.1,halign="end",valign="middle");
// &"QN5" @WIRE(mode="straight",linecolor="#30485d",linewidth=0.16) {#XINITIAL5:3 (10,-141)};
// (10.4,-141) @TEXT("QN5",size=1.1,halign="start",valign="middle");
// &"VDD" @WIRE(mode="straight",linecolor="#30485d",linewidth=0.16) {#XINITIAL5:4 (0,-131)};
// (0,-130.6) @TEXT("VDD",size=1.1,halign="middle",valign="bottom");
// &"VSS" @WIRE(mode="straight",linecolor="#30485d",linewidth=0.16) {#XINITIAL5:5 (0,-151)};
// (0,-151.4) @TEXT("VSS",size=1.1,halign="middle",valign="top");
// &"QN5" @WIRE(mode="straight",linecolor="#30485d",linewidth=0.16) {#XPN5:1 (24,-141)};
// (23.6,-141) @TEXT("QN5",size=1.1,halign="end",valign="middle");
// &"GPN5" @WIRE(mode="straight",linecolor="#30485d",linewidth=0.16) {#XPN5:2 (44,-141)};
// (44.4,-141) @TEXT("GPN5",size=1.1,halign="start",valign="middle");
// &"VDD" @WIRE(mode="straight",linecolor="#30485d",linewidth=0.16) {#XPN5:3 (34,-131)};
// (34,-130.6) @TEXT("VDD",size=1.1,halign="middle",valign="bottom");
// &"VSS" @WIRE(mode="straight",linecolor="#30485d",linewidth=0.16) {#XPN5:4 (34,-151)};
// (34,-151.4) @TEXT("VSS",size=1.1,halign="middle",valign="top");
// &"QN5" @WIRE(mode="straight",linecolor="#30485d",linewidth=0.16) {#XNN5:1 (52,-141)};
// (51.6,-141) @TEXT("QN5",size=1.1,halign="end",valign="middle");
// &"VDD" @WIRE(mode="straight",linecolor="#30485d",linewidth=0.16) {#XNN5:3 (68,-130)};
// (68,-129.6) @TEXT("VDD",size=1.1,halign="middle",valign="bottom");
// &"VSS" @WIRE(mode="straight",linecolor="#30485d",linewidth=0.16) {#XNN5:4 (68,-152)};
// (68,-152.4) @TEXT("VSS",size=1.1,halign="middle",valign="top");
// &"GNP5" @WIRE(mode="straight",linecolor="#30485d",linewidth=0.16) {#WNP5:2 (86,-142.65)};
// (85.6,-142.65) @TEXT("GNP5",size=1.1,halign="end",valign="middle");
// &"GPN5" @WIRE(mode="straight",linecolor="#30485d",linewidth=0.16) {#WPP5:1 (120,-139.35)};
// (119.6,-139.35) @TEXT("GPN5",size=1.1,halign="end",valign="middle");
// &"GPP5" @WIRE(mode="straight",linecolor="#30485d",linewidth=0.16) {#WPP5:2 (120,-142.65)};
// (119.6,-142.65) @TEXT("GPP5",size=1.1,halign="end",valign="middle");
// &"CODE6" @WIRE(mode="straight",linecolor="#30485d",linewidth=0.16) {#XINITIAL6:1 (-10,-169.3)};
// (-10.4,-169.3) @TEXT("CODE6",size=1.1,halign="end",valign="middle");
// &"RUN" @WIRE(mode="straight",linecolor="#30485d",linewidth=0.16) {#XINITIAL6:2 (-10,-172.7)};
// (-10.4,-172.7) @TEXT("RUN",size=1.1,halign="end",valign="middle");
// &"QN6" @WIRE(mode="straight",linecolor="#30485d",linewidth=0.16) {#XINITIAL6:3 (10,-171)};
// (10.4,-171) @TEXT("QN6",size=1.1,halign="start",valign="middle");
// &"VDD" @WIRE(mode="straight",linecolor="#30485d",linewidth=0.16) {#XINITIAL6:4 (0,-161)};
// (0,-160.6) @TEXT("VDD",size=1.1,halign="middle",valign="bottom");
// &"VSS" @WIRE(mode="straight",linecolor="#30485d",linewidth=0.16) {#XINITIAL6:5 (0,-181)};
// (0,-181.4) @TEXT("VSS",size=1.1,halign="middle",valign="top");
// &"QN6" @WIRE(mode="straight",linecolor="#30485d",linewidth=0.16) {#XPN6:1 (24,-171)};
// (23.6,-171) @TEXT("QN6",size=1.1,halign="end",valign="middle");
// &"GPN6" @WIRE(mode="straight",linecolor="#30485d",linewidth=0.16) {#XPN6:2 (44,-171)};
// (44.4,-171) @TEXT("GPN6",size=1.1,halign="start",valign="middle");
// &"VDD" @WIRE(mode="straight",linecolor="#30485d",linewidth=0.16) {#XPN6:3 (34,-161)};
// (34,-160.6) @TEXT("VDD",size=1.1,halign="middle",valign="bottom");
// &"VSS" @WIRE(mode="straight",linecolor="#30485d",linewidth=0.16) {#XPN6:4 (34,-181)};
// (34,-181.4) @TEXT("VSS",size=1.1,halign="middle",valign="top");
// &"QN6" @WIRE(mode="straight",linecolor="#30485d",linewidth=0.16) {#XNN6:1 (52,-171)};
// (51.6,-171) @TEXT("QN6",size=1.1,halign="end",valign="middle");
// &"VDD" @WIRE(mode="straight",linecolor="#30485d",linewidth=0.16) {#XNN6:3 (68,-160)};
// (68,-159.6) @TEXT("VDD",size=1.1,halign="middle",valign="bottom");
// &"VSS" @WIRE(mode="straight",linecolor="#30485d",linewidth=0.16) {#XNN6:4 (68,-182)};
// (68,-182.4) @TEXT("VSS",size=1.1,halign="middle",valign="top");
// &"GNP6" @WIRE(mode="straight",linecolor="#30485d",linewidth=0.16) {#WNP6:2 (86,-172.65)};
// (85.6,-172.65) @TEXT("GNP6",size=1.1,halign="end",valign="middle");
// &"GPN6" @WIRE(mode="straight",linecolor="#30485d",linewidth=0.16) {#WPP6:1 (120,-169.35)};
// (119.6,-169.35) @TEXT("GPN6",size=1.1,halign="end",valign="middle");
// &"GPP6" @WIRE(mode="straight",linecolor="#30485d",linewidth=0.16) {#WPP6:2 (120,-172.65)};
// (119.6,-172.65) @TEXT("GPP6",size=1.1,halign="end",valign="middle");
// &"CODE7" @WIRE(mode="straight",linecolor="#30485d",linewidth=0.16) {#XINITIAL7_A:1 (-10,-201)};
// (-10.4,-201) @TEXT("CODE7",size=1.1,halign="end",valign="middle");
// &"CODE7_B" @WIRE(mode="straight",linecolor="#30485d",linewidth=0.16) {#XINITIAL7_A:2 (10,-201)};
// (10.4,-201) @TEXT("CODE7_B",size=1.1,halign="start",valign="middle");
// &"VDD" @WIRE(mode="straight",linecolor="#30485d",linewidth=0.16) {#XINITIAL7_A:3 (0,-191)};
// (0,-190.6) @TEXT("VDD",size=1.1,halign="middle",valign="bottom");
// &"VSS" @WIRE(mode="straight",linecolor="#30485d",linewidth=0.16) {#XINITIAL7_A:4 (0,-211)};
// (0,-211.4) @TEXT("VSS",size=1.1,halign="middle",valign="top");
// &"PRESET" @WIRE(mode="straight",linecolor="#30485d",linewidth=0.16) {#XINITIAL7_B:1 (24,-201)};
// (23.6,-201) @TEXT("PRESET",size=1.1,halign="end",valign="middle");
// &"VDD" @WIRE(mode="straight",linecolor="#30485d",linewidth=0.16) {#XINITIAL7_B:3 (34,-191)};
// (34,-190.6) @TEXT("VDD",size=1.1,halign="middle",valign="bottom");
// &"VSS" @WIRE(mode="straight",linecolor="#30485d",linewidth=0.16) {#XINITIAL7_B:4 (34,-211)};
// (34,-211.4) @TEXT("VSS",size=1.1,halign="middle",valign="top");
// &"CODE7_B" @WIRE(mode="straight",linecolor="#30485d",linewidth=0.16) {#XINITIAL7:1 (58,-199.3)};
// (57.6,-199.3) @TEXT("CODE7_B",size=1.1,halign="end",valign="middle");
// &"VDD" @WIRE(mode="straight",linecolor="#30485d",linewidth=0.16) {#XINITIAL7:4 (68,-191)};
// (68,-190.6) @TEXT("VDD",size=1.1,halign="middle",valign="bottom");
// &"VSS" @WIRE(mode="straight",linecolor="#30485d",linewidth=0.16) {#XINITIAL7:5 (68,-211)};
// (68,-211.4) @TEXT("VSS",size=1.1,halign="middle",valign="top");
// &"QN7" @WIRE(mode="straight",linecolor="#30485d",linewidth=0.16) {#XINV7:2 (112,-201)};
// (112.4,-201) @TEXT("QN7",size=1.1,halign="start",valign="middle");
// &"VDD" @WIRE(mode="straight",linecolor="#30485d",linewidth=0.16) {#XINV7:3 (102,-191)};
// (102,-190.6) @TEXT("VDD",size=1.1,halign="middle",valign="bottom");
// &"VSS" @WIRE(mode="straight",linecolor="#30485d",linewidth=0.16) {#XINV7:4 (102,-211)};
// (102,-211.4) @TEXT("VSS",size=1.1,halign="middle",valign="top");
// &"QN7" @WIRE(mode="straight",linecolor="#30485d",linewidth=0.16) {#XPN7:1 (120,-201)};
// (119.6,-201) @TEXT("QN7",size=1.1,halign="end",valign="middle");
// &"GPN7" @WIRE(mode="straight",linecolor="#30485d",linewidth=0.16) {#XPN7:2 (152,-201)};
// (152.4,-201) @TEXT("GPN7",size=1.1,halign="start",valign="middle");
// &"VDD" @WIRE(mode="straight",linecolor="#30485d",linewidth=0.16) {#XPN7:3 (136,-190)};
// (136,-189.6) @TEXT("VDD",size=1.1,halign="middle",valign="bottom");
// &"VSS" @WIRE(mode="straight",linecolor="#30485d",linewidth=0.16) {#XPN7:4 (136,-212)};
// (136,-212.4) @TEXT("VSS",size=1.1,halign="middle",valign="top");
// &"QN7" @WIRE(mode="straight",linecolor="#30485d",linewidth=0.16) {#XNN7:1 (154,-201)};
// (153.6,-201) @TEXT("QN7",size=1.1,halign="end",valign="middle");
// &"VDD" @WIRE(mode="straight",linecolor="#30485d",linewidth=0.16) {#XNN7:3 (170,-190)};
// (170,-189.6) @TEXT("VDD",size=1.1,halign="middle",valign="bottom");
// &"VSS" @WIRE(mode="straight",linecolor="#30485d",linewidth=0.16) {#XNN7:4 (170,-212)};
// (170,-212.4) @TEXT("VSS",size=1.1,halign="middle",valign="top");
// &"GNP7" @WIRE(mode="straight",linecolor="#30485d",linewidth=0.16) {#WNP7:2 (188,-202.65)};
// (187.6,-202.65) @TEXT("GNP7",size=1.1,halign="end",valign="middle");
// &"GPN7" @WIRE(mode="straight",linecolor="#30485d",linewidth=0.16) {#WPP7:1 (222,-199.35)};
// (221.6,-199.35) @TEXT("GPN7",size=1.1,halign="end",valign="middle");
// &"GPP7" @WIRE(mode="straight",linecolor="#30485d",linewidth=0.16) {#WPP7:2 (222,-202.65)};
// (221.6,-202.65) @TEXT("GPP7",size=1.1,halign="end",valign="middle");
// &"RST_DONE" @WIRE(mode="straight",linecolor="#30485d",linewidth=0.16) {#WUNUSED:1 (18,43.65)};
// (17.6,43.65) @TEXT("RST_DONE",size=1.1,halign="end",valign="middle");
// &"VSS" @WIRE(mode="straight",linecolor="#30485d",linewidth=0.16) {#WUNUSED:2 (18,40.35)};
// (17.6,40.35) @TEXT("VSS",size=1.1,halign="end",valign="middle");
// }
// END SARADC RNL
ends sar8i_refword
