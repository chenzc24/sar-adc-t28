// Native-cell reference decoding and complementary gate drives for the single-edge top.
subckt sar8i_refword CODE0 CODE1 CODE2 CODE3 CODE4 CODE5 CODE6 CODE7 D0 D1  D2 D3 D4 D5 D6 D7 GNN0 GNN1 GNN2 GNN3 GNN4 GNN5 GNN6 GNN7 GNP0  GNP1 GNP2 GNP3 GNP4 GNP5 GNP6 GNP7 GPN0 GPN1 GPN2 GPN3 GPN4 GPN5  GPN6 GPN7 GPP0 GPP1 GPP2 GPP3 GPP4 GPP5 GPP6 GPP7 PHI_U SAMPLE VDD  VSS RST_DONE PRESET
XPRESET_N (PRESET RUN VDD VSS) INVD1BWP12T30P140
XINITIAL0 (CODE0 RUN QN0 VDD VSS) ND2D1BWP12T30P140
XPN0 (QN0 GPN0 VDD VSS) INVD1BWP12T30P140
XNN0 (QN0 GNN0 VDD VSS) BUFFD1BWP12T30P140
WNP0 (GNN0 GNP0) iprobe
WPP0 (GPN0 GPP0) iprobe
XINITIAL1 (CODE1 RUN QN1 VDD VSS) ND2D1BWP12T30P140
XPN1 (QN1 GPN1 VDD VSS) INVD1BWP12T30P140
XNN1 (QN1 GNN1 VDD VSS) BUFFD1BWP12T30P140
WNP1 (GNN1 GNP1) iprobe
WPP1 (GPN1 GPP1) iprobe
XINITIAL2 (CODE2 RUN QN2 VDD VSS) ND2D1BWP12T30P140
XPN2 (QN2 GPN2 VDD VSS) INVD1BWP12T30P140
XNN2 (QN2 GNN2 VDD VSS) BUFFD1BWP12T30P140
WNP2 (GNN2 GNP2) iprobe
WPP2 (GPN2 GPP2) iprobe
XINITIAL3 (CODE3 RUN QN3 VDD VSS) ND2D1BWP12T30P140
XPN3 (QN3 GPN3 VDD VSS) INVD1BWP12T30P140
XNN3 (QN3 GNN3 VDD VSS) BUFFD1BWP12T30P140
WNP3 (GNN3 GNP3) iprobe
WPP3 (GPN3 GPP3) iprobe
XINITIAL4 (CODE4 RUN QN4 VDD VSS) ND2D1BWP12T30P140
XPN4 (QN4 GPN4 VDD VSS) INVD1BWP12T30P140
XNN4 (QN4 GNN4 VDD VSS) BUFFD1BWP12T30P140
WNP4 (GNN4 GNP4) iprobe
WPP4 (GPN4 GPP4) iprobe
XINITIAL5 (CODE5 RUN QN5 VDD VSS) ND2D1BWP12T30P140
XPN5 (QN5 GPN5 VDD VSS) INVD1BWP12T30P140
XNN5 (QN5 GNN5 VDD VSS) BUFFD1BWP12T30P140
WNP5 (GNN5 GNP5) iprobe
WPP5 (GPN5 GPP5) iprobe
XINITIAL6 (CODE6 RUN QN6 VDD VSS) ND2D1BWP12T30P140
XPN6 (QN6 GPN6 VDD VSS) INVD1BWP12T30P140
XNN6 (QN6 GNN6 VDD VSS) BUFFD1BWP12T30P140
WNP6 (GNN6 GNP6) iprobe
WPP6 (GPN6 GPP6) iprobe
XINITIAL7 (CODE7 PRESET Q7 VDD VSS) OR2D1BWP12T30P140
XINV7 (Q7 QN7 VDD VSS) INVD1BWP12T30P140
XPN7 (QN7 GPN7 VDD VSS) INVD2BWP12T30P140
XNN7 (QN7 GNN7 VDD VSS) BUFFD2BWP12T30P140
WNP7 (GNN7 GNP7) iprobe
WPP7 (GPN7 GPP7) iprobe
WUNUSED (RST_DONE VSS) iprobe
ends sar8i_refword
