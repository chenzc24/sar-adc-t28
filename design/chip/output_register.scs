// Chip-level output register XOREG (Layout/design/io_ring.json chip_netlist, decisions.data_outputs).
// Eight flip-flops on DVDD/VSS capture ADC_D0-ADC_D7 on the rising edge of SAMPLE_CORE and drive the
// PRUW08SDGZ I pins (D0_CORE-D7_CORE). All devices are native tcbn28hpcplusbwp12t30p140 cells.
// Clocking (user decision 2026-11-22): every CP pin taps SAMPLE_CORE directly, with no clock buffer, and a
// DEL250D1 on each D input holds the captured word while the SAR clears ADC_D on the same edge
// (D_i = CODE_i AND DONE; DONE resets while SAMPLE is high). Setup has the SAR's conversion slack.
// No reset: the word is undefined until the first SAMPLE rising edge after power-up.
simulator lang=spectre
subckt sar8_out_reg D0 D1 D2 D3 D4 D5 D6 D7 Q0 Q1 Q2 Q3 Q4 Q5 Q6 Q7 CK VDD VSS
XDEL0 (D0 DD0 VDD VSS) DEL250D1BWP12T30P140
XDEL1 (D1 DD1 VDD VSS) DEL250D1BWP12T30P140
XDEL2 (D2 DD2 VDD VSS) DEL250D1BWP12T30P140
XDEL3 (D3 DD3 VDD VSS) DEL250D1BWP12T30P140
XDEL4 (D4 DD4 VDD VSS) DEL250D1BWP12T30P140
XDEL5 (D5 DD5 VDD VSS) DEL250D1BWP12T30P140
XDEL6 (D6 DD6 VDD VSS) DEL250D1BWP12T30P140
XDEL7 (D7 DD7 VDD VSS) DEL250D1BWP12T30P140
XFF0 (DD0 CK QI0 VDD VSS) DFQD1BWP12T30P140
XFF1 (DD1 CK QI1 VDD VSS) DFQD1BWP12T30P140
XFF2 (DD2 CK QI2 VDD VSS) DFQD1BWP12T30P140
XFF3 (DD3 CK QI3 VDD VSS) DFQD1BWP12T30P140
XFF4 (DD4 CK QI4 VDD VSS) DFQD1BWP12T30P140
XFF5 (DD5 CK QI5 VDD VSS) DFQD1BWP12T30P140
XFF6 (DD6 CK QI6 VDD VSS) DFQD1BWP12T30P140
XFF7 (DD7 CK QI7 VDD VSS) DFQD1BWP12T30P140
XBUF0 (QI0 Q0 VDD VSS) BUFFD4BWP12T30P140
XBUF1 (QI1 Q1 VDD VSS) BUFFD4BWP12T30P140
XBUF2 (QI2 Q2 VDD VSS) BUFFD4BWP12T30P140
XBUF3 (QI3 Q3 VDD VSS) BUFFD4BWP12T30P140
XBUF4 (QI4 Q4 VDD VSS) BUFFD4BWP12T30P140
XBUF5 (QI5 Q5 VDD VSS) BUFFD4BWP12T30P140
XBUF6 (QI6 Q6 VDD VSS) BUFFD4BWP12T30P140
XBUF7 (QI7 Q7 VDD VSS) BUFFD4BWP12T30P140
ends sar8_out_reg
