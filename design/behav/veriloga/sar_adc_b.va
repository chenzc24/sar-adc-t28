`include "constants.vams"
`include "disciplines.vams"
`include "b_defaults.vh"

module sar_adc_b(D0,D1,D2,D3,D4,D5,D6,D7,SAMPLE,VDD,VINN,VINP,VREFN,VREFP,VSS);
    input SAMPLE,VDD;
    output D0,D1,D2,D3,D4,D5,D6,D7;
    inout VINN,VINP,VREFN,VREFP,VSS;
    electrical D0,D1,D2,D3,D4,D5,D6,D7,SAMPLE,VDD,VINN,VINP,VREFN,VREFP,VSS;
    parameter integer model_id=0;
    parameter real comparator_offset_v=0;
    parameter integer force_stuck=0;
    electrical sample_int,sample_match,seq_sample,active,preset,cmp_clk,comp_n,comp_p,phi_u,rst_done,topn,topp;
    electrical code0,code1,code2,code3,code4,code5,code6,code7,gnn0,gnn1,gnn2,gnn3,gnn4,gnn5,gnn6,gnn7,gnp0,gnp1,gnp2,gnp3,gnp4,gnp5,gnp6,gnp7,gpn0,gpn1,gpn2,gpn3,gpn4,gpn5,gpn6,gpn7,gpp0,gpp1,gpp2,gpp3,gpp4,gpp5,gpp6,gpp7;
    b_edge #(.delay_s(`B_SAMPLE_BUFFER_S)) XSAMPLE (SAMPLE,VDD,VSS,sample_int);
    b_idle XIDLE (active,sample_int,VDD,VSS,preset,sample_match);
    b_edge XSEQ (sample_match,VDD,VSS,seq_sample);
    b_sampler XBOOTN (seq_sample,topn,VINN,VDD,VSS);
    b_sampler XBOOTP (seq_sample,topp,VINP,VDD,VSS);
    b_cdac  XCDAC (gnn0,gnn1,gnn2,gnn3,gnn4,gnn5,gnn6,gnn7,gnp0,gnp1,gnp2,gnp3,gnp4,gnp5,gnp6,gnp7,gpn0,gpn1,gpn2,gpn3,gpn4,gpn5,gpn6,gpn7,gpp0,gpp1,gpp2,gpp3,gpp4,gpp5,gpp6,gpp7,topn,topp,VDD,VREFN,VREFP,VSS);
    b_sar #(.model_id(model_id)) XCTRL (cmp_clk,code0,code1,code2,code3,code4,code5,code6,code7,comp_n,comp_p,D0,D1,D2,D3,D4,D5,D6,D7,phi_u,sample_int,VDD,VSS,active);
    b_reference  XREF (code0,code1,code2,code3,code4,code5,code6,code7,D0,D1,D2,D3,D4,D5,D6,D7,gnn0,gnn1,gnn2,gnn3,gnn4,gnn5,gnn6,gnn7,gnp0,gnp1,gnp2,gnp3,gnp4,gnp5,gnp6,gnp7,gpn0,gpn1,gpn2,gpn3,gpn4,gpn5,gpn6,gpn7,gpp0,gpp1,gpp2,gpp3,gpp4,gpp5,gpp6,gpp7,phi_u,sample_int,VDD,VSS,rst_done,preset);
    b_comparator #(.offset_v(comparator_offset_v),.force_stuck(force_stuck)) XCOMP (cmp_clk,comp_n,comp_p,VDD,topn,topp,VSS);
endmodule
