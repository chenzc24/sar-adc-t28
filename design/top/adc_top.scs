// Single-edge ADC top. Electrical statements are authoritative; RNL comments are drawing only.
// BEGIN SARADC RNL
// @RNL(type="header") { @VERSION("0.3");
// @USE-PACKAGE(name="sar8",version="0.1",path="../rnl/sar8.rnl");
// @USE-PACKAGE(name="rnl-std-fill") {}; }
// END SARADC RNL
subckt sar_adc8_join_r4 D0 D1 D2 D3 D4 D5 D6 D7 SAMPLE VDD! VINN VINP  VREFN VREFP 0
    XSEQ (SAMPLE_INT VDD! 0 SEQ_SAMPLE) sar8_se_acquire
    XDONE (ACTIVE DONE VDD! 0) INVD1BWP12T30P140
    XPRESET (DONE SEQ_SAMPLE PRESET VDD! 0) OR2D1BWP12T30P140
    XSAMPLE (SAMPLE SAMPLE_INT VDD! 0) CKBD1BWP12T30P140
    XBOOTN (SEQ_SAMPLE TOPN VINN) sar_bootstrap_flat_8b_p
    XBOOTP (SEQ_SAMPLE TOPP VINP) sar_bootstrap_flat_8b_p
    XCDAC (REFSEL_N0 REFSEL_N1 REFSEL_N2 REFSEL_N3 REFSEL_N4 REFSEL_N5 REFSEL_N6 REFSEL_N7 REFSEL_P0 REFSEL_P1 REFSEL_P2 REFSEL_P3 REFSEL_P4 REFSEL_P5 REFSEL_P6 REFSEL_P7 TOPN TOPP VDD! VREFN VREFP 0)  sar8j_r1_cdac
    XCTRL (CMP_CLK CODE0 CODE1 CODE2 CODE3 CODE4 CODE5 CODE6 CODE7 COMP_N  COMP_P D0 D1 D2 D3 D4 D5 D6 D7 PHI_U SEQ_SAMPLE VDD! 0 ACTIVE) sar8_se_ctrl
    XREF (CODE0 CODE1 CODE2 CODE3 CODE4 CODE5 CODE6 CODE7 REFSEL_N0 REFSEL_N1 REFSEL_N2 REFSEL_N3 REFSEL_N4 REFSEL_N5 REFSEL_N6 REFSEL_N7 REFSEL_P0 REFSEL_P1 REFSEL_P2 REFSEL_P3 REFSEL_P4 REFSEL_P5 REFSEL_P6 REFSEL_P7 VDD! 0 PRESET)  sar8i_refword
    XCOMP (CMP_CLK COMP_N COMP_P VDD! TOPN TOPP 0) sar_strongarm_t28
    CL_COMP_N (COMP_N 0) cfmom_2t nr=8 lr=2.5u w=50n s=50n stm=1 spm=3  multi=2 mismatchflag=1
    CL_COMP_P (COMP_P 0) cfmom_2t nr=8 lr=2.5u w=50n s=50n stm=1 spm=3  multi=2 mismatchflag=1
    CL_CMP_CLK (CMP_CLK 0) cfmom_2t nr=8 lr=2.5u w=50n s=50n stm=1 spm=3  multi=2 mismatchflag=1
// BEGIN SARADC RNL
// @RNL(author="saradc topology") {
// (-24,68) @TEXT("SAR8 / Asynchronous differential ADC",size=2.7,halign="start",textcolor="#223d52");
// (-15,60) @TEXT("Acquisition",size=1.4,halign="start",textcolor="#223d52");
// (65,60) @TEXT("Reference preset",size=1.4,halign="start",textcolor="#223d52");
// #XSAMPLE @SET-SYMBOL $S_CKBD1BWP12T30P140;
// #XSAMPLE @PLACE(0,46) => @ORIENT("R0");
// #XSEQ @SET-SYMBOL $S_sar8_se_acquire;
// #XSEQ @PLACE(29,46) => @ORIENT("R0");
// #XDONE @SET-SYMBOL $S_INVD1BWP12T30P140;
// #XDONE @PLACE(77,46) => @ORIENT("R0");
// #XPRESET @SET-SYMBOL $S_OR2D1BWP12T30P140;
// #XPRESET @PLACE(112,46) => @ORIENT("R0");
// #XBOOTP @SET-SYMBOL $S_sar_bootstrap_flat_8b_p;
// #XBOOTP @PLACE(0,24) => @ORIENT("R0");
// #XBOOTN @SET-SYMBOL $S_sar_bootstrap_flat_8b_p;
// #XBOOTN @PLACE(0,3) => @ORIENT("MX");
// #XCOMP @SET-SYMBOL $S_sar_strongarm_t28;
// #XCOMP @PLACE(67,13) => @ORIENT("R0");
// #XCTRL @SET-SYMBOL $S_sar8_se_ctrl;
// #XCTRL @PLACE(111,13) => @ORIENT("R0");
// #XCDAC @SET-SYMBOL $S_sar8j_r1_cdac;
// #XCDAC @PLACE(36,-11) => @ORIENT("R0");
// #XREF @SET-SYMBOL $S_sar8i_refword;
// #XREF @PLACE(36,-38) => @ORIENT("R0");
// #CL_COMP_P @SET-SYMBOL $CAPACITOR;
// #CL_COMP_P @PLACE(88,23) => @ORIENT("MX");
// #CL_COMP_P @TEXT("CL_COMP_P",key="name",size=1.3,halign="start") => @PLACE(91,26);
// #CL_COMP_P @TEXT("nr=8 lr=2.5u w=50n multi=2",key="value",size=0.9,halign="start") => @PLACE(91,19);
// #CL_COMP_P @TEXT("",key="model");
// #CL_COMP_N @SET-SYMBOL $CAPACITOR;
// #CL_COMP_N @PLACE(84,3) => @ORIENT("R0");
// #CL_COMP_N @TEXT("CL_COMP_N",key="name",size=1.3,halign="start") => @PLACE(87,6);
// #CL_COMP_N @TEXT("nr=8 lr=2.5u w=50n multi=2",key="value",size=0.9,halign="start") => @PLACE(87,-1);
// #CL_COMP_N @TEXT("",key="model");
// #CL_CMP_CLK @SET-SYMBOL $CAPACITOR;
// #CL_CMP_CLK @PLACE(92,36) => @ORIENT("MX");
// #CL_CMP_CLK @TEXT("CL_CMP_CLK",key="name",size=1.3,halign="start") => @PLACE(95,39);
// #CL_CMP_CLK @TEXT("nr=8 lr=2.5u w=50n multi=2",key="value",size=0.9,halign="start") => @PLACE(95,32);
// #CL_CMP_CLK @TEXT("",key="model");
// #XSAMPLE @TEXT("Sample buffer",key="name",size=1.65,halign="middle",textcolor="#223d52") => @PLACE(0,46);
// #XSAMPLE @TEXT("",key="model");
// #XSEQ @TEXT("Track control",key="name",size=1.65,halign="middle",textcolor="#223d52") => @PLACE(29,48.7);
// #XSEQ @TEXT("",key="model");
// #XDONE @TEXT("Done",key="name",size=1.65,halign="middle",textcolor="#223d52") => @PLACE(77,54);
// #XDONE @TEXT("",key="model");
// #XPRESET @TEXT("Preset",key="name",size=1.65,halign="middle",textcolor="#223d52") => @PLACE(112,54);
// #XPRESET @TEXT("",key="model");
// #XBOOTP @TEXT("Bootstrap P",key="name",size=1.65,halign="middle",textcolor="#223d52") => @PLACE(0,24);
// #XBOOTP @TEXT("",key="model");
// #XBOOTN @TEXT("Bootstrap N",key="name",size=1.65,halign="middle",textcolor="#223d52") => @PLACE(0,3);
// #XBOOTN @TEXT("",key="model");
// #XCOMP @TEXT("StrongARM",key="name",size=1.65,halign="middle",textcolor="#223d52") => @PLACE(67,13);
// #XCOMP @TEXT("",key="model");
// #XCTRL @TEXT("SAR",key="name",size=1.65,halign="middle",textcolor="#223d52") => @PLACE(111,13);
// #XCTRL @TEXT("",key="model");
// #XCDAC @TEXT("MOM CDAC",key="name",size=1.65,halign="middle",textcolor="#223d52") => @PLACE(36,-11);
// #XCDAC @TEXT("",key="model");
// #XREF @TEXT("Reference driver",key="name",size=1.65,halign="middle",textcolor="#223d52") => @PLACE(36,-35.5);
// #XREF @TEXT("",key="model");
// #CL_COMP_P @TEXT("C_P",key="name",size=1.05,halign="start") => @PLACE(91,26);
// #CL_COMP_P @TEXT("",key="value");
// #CL_COMP_N @TEXT("C_N",key="name",size=1.05,halign="start") => @PLACE(87,6);
// #CL_COMP_N @TEXT("",key="value");
// #CL_CMP_CLK @TEXT("C_CLK",key="name",size=1.05,halign="start") => @PLACE(95,39);
// #CL_CMP_CLK @TEXT("",key="value");
// %sar_port1 = $IO_PORT @ATTACH &"SAMPLE" => @PLACE(-23,46);
// &"SAMPLE" @WIRE(mode="straight",linecolor="#94601a",linewidth=0.16) {%sar_port1:p #XSAMPLE:1};
// &"SAMPLE_INT" @WIRE(mode="straight",linecolor="#30485d",linewidth=0.16) {#XSAMPLE:2 (14.5,46) (14.5,46) #XSEQ:1};
// &"DONE" @WIRE(mode="straight",linecolor="#30485d",linewidth=0.16) {#XDONE:2 (94.5,46) (94.5,47.7) #XPRESET:1};
// %sar_port2 = $IO_PORT @ATTACH &"VINP" => @PLACE(-25,22.35);
// &"VINP" @WIRE(mode="straight",linecolor="#226e85",linewidth=0.16) {%sar_port2:p #XBOOTP:3};
// %sar_port3 = $IO_PORT @ATTACH &"VINN" => @PLACE(-25,4.65);
// &"VINN" @WIRE(mode="straight",linecolor="#226e85",linewidth=0.16) {%sar_port3:p #XBOOTN:3};
// %sar_port4 = $IO_PORT @ATTACH &"VREFP" => @PLACE(11,-9.35);
// &"VREFP" @WIRE(mode="straight",linecolor="#226e85",linewidth=0.16) {%sar_port4:p #XCDAC:21};
// %sar_port5 = $IO_PORT @ATTACH &"VREFN" => @PLACE(11,-12.65);
// &"VREFN" @WIRE(mode="straight",linecolor="#226e85",linewidth=0.16) {%sar_port5:p #XCDAC:20};
// %sar_junction6 = (28,24);
// %sar_junction6 @CIRCLE(radius=0.34,linecolor="#30485d",fill="fillcolor",fillcolor="#30485d") => @LAYER("top");
// &"TOPP" @WIRE(mode="straight",linecolor="#226e85",linewidth=0.16) {#XBOOTP:2 %sar_junction6 (46,24) (46,14.65) #XCOMP:6};
// &"TOPP" @WIRE(mode="straight",linecolor="#226e85",linewidth=0.16) {%sar_junction6 #XCDAC:18};
// (30,25.8) @TEXT("TOPP",size=1.1,halign="start",textcolor="#223d52");
// %sar_junction7 = (44,3);
// %sar_junction7 @CIRCLE(radius=0.34,linecolor="#30485d",fill="fillcolor",fillcolor="#30485d") => @LAYER("top");
// &"TOPN" @WIRE(mode="straight",linecolor="#226e85",linewidth=0.16) {#XBOOTN:2 %sar_junction7 (46,3) (46,11.35) #XCOMP:5};
// &"TOPN" @WIRE(mode="straight",linecolor="#226e85",linewidth=0.16) {%sar_junction7 #XCDAC:17};
// (32,4.8) @TEXT("TOPN",size=1.1,halign="start",textcolor="#223d52");
// %sar_junction8 = (88,14.65);
// %sar_junction8 @CIRCLE(radius=0.34,linecolor="#30485d",fill="fillcolor",fillcolor="#30485d") => @LAYER("top");
// &"COMP_P" @WIRE(mode="straight",linecolor="#226e85",linewidth=0.16) {#XCOMP:3 %sar_junction8 (92,14.65) (92,16.3) #XCTRL:11};
// &"COMP_P" @WIRE(mode="straight",linecolor="#226e85",linewidth=0.16) {%sar_junction8 #CL_COMP_P:1};
// %sar_junction9 = (84,11.35);
// %sar_junction9 @CIRCLE(radius=0.34,linecolor="#30485d",fill="fillcolor",fillcolor="#30485d") => @LAYER("top");
// &"COMP_N" @WIRE(mode="straight",linecolor="#226e85",linewidth=0.16) {#XCOMP:2 %sar_junction9 (92,11.35) (92,13) #XCTRL:10};
// &"COMP_N" @WIRE(mode="straight",linecolor="#226e85",linewidth=0.16) {%sar_junction9 #CL_COMP_N:1};
// %sar_junction10 = (92,31);
// %sar_junction10 @CIRCLE(radius=0.34,linecolor="#30485d",fill="fillcolor",fillcolor="#30485d") => @LAYER("top");
// &"CMP_CLK" @WIRE(mode="straight",linecolor="#94601a",linewidth=0.16) {#XCOMP:1 (63,31) %sar_junction10 (107,31) #XCTRL:1};
// &"CMP_CLK" @WIRE(mode="straight",linecolor="#94601a",linewidth=0.16) {%sar_junction10 #CL_CMP_CLK:1};
// (70,32.8) @TEXT("CMP_CLK",size=1,halign="start",textcolor="#223d52");
// {&"REFSEL_N0" &"REFSEL_N1" &"REFSEL_N2" &"REFSEL_N3" &"REFSEL_N4" &"REFSEL_N5" &"REFSEL_N6" &"REFSEL_N7"} @WIRE(mode="straight",linewidth=0.24,linecolor="#536f4b") {#XREF:9  #XCDAC:1};
// {&"REFSEL_P0" &"REFSEL_P1" &"REFSEL_P2" &"REFSEL_P3" &"REFSEL_P4" &"REFSEL_P5" &"REFSEL_P6" &"REFSEL_P7"} @WIRE(mode="straight",linewidth=0.24,linecolor="#536f4b") {#XREF:17  #XCDAC:9};
// {&"CODE0" &"CODE1" &"CODE2" &"CODE3" &"CODE4" &"CODE5" &"CODE6" &"CODE7"} @WIRE(mode="straight",linewidth=0.24,linecolor="#66538a") {#XCTRL:2 (107,-29) (58,-29) (58,-38) #XREF:1};
// (72,-27.2) @TEXT("CODE[7:0]",size=1.1,halign="start",textcolor="#223d52");
// &"VDD!" @WIRE(mode="straight",linecolor="#30485d",linewidth=0.16) {#XSEQ:2 (29,57)};
// (29,57.4) @TEXT("VDD!",size=1.1,halign="middle",valign="bottom");
// &"0" @WIRE(mode="straight",linecolor="#30485d",linewidth=0.16) {#XSEQ:3 (29,35)};
// (29,34.6) @TEXT("0",size=1.1,halign="middle",valign="top");
// &"SEQ_SAMPLE" @WIRE(mode="straight",linecolor="#30485d",linewidth=0.16) {#XSEQ:4 (45,46)};
// (45.4,46) @TEXT("SEQ_SAMPLE",size=1.1,halign="start",valign="middle");
// &"ACTIVE" @WIRE(mode="straight",linecolor="#30485d",linewidth=0.16) {#XDONE:1 (67,46)};
// (66.6,46) @TEXT("ACTIVE",size=1.1,halign="end",valign="middle");
// &"VDD!" @WIRE(mode="straight",linecolor="#30485d",linewidth=0.16) {#XDONE:3 (77,56)};
// (77,56.4) @TEXT("VDD!",size=1.1,halign="middle",valign="bottom");
// &"0" @WIRE(mode="straight",linecolor="#30485d",linewidth=0.16) {#XDONE:4 (77,36)};
// (77,35.6) @TEXT("0",size=1.1,halign="middle",valign="top");
// &"SEQ_SAMPLE" @WIRE(mode="straight",linecolor="#30485d",linewidth=0.16) {#XPRESET:2 (102,44.3)};
// (101.6,44.3) @TEXT("SEQ_SAMPLE",size=1.1,halign="end",valign="middle");
// &"PRESET" @WIRE(mode="straight",linecolor="#30485d",linewidth=0.16) {#XPRESET:3 (122,46)};
// (122.4,46) @TEXT("PRESET",size=1.1,halign="start",valign="middle");
// &"VDD!" @WIRE(mode="straight",linecolor="#30485d",linewidth=0.16) {#XPRESET:4 (112,56)};
// (112,56.4) @TEXT("VDD!",size=1.1,halign="middle",valign="bottom");
// &"0" @WIRE(mode="straight",linecolor="#30485d",linewidth=0.16) {#XPRESET:5 (112,36)};
// (112,35.6) @TEXT("0",size=1.1,halign="middle",valign="top");
// &"VDD!" @WIRE(mode="straight",linecolor="#30485d",linewidth=0.16) {#XSAMPLE:3 (0,57)};
// (0,57.4) @TEXT("VDD!",size=1.1,halign="middle",valign="bottom");
// &"0" @WIRE(mode="straight",linecolor="#30485d",linewidth=0.16) {#XSAMPLE:4 (0,35)};
// (0,34.6) @TEXT("0",size=1.1,halign="middle",valign="top");
// &"SEQ_SAMPLE" @WIRE(mode="straight",linecolor="#30485d",linewidth=0.16) {#XBOOTN:1 (-18,1.35)};
// (-18.4,1.35) @TEXT("SEQ_SAMPLE",size=1.1,halign="end",valign="middle");
// &"SEQ_SAMPLE" @WIRE(mode="straight",linecolor="#30485d",linewidth=0.16) {#XBOOTP:1 (-18,25.65)};
// (-18.4,25.65) @TEXT("SEQ_SAMPLE",size=1.1,halign="end",valign="middle");
// &"VDD!" @WIRE(mode="straight",linecolor="#30485d",linewidth=0.16) {#XCDAC:19 (36,0)};
// (36,0.4) @TEXT("VDD!",size=1.1,halign="middle",valign="bottom");
// &"0" @WIRE(mode="straight",linecolor="#30485d",linewidth=0.16) {#XCDAC:22 (36,-22)};
// (36,-22.4) @TEXT("0",size=1.1,halign="middle",valign="top");
// {&"D0" &"D1" &"D2" &"D3" &"D4" &"D5" &"D6" &"D7"} @WIRE(mode="straight",linewidth=0.3) {#XCTRL:12 (129,16.3)};
// (129.4,16.3) @TEXT("D[7:0]",size=1.1,halign="start",valign="middle");
// &"PHI_U" @WIRE(mode="straight",linecolor="#30485d",linewidth=0.16) {#XCTRL:20 (129,9.7)};
// (129.4,9.7) @TEXT("PHI_U",size=1.1,halign="start",valign="middle");
// &"SEQ_SAMPLE" @WIRE(mode="straight",linecolor="#30485d",linewidth=0.16) {#XCTRL:21 (93,9.7)};
// (92.6,9.7) @TEXT("SEQ_SAMPLE",size=1.1,halign="end",valign="middle");
// &"VDD!" @WIRE(mode="straight",linecolor="#30485d",linewidth=0.16) {#XCTRL:22 (115,24.6)};
// (115,25) @TEXT("VDD!",size=1.1,halign="middle",valign="bottom");
// &"0" @WIRE(mode="straight",linecolor="#30485d",linewidth=0.16) {#XCTRL:23 (115,1.4)};
// (115,1) @TEXT("0",size=1.1,halign="middle",valign="top");
// &"ACTIVE" @WIRE(mode="straight",linecolor="#30485d",linewidth=0.16) {#XCTRL:24 (129,13)};
// (129.4,13) @TEXT("ACTIVE",size=1.1,halign="start",valign="middle");
// &"VDD!" @WIRE(mode="straight",linecolor="#30485d",linewidth=0.16) {#XREF:25 (36,-27)};
// (36,-26.6) @TEXT("VDD!",size=1.1,halign="middle",valign="bottom");
// &"0" @WIRE(mode="straight",linecolor="#30485d",linewidth=0.16) {#XREF:26 (36,-49)};
// (36,-49.4) @TEXT("0",size=1.1,halign="middle",valign="top");
// &"PRESET" @WIRE(mode="straight",linecolor="#30485d",linewidth=0.16) {#XREF:27 (18,-38)};
// (17.6,-38) @TEXT("PRESET",size=1.1,halign="end",valign="middle");
// &"VDD!" @WIRE(mode="straight",linecolor="#30485d",linewidth=0.16) {#XCOMP:4 (71,24)};
// (71,24.4) @TEXT("VDD!",size=1.1,halign="middle",valign="bottom");
// &"0" @WIRE(mode="straight",linecolor="#30485d",linewidth=0.16) {#XCOMP:7 (67,2)};
// (67,1.6) @TEXT("0",size=1.1,halign="middle",valign="top");
// &"0" @WIRE(mode="straight",linecolor="#30485d",linewidth=0.16) {#CL_COMP_N:2 (84,-2)};
// (84,-2.4) @TEXT("0",size=1.1,halign="middle",valign="top");
// &"0" @WIRE(mode="straight",linecolor="#30485d",linewidth=0.16) {#CL_COMP_P:2 (88,28)};
// (88,28.4) @TEXT("0",size=1.1,halign="middle",valign="bottom");
// &"0" @WIRE(mode="straight",linecolor="#30485d",linewidth=0.16) {#CL_CMP_CLK:2 (92,41)};
// (92,41.4) @TEXT("0",size=1.1,halign="middle",valign="bottom");
// }
// END SARADC RNL
ends sar_adc8_join_r4
