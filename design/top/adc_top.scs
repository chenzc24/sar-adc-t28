// Single-edge ADC top. Electrical statements are authoritative; RNL comments are drawing only.
// BEGIN SARADC RNL
// @RNL(type="header") { @VERSION("0.3");
// @USE-PACKAGE(name="sar8",version="0.1",path="../rnl/sar8.rnl");
// @USE-PACKAGE(name="rnl-std-fill") {}; }
// END SARADC RNL
subckt sar_adc8_join_r4 D0 D1 D2 D3 D4 D5 D6 D7 SAMPLE VDD! VINN VINP  VREFN VREFP 0
    XSEQ (SAMPLE_INT VDD! 0 SEQ_SAMPLE) sar8_se_acquire
    XDONE (ACTIVE DONE VDD! 0) INVD1BWP12T30P140
    XPRESET (DONE SEQ_SAMPLE PRESET VDD! 0) OR2D1BWP12T30P140
    XSAMPLE (SAMPLE SAMPLE_INT VDD! 0) CKBD1BWP12T30P140
    XBOOTN (SEQ_SAMPLE TOPN VINN) sar_bootstrap_flat_8b_p
    XBOOTP (SEQ_SAMPLE TOPP VINP) sar_bootstrap_flat_8b_p
    XCDAC (GNN0 GNN1 GNN2 GNN3 GNN4 GNN5 GNN6 GNN7 GNP0 GNP1 GNP2 GNP3  GNP4 GNP5 GNP6 GNP7 GPN0 GPN1 GPN2 GPN3 GPN4 GPN5 GPN6 GPN7 GPP0  GPP1 GPP2 GPP3 GPP4 GPP5 GPP6 GPP7 TOPN TOPP VDD! VREFN VREFP 0)  sar8j_r1_cdac
    XCTRL (CMP_CLK CODE0 CODE1 CODE2 CODE3 CODE4 CODE5 CODE6 CODE7 COMP_N  COMP_P D0 D1 D2 D3 D4 D5 D6 D7 PHI_U SEQ_SAMPLE VDD! 0 ACTIVE) sar8_se_ctrl
    XREF (CODE0 CODE1 CODE2 CODE3 CODE4 CODE5 CODE6 CODE7 D0 D1 D2 D3 D4  D5 D6 D7 GNN0 GNN1 GNN2 GNN3 GNN4 GNN5 GNN6 GNN7 GNP0 GNP1 GNP2  GNP3 GNP4 GNP5 GNP6 GNP7 GPN0 GPN1 GPN2 GPN3 GPN4 GPN5 GPN6 GPN7  GPP0 GPP1 GPP2 GPP3 GPP4 GPP5 GPP6 GPP7 PHI_U SAMPLE_INT VDD! 0 RST_DONE PRESET)  sar8i_refword
    XCOMP (CMP_CLK COMP_N COMP_P VDD! TOPN TOPP 0) sar_strongarm_t28
    CL_COMP_N (COMP_N 0) cfmom_2t nr=8 lr=2.5u w=50n s=50n stm=1 spm=3  multi=2 mismatchflag=1
    CL_COMP_P (COMP_P 0) cfmom_2t nr=8 lr=2.5u w=50n s=50n stm=1 spm=3  multi=2 mismatchflag=1
    CL_CMP_CLK (CMP_CLK 0) cfmom_2t nr=8 lr=2.5u w=50n s=50n stm=1 spm=3  multi=2 mismatchflag=1
// BEGIN SARADC RNL
// @RNL(author="saradc topology") {
// (-29,84) @TEXT("SAR8   /   Asynchronous differential ADC",size=2.75,halign="start",textcolor="#223d52");
// (-29,76) @TEXT("Sample control",size=1.35,halign="start",textcolor="#223d52");
// (111,76) @TEXT("Reference preset",size=1.35,halign="start",textcolor="#223d52");
// #XSAMPLE @SET-SYMBOL $S_CKBD1BWP12T30P140;
// #XSAMPLE @PLACE(0,62) => @ORIENT("R0");
// #XSEQ @SET-SYMBOL $S_sar8_se_acquire;
// #XSEQ @PLACE(36,62) => @ORIENT("R0");
// #XDONE @SET-SYMBOL $S_INVD1BWP12T30P140;
// #XDONE @PLACE(132,62) => @ORIENT("R0");
// #XPRESET @SET-SYMBOL $S_OR2D1BWP12T30P140;
// #XPRESET @PLACE(161,62) => @ORIENT("R0");
// #XBOOTN @SET-SYMBOL $S_sar_bootstrap_flat_8b_p;
// #XBOOTN @PLACE(0,27) => @ORIENT("R0");
// #XBOOTP @SET-SYMBOL $S_sar_bootstrap_flat_8b_p;
// #XBOOTP @PLACE(0,4) => @ORIENT("R0");
// #XCDAC @SET-SYMBOL $S_sar8j_r1_cdac;
// #XCDAC @PLACE(46,-12) => @ORIENT("R0");
// #XCOMP @SET-SYMBOL $S_sar_strongarm_t28;
// #XCOMP @PLACE(94,18) => @ORIENT("R0");
// #XCTRL @SET-SYMBOL $S_sar8_se_ctrl;
// #XCTRL @PLACE(139,18) => @ORIENT("R0");
// #XREF @SET-SYMBOL $S_sar8i_refword;
// #XREF @PLACE(46,-48) => @ORIENT("R0");
// #CL_COMP_N @SET-SYMBOL $CAPACITOR;
// #CL_COMP_N @PLACE(113,-13) => @ORIENT("R0");
// #CL_COMP_N @TEXT("CL_COMP_N",key="name",size=1.3,halign="start") => @PLACE(116,-10);
// #CL_COMP_N @TEXT("nr=8 lr=2.5u w=50n multi=2",key="value",size=0.9,halign="start") => @PLACE(116,-17);
// #CL_COMP_N @TEXT("",key="model");
// #CL_COMP_P @SET-SYMBOL $CAPACITOR;
// #CL_COMP_P @PLACE(127,-24) => @ORIENT("R0");
// #CL_COMP_P @TEXT("CL_COMP_P",key="name",size=1.3,halign="start") => @PLACE(130,-21);
// #CL_COMP_P @TEXT("nr=8 lr=2.5u w=50n multi=2",key="value",size=0.9,halign="start") => @PLACE(130,-28);
// #CL_COMP_P @TEXT("",key="model");
// #CL_CMP_CLK @SET-SYMBOL $CAPACITOR;
// #CL_CMP_CLK @PLACE(95,51) => @ORIENT("MX");
// #CL_CMP_CLK @TEXT("CL_CMP_CLK",key="name",size=1.3,halign="start") => @PLACE(98,54);
// #CL_CMP_CLK @TEXT("nr=8 lr=2.5u w=50n multi=2",key="value",size=0.9,halign="start") => @PLACE(98,47);
// #CL_CMP_CLK @TEXT("",key="model");
// #XSAMPLE @TEXT("Buffer",key="name",size=1.65,halign="middle",textcolor="#223d52") => @PLACE(0,62);
// #XSAMPLE @TEXT("",key="model");
// #XSEQ @TEXT("Acquisition",key="name",size=1.65,halign="middle",textcolor="#223d52") => @PLACE(36,62);
// #XSEQ @TEXT("",key="model");
// #XDONE @TEXT("Done",key="name",size=1.65,halign="middle",textcolor="#223d52") => @PLACE(132,70);
// #XDONE @TEXT("",key="model");
// #XPRESET @TEXT("Preset",key="name",size=1.65,halign="middle",textcolor="#223d52") => @PLACE(161,62);
// #XPRESET @TEXT("",key="model");
// #XBOOTN @TEXT("Sampler N",key="name",size=1.65,halign="middle",textcolor="#223d52") => @PLACE(0,27);
// #XBOOTN @TEXT("",key="model");
// #XBOOTP @TEXT("Sampler P",key="name",size=1.65,halign="middle",textcolor="#223d52") => @PLACE(0,4);
// #XBOOTP @TEXT("",key="model");
// #XCDAC @TEXT("MOM CDAC",key="name",size=1.65,halign="middle",textcolor="#223d52") => @PLACE(46,-12);
// #XCDAC @TEXT("",key="model");
// #XCOMP @TEXT("StrongARM",key="name",size=1.65,halign="middle",textcolor="#223d52") => @PLACE(94,18);
// #XCOMP @TEXT("",key="model");
// #XCTRL @TEXT("SAR",key="name",size=1.65,halign="middle",textcolor="#223d52") => @PLACE(139,23);
// #XCTRL @TEXT("",key="model");
// #XREF @TEXT("Reference drive",key="name",size=1.65,halign="middle",textcolor="#223d52") => @PLACE(46,-48);
// #XREF @TEXT("",key="model");
// #CL_COMP_N @TEXT("",key="value");
// #CL_COMP_P @TEXT("",key="value");
// #CL_CMP_CLK @TEXT("",key="value");
// %sar_port1 = $IO_PORT @ATTACH &"SAMPLE" => @PLACE(-23,62);
// &"SAMPLE" @WIRE(mode="straight",linecolor="#94601a",linewidth=0.16) {%sar_port1:p #XSAMPLE:1};
// %sar_port2 = $IO_PORT @ATTACH &"VINN" => @PLACE(-23,25.35);
// &"VINN" @WIRE(mode="straight",linecolor="#226e85",linewidth=0.16) {%sar_port2:p #XBOOTN:3};
// %sar_port3 = $IO_PORT @ATTACH &"VINP" => @PLACE(-23,2.35);
// &"VINP" @WIRE(mode="straight",linecolor="#226e85",linewidth=0.16) {%sar_port3:p #XBOOTP:3};
// &"SAMPLE_INT" @WIRE(mode="straight",linecolor="#30485d",linewidth=0.16) {#XSAMPLE:2 (18,62) (18,62) #XSEQ:1};
// &"DONE" @WIRE(mode="straight",linecolor="#30485d",linewidth=0.16) {#XDONE:2 (143.5,62) (143.5,63.65) #XPRESET:1};
// &"TOPN" @WIRE(mode="straight",linecolor="#226e85",linewidth=0.16) {#XBOOTN:2 (38,27) (75,27) (75,18) #XCOMP:5};
// &"TOPN" @WIRE(mode="straight",linecolor="#226e85",linewidth=0.16) {#XCDAC:33 (38,27)};
// $JUNCTION @ATTACH (38,27);
// (46,28.6) @TEXT("TOPN",size=1.13,halign="start",textcolor="#223d52");
// &"TOPP" @WIRE(mode="straight",linecolor="#226e85",linewidth=0.16) {#XBOOTP:2 (19,4) (19,7) (46,7) (75,7) (75,14.7) #XCOMP:6};
// &"TOPP" @WIRE(mode="straight",linecolor="#226e85",linewidth=0.16) {#XCDAC:34 (46,7)};
// $JUNCTION @ATTACH (46,7);
// (54,8.6) @TEXT("TOPP",size=1.13,halign="start",textcolor="#223d52");
// &"COMP_N" @WIRE(mode="straight",linecolor="#226e85",linewidth=0.16) {(113,-11) (113,19.65) (113,21.3)};
// &"COMP_N" @WIRE(mode="straight",linecolor="#226e85",linewidth=0.16) {#XCOMP:2 (113,19.65)};
// $JUNCTION @ATTACH (113,19.65);
// &"COMP_N" @WIRE(mode="straight",linecolor="#226e85",linewidth=0.16) {#XCTRL:10 (113,21.3)};
// $JUNCTION @ATTACH (113,21.3);
// &"COMP_N" @WIRE(mode="straight",linecolor="#226e85",linewidth=0.16) {#CL_COMP_N:1 (113,-11)};
// $JUNCTION @ATTACH (113,-11);
// &"COMP_P" @WIRE(mode="straight",linecolor="#226e85",linewidth=0.16) {(122,-22) (122,16.35) (122,18)};
// &"COMP_P" @WIRE(mode="straight",linecolor="#226e85",linewidth=0.16) {#XCOMP:3 (122,16.35)};
// $JUNCTION @ATTACH (122,16.35);
// &"COMP_P" @WIRE(mode="straight",linecolor="#226e85",linewidth=0.16) {#XCTRL:11 (122,18)};
// $JUNCTION @ATTACH (122,18);
// &"COMP_P" @WIRE(mode="straight",linecolor="#226e85",linewidth=0.16) {#CL_COMP_P:1 (122,-22)};
// $JUNCTION @ATTACH (122,-22);
// &"CMP_CLK" @WIRE(mode="straight",linecolor="#94601a",linewidth=0.16) {(81,42) (95,42) (152,42)};
// &"CMP_CLK" @WIRE(mode="straight",linecolor="#94601a",linewidth=0.16) {#XCTRL:1 (152,42)};
// $JUNCTION @ATTACH (152,42);
// &"CMP_CLK" @WIRE(mode="straight",linecolor="#94601a",linewidth=0.16) {#XCOMP:1 (81,42)};
// $JUNCTION @ATTACH (81,42);
// &"CMP_CLK" @WIRE(mode="straight",linecolor="#94601a",linewidth=0.16) {#CL_CMP_CLK:1 (95,42)};
// $JUNCTION @ATTACH (95,42);
// {&"GNN0" &"GNN1" &"GNN2" &"GNN3" &"GNN4" &"GNN5" &"GNN6" &"GNN7"} @WIRE(mode="straight",linewidth=0.24,linecolor="#536f4b") {#XREF:17  #XCDAC:1};
// {&"GNP0" &"GNP1" &"GNP2" &"GNP3" &"GNP4" &"GNP5" &"GNP6" &"GNP7"} @WIRE(mode="straight",linewidth=0.24,linecolor="#536f4b") {#XREF:25  #XCDAC:9};
// {&"GPN0" &"GPN1" &"GPN2" &"GPN3" &"GPN4" &"GPN5" &"GPN6" &"GPN7"} @WIRE(mode="straight",linewidth=0.24,linecolor="#536f4b") {#XREF:33  #XCDAC:17};
// {&"GPP0" &"GPP1" &"GPP2" &"GPP3" &"GPP4" &"GPP5" &"GPP6" &"GPP7"} @WIRE(mode="straight",linewidth=0.24,linecolor="#536f4b") {#XREF:41  #XCDAC:25};
// {&"CODE0" &"CODE1" &"CODE2" &"CODE3" &"CODE4" &"CODE5" &"CODE6" &"CODE7"} @WIRE(mode="straight",linewidth=0.24,linecolor="#66538a") {#XCTRL:2 (161,21.3) (161,-43.05) #XREF:1};
// {&"D0" &"D1" &"D2" &"D3" &"D4" &"D5" &"D6" &"D7"} @WIRE(mode="straight",linewidth=0.24,linecolor="#66538a") {#XCTRL:12 (170,18) (170,-46.35) #XREF:9};
// (121,-37) @TEXT("Digital feedback",size=1.3,halign="start",textcolor="#223d52");
// &"VDD!" @WIRE(mode="straight",linecolor="#30485d",linewidth=0.16) {#XSEQ:2 (36,73)};
// (36,73.4) @TEXT("VDD!",size=1.1,halign="middle",valign="bottom");
// &"0" @WIRE(mode="straight",linecolor="#30485d",linewidth=0.16) {#XSEQ:3 (36,51)};
// (36,50.6) @TEXT("0",size=1.1,halign="middle",valign="top");
// &"SEQ_SAMPLE" @WIRE(mode="straight",linecolor="#30485d",linewidth=0.16) {#XSEQ:4 (52,62)};
// (52.4,62) @TEXT("SEQ_SAMPLE",size=1.1,halign="start",valign="middle");
// &"ACTIVE" @WIRE(mode="straight",linecolor="#30485d",linewidth=0.16) {#XDONE:1 (122,62)};
// (121.6,62) @TEXT("ACTIVE",size=1.1,halign="end",valign="middle");
// &"VDD!" @WIRE(mode="straight",linecolor="#30485d",linewidth=0.16) {#XDONE:3 (132,72)};
// (132,72.4) @TEXT("VDD!",size=1.1,halign="middle",valign="bottom");
// &"0" @WIRE(mode="straight",linecolor="#30485d",linewidth=0.16) {#XDONE:4 (132,52)};
// (132,51.6) @TEXT("0",size=1.1,halign="middle",valign="top");
// &"SEQ_SAMPLE" @WIRE(mode="straight",linecolor="#30485d",linewidth=0.16) {#XPRESET:2 (145,60.35)};
// (144.6,60.35) @TEXT("SEQ_SAMPLE",size=1.1,halign="end",valign="middle");
// &"PRESET" @WIRE(mode="straight",linecolor="#30485d",linewidth=0.16) {#XPRESET:3 (177,62)};
// (177.4,62) @TEXT("PRESET",size=1.1,halign="start",valign="middle");
// &"VDD!" @WIRE(mode="straight",linecolor="#30485d",linewidth=0.16) {#XPRESET:4 (161,73)};
// (161,73.4) @TEXT("VDD!",size=1.1,halign="middle",valign="bottom");
// &"0" @WIRE(mode="straight",linecolor="#30485d",linewidth=0.16) {#XPRESET:5 (161,51)};
// (161,50.6) @TEXT("0",size=1.1,halign="middle",valign="top");
// &"VDD!" @WIRE(mode="straight",linecolor="#30485d",linewidth=0.16) {#XSAMPLE:3 (0,73)};
// (0,73.4) @TEXT("VDD!",size=1.1,halign="middle",valign="bottom");
// &"0" @WIRE(mode="straight",linecolor="#30485d",linewidth=0.16) {#XSAMPLE:4 (0,51)};
// (0,50.6) @TEXT("0",size=1.1,halign="middle",valign="top");
// &"SEQ_SAMPLE" @WIRE(mode="straight",linecolor="#30485d",linewidth=0.16) {#XBOOTN:1 (-16,28.65)};
// (-16.4,28.65) @TEXT("SEQ_SAMPLE",size=1.1,halign="end",valign="middle");
// &"SEQ_SAMPLE" @WIRE(mode="straight",linecolor="#30485d",linewidth=0.16) {#XBOOTP:1 (-16,5.65)};
// (-16.4,5.65) @TEXT("SEQ_SAMPLE",size=1.1,halign="end",valign="middle");
// &"VDD!" @WIRE(mode="straight",linecolor="#30485d",linewidth=0.16) {#XCDAC:35 (54,-1)};
// (54,-0.6) @TEXT("VDD!",size=1.1,halign="middle",valign="bottom");
// &"VREFN" @WIRE(mode="straight",linecolor="#30485d",linewidth=0.16) {#XCDAC:36 (23,-10.35)};
// (22.6,-10.35) @TEXT("VREFN",size=1.1,halign="end",valign="middle");
// &"VREFP" @WIRE(mode="straight",linecolor="#30485d",linewidth=0.16) {#XCDAC:37 (23,-13.65)};
// (22.6,-13.65) @TEXT("VREFP",size=1.1,halign="end",valign="middle");
// &"0" @WIRE(mode="straight",linecolor="#30485d",linewidth=0.16) {#XCDAC:38 (62,-23)};
// (62,-23.4) @TEXT("0",size=1.1,halign="middle",valign="top");
// &"PHI_U" @WIRE(mode="straight",linecolor="#30485d",linewidth=0.16) {#XCTRL:20 (155,14.7)};
// (155.4,14.7) @TEXT("PHI_U",size=1.1,halign="start",valign="middle");
// &"SEQ_SAMPLE" @WIRE(mode="straight",linecolor="#30485d",linewidth=0.16) {#XCTRL:21 (123,14.7)};
// (122.6,14.7) @TEXT("SEQ_SAMPLE",size=1.1,halign="end",valign="middle");
// &"VDD!" @WIRE(mode="straight",linecolor="#30485d",linewidth=0.16) {#XCTRL:22 (139,32.9)};
// (139,33.3) @TEXT("VDD!",size=1.1,halign="middle",valign="bottom");
// &"0" @WIRE(mode="straight",linecolor="#30485d",linewidth=0.16) {#XCTRL:23 (139,3.1)};
// (139,2.7) @TEXT("0",size=1.1,halign="middle",valign="top");
// &"ACTIVE" @WIRE(mode="straight",linecolor="#30485d",linewidth=0.16) {#XCTRL:24 (155,11.4)};
// (155.4,11.4) @TEXT("ACTIVE",size=1.1,halign="start",valign="middle");
// &"PHI_U" @WIRE(mode="straight",linecolor="#30485d",linewidth=0.16) {#XREF:49 (23,-46.35)};
// (22.6,-46.35) @TEXT("PHI_U",size=1.1,halign="end",valign="middle");
// &"SAMPLE_INT" @WIRE(mode="straight",linecolor="#30485d",linewidth=0.16) {#XREF:50 (23,-49.65)};
// (22.6,-49.65) @TEXT("SAMPLE_INT",size=1.1,halign="end",valign="middle");
// &"VDD!" @WIRE(mode="straight",linecolor="#30485d",linewidth=0.16) {#XREF:51 (62,-34.75)};
// (62,-34.35) @TEXT("VDD!",size=1.1,halign="middle",valign="bottom");
// &"0" @WIRE(mode="straight",linecolor="#30485d",linewidth=0.16) {#XREF:52 (46,-61.25)};
// (46,-61.65) @TEXT("0",size=1.1,halign="middle",valign="top");
// &"RST_DONE" @WIRE(mode="straight",linecolor="#30485d",linewidth=0.16) {#XREF:53 (69,-49.65)};
// (69.4,-49.65) @TEXT("RST_DONE",size=1.1,halign="start",valign="middle");
// &"PRESET" @WIRE(mode="straight",linecolor="#30485d",linewidth=0.16) {#XREF:54 (69,-52.95)};
// (69.4,-52.95) @TEXT("PRESET",size=1.1,halign="start",valign="middle");
// &"VDD!" @WIRE(mode="straight",linecolor="#30485d",linewidth=0.16) {#XCOMP:4 (94,29.6)};
// (94,30) @TEXT("VDD!",size=1.1,halign="middle",valign="bottom");
// &"0" @WIRE(mode="straight",linecolor="#30485d",linewidth=0.16) {#XCOMP:7 (94,6.4)};
// (94,6) @TEXT("0",size=1.1,halign="middle",valign="top");
// &"0" @WIRE(mode="straight",linecolor="#30485d",linewidth=0.16) {#CL_COMP_N:2 (113,-18)};
// (113,-18.4) @TEXT("0",size=1.1,halign="middle",valign="top");
// &"0" @WIRE(mode="straight",linecolor="#30485d",linewidth=0.16) {#CL_COMP_P:2 (127,-29)};
// (127,-29.4) @TEXT("0",size=1.1,halign="middle",valign="top");
// &"0" @WIRE(mode="straight",linecolor="#30485d",linewidth=0.16) {#CL_CMP_CLK:2 (95,56)};
// (95,56.4) @TEXT("0",size=1.1,halign="middle",valign="bottom");
// }
// END SARADC RNL
ends sar_adc8_join_r4
