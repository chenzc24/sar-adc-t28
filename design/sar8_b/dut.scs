// Frozen B electrical view. PDK and standard-cell includes belong to the test deck.
simulator lang=spectre
include "blocks/standard_cells.scs"
include "blocks/delays.scs"
include "blocks/bootstrap.scs"
include "blocks/cdac.scs"
include "blocks/comparator.scs"
include "blocks/sar_logic.scs"
include "blocks/reference.scs"
include "top/adc_top.scs"
