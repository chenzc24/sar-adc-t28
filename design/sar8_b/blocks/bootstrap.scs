// Generated from frozen B by scripts/sar8_entry.py build.
// Electrical subcircuit statements are preserved verbatim.

subckt sar_bootstrap_flat_8b_p CLKS VOUT Vin
    Mmain (VOUT G Vin 0) nch_18_mac l=150.0n w=1u multi=1 nf=1 sd=180.0n \
        ad=1.55e-13 as=1.55e-13 pd=2.31u ps=2.31u nrd=0 nrs=0 sa=155.00n \
        sb=155.00n sa1=155.00n sa2=155.00n sa3=155.00n sa4=155.00n \
        sb1=155.00n sb2=155.00n sb3=155.00n spa=180.0n spa1=180.0n \
        spa2=180.0n spa3=180.0n sap=172.362n sapb=242.67n spba=233.666n \
        spba1=239.844n spmt=1.11111e+15 spomt=0 spomt1=1.11111e+60 \
        spmb=1.11111e+15 spomb=0 spomb1=1.11111e+60
    Mmain_U1 (VOUT G Vin 0) nch_18_mac l=150.0n w=1u multi=1 nf=1 sd=180.0n \
        ad=1.55e-13 as=1.55e-13 pd=2.31u ps=2.31u nrd=0 nrs=0 sa=155.00n \
        sb=155.00n sa1=155.00n sa2=155.00n sa3=155.00n sa4=155.00n \
        sb1=155.00n sb2=155.00n sb3=155.00n spa=180.0n spa1=180.0n \
        spa2=180.0n spa3=180.0n sap=172.362n sapb=242.67n spba=233.666n \
        spba1=239.844n spmt=1.11111e+15 spomt=0 spomt1=1.11111e+60 \
        spmb=1.11111e+15 spomb=0 spomb1=1.11111e+60
    M4C (CTRL CLKS BBOT 0) nch_18_mac l=150.0n w=1u multi=1 nf=1 sd=180.0n \
        ad=1.55e-13 as=1.55e-13 pd=2.31u ps=2.31u nrd=0 nrs=0 sa=155.00n \
        sb=155.00n sa1=155.00n sa2=155.00n sa3=155.00n sa4=155.00n \
        sb1=155.00n sb2=155.00n sb3=155.00n spa=180.0n spa1=180.0n \
        spa2=180.0n spa3=180.0n sap=172.362n sapb=242.67n spba=233.666n \
        spba1=239.844n spmt=1.11111e+15 spomt=0 spomt1=1.11111e+60 \
        spmb=1.11111e+15 spomb=0 spomb1=1.11111e+60
    Msin (BBOT G Vin 0) nch_18_mac l=150.0n w=1u multi=1 nf=1 sd=180.0n \
        ad=1.55e-13 as=1.55e-13 pd=2.31u ps=2.31u nrd=0 nrs=0 sa=155.00n \
        sb=155.00n sa1=155.00n sa2=155.00n sa3=155.00n sa4=155.00n \
        sb1=155.00n sb2=155.00n sb3=155.00n spa=180.0n spa1=180.0n \
        spa2=180.0n spa3=180.0n sap=172.362n sapb=242.67n spba=233.666n \
        spba1=239.844n spmt=1.11111e+15 spomt=0 spomt1=1.11111e+60 \
        spmb=1.11111e+15 spomb=0 spomb1=1.11111e+60
    Maux (G VDD! GRESET 0) nch_18_mac l=150.0n w=1u multi=1 nf=1 sd=180.0n \
        ad=1.55e-13 as=1.55e-13 pd=2.31u ps=2.31u nrd=0 nrs=0 sa=155.00n \
        sb=155.00n sa1=155.00n sa2=155.00n sa3=155.00n sa4=155.00n \
        sb1=155.00n sb2=155.00n sb3=155.00n spa=180.0n spa1=180.0n \
        spa2=180.0n spa3=180.0n sap=172.362n sapb=242.67n spba=233.666n \
        spba1=239.844n spmt=1.11111e+15 spomt=0 spomt1=1.11111e+60 \
        spmb=1.11111e+15 spomb=0 spomb1=1.11111e+60
    MRSTG (GRESET CLKSB 0 0) nch_18_mac l=150.0n w=1u multi=1 nf=1 \
        sd=180.0n ad=1.55e-13 as=1.55e-13 pd=2.31u ps=2.31u nrd=0 nrs=0 \
        sa=155.00n sb=155.00n sa1=155.00n sa2=155.00n sa3=155.00n \
        sa4=155.00n sb1=155.00n sb2=155.00n sb3=155.00n spa=180.0n \
        spa1=180.0n spa2=180.0n spa3=180.0n sap=172.362n sapb=242.67n \
        spba=233.666n spba1=239.844n spmt=1.11111e+15 spomt=0 \
        spomt1=1.11111e+60 spmb=1.11111e+15 spomb=0 spomb1=1.11111e+60
    M4A (CTRL G BBOT 0) nch_18_mac l=150.0n w=1u multi=1 nf=1 sd=180.0n \
        ad=1.55e-13 as=1.55e-13 pd=2.31u ps=2.31u nrd=0 nrs=0 sa=155.00n \
        sb=155.00n sa1=155.00n sa2=155.00n sa3=155.00n sa4=155.00n \
        sb1=155.00n sb2=155.00n sb3=155.00n spa=180.0n spa1=180.0n \
        spa2=180.0n spa3=180.0n sap=172.362n sapb=242.67n spba=233.666n \
        spba1=239.844n spmt=1.11111e+15 spomt=0 spomt1=1.11111e+60 \
        spmb=1.11111e+15 spomb=0 spomb1=1.11111e+60
    M8 (BBOT CLKSB 0 0) nch_18_mac l=150.0n w=1u multi=1 nf=1 sd=180.0n \
        ad=1.55e-13 as=1.55e-13 pd=2.31u ps=2.31u nrd=0 nrs=0 sa=155.00n \
        sb=155.00n sa1=155.00n sa2=155.00n sa3=155.00n sa4=155.00n \
        sb1=155.00n sb2=155.00n sb3=155.00n spa=180.0n spa1=180.0n \
        spa2=180.0n spa3=180.0n sap=172.362n sapb=242.67n spba=233.666n \
        spba1=239.844n spmt=1.11111e+15 spomt=0 spomt1=1.11111e+60 \
        spmb=1.11111e+15 spomb=0 spomb1=1.11111e+60
    MNCLK (CLKSB CLKS 0 0) nch_18_mac l=150.0n w=1u multi=1 nf=1 sd=180.0n \
        ad=1.55e-13 as=1.55e-13 pd=2.31u ps=2.31u nrd=0 nrs=0 sa=155.00n \
        sb=155.00n sa1=155.00n sa2=155.00n sa3=155.00n sa4=155.00n \
        sb1=155.00n sb2=155.00n sb3=155.00n spa=180.0n spa1=180.0n \
        spa2=180.0n spa3=180.0n sap=172.362n sapb=242.67n spba=233.666n \
        spba1=239.844n spmt=1.11111e+15 spomt=0 spomt1=1.11111e+60 \
        spmb=1.11111e+15 spomb=0 spomb1=1.11111e+60
    M2 (BTOP G VDD! BTOP) pch_18_mac l=150.0n w=1u multi=1 nf=1 sd=180.0n \
        ad=1.55e-13 as=1.55e-13 pd=2.31u ps=2.31u nrd=0 nrs=0 sa=155.00n \
        sb=155.00n sa1=155.00n sa2=155.00n sa3=155.00n sa4=155.00n \
        sb1=155.00n sb2=155.00n sb3=155.00n spa=180.0n spa1=180.0n \
        spa2=180.0n spa3=180.0n sap=172.362n sapb=242.67n spba=233.666n \
        spba1=239.844n spmt=1.11111e+15 spomt=0 spomt1=1.11111e+60 \
        spmb=1.11111e+15 spomb=0 spomb1=1.11111e+60
    M4 (G CTRL BTOP BTOP) pch_18_mac l=150.0n w=1u multi=1 nf=1 sd=180.0n \
        ad=1.55e-13 as=1.55e-13 pd=2.31u ps=2.31u nrd=0 nrs=0 sa=155.00n \
        sb=155.00n sa1=155.00n sa2=155.00n sa3=155.00n sa4=155.00n \
        sb1=155.00n sb2=155.00n sb3=155.00n spa=180.0n spa1=180.0n \
        spa2=180.0n spa3=180.0n sap=172.362n sapb=242.67n spba=233.666n \
        spba1=239.844n spmt=1.11111e+15 spomt=0 spomt1=1.11111e+60 \
        spmb=1.11111e+15 spomb=0 spomb1=1.11111e+60
    M4B (CTRL CLKS VDD! VDD!) pch_18_mac l=150.0n w=1u multi=1 nf=1 \
        sd=180.0n ad=1.55e-13 as=1.55e-13 pd=2.31u ps=2.31u nrd=0 nrs=0 \
        sa=155.00n sb=155.00n sa1=155.00n sa2=155.00n sa3=155.00n \
        sa4=155.00n sb1=155.00n sb2=155.00n sb3=155.00n spa=180.0n \
        spa1=180.0n spa2=180.0n spa3=180.0n sap=172.362n sapb=242.67n \
        spba=233.666n spba1=239.844n spmt=1.11111e+15 spomt=0 \
        spomt1=1.11111e+60 spmb=1.11111e+15 spomb=0 spomb1=1.11111e+60
    MPCLK (CLKSB CLKS VDD! VDD!) pch_18_mac l=150.0n w=1u multi=1 nf=1 \
        sd=180.0n ad=1.55e-13 as=1.55e-13 pd=2.31u ps=2.31u nrd=0 nrs=0 \
        sa=155.00n sb=155.00n sa1=155.00n sa2=155.00n sa3=155.00n \
        sa4=155.00n sb1=155.00n sb2=155.00n sb3=155.00n spa=180.0n \
        spa1=180.0n spa2=180.0n spa3=180.0n sap=172.362n sapb=242.67n \
        spba=233.666n spba1=239.844n spmt=1.11111e+15 spomt=0 \
        spomt1=1.11111e+60 spmb=1.11111e+15 spomb=0 spomb1=1.11111e+60
    Cboot (BTOP BBOT) cfmom_2t nr=8 lr=2.5u w=50n s=50n stm=1 spm=3 \
        multi=200 mismatchflag=1
ends sar_bootstrap_flat_8b_p
