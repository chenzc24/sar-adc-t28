// Generated from frozen B by scripts/sar8_entry.py build.
// Electrical subcircuit statements are preserved verbatim.

subckt sar8p_inv A VDD VSS Y
    XLIB (A Y VDD VSS) INVD1BWP12T30P140
ends sar8p_inv

subckt sar8p_clkbuf A VDD VSS Y
    X000 (A VDD VSS AB) sar8p_inv
    XFINAL (AB VDD VSS Y) sar8p_inv
ends sar8p_clkbuf

subckt sar8p_nand2 A B VDD VSS Y
    XLIB (A B Y VDD VSS) ND2D1BWP12T30P140
ends sar8p_nand2

subckt sar8p_and2 A B VDD VSS Y
    X000 (A B VDD VSS N) sar8p_nand2
    X001 (N VDD VSS Y) sar8p_inv
ends sar8p_and2

subckt sar8p_buf A VDD VSS Y
    X001 (N VDD VSS Y) sar8p_inv
    X000 (A VDD VSS N) sar8p_inv
ends sar8p_buf

subckt sar8p_xor2 A B VDD VSS Y
    X003 (NA NB VDD VSS Y) sar8p_nand2
    X002 (B N VDD VSS NB) sar8p_nand2
    X001 (A N VDD VSS NA) sar8p_nand2
    X000 (A B VDD VSS N) sar8p_nand2
ends sar8p_xor2

subckt sar8p_or2 A B VDD VSS Y
    X001 (B VDD VSS BB) sar8p_inv
    X000 (A VDD VSS AB) sar8p_inv
    X002 (AB BB VDD VSS Y) sar8p_nand2
ends sar8p_or2

subckt sar8p_sr Q R S VDD VSS
    X000 (R VDD VSS RB) sar8p_inv
    X003 (RB Q VDD VSS QB) sar8p_nand2
    X002 (SN QB VDD VSS Q) sar8p_nand2
    X001 (S RB VDD VSS SN) sar8p_nand2
    CQB (QB VSS) cfmom_2t nr=8 lr=2.5u w=50n s=50n stm=1 spm=3 multi=1 \
        mismatchflag=1
ends sar8p_sr

subckt sar8p_dffr CK D Q RST VDD VSS
    XRESET (RST RN VDD VSS) INVD1BWP12T30P140
    XFF (D CK RN Q VDD VSS) DFCNQD1BWP12T30P140
ends sar8p_dffr

subckt sar8p_mux2 D0 D1 SEL VDD VSS Y
    X000 (SEL VDD VSS SB) sar8p_inv
    X003 (N0 N1 VDD VSS Y) sar8p_nand2
    X002 (D1 SEL VDD VSS N1) sar8p_nand2
    X001 (D0 SB VDD VSS N0) sar8p_nand2
ends sar8p_mux2
