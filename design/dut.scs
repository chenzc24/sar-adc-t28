simulator lang=spectre
include "xtor/common/standard_cells.scs"
include "xtor/clock/delays_std.scs"
include "xtor/bootstrap/bootstrap.scs"
include "xtor/cdac/cdac.scs"
include "xtor/comparator/comparator.scs"
include "xtor/sar/reset_data_or_std_delay.scs"
include "xtor/reference/minimal_msb_d2.scs"
include "top/adc_top.scs"
