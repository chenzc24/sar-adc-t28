simulator lang=spectre
include "xtor/common/standard_cells.scs"
include "xtor/clock/delays.scs"
include "xtor/bootstrap/bootstrap.scs"
include "xtor/cdac/cdac.scs"
include "xtor/comparator/comparator.scs"
include "xtor/sar/sar.scs"
include "xtor/reference/minimal_direct.scs"
include "top/adc_top.scs"
