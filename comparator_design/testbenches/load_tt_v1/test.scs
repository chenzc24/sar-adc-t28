simulator lang=spectre
include "models.scs"
VVDD (VDD 0) vsource dc=.9
VFP (FP 0) vsource type=pwl wave=[0 0 5n 0 5.05n .9 10n .9 10.05n 0]
XFP0 (FP 0 QFP0 VDD 0) DFQD1BWP12T30P140
XFP1 (FP 0 QFP1 VDD 0) DFQD1BWP12T30P140
XFP2 (FP 0 QFP2 VDD 0) DFQD1BWP12T30P140
XFP3 (FP 0 QFP3 VDD 0) DFQD1BWP12T30P140
XFP4 (FP 0 QFP4 VDD 0) DFQD1BWP12T30P140
XFP5 (FP 0 QFP5 VDD 0) DFQD1BWP12T30P140
XFP6 (FP 0 QFP6 VDD 0) DFQD1BWP12T30P140
XFP7 (FP 0 QFP7 VDD 0) DFQD1BWP12T30P140
VFN (FN 0) vsource type=pwl wave=[0 0 15n 0 15.05n .9 20n .9 20.05n 0]
XFN0 (FN 0 QFN0 VDD 0) DFQD1BWP12T30P140
XFN1 (FN 0 QFN1 VDD 0) DFQD1BWP12T30P140
XFN2 (FN 0 QFN2 VDD 0) DFQD1BWP12T30P140
XFN3 (FN 0 QFN3 VDD 0) DFQD1BWP12T30P140
XFN4 (FN 0 QFN4 VDD 0) DFQD1BWP12T30P140
XFN5 (FN 0 QFN5 VDD 0) DFQD1BWP12T30P140
XFN6 (FN 0 QFN6 VDD 0) DFQD1BWP12T30P140
XFN7 (FN 0 QFN7 VDD 0) DFQD1BWP12T30P140
XORF (FP FN VALIDF VDD 0) OR2D4BWP12T30P140
VSP (SP 0) vsource type=pwl wave=[0 0 5n 0 5.2n .9 10n .9 10.2n 0]
XSP0 (SP 0 QSP0 VDD 0) DFQD1BWP12T30P140
XSP1 (SP 0 QSP1 VDD 0) DFQD1BWP12T30P140
XSP2 (SP 0 QSP2 VDD 0) DFQD1BWP12T30P140
XSP3 (SP 0 QSP3 VDD 0) DFQD1BWP12T30P140
XSP4 (SP 0 QSP4 VDD 0) DFQD1BWP12T30P140
XSP5 (SP 0 QSP5 VDD 0) DFQD1BWP12T30P140
XSP6 (SP 0 QSP6 VDD 0) DFQD1BWP12T30P140
XSP7 (SP 0 QSP7 VDD 0) DFQD1BWP12T30P140
VSN (SN 0) vsource type=pwl wave=[0 0 15n 0 15.2n .9 20n .9 20.2n 0]
XSN0 (SN 0 QSN0 VDD 0) DFQD1BWP12T30P140
XSN1 (SN 0 QSN1 VDD 0) DFQD1BWP12T30P140
XSN2 (SN 0 QSN2 VDD 0) DFQD1BWP12T30P140
XSN3 (SN 0 QSN3 VDD 0) DFQD1BWP12T30P140
XSN4 (SN 0 QSN4 VDD 0) DFQD1BWP12T30P140
XSN5 (SN 0 QSN5 VDD 0) DFQD1BWP12T30P140
XSN6 (SN 0 QSN6 VDD 0) DFQD1BWP12T30P140
XSN7 (SN 0 QSN7 VDD 0) DFQD1BWP12T30P140
XORS (SP SN VALIDS VDD 0) OR2D4BWP12T30P140
simulatorOptions options reltol=1e-6 vabstol=1e-8 iabstol=1e-14 temp=27
saveOptions options save=selected currents=selected
tran_test tran stop=25n maxstep=20p errpreset=conservative
save VDD VVDD:1 FP VFP:1 FN VFN:1 SP VSP:1 SN VSN:1
