simulator lang=spectre
include "models.scs"
include "dut.scs"
VCK (CK 0) vsource type=pwl wave=[0 0 5.392499999999999e-08 0 5.4125e-08 0.99 5.5275e-08 0.99 5.5775e-08 0 5.7925e-08 0 5.812500000000001e-08 0.99 5.927500000000001e-08 0.99 5.9775e-08 0 6.192500000000001e-08 0 6.2125e-08 0.99 6.327499999999999e-08 0.99 6.3775e-08 0 6.5925e-08 0 6.612499999999999e-08 0.99 6.7275e-08 0.99 6.777500000000001e-08 0 6.9925e-08 0 7.012499999999999e-08 0.99 7.127499999999999e-08 0.99 7.177500000000001e-08 0 7.392500000000001e-08 0 7.4125e-08 0.99 7.527499999999999e-08 0.99 7.5775e-08 0 7.7925e-08 0 7.812499999999999e-08 0.99 7.9275e-08 0.99 7.977500000000001e-08 0 8.1925e-08 0 8.212499999999999e-08 0.99 8.3275e-08 0.99 8.377500000000001e-08 0 1.53925e-07 0 1.54125e-07 0.99 1.55275e-07 0.99 1.55775e-07 0 1.57925e-07 0 1.58125e-07 0.99 1.59275e-07 0.99 1.59775e-07 0 1.61925e-07 0 1.62125e-07 0.99 1.63275e-07 0.99 1.63775e-07 0 1.65925e-07 0 1.66125e-07 0.99 1.67275e-07 0.99 1.67775e-07 0 1.69925e-07 0 1.70125e-07 0.99 1.71275e-07 0.99 1.71775e-07 0 1.73925e-07 0 1.74125e-07 0.99 1.75275e-07 0.99 1.75775e-07 0 1.77925e-07 0 1.78125e-07 0.99 1.79275e-07 0.99 1.79775e-07 0 1.81925e-07 0 1.82125e-07 0.99 1.83275e-07 0.99 1.83775e-07 0 2.53925e-07 0 2.54125e-07 0.99 2.55275e-07 0.99 2.557750000000001e-07 0 2.57925e-07 0 2.58125e-07 0.99 2.59275e-07 0.99 2.59775e-07 0 2.61925e-07 0 2.62125e-07 0.99 2.63275e-07 0.99 2.63775e-07 0 2.65925e-07 0 2.66125e-07 0.99 2.67275e-07 0.99 2.677750000000001e-07 0 2.69925e-07 0 2.70125e-07 0.99 2.71275e-07 0.99 2.71775e-07 0 2.73925e-07 0 2.74125e-07 0.99 2.75275e-07 0.99 2.75775e-07 0 2.77925e-07 0 2.78125e-07 0.99 2.79275e-07 0.99 2.797750000000001e-07 0 2.81925e-07 0 2.82125e-07 0.99 2.83275e-07 0.99 2.83775e-07 0 3.53925e-07 0 3.54125e-07 0.99 3.55275e-07 0.99 3.55775e-07 0 3.57925e-07 0 3.58125e-07 0.99 3.59275e-07 0.99 3.59775e-07 0 3.61925e-07 0 3.62125e-07 0.99 3.63275e-07 0.99 3.637750000000001e-07 0 3.65925e-07 0 3.66125e-07 0.99 3.67275e-07 0.99 3.67775e-07 0 3.69925e-07 0 3.70125e-07 0.99 3.71275e-07 0.99 3.71775e-07 0 3.73925e-07 0 3.74125e-07 0.99 3.75275e-07 0.99 3.757750000000001e-07 0 3.77925e-07 0 3.78125e-07 0.99 3.79275e-07 0.99 3.797750000000001e-07 0 3.81925e-07 0 3.82125e-07 0.99 3.83275e-07 0.99 3.83775e-07 0]
VTRACK (TRACK 0) vsource type=pwl wave=[0 1 5.2e-08 1 5.205e-08 1 5.345e-08 1 5.35e-08 0 5.6e-08 0 5.605e-08 1 5.745e-08 1 5.75e-08 0 6e-08 0 6.005e-08 1 6.145e-08 1 6.15e-08 0 6.4e-08 0 6.405e-08 1 6.545e-08 1 6.55e-08 0 6.8e-08 0 6.805e-08 1 6.945e-08 1 6.95e-08 0 7.2e-08 0 7.205e-08 1 7.345e-08 1 7.35e-08 0 7.6e-08 0 7.605e-08 1 7.745e-08 1 7.75e-08 0 8e-08 0 8.005e-08 1 8.145e-08 1 8.15e-08 0 1.52e-07 0 1.5205e-07 1 1.5345e-07 1 1.535e-07 0 1.56e-07 0 1.5605e-07 1 1.5745e-07 1 1.575e-07 0 1.6e-07 0 1.6005e-07 1 1.6145e-07 1 1.615e-07 0 1.64e-07 0 1.6405e-07 1 1.6545e-07 1 1.655e-07 0 1.68e-07 0 1.6805e-07 1 1.6945e-07 1 1.695e-07 0 1.72e-07 0 1.7205e-07 1 1.7345e-07 1 1.735e-07 0 1.76e-07 0 1.7605e-07 1 1.7745e-07 1 1.775e-07 0 1.8e-07 0 1.8005e-07 1 1.8145e-07 1 1.815e-07 0 2.52e-07 0 2.5205e-07 1 2.5345e-07 1 2.535e-07 0 2.56e-07 0 2.5605e-07 1 2.5745e-07 1 2.575e-07 0 2.6e-07 0 2.6005e-07 1 2.6145e-07 1 2.615e-07 0 2.64e-07 0 2.6405e-07 1 2.6545e-07 1 2.655e-07 0 2.68e-07 0 2.6805e-07 1 2.6945e-07 1 2.695e-07 0 2.72e-07 0 2.7205e-07 1 2.7345e-07 1 2.735e-07 0 2.76e-07 0 2.7605e-07 1 2.7745e-07 1 2.775e-07 0 2.8e-07 0 2.8005e-07 1 2.8145e-07 1 2.815e-07 0 3.52e-07 0 3.5205e-07 1 3.5345e-07 1 3.535e-07 0 3.56e-07 0 3.5605e-07 1 3.5745e-07 1 3.575e-07 0 3.6e-07 0 3.6005e-07 1 3.6145e-07 1 3.615e-07 0 3.64e-07 0 3.6405e-07 1 3.6545e-07 1 3.655e-07 0 3.68e-07 0 3.6805e-07 1 3.6945e-07 1 3.695e-07 0 3.72e-07 0 3.7205e-07 1 3.7345e-07 1 3.735e-07 0 3.76e-07 0 3.7605e-07 1 3.7745e-07 1 3.775e-07 0 3.8e-07 0 3.8005e-07 1 3.8145e-07 1 3.815e-07 0]
VIP (IP 0) vsource type=pwl wave=[0 0.45087890625 5.21e-08 0.45087890625 5.215e-08 0.45087890625 5.61e-08 0.45087890625 5.615e-08 0.44912109375 6.01e-08 0.44912109375 6.015e-08 0.4517578125 6.41e-08 0.4517578125 6.415e-08 0.4482421875 6.81e-08 0.4482421875 6.815e-08 0.453515625 7.21e-08 0.453515625 7.215e-08 0.446484375 7.61e-08 0.446484375 7.615e-08 0.875 8.01e-08 0.875 8.015e-08 0.025 1.521e-07 0.025 1.5215e-07 0.67587890625 1.561e-07 0.67587890625 1.5615e-07 0.67412109375 1.601e-07 0.67412109375 1.6015e-07 0.6767578125 1.641e-07 0.6767578125 1.6415e-07 0.6732421875 1.681e-07 0.6732421875 1.6815e-07 0.678515625 1.721e-07 0.678515625 1.7215e-07 0.671484375 1.761e-07 0.671484375 1.7615e-07 0.875 1.801e-07 0.875 1.8015e-07 0.475 2.521e-07 0.475 2.5215e-07 0.45439453125 2.561e-07 0.45439453125 2.5615e-07 0.45263671875 2.601e-07 0.45263671875 2.6015e-07 0.4552734375 2.641e-07 0.4552734375 2.6415e-07 0.4517578125 2.681e-07 0.4517578125 2.6815e-07 0.45703125 2.721e-07 0.45703125 2.7215e-07 0.45 2.761e-07 0.45 2.7615e-07 0.45439453125 2.801e-07 0.45439453125 2.8015e-07 0.45263671875 3.521e-07 0.45263671875 3.5215e-07 0.85 3.561e-07 0.85 3.5615e-07 0.45087890625 3.601e-07 0.45087890625 3.6015e-07 0.05 3.641e-07 0.05 3.6415e-07 0.45087890625 3.681e-07 0.45087890625 3.6815e-07 0.85 3.721e-07 0.85 3.7215e-07 0.44912109375 3.761e-07 0.44912109375 3.7615e-07 0.05 3.801e-07 0.05 3.8015e-07 0.44912109375]
VIN (IN 0) vsource type=pwl wave=[0 0.44912109375 5.21e-08 0.44912109375 5.215e-08 0.44912109375 5.61e-08 0.44912109375 5.615e-08 0.45087890625 6.01e-08 0.45087890625 6.015e-08 0.4482421875 6.41e-08 0.4482421875 6.415e-08 0.4517578125 6.81e-08 0.4517578125 6.815e-08 0.446484375 7.21e-08 0.446484375 7.215e-08 0.453515625 7.61e-08 0.453515625 7.615e-08 0.025 8.01e-08 0.025 8.015e-08 0.875 1.521e-07 0.875 1.5215e-07 0.67412109375 1.561e-07 0.67412109375 1.5615e-07 0.67587890625 1.601e-07 0.67587890625 1.6015e-07 0.6732421875 1.641e-07 0.6732421875 1.6415e-07 0.6767578125 1.681e-07 0.6767578125 1.6815e-07 0.671484375 1.721e-07 0.671484375 1.7215e-07 0.678515625 1.761e-07 0.678515625 1.7615e-07 0.475 1.801e-07 0.475 1.8015e-07 0.875 2.521e-07 0.875 2.5215e-07 0.45263671875 2.561e-07 0.45263671875 2.5615e-07 0.45439453125 2.601e-07 0.45439453125 2.6015e-07 0.4517578125 2.641e-07 0.4517578125 2.6415e-07 0.4552734375 2.681e-07 0.4552734375 2.6815e-07 0.45 2.721e-07 0.45 2.7215e-07 0.45703125 2.761e-07 0.45703125 2.7615e-07 0.45263671875 2.801e-07 0.45263671875 2.8015e-07 0.45439453125 3.521e-07 0.45439453125 3.5215e-07 0.05 3.561e-07 0.05 3.5615e-07 0.44912109375 3.601e-07 0.44912109375 3.6015e-07 0.85 3.641e-07 0.85 3.6415e-07 0.44912109375 3.681e-07 0.44912109375 3.6815e-07 0.05 3.721e-07 0.05 3.7215e-07 0.45087890625 3.761e-07 0.45087890625 3.7615e-07 0.85 3.801e-07 0.85 3.8015e-07 0.45087890625]
VSA4_driven (UA4_driven 0) vsource dc=0.99
XA4_driven (CK IP IN UA4_driven 0 OPA4_driven ONA4_driven) cmp_A4
CLPA4_driven (OPA4_driven 0) capacitor c=6.1e-15
CLNA4_driven (ONA4_driven 0) capacitor c=6.1e-15
VSA4_held (UA4_held 0) vsource dc=0.99
SPA4_held (IP PA4_held TRACK 0) relay rclosed=1 ropen=1e15 vt1=.4 vt2=.6
SNA4_held (IN NA4_held TRACK 0) relay rclosed=1 ropen=1e15 vt1=.4 vt2=.6
CPA4_held (PA4_held 0) capacitor c=1.28p
CNA4_held (NA4_held 0) capacitor c=1.28p
XA4_held (CK PA4_held NA4_held UA4_held 0 OPA4_held ONA4_held) cmp_A4
CLPA4_held (OPA4_held 0) capacitor c=6.1e-15
CLNA4_held (ONA4_held 0) capacitor c=6.1e-15
simulatorOptions options reltol=1e-6 vabstol=1e-8 iabstol=1e-14 temp=125 tnom=27
saveOptions options save=selected currents=selected
tran_test tran stop=3.81025e-07 maxstep=20p errpreset=conservative
save CK IN IP NA4_held ONA4_driven ONA4_held OPA4_driven OPA4_held PA4_held TRACK UA4_driven UA4_held VCK:1 VSA4_driven:1 VSA4_held:1 XA4_driven.LN XA4_driven.LP XA4_driven.net1 XA4_driven.net2 XA4_driven.net3 XA4_held.LN XA4_held.LP XA4_held.net1 XA4_held.net2 XA4_held.net3
save XA4_held.M6:2 XA4_held.M0:2 XA4_held.M7:1 XA4_held.M1:1 XA4_held.M4:1 XA4_held.M13:2 XA4_held.M14:2
save XA4_held.M0:1 XA4_held.M0:2 XA4_held.M0:3 XA4_held.M0:4 XA4_held.M1:1 XA4_held.M1:2 XA4_held.M1:3 XA4_held.M1:4 XA4_held.M2:1 XA4_held.M2:2 XA4_held.M2:3 XA4_held.M2:4 XA4_held.M3:1 XA4_held.M3:2 XA4_held.M3:3 XA4_held.M3:4 XA4_held.M4:1 XA4_held.M4:2 XA4_held.M4:3 XA4_held.M4:4 XA4_held.M5:1 XA4_held.M5:2 XA4_held.M5:3 XA4_held.M5:4 XA4_held.M6:1 XA4_held.M6:2 XA4_held.M6:3 XA4_held.M6:4 XA4_held.M7:1 XA4_held.M7:2 XA4_held.M7:3 XA4_held.M7:4 XA4_held.M8:1 XA4_held.M8:2 XA4_held.M8:3 XA4_held.M8:4 XA4_held.M9:1 XA4_held.M9:2 XA4_held.M9:3 XA4_held.M9:4 XA4_held.M10:1 XA4_held.M10:2 XA4_held.M10:3 XA4_held.M10:4 XA4_held.M11:1 XA4_held.M11:2 XA4_held.M11:3 XA4_held.M11:4 XA4_held.M12:1 XA4_held.M12:2 XA4_held.M12:3 XA4_held.M12:4 XA4_held.M13:1 XA4_held.M13:2 XA4_held.M13:3 XA4_held.M13:4 XA4_held.M14:1 XA4_held.M14:2 XA4_held.M14:3 XA4_held.M14:4 XA4_held.M0:id XA4_held.M0:ids XA4_held.M0:igs XA4_held.M0:igd XA4_held.M0:igb XA4_held.M0:ibd XA4_held.M0:ibs XA4_held.M0:igidl XA4_held.M0:igisl XA4_held.M0:qg XA4_held.M0:qd XA4_held.M0:qs XA4_held.M0:qb XA4_held.M1:id XA4_held.M1:ids XA4_held.M1:igs XA4_held.M1:igd XA4_held.M1:igb XA4_held.M1:ibd XA4_held.M1:ibs XA4_held.M1:igidl XA4_held.M1:igisl XA4_held.M1:qg XA4_held.M1:qd XA4_held.M1:qs XA4_held.M1:qb XA4_held.M2:id XA4_held.M2:ids XA4_held.M2:igs XA4_held.M2:igd XA4_held.M2:igb XA4_held.M2:ibd XA4_held.M2:ibs XA4_held.M2:igidl XA4_held.M2:igisl XA4_held.M2:qg XA4_held.M2:qd XA4_held.M2:qs XA4_held.M2:qb XA4_held.M3:id XA4_held.M3:ids XA4_held.M3:igs XA4_held.M3:igd XA4_held.M3:igb XA4_held.M3:ibd XA4_held.M3:ibs XA4_held.M3:igidl XA4_held.M3:igisl XA4_held.M3:qg XA4_held.M3:qd XA4_held.M3:qs XA4_held.M3:qb XA4_held.M4:id XA4_held.M4:ids XA4_held.M4:igs XA4_held.M4:igd XA4_held.M4:igb XA4_held.M4:ibd XA4_held.M4:ibs XA4_held.M4:igidl XA4_held.M4:igisl XA4_held.M4:qg XA4_held.M4:qd XA4_held.M4:qs XA4_held.M4:qb XA4_held.M5:id XA4_held.M5:ids XA4_held.M5:igs XA4_held.M5:igd XA4_held.M5:igb XA4_held.M5:ibd XA4_held.M5:ibs XA4_held.M5:igidl XA4_held.M5:igisl XA4_held.M5:qg XA4_held.M5:qd XA4_held.M5:qs XA4_held.M5:qb XA4_held.M6:id XA4_held.M6:ids XA4_held.M6:igs XA4_held.M6:igd XA4_held.M6:igb XA4_held.M6:ibd XA4_held.M6:ibs XA4_held.M6:igidl XA4_held.M6:igisl XA4_held.M6:qg XA4_held.M6:qd XA4_held.M6:qs XA4_held.M6:qb XA4_held.M7:id XA4_held.M7:ids XA4_held.M7:igs XA4_held.M7:igd XA4_held.M7:igb XA4_held.M7:ibd XA4_held.M7:ibs XA4_held.M7:igidl XA4_held.M7:igisl XA4_held.M7:qg XA4_held.M7:qd XA4_held.M7:qs XA4_held.M7:qb XA4_held.M8:id XA4_held.M8:ids XA4_held.M8:igs XA4_held.M8:igd XA4_held.M8:igb XA4_held.M8:ibd XA4_held.M8:ibs XA4_held.M8:igidl XA4_held.M8:igisl XA4_held.M8:qg XA4_held.M8:qd XA4_held.M8:qs XA4_held.M8:qb XA4_held.M9:id XA4_held.M9:ids XA4_held.M9:igs XA4_held.M9:igd XA4_held.M9:igb XA4_held.M9:ibd XA4_held.M9:ibs XA4_held.M9:igidl XA4_held.M9:igisl XA4_held.M9:qg XA4_held.M9:qd XA4_held.M9:qs XA4_held.M9:qb XA4_held.M10:id XA4_held.M10:ids XA4_held.M10:igs XA4_held.M10:igd XA4_held.M10:igb XA4_held.M10:ibd XA4_held.M10:ibs XA4_held.M10:igidl XA4_held.M10:igisl XA4_held.M10:qg XA4_held.M10:qd XA4_held.M10:qs XA4_held.M10:qb XA4_held.M11:id XA4_held.M11:ids XA4_held.M11:igs XA4_held.M11:igd XA4_held.M11:igb XA4_held.M11:ibd XA4_held.M11:ibs XA4_held.M11:igidl XA4_held.M11:igisl XA4_held.M11:qg XA4_held.M11:qd XA4_held.M11:qs XA4_held.M11:qb XA4_held.M12:id XA4_held.M12:ids XA4_held.M12:igs XA4_held.M12:igd XA4_held.M12:igb XA4_held.M12:ibd XA4_held.M12:ibs XA4_held.M12:igidl XA4_held.M12:igisl XA4_held.M12:qg XA4_held.M12:qd XA4_held.M12:qs XA4_held.M12:qb XA4_held.M13:id XA4_held.M13:ids XA4_held.M13:igs XA4_held.M13:igd XA4_held.M13:igb XA4_held.M13:ibd XA4_held.M13:ibs XA4_held.M13:igidl XA4_held.M13:igisl XA4_held.M13:qg XA4_held.M13:qd XA4_held.M13:qs XA4_held.M13:qb XA4_held.M14:id XA4_held.M14:ids XA4_held.M14:igs XA4_held.M14:igd XA4_held.M14:igb XA4_held.M14:ibd XA4_held.M14:ibs XA4_held.M14:igidl XA4_held.M14:igisl XA4_held.M14:qg XA4_held.M14:qd XA4_held.M14:qs XA4_held.M14:qb
