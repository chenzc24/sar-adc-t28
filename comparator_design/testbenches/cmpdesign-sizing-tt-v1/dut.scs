simulator lang=spectre
subckt cmp_B0 CLK VINP VINN VDD GND DCMPP DCMPN
M13 (DCMPN LN VDD VDD) pch_mac l=30n w=100n multi=1 nf=1 sd=100n          ad=7.5e-15 as=7.5e-15 pd=350.0n ps=350.0n nrd=1.466664          nrs=1.466664 sa=75.0n sb=75.0n sa1=75.0n sa2=75.0n sa3=75.0n          sa4=75.0n sb1=75.0n sb2=75.0n sb3=75.0n spa=100n spa1=100n          spa2=100n spa3=100n sap=91.9776n sapb=114.444n spba=115.715n          spba1=117.043n dfm_flag=0 spmt=1.11111e+15 spomt=0          spomt1=1.11111e+60 spmb=1.11111e+15 spomb=0 spomb1=1.11111e+60
M11 (DCMPP LP VDD VDD) pch_mac l=30n w=100n multi=1 nf=1 sd=100n          ad=7.5e-15 as=7.5e-15 pd=350.0n ps=350.0n nrd=1.466664          nrs=1.466664 sa=75.0n sb=75.0n sa1=75.0n sa2=75.0n sa3=75.0n          sa4=75.0n sb1=75.0n sb2=75.0n sb3=75.0n spa=100n spa1=100n          spa2=100n spa3=100n sap=91.9776n sapb=114.444n spba=115.715n          spba1=117.043n dfm_flag=0 spmt=1.11111e+15 spomt=0          spomt1=1.11111e+60 spmb=1.11111e+15 spomb=0 spomb1=1.11111e+60
M5 (net2 CLK VDD VDD) pch_mac l=30n w=100n multi=1 nf=1 sd=100n ad=7.5e-15          as=7.5e-15 pd=350.0n ps=350.0n nrd=1.466664 nrs=1.466664 sa=75.0n          sb=75.0n sa1=75.0n sa2=75.0n sa3=75.0n sa4=75.0n sb1=75.0n          sb2=75.0n sb3=75.0n spa=100n spa1=100n spa2=100n spa3=100n          sap=91.9776n sapb=114.444n spba=115.715n spba1=117.043n dfm_flag=0          spmt=1.11111e+15 spomt=0 spomt1=1.11111e+60 spmb=1.11111e+15          spomb=0 spomb1=1.11111e+60
M4 (LN CLK VDD VDD) pch_mac l=30n w=100n multi=1 nf=1 sd=100n ad=7.5e-15          as=7.5e-15 pd=350.0n ps=350.0n nrd=1.466664 nrs=1.466664 sa=75.0n          sb=75.0n sa1=75.0n sa2=75.0n sa3=75.0n sa4=75.0n sb1=75.0n          sb2=75.0n sb3=75.0n spa=100n spa1=100n spa2=100n spa3=100n          sap=91.9776n sapb=114.444n spba=115.715n spba1=117.043n dfm_flag=0          spmt=1.11111e+15 spomt=0 spomt1=1.11111e+60 spmb=1.11111e+15          spomb=0 spomb1=1.11111e+60
M3 (net1 CLK VDD VDD) pch_mac l=30n w=100n multi=1 nf=1 sd=100n ad=7.5e-15          as=7.5e-15 pd=350.0n ps=350.0n nrd=1.466664 nrs=1.466664 sa=75.0n          sb=75.0n sa1=75.0n sa2=75.0n sa3=75.0n sa4=75.0n sb1=75.0n          sb2=75.0n sb3=75.0n spa=100n spa1=100n spa2=100n spa3=100n          sap=91.9776n sapb=114.444n spba=115.715n spba1=117.043n dfm_flag=0          spmt=1.11111e+15 spomt=0 spomt1=1.11111e+60 spmb=1.11111e+15          spomb=0 spomb1=1.11111e+60
M2 (LP CLK VDD VDD) pch_mac l=30n w=100n multi=1 nf=1 sd=100n ad=7.5e-15          as=7.5e-15 pd=350.0n ps=350.0n nrd=1.466664 nrs=1.466664 sa=75.0n          sb=75.0n sa1=75.0n sa2=75.0n sa3=75.0n sa4=75.0n sb1=75.0n          sb2=75.0n sb3=75.0n spa=100n spa1=100n spa2=100n spa3=100n          sap=91.9776n sapb=114.444n spba=115.715n spba1=117.043n dfm_flag=0          spmt=1.11111e+15 spomt=0 spomt1=1.11111e+60 spmb=1.11111e+15          spomb=0 spomb1=1.11111e+60
M0 (LP LN VDD VDD) pch_mac l=30n w=100n multi=1 nf=1 sd=100n ad=7.5e-15          as=7.5e-15 pd=350.0n ps=350.0n nrd=1.466664 nrs=1.466664 sa=75.0n          sb=75.0n sa1=75.0n sa2=75.0n sa3=75.0n sa4=75.0n sb1=75.0n          sb2=75.0n sb3=75.0n spa=100n spa1=100n spa2=100n spa3=100n          sap=91.9776n sapb=114.444n spba=115.715n spba1=117.043n dfm_flag=0          spmt=1.11111e+15 spomt=0 spomt1=1.11111e+60 spmb=1.11111e+15          spomb=0 spomb1=1.11111e+60
M1 (LN LP VDD VDD) pch_mac l=30n w=100n multi=1 nf=1 sd=100n ad=7.5e-15          as=7.5e-15 pd=350.0n ps=350.0n nrd=1.466664 nrs=1.466664 sa=75.0n          sb=75.0n sa1=75.0n sa2=75.0n sa3=75.0n sa4=75.0n sb1=75.0n          sb2=75.0n sb3=75.0n spa=100n spa1=100n spa2=100n spa3=100n          sap=91.9776n sapb=114.444n spba=115.715n spba1=117.043n dfm_flag=0          spmt=1.11111e+15 spomt=0 spomt1=1.11111e+60 spmb=1.11111e+15          spomb=0 spomb1=1.11111e+60
M14 (DCMPN LN GND GND) nch_mac l=30n w=100n multi=1 nf=1 sd=100n          ad=7.5e-15 as=7.5e-15 pd=350.0n ps=350.0n nrd=2.576626          nrs=2.576626 sa=75.0n sb=75.0n sa1=75.0n sa2=75.0n sa3=75.0n          sa4=75.0n sb1=75.0n sb2=75.0n sb3=75.0n spa=100n spa1=100n          spa2=100n spa3=100n sap=91.9776n sapb=114.444n spba=115.715n          spba1=117.043n dfm_flag=0 spmt=1.11111e+15 spomt=0          spomt1=1.11111e+60 spmb=1.11111e+15 spomb=0 spomb1=1.11111e+60
M12 (DCMPP LP GND GND) nch_mac l=30n w=100n multi=1 nf=1 sd=100n          ad=7.5e-15 as=7.5e-15 pd=350.0n ps=350.0n nrd=2.576626          nrs=2.576626 sa=75.0n sb=75.0n sa1=75.0n sa2=75.0n sa3=75.0n          sa4=75.0n sb1=75.0n sb2=75.0n sb3=75.0n spa=100n spa1=100n          spa2=100n spa3=100n sap=91.9776n sapb=114.444n spba=115.715n          spba1=117.043n dfm_flag=0 spmt=1.11111e+15 spomt=0          spomt1=1.11111e+60 spmb=1.11111e+15 spomb=0 spomb1=1.11111e+60
M10 (net3 CLK GND GND) nch_mac l=30n w=100n multi=1 nf=1 sd=100n          ad=7.5e-15 as=7.5e-15 pd=350.0n ps=350.0n nrd=2.576626          nrs=2.576626 sa=75.0n sb=75.0n sa1=75.0n sa2=75.0n sa3=75.0n          sa4=75.0n sb1=75.0n sb2=75.0n sb3=75.0n spa=100n spa1=100n          spa2=100n spa3=100n sap=91.9776n sapb=114.444n spba=115.715n          spba1=117.043n dfm_flag=0 spmt=1.11111e+15 spomt=0          spomt1=1.11111e+60 spmb=1.11111e+15 spomb=0 spomb1=1.11111e+60
M9 (net2 VINN net3 GND) nch_mac l=30n w=100n multi=1 nf=1 sd=100n          ad=7.5e-15 as=7.5e-15 pd=350.0n ps=350.0n nrd=2.576626          nrs=2.576626 sa=75.0n sb=75.0n sa1=75.0n sa2=75.0n sa3=75.0n          sa4=75.0n sb1=75.0n sb2=75.0n sb3=75.0n spa=100n spa1=100n          spa2=100n spa3=100n sap=91.9776n sapb=114.444n spba=115.715n          spba1=117.043n dfm_flag=0 spmt=1.11111e+15 spomt=0          spomt1=1.11111e+60 spmb=1.11111e+15 spomb=0 spomb1=1.11111e+60
M8 (net1 VINP net3 GND) nch_mac l=30n w=100n multi=1 nf=1 sd=100n          ad=7.5e-15 as=7.5e-15 pd=350.0n ps=350.0n nrd=2.576626          nrs=2.576626 sa=75.0n sb=75.0n sa1=75.0n sa2=75.0n sa3=75.0n          sa4=75.0n sb1=75.0n sb2=75.0n sb3=75.0n spa=100n spa1=100n          spa2=100n spa3=100n sap=91.9776n sapb=114.444n spba=115.715n          spba1=117.043n dfm_flag=0 spmt=1.11111e+15 spomt=0          spomt1=1.11111e+60 spmb=1.11111e+15 spomb=0 spomb1=1.11111e+60
M7 (LN LP net2 GND) nch_mac l=30n w=100n multi=1 nf=1 sd=100n ad=7.5e-15          as=7.5e-15 pd=350.0n ps=350.0n nrd=2.576626 nrs=2.576626 sa=75.0n          sb=75.0n sa1=75.0n sa2=75.0n sa3=75.0n sa4=75.0n sb1=75.0n          sb2=75.0n sb3=75.0n spa=100n spa1=100n spa2=100n spa3=100n          sap=91.9776n sapb=114.444n spba=115.715n spba1=117.043n dfm_flag=0          spmt=1.11111e+15 spomt=0 spomt1=1.11111e+60 spmb=1.11111e+15          spomb=0 spomb1=1.11111e+60
M6 (LP LN net1 GND) nch_mac l=30n w=100n multi=1 nf=1 sd=100n ad=7.5e-15          as=7.5e-15 pd=350.0n ps=350.0n nrd=2.576626 nrs=2.576626 sa=75.0n          sb=75.0n sa1=75.0n sa2=75.0n sa3=75.0n sa4=75.0n sb1=75.0n          sb2=75.0n sb3=75.0n spa=100n spa1=100n spa2=100n spa3=100n          sap=91.9776n sapb=114.444n spba=115.715n spba1=117.043n dfm_flag=0          spmt=1.11111e+15 spomt=0 spomt1=1.11111e+60 spmb=1.11111e+15          spomb=0 spomb1=1.11111e+60
ends cmp_B0
subckt cmp_I4 CLK VINP VINN VDD GND DCMPP DCMPN
M13 (DCMPN LN VDD VDD) pch_mac l=30n w=100n multi=1 nf=1 sd=100n          ad=7.5e-15 as=7.5e-15 pd=350.0n ps=350.0n nrd=1.466664          nrs=1.466664 sa=75.0n sb=75.0n sa1=75.0n sa2=75.0n sa3=75.0n          sa4=75.0n sb1=75.0n sb2=75.0n sb3=75.0n spa=100n spa1=100n          spa2=100n spa3=100n sap=91.9776n sapb=114.444n spba=115.715n          spba1=117.043n dfm_flag=0 spmt=1.11111e+15 spomt=0          spomt1=1.11111e+60 spmb=1.11111e+15 spomb=0 spomb1=1.11111e+60
M11 (DCMPP LP VDD VDD) pch_mac l=30n w=100n multi=1 nf=1 sd=100n          ad=7.5e-15 as=7.5e-15 pd=350.0n ps=350.0n nrd=1.466664          nrs=1.466664 sa=75.0n sb=75.0n sa1=75.0n sa2=75.0n sa3=75.0n          sa4=75.0n sb1=75.0n sb2=75.0n sb3=75.0n spa=100n spa1=100n          spa2=100n spa3=100n sap=91.9776n sapb=114.444n spba=115.715n          spba1=117.043n dfm_flag=0 spmt=1.11111e+15 spomt=0          spomt1=1.11111e+60 spmb=1.11111e+15 spomb=0 spomb1=1.11111e+60
M5 (net2 CLK VDD VDD) pch_mac l=30n w=100n multi=1 nf=1 sd=100n ad=7.5e-15          as=7.5e-15 pd=350.0n ps=350.0n nrd=1.466664 nrs=1.466664 sa=75.0n          sb=75.0n sa1=75.0n sa2=75.0n sa3=75.0n sa4=75.0n sb1=75.0n          sb2=75.0n sb3=75.0n spa=100n spa1=100n spa2=100n spa3=100n          sap=91.9776n sapb=114.444n spba=115.715n spba1=117.043n dfm_flag=0          spmt=1.11111e+15 spomt=0 spomt1=1.11111e+60 spmb=1.11111e+15          spomb=0 spomb1=1.11111e+60
M4 (LN CLK VDD VDD) pch_mac l=30n w=100n multi=1 nf=1 sd=100n ad=7.5e-15          as=7.5e-15 pd=350.0n ps=350.0n nrd=1.466664 nrs=1.466664 sa=75.0n          sb=75.0n sa1=75.0n sa2=75.0n sa3=75.0n sa4=75.0n sb1=75.0n          sb2=75.0n sb3=75.0n spa=100n spa1=100n spa2=100n spa3=100n          sap=91.9776n sapb=114.444n spba=115.715n spba1=117.043n dfm_flag=0          spmt=1.11111e+15 spomt=0 spomt1=1.11111e+60 spmb=1.11111e+15          spomb=0 spomb1=1.11111e+60
M3 (net1 CLK VDD VDD) pch_mac l=30n w=100n multi=1 nf=1 sd=100n ad=7.5e-15          as=7.5e-15 pd=350.0n ps=350.0n nrd=1.466664 nrs=1.466664 sa=75.0n          sb=75.0n sa1=75.0n sa2=75.0n sa3=75.0n sa4=75.0n sb1=75.0n          sb2=75.0n sb3=75.0n spa=100n spa1=100n spa2=100n spa3=100n          sap=91.9776n sapb=114.444n spba=115.715n spba1=117.043n dfm_flag=0          spmt=1.11111e+15 spomt=0 spomt1=1.11111e+60 spmb=1.11111e+15          spomb=0 spomb1=1.11111e+60
M2 (LP CLK VDD VDD) pch_mac l=30n w=100n multi=1 nf=1 sd=100n ad=7.5e-15          as=7.5e-15 pd=350.0n ps=350.0n nrd=1.466664 nrs=1.466664 sa=75.0n          sb=75.0n sa1=75.0n sa2=75.0n sa3=75.0n sa4=75.0n sb1=75.0n          sb2=75.0n sb3=75.0n spa=100n spa1=100n spa2=100n spa3=100n          sap=91.9776n sapb=114.444n spba=115.715n spba1=117.043n dfm_flag=0          spmt=1.11111e+15 spomt=0 spomt1=1.11111e+60 spmb=1.11111e+15          spomb=0 spomb1=1.11111e+60
M0 (LP LN VDD VDD) pch_mac l=30n w=100n multi=1 nf=1 sd=100n ad=7.5e-15          as=7.5e-15 pd=350.0n ps=350.0n nrd=1.466664 nrs=1.466664 sa=75.0n          sb=75.0n sa1=75.0n sa2=75.0n sa3=75.0n sa4=75.0n sb1=75.0n          sb2=75.0n sb3=75.0n spa=100n spa1=100n spa2=100n spa3=100n          sap=91.9776n sapb=114.444n spba=115.715n spba1=117.043n dfm_flag=0          spmt=1.11111e+15 spomt=0 spomt1=1.11111e+60 spmb=1.11111e+15          spomb=0 spomb1=1.11111e+60
M1 (LN LP VDD VDD) pch_mac l=30n w=100n multi=1 nf=1 sd=100n ad=7.5e-15          as=7.5e-15 pd=350.0n ps=350.0n nrd=1.466664 nrs=1.466664 sa=75.0n          sb=75.0n sa1=75.0n sa2=75.0n sa3=75.0n sa4=75.0n sb1=75.0n          sb2=75.0n sb3=75.0n spa=100n spa1=100n spa2=100n spa3=100n          sap=91.9776n sapb=114.444n spba=115.715n spba1=117.043n dfm_flag=0          spmt=1.11111e+15 spomt=0 spomt1=1.11111e+60 spmb=1.11111e+15          spomb=0 spomb1=1.11111e+60
M14 (DCMPN LN GND GND) nch_mac l=30n w=100n multi=1 nf=1 sd=100n          ad=7.5e-15 as=7.5e-15 pd=350.0n ps=350.0n nrd=2.576626          nrs=2.576626 sa=75.0n sb=75.0n sa1=75.0n sa2=75.0n sa3=75.0n          sa4=75.0n sb1=75.0n sb2=75.0n sb3=75.0n spa=100n spa1=100n          spa2=100n spa3=100n sap=91.9776n sapb=114.444n spba=115.715n          spba1=117.043n dfm_flag=0 spmt=1.11111e+15 spomt=0          spomt1=1.11111e+60 spmb=1.11111e+15 spomb=0 spomb1=1.11111e+60
M12 (DCMPP LP GND GND) nch_mac l=30n w=100n multi=1 nf=1 sd=100n          ad=7.5e-15 as=7.5e-15 pd=350.0n ps=350.0n nrd=2.576626          nrs=2.576626 sa=75.0n sb=75.0n sa1=75.0n sa2=75.0n sa3=75.0n          sa4=75.0n sb1=75.0n sb2=75.0n sb3=75.0n spa=100n spa1=100n          spa2=100n spa3=100n sap=91.9776n sapb=114.444n spba=115.715n          spba1=117.043n dfm_flag=0 spmt=1.11111e+15 spomt=0          spomt1=1.11111e+60 spmb=1.11111e+15 spomb=0 spomb1=1.11111e+60
M10 (net3 CLK GND GND) nch_mac l=30n w=100n multi=1 nf=1 sd=100n          ad=7.5e-15 as=7.5e-15 pd=350.0n ps=350.0n nrd=2.576626          nrs=2.576626 sa=75.0n sb=75.0n sa1=75.0n sa2=75.0n sa3=75.0n          sa4=75.0n sb1=75.0n sb2=75.0n sb3=75.0n spa=100n spa1=100n          spa2=100n spa3=100n sap=91.9776n sapb=114.444n spba=115.715n          spba1=117.043n dfm_flag=0 spmt=1.11111e+15 spomt=0          spomt1=1.11111e+60 spmb=1.11111e+15 spomb=0 spomb1=1.11111e+60
M9 (net2 VINN net3 GND) nch_mac l=30n w=100n multi=4 nf=1 sd=100n          ad=7.5e-15 as=7.5e-15 pd=350.0n ps=350.0n nrd=2.576626          nrs=2.576626 sa=75.0n sb=75.0n sa1=75.0n sa2=75.0n sa3=75.0n          sa4=75.0n sb1=75.0n sb2=75.0n sb3=75.0n spa=100n spa1=100n          spa2=100n spa3=100n sap=91.9776n sapb=114.444n spba=115.715n          spba1=117.043n dfm_flag=0 spmt=1.11111e+15 spomt=0          spomt1=1.11111e+60 spmb=1.11111e+15 spomb=0 spomb1=1.11111e+60
M8 (net1 VINP net3 GND) nch_mac l=30n w=100n multi=4 nf=1 sd=100n          ad=7.5e-15 as=7.5e-15 pd=350.0n ps=350.0n nrd=2.576626          nrs=2.576626 sa=75.0n sb=75.0n sa1=75.0n sa2=75.0n sa3=75.0n          sa4=75.0n sb1=75.0n sb2=75.0n sb3=75.0n spa=100n spa1=100n          spa2=100n spa3=100n sap=91.9776n sapb=114.444n spba=115.715n          spba1=117.043n dfm_flag=0 spmt=1.11111e+15 spomt=0          spomt1=1.11111e+60 spmb=1.11111e+15 spomb=0 spomb1=1.11111e+60
M7 (LN LP net2 GND) nch_mac l=30n w=100n multi=1 nf=1 sd=100n ad=7.5e-15          as=7.5e-15 pd=350.0n ps=350.0n nrd=2.576626 nrs=2.576626 sa=75.0n          sb=75.0n sa1=75.0n sa2=75.0n sa3=75.0n sa4=75.0n sb1=75.0n          sb2=75.0n sb3=75.0n spa=100n spa1=100n spa2=100n spa3=100n          sap=91.9776n sapb=114.444n spba=115.715n spba1=117.043n dfm_flag=0          spmt=1.11111e+15 spomt=0 spomt1=1.11111e+60 spmb=1.11111e+15          spomb=0 spomb1=1.11111e+60
M6 (LP LN net1 GND) nch_mac l=30n w=100n multi=1 nf=1 sd=100n ad=7.5e-15          as=7.5e-15 pd=350.0n ps=350.0n nrd=2.576626 nrs=2.576626 sa=75.0n          sb=75.0n sa1=75.0n sa2=75.0n sa3=75.0n sa4=75.0n sb1=75.0n          sb2=75.0n sb3=75.0n spa=100n spa1=100n spa2=100n spa3=100n          sap=91.9776n sapb=114.444n spba=115.715n spba1=117.043n dfm_flag=0          spmt=1.11111e+15 spomt=0 spomt1=1.11111e+60 spmb=1.11111e+15          spomb=0 spomb1=1.11111e+60
ends cmp_I4
subckt cmp_T4 CLK VINP VINN VDD GND DCMPP DCMPN
M13 (DCMPN LN VDD VDD) pch_mac l=30n w=100n multi=1 nf=1 sd=100n          ad=7.5e-15 as=7.5e-15 pd=350.0n ps=350.0n nrd=1.466664          nrs=1.466664 sa=75.0n sb=75.0n sa1=75.0n sa2=75.0n sa3=75.0n          sa4=75.0n sb1=75.0n sb2=75.0n sb3=75.0n spa=100n spa1=100n          spa2=100n spa3=100n sap=91.9776n sapb=114.444n spba=115.715n          spba1=117.043n dfm_flag=0 spmt=1.11111e+15 spomt=0          spomt1=1.11111e+60 spmb=1.11111e+15 spomb=0 spomb1=1.11111e+60
M11 (DCMPP LP VDD VDD) pch_mac l=30n w=100n multi=1 nf=1 sd=100n          ad=7.5e-15 as=7.5e-15 pd=350.0n ps=350.0n nrd=1.466664          nrs=1.466664 sa=75.0n sb=75.0n sa1=75.0n sa2=75.0n sa3=75.0n          sa4=75.0n sb1=75.0n sb2=75.0n sb3=75.0n spa=100n spa1=100n          spa2=100n spa3=100n sap=91.9776n sapb=114.444n spba=115.715n          spba1=117.043n dfm_flag=0 spmt=1.11111e+15 spomt=0          spomt1=1.11111e+60 spmb=1.11111e+15 spomb=0 spomb1=1.11111e+60
M5 (net2 CLK VDD VDD) pch_mac l=30n w=100n multi=1 nf=1 sd=100n ad=7.5e-15          as=7.5e-15 pd=350.0n ps=350.0n nrd=1.466664 nrs=1.466664 sa=75.0n          sb=75.0n sa1=75.0n sa2=75.0n sa3=75.0n sa4=75.0n sb1=75.0n          sb2=75.0n sb3=75.0n spa=100n spa1=100n spa2=100n spa3=100n          sap=91.9776n sapb=114.444n spba=115.715n spba1=117.043n dfm_flag=0          spmt=1.11111e+15 spomt=0 spomt1=1.11111e+60 spmb=1.11111e+15          spomb=0 spomb1=1.11111e+60
M4 (LN CLK VDD VDD) pch_mac l=30n w=100n multi=1 nf=1 sd=100n ad=7.5e-15          as=7.5e-15 pd=350.0n ps=350.0n nrd=1.466664 nrs=1.466664 sa=75.0n          sb=75.0n sa1=75.0n sa2=75.0n sa3=75.0n sa4=75.0n sb1=75.0n          sb2=75.0n sb3=75.0n spa=100n spa1=100n spa2=100n spa3=100n          sap=91.9776n sapb=114.444n spba=115.715n spba1=117.043n dfm_flag=0          spmt=1.11111e+15 spomt=0 spomt1=1.11111e+60 spmb=1.11111e+15          spomb=0 spomb1=1.11111e+60
M3 (net1 CLK VDD VDD) pch_mac l=30n w=100n multi=1 nf=1 sd=100n ad=7.5e-15          as=7.5e-15 pd=350.0n ps=350.0n nrd=1.466664 nrs=1.466664 sa=75.0n          sb=75.0n sa1=75.0n sa2=75.0n sa3=75.0n sa4=75.0n sb1=75.0n          sb2=75.0n sb3=75.0n spa=100n spa1=100n spa2=100n spa3=100n          sap=91.9776n sapb=114.444n spba=115.715n spba1=117.043n dfm_flag=0          spmt=1.11111e+15 spomt=0 spomt1=1.11111e+60 spmb=1.11111e+15          spomb=0 spomb1=1.11111e+60
M2 (LP CLK VDD VDD) pch_mac l=30n w=100n multi=1 nf=1 sd=100n ad=7.5e-15          as=7.5e-15 pd=350.0n ps=350.0n nrd=1.466664 nrs=1.466664 sa=75.0n          sb=75.0n sa1=75.0n sa2=75.0n sa3=75.0n sa4=75.0n sb1=75.0n          sb2=75.0n sb3=75.0n spa=100n spa1=100n spa2=100n spa3=100n          sap=91.9776n sapb=114.444n spba=115.715n spba1=117.043n dfm_flag=0          spmt=1.11111e+15 spomt=0 spomt1=1.11111e+60 spmb=1.11111e+15          spomb=0 spomb1=1.11111e+60
M0 (LP LN VDD VDD) pch_mac l=30n w=100n multi=1 nf=1 sd=100n ad=7.5e-15          as=7.5e-15 pd=350.0n ps=350.0n nrd=1.466664 nrs=1.466664 sa=75.0n          sb=75.0n sa1=75.0n sa2=75.0n sa3=75.0n sa4=75.0n sb1=75.0n          sb2=75.0n sb3=75.0n spa=100n spa1=100n spa2=100n spa3=100n          sap=91.9776n sapb=114.444n spba=115.715n spba1=117.043n dfm_flag=0          spmt=1.11111e+15 spomt=0 spomt1=1.11111e+60 spmb=1.11111e+15          spomb=0 spomb1=1.11111e+60
M1 (LN LP VDD VDD) pch_mac l=30n w=100n multi=1 nf=1 sd=100n ad=7.5e-15          as=7.5e-15 pd=350.0n ps=350.0n nrd=1.466664 nrs=1.466664 sa=75.0n          sb=75.0n sa1=75.0n sa2=75.0n sa3=75.0n sa4=75.0n sb1=75.0n          sb2=75.0n sb3=75.0n spa=100n spa1=100n spa2=100n spa3=100n          sap=91.9776n sapb=114.444n spba=115.715n spba1=117.043n dfm_flag=0          spmt=1.11111e+15 spomt=0 spomt1=1.11111e+60 spmb=1.11111e+15          spomb=0 spomb1=1.11111e+60
M14 (DCMPN LN GND GND) nch_mac l=30n w=100n multi=1 nf=1 sd=100n          ad=7.5e-15 as=7.5e-15 pd=350.0n ps=350.0n nrd=2.576626          nrs=2.576626 sa=75.0n sb=75.0n sa1=75.0n sa2=75.0n sa3=75.0n          sa4=75.0n sb1=75.0n sb2=75.0n sb3=75.0n spa=100n spa1=100n          spa2=100n spa3=100n sap=91.9776n sapb=114.444n spba=115.715n          spba1=117.043n dfm_flag=0 spmt=1.11111e+15 spomt=0          spomt1=1.11111e+60 spmb=1.11111e+15 spomb=0 spomb1=1.11111e+60
M12 (DCMPP LP GND GND) nch_mac l=30n w=100n multi=1 nf=1 sd=100n          ad=7.5e-15 as=7.5e-15 pd=350.0n ps=350.0n nrd=2.576626          nrs=2.576626 sa=75.0n sb=75.0n sa1=75.0n sa2=75.0n sa3=75.0n          sa4=75.0n sb1=75.0n sb2=75.0n sb3=75.0n spa=100n spa1=100n          spa2=100n spa3=100n sap=91.9776n sapb=114.444n spba=115.715n          spba1=117.043n dfm_flag=0 spmt=1.11111e+15 spomt=0          spomt1=1.11111e+60 spmb=1.11111e+15 spomb=0 spomb1=1.11111e+60
M10 (net3 CLK GND GND) nch_mac l=30n w=100n multi=4 nf=1 sd=100n          ad=7.5e-15 as=7.5e-15 pd=350.0n ps=350.0n nrd=2.576626          nrs=2.576626 sa=75.0n sb=75.0n sa1=75.0n sa2=75.0n sa3=75.0n          sa4=75.0n sb1=75.0n sb2=75.0n sb3=75.0n spa=100n spa1=100n          spa2=100n spa3=100n sap=91.9776n sapb=114.444n spba=115.715n          spba1=117.043n dfm_flag=0 spmt=1.11111e+15 spomt=0          spomt1=1.11111e+60 spmb=1.11111e+15 spomb=0 spomb1=1.11111e+60
M9 (net2 VINN net3 GND) nch_mac l=30n w=100n multi=4 nf=1 sd=100n          ad=7.5e-15 as=7.5e-15 pd=350.0n ps=350.0n nrd=2.576626          nrs=2.576626 sa=75.0n sb=75.0n sa1=75.0n sa2=75.0n sa3=75.0n          sa4=75.0n sb1=75.0n sb2=75.0n sb3=75.0n spa=100n spa1=100n          spa2=100n spa3=100n sap=91.9776n sapb=114.444n spba=115.715n          spba1=117.043n dfm_flag=0 spmt=1.11111e+15 spomt=0          spomt1=1.11111e+60 spmb=1.11111e+15 spomb=0 spomb1=1.11111e+60
M8 (net1 VINP net3 GND) nch_mac l=30n w=100n multi=4 nf=1 sd=100n          ad=7.5e-15 as=7.5e-15 pd=350.0n ps=350.0n nrd=2.576626          nrs=2.576626 sa=75.0n sb=75.0n sa1=75.0n sa2=75.0n sa3=75.0n          sa4=75.0n sb1=75.0n sb2=75.0n sb3=75.0n spa=100n spa1=100n          spa2=100n spa3=100n sap=91.9776n sapb=114.444n spba=115.715n          spba1=117.043n dfm_flag=0 spmt=1.11111e+15 spomt=0          spomt1=1.11111e+60 spmb=1.11111e+15 spomb=0 spomb1=1.11111e+60
M7 (LN LP net2 GND) nch_mac l=30n w=100n multi=1 nf=1 sd=100n ad=7.5e-15          as=7.5e-15 pd=350.0n ps=350.0n nrd=2.576626 nrs=2.576626 sa=75.0n          sb=75.0n sa1=75.0n sa2=75.0n sa3=75.0n sa4=75.0n sb1=75.0n          sb2=75.0n sb3=75.0n spa=100n spa1=100n spa2=100n spa3=100n          sap=91.9776n sapb=114.444n spba=115.715n spba1=117.043n dfm_flag=0          spmt=1.11111e+15 spomt=0 spomt1=1.11111e+60 spmb=1.11111e+15          spomb=0 spomb1=1.11111e+60
M6 (LP LN net1 GND) nch_mac l=30n w=100n multi=1 nf=1 sd=100n ad=7.5e-15          as=7.5e-15 pd=350.0n ps=350.0n nrd=2.576626 nrs=2.576626 sa=75.0n          sb=75.0n sa1=75.0n sa2=75.0n sa3=75.0n sa4=75.0n sb1=75.0n          sb2=75.0n sb3=75.0n spa=100n spa1=100n spa2=100n spa3=100n          sap=91.9776n sapb=114.444n spba=115.715n spba1=117.043n dfm_flag=0          spmt=1.11111e+15 spomt=0 spomt1=1.11111e+60 spmb=1.11111e+15          spomb=0 spomb1=1.11111e+60
ends cmp_T4
subckt cmp_R2 CLK VINP VINN VDD GND DCMPP DCMPN
M13 (DCMPN LN VDD VDD) pch_mac l=30n w=100n multi=1 nf=1 sd=100n          ad=7.5e-15 as=7.5e-15 pd=350.0n ps=350.0n nrd=1.466664          nrs=1.466664 sa=75.0n sb=75.0n sa1=75.0n sa2=75.0n sa3=75.0n          sa4=75.0n sb1=75.0n sb2=75.0n sb3=75.0n spa=100n spa1=100n          spa2=100n spa3=100n sap=91.9776n sapb=114.444n spba=115.715n          spba1=117.043n dfm_flag=0 spmt=1.11111e+15 spomt=0          spomt1=1.11111e+60 spmb=1.11111e+15 spomb=0 spomb1=1.11111e+60
M11 (DCMPP LP VDD VDD) pch_mac l=30n w=100n multi=1 nf=1 sd=100n          ad=7.5e-15 as=7.5e-15 pd=350.0n ps=350.0n nrd=1.466664          nrs=1.466664 sa=75.0n sb=75.0n sa1=75.0n sa2=75.0n sa3=75.0n          sa4=75.0n sb1=75.0n sb2=75.0n sb3=75.0n spa=100n spa1=100n          spa2=100n spa3=100n sap=91.9776n sapb=114.444n spba=115.715n          spba1=117.043n dfm_flag=0 spmt=1.11111e+15 spomt=0          spomt1=1.11111e+60 spmb=1.11111e+15 spomb=0 spomb1=1.11111e+60
M5 (net2 CLK VDD VDD) pch_mac l=30n w=100n multi=1 nf=1 sd=100n ad=7.5e-15          as=7.5e-15 pd=350.0n ps=350.0n nrd=1.466664 nrs=1.466664 sa=75.0n          sb=75.0n sa1=75.0n sa2=75.0n sa3=75.0n sa4=75.0n sb1=75.0n          sb2=75.0n sb3=75.0n spa=100n spa1=100n spa2=100n spa3=100n          sap=91.9776n sapb=114.444n spba=115.715n spba1=117.043n dfm_flag=0          spmt=1.11111e+15 spomt=0 spomt1=1.11111e+60 spmb=1.11111e+15          spomb=0 spomb1=1.11111e+60
M4 (LN CLK VDD VDD) pch_mac l=30n w=100n multi=1 nf=1 sd=100n ad=7.5e-15          as=7.5e-15 pd=350.0n ps=350.0n nrd=1.466664 nrs=1.466664 sa=75.0n          sb=75.0n sa1=75.0n sa2=75.0n sa3=75.0n sa4=75.0n sb1=75.0n          sb2=75.0n sb3=75.0n spa=100n spa1=100n spa2=100n spa3=100n          sap=91.9776n sapb=114.444n spba=115.715n spba1=117.043n dfm_flag=0          spmt=1.11111e+15 spomt=0 spomt1=1.11111e+60 spmb=1.11111e+15          spomb=0 spomb1=1.11111e+60
M3 (net1 CLK VDD VDD) pch_mac l=30n w=100n multi=1 nf=1 sd=100n ad=7.5e-15          as=7.5e-15 pd=350.0n ps=350.0n nrd=1.466664 nrs=1.466664 sa=75.0n          sb=75.0n sa1=75.0n sa2=75.0n sa3=75.0n sa4=75.0n sb1=75.0n          sb2=75.0n sb3=75.0n spa=100n spa1=100n spa2=100n spa3=100n          sap=91.9776n sapb=114.444n spba=115.715n spba1=117.043n dfm_flag=0          spmt=1.11111e+15 spomt=0 spomt1=1.11111e+60 spmb=1.11111e+15          spomb=0 spomb1=1.11111e+60
M2 (LP CLK VDD VDD) pch_mac l=30n w=100n multi=1 nf=1 sd=100n ad=7.5e-15          as=7.5e-15 pd=350.0n ps=350.0n nrd=1.466664 nrs=1.466664 sa=75.0n          sb=75.0n sa1=75.0n sa2=75.0n sa3=75.0n sa4=75.0n sb1=75.0n          sb2=75.0n sb3=75.0n spa=100n spa1=100n spa2=100n spa3=100n          sap=91.9776n sapb=114.444n spba=115.715n spba1=117.043n dfm_flag=0          spmt=1.11111e+15 spomt=0 spomt1=1.11111e+60 spmb=1.11111e+15          spomb=0 spomb1=1.11111e+60
M0 (LP LN VDD VDD) pch_mac l=30n w=100n multi=2 nf=1 sd=100n ad=7.5e-15          as=7.5e-15 pd=350.0n ps=350.0n nrd=1.466664 nrs=1.466664 sa=75.0n          sb=75.0n sa1=75.0n sa2=75.0n sa3=75.0n sa4=75.0n sb1=75.0n          sb2=75.0n sb3=75.0n spa=100n spa1=100n spa2=100n spa3=100n          sap=91.9776n sapb=114.444n spba=115.715n spba1=117.043n dfm_flag=0          spmt=1.11111e+15 spomt=0 spomt1=1.11111e+60 spmb=1.11111e+15          spomb=0 spomb1=1.11111e+60
M1 (LN LP VDD VDD) pch_mac l=30n w=100n multi=2 nf=1 sd=100n ad=7.5e-15          as=7.5e-15 pd=350.0n ps=350.0n nrd=1.466664 nrs=1.466664 sa=75.0n          sb=75.0n sa1=75.0n sa2=75.0n sa3=75.0n sa4=75.0n sb1=75.0n          sb2=75.0n sb3=75.0n spa=100n spa1=100n spa2=100n spa3=100n          sap=91.9776n sapb=114.444n spba=115.715n spba1=117.043n dfm_flag=0          spmt=1.11111e+15 spomt=0 spomt1=1.11111e+60 spmb=1.11111e+15          spomb=0 spomb1=1.11111e+60
M14 (DCMPN LN GND GND) nch_mac l=30n w=100n multi=1 nf=1 sd=100n          ad=7.5e-15 as=7.5e-15 pd=350.0n ps=350.0n nrd=2.576626          nrs=2.576626 sa=75.0n sb=75.0n sa1=75.0n sa2=75.0n sa3=75.0n          sa4=75.0n sb1=75.0n sb2=75.0n sb3=75.0n spa=100n spa1=100n          spa2=100n spa3=100n sap=91.9776n sapb=114.444n spba=115.715n          spba1=117.043n dfm_flag=0 spmt=1.11111e+15 spomt=0          spomt1=1.11111e+60 spmb=1.11111e+15 spomb=0 spomb1=1.11111e+60
M12 (DCMPP LP GND GND) nch_mac l=30n w=100n multi=1 nf=1 sd=100n          ad=7.5e-15 as=7.5e-15 pd=350.0n ps=350.0n nrd=2.576626          nrs=2.576626 sa=75.0n sb=75.0n sa1=75.0n sa2=75.0n sa3=75.0n          sa4=75.0n sb1=75.0n sb2=75.0n sb3=75.0n spa=100n spa1=100n          spa2=100n spa3=100n sap=91.9776n sapb=114.444n spba=115.715n          spba1=117.043n dfm_flag=0 spmt=1.11111e+15 spomt=0          spomt1=1.11111e+60 spmb=1.11111e+15 spomb=0 spomb1=1.11111e+60
M10 (net3 CLK GND GND) nch_mac l=30n w=100n multi=4 nf=1 sd=100n          ad=7.5e-15 as=7.5e-15 pd=350.0n ps=350.0n nrd=2.576626          nrs=2.576626 sa=75.0n sb=75.0n sa1=75.0n sa2=75.0n sa3=75.0n          sa4=75.0n sb1=75.0n sb2=75.0n sb3=75.0n spa=100n spa1=100n          spa2=100n spa3=100n sap=91.9776n sapb=114.444n spba=115.715n          spba1=117.043n dfm_flag=0 spmt=1.11111e+15 spomt=0          spomt1=1.11111e+60 spmb=1.11111e+15 spomb=0 spomb1=1.11111e+60
M9 (net2 VINN net3 GND) nch_mac l=30n w=100n multi=4 nf=1 sd=100n          ad=7.5e-15 as=7.5e-15 pd=350.0n ps=350.0n nrd=2.576626          nrs=2.576626 sa=75.0n sb=75.0n sa1=75.0n sa2=75.0n sa3=75.0n          sa4=75.0n sb1=75.0n sb2=75.0n sb3=75.0n spa=100n spa1=100n          spa2=100n spa3=100n sap=91.9776n sapb=114.444n spba=115.715n          spba1=117.043n dfm_flag=0 spmt=1.11111e+15 spomt=0          spomt1=1.11111e+60 spmb=1.11111e+15 spomb=0 spomb1=1.11111e+60
M8 (net1 VINP net3 GND) nch_mac l=30n w=100n multi=4 nf=1 sd=100n          ad=7.5e-15 as=7.5e-15 pd=350.0n ps=350.0n nrd=2.576626          nrs=2.576626 sa=75.0n sb=75.0n sa1=75.0n sa2=75.0n sa3=75.0n          sa4=75.0n sb1=75.0n sb2=75.0n sb3=75.0n spa=100n spa1=100n          spa2=100n spa3=100n sap=91.9776n sapb=114.444n spba=115.715n          spba1=117.043n dfm_flag=0 spmt=1.11111e+15 spomt=0          spomt1=1.11111e+60 spmb=1.11111e+15 spomb=0 spomb1=1.11111e+60
M7 (LN LP net2 GND) nch_mac l=30n w=100n multi=2 nf=1 sd=100n ad=7.5e-15          as=7.5e-15 pd=350.0n ps=350.0n nrd=2.576626 nrs=2.576626 sa=75.0n          sb=75.0n sa1=75.0n sa2=75.0n sa3=75.0n sa4=75.0n sb1=75.0n          sb2=75.0n sb3=75.0n spa=100n spa1=100n spa2=100n spa3=100n          sap=91.9776n sapb=114.444n spba=115.715n spba1=117.043n dfm_flag=0          spmt=1.11111e+15 spomt=0 spomt1=1.11111e+60 spmb=1.11111e+15          spomb=0 spomb1=1.11111e+60
M6 (LP LN net1 GND) nch_mac l=30n w=100n multi=2 nf=1 sd=100n ad=7.5e-15          as=7.5e-15 pd=350.0n ps=350.0n nrd=2.576626 nrs=2.576626 sa=75.0n          sb=75.0n sa1=75.0n sa2=75.0n sa3=75.0n sa4=75.0n sb1=75.0n          sb2=75.0n sb3=75.0n spa=100n spa1=100n spa2=100n spa3=100n          sap=91.9776n sapb=114.444n spba=115.715n spba1=117.043n dfm_flag=0          spmt=1.11111e+15 spomt=0 spomt1=1.11111e+60 spmb=1.11111e+15          spomb=0 spomb1=1.11111e+60
ends cmp_R2
subckt cmp_O4 CLK VINP VINN VDD GND DCMPP DCMPN
M13 (DCMPN LN VDD VDD) pch_mac l=30n w=100n multi=8 nf=1 sd=100n          ad=7.5e-15 as=7.5e-15 pd=350.0n ps=350.0n nrd=1.466664          nrs=1.466664 sa=75.0n sb=75.0n sa1=75.0n sa2=75.0n sa3=75.0n          sa4=75.0n sb1=75.0n sb2=75.0n sb3=75.0n spa=100n spa1=100n          spa2=100n spa3=100n sap=91.9776n sapb=114.444n spba=115.715n          spba1=117.043n dfm_flag=0 spmt=1.11111e+15 spomt=0          spomt1=1.11111e+60 spmb=1.11111e+15 spomb=0 spomb1=1.11111e+60
M11 (DCMPP LP VDD VDD) pch_mac l=30n w=100n multi=8 nf=1 sd=100n          ad=7.5e-15 as=7.5e-15 pd=350.0n ps=350.0n nrd=1.466664          nrs=1.466664 sa=75.0n sb=75.0n sa1=75.0n sa2=75.0n sa3=75.0n          sa4=75.0n sb1=75.0n sb2=75.0n sb3=75.0n spa=100n spa1=100n          spa2=100n spa3=100n sap=91.9776n sapb=114.444n spba=115.715n          spba1=117.043n dfm_flag=0 spmt=1.11111e+15 spomt=0          spomt1=1.11111e+60 spmb=1.11111e+15 spomb=0 spomb1=1.11111e+60
M5 (net2 CLK VDD VDD) pch_mac l=30n w=100n multi=1 nf=1 sd=100n ad=7.5e-15          as=7.5e-15 pd=350.0n ps=350.0n nrd=1.466664 nrs=1.466664 sa=75.0n          sb=75.0n sa1=75.0n sa2=75.0n sa3=75.0n sa4=75.0n sb1=75.0n          sb2=75.0n sb3=75.0n spa=100n spa1=100n spa2=100n spa3=100n          sap=91.9776n sapb=114.444n spba=115.715n spba1=117.043n dfm_flag=0          spmt=1.11111e+15 spomt=0 spomt1=1.11111e+60 spmb=1.11111e+15          spomb=0 spomb1=1.11111e+60
M4 (LN CLK VDD VDD) pch_mac l=30n w=100n multi=1 nf=1 sd=100n ad=7.5e-15          as=7.5e-15 pd=350.0n ps=350.0n nrd=1.466664 nrs=1.466664 sa=75.0n          sb=75.0n sa1=75.0n sa2=75.0n sa3=75.0n sa4=75.0n sb1=75.0n          sb2=75.0n sb3=75.0n spa=100n spa1=100n spa2=100n spa3=100n          sap=91.9776n sapb=114.444n spba=115.715n spba1=117.043n dfm_flag=0          spmt=1.11111e+15 spomt=0 spomt1=1.11111e+60 spmb=1.11111e+15          spomb=0 spomb1=1.11111e+60
M3 (net1 CLK VDD VDD) pch_mac l=30n w=100n multi=1 nf=1 sd=100n ad=7.5e-15          as=7.5e-15 pd=350.0n ps=350.0n nrd=1.466664 nrs=1.466664 sa=75.0n          sb=75.0n sa1=75.0n sa2=75.0n sa3=75.0n sa4=75.0n sb1=75.0n          sb2=75.0n sb3=75.0n spa=100n spa1=100n spa2=100n spa3=100n          sap=91.9776n sapb=114.444n spba=115.715n spba1=117.043n dfm_flag=0          spmt=1.11111e+15 spomt=0 spomt1=1.11111e+60 spmb=1.11111e+15          spomb=0 spomb1=1.11111e+60
M2 (LP CLK VDD VDD) pch_mac l=30n w=100n multi=1 nf=1 sd=100n ad=7.5e-15          as=7.5e-15 pd=350.0n ps=350.0n nrd=1.466664 nrs=1.466664 sa=75.0n          sb=75.0n sa1=75.0n sa2=75.0n sa3=75.0n sa4=75.0n sb1=75.0n          sb2=75.0n sb3=75.0n spa=100n spa1=100n spa2=100n spa3=100n          sap=91.9776n sapb=114.444n spba=115.715n spba1=117.043n dfm_flag=0          spmt=1.11111e+15 spomt=0 spomt1=1.11111e+60 spmb=1.11111e+15          spomb=0 spomb1=1.11111e+60
M0 (LP LN VDD VDD) pch_mac l=30n w=100n multi=2 nf=1 sd=100n ad=7.5e-15          as=7.5e-15 pd=350.0n ps=350.0n nrd=1.466664 nrs=1.466664 sa=75.0n          sb=75.0n sa1=75.0n sa2=75.0n sa3=75.0n sa4=75.0n sb1=75.0n          sb2=75.0n sb3=75.0n spa=100n spa1=100n spa2=100n spa3=100n          sap=91.9776n sapb=114.444n spba=115.715n spba1=117.043n dfm_flag=0          spmt=1.11111e+15 spomt=0 spomt1=1.11111e+60 spmb=1.11111e+15          spomb=0 spomb1=1.11111e+60
M1 (LN LP VDD VDD) pch_mac l=30n w=100n multi=2 nf=1 sd=100n ad=7.5e-15          as=7.5e-15 pd=350.0n ps=350.0n nrd=1.466664 nrs=1.466664 sa=75.0n          sb=75.0n sa1=75.0n sa2=75.0n sa3=75.0n sa4=75.0n sb1=75.0n          sb2=75.0n sb3=75.0n spa=100n spa1=100n spa2=100n spa3=100n          sap=91.9776n sapb=114.444n spba=115.715n spba1=117.043n dfm_flag=0          spmt=1.11111e+15 spomt=0 spomt1=1.11111e+60 spmb=1.11111e+15          spomb=0 spomb1=1.11111e+60
M14 (DCMPN LN GND GND) nch_mac l=30n w=100n multi=4 nf=1 sd=100n          ad=7.5e-15 as=7.5e-15 pd=350.0n ps=350.0n nrd=2.576626          nrs=2.576626 sa=75.0n sb=75.0n sa1=75.0n sa2=75.0n sa3=75.0n          sa4=75.0n sb1=75.0n sb2=75.0n sb3=75.0n spa=100n spa1=100n          spa2=100n spa3=100n sap=91.9776n sapb=114.444n spba=115.715n          spba1=117.043n dfm_flag=0 spmt=1.11111e+15 spomt=0          spomt1=1.11111e+60 spmb=1.11111e+15 spomb=0 spomb1=1.11111e+60
M12 (DCMPP LP GND GND) nch_mac l=30n w=100n multi=4 nf=1 sd=100n          ad=7.5e-15 as=7.5e-15 pd=350.0n ps=350.0n nrd=2.576626          nrs=2.576626 sa=75.0n sb=75.0n sa1=75.0n sa2=75.0n sa3=75.0n          sa4=75.0n sb1=75.0n sb2=75.0n sb3=75.0n spa=100n spa1=100n          spa2=100n spa3=100n sap=91.9776n sapb=114.444n spba=115.715n          spba1=117.043n dfm_flag=0 spmt=1.11111e+15 spomt=0          spomt1=1.11111e+60 spmb=1.11111e+15 spomb=0 spomb1=1.11111e+60
M10 (net3 CLK GND GND) nch_mac l=30n w=100n multi=4 nf=1 sd=100n          ad=7.5e-15 as=7.5e-15 pd=350.0n ps=350.0n nrd=2.576626          nrs=2.576626 sa=75.0n sb=75.0n sa1=75.0n sa2=75.0n sa3=75.0n          sa4=75.0n sb1=75.0n sb2=75.0n sb3=75.0n spa=100n spa1=100n          spa2=100n spa3=100n sap=91.9776n sapb=114.444n spba=115.715n          spba1=117.043n dfm_flag=0 spmt=1.11111e+15 spomt=0          spomt1=1.11111e+60 spmb=1.11111e+15 spomb=0 spomb1=1.11111e+60
M9 (net2 VINN net3 GND) nch_mac l=30n w=100n multi=4 nf=1 sd=100n          ad=7.5e-15 as=7.5e-15 pd=350.0n ps=350.0n nrd=2.576626          nrs=2.576626 sa=75.0n sb=75.0n sa1=75.0n sa2=75.0n sa3=75.0n          sa4=75.0n sb1=75.0n sb2=75.0n sb3=75.0n spa=100n spa1=100n          spa2=100n spa3=100n sap=91.9776n sapb=114.444n spba=115.715n          spba1=117.043n dfm_flag=0 spmt=1.11111e+15 spomt=0          spomt1=1.11111e+60 spmb=1.11111e+15 spomb=0 spomb1=1.11111e+60
M8 (net1 VINP net3 GND) nch_mac l=30n w=100n multi=4 nf=1 sd=100n          ad=7.5e-15 as=7.5e-15 pd=350.0n ps=350.0n nrd=2.576626          nrs=2.576626 sa=75.0n sb=75.0n sa1=75.0n sa2=75.0n sa3=75.0n          sa4=75.0n sb1=75.0n sb2=75.0n sb3=75.0n spa=100n spa1=100n          spa2=100n spa3=100n sap=91.9776n sapb=114.444n spba=115.715n          spba1=117.043n dfm_flag=0 spmt=1.11111e+15 spomt=0          spomt1=1.11111e+60 spmb=1.11111e+15 spomb=0 spomb1=1.11111e+60
M7 (LN LP net2 GND) nch_mac l=30n w=100n multi=2 nf=1 sd=100n ad=7.5e-15          as=7.5e-15 pd=350.0n ps=350.0n nrd=2.576626 nrs=2.576626 sa=75.0n          sb=75.0n sa1=75.0n sa2=75.0n sa3=75.0n sa4=75.0n sb1=75.0n          sb2=75.0n sb3=75.0n spa=100n spa1=100n spa2=100n spa3=100n          sap=91.9776n sapb=114.444n spba=115.715n spba1=117.043n dfm_flag=0          spmt=1.11111e+15 spomt=0 spomt1=1.11111e+60 spmb=1.11111e+15          spomb=0 spomb1=1.11111e+60
M6 (LP LN net1 GND) nch_mac l=30n w=100n multi=2 nf=1 sd=100n ad=7.5e-15          as=7.5e-15 pd=350.0n ps=350.0n nrd=2.576626 nrs=2.576626 sa=75.0n          sb=75.0n sa1=75.0n sa2=75.0n sa3=75.0n sa4=75.0n sb1=75.0n          sb2=75.0n sb3=75.0n spa=100n spa1=100n spa2=100n spa3=100n          sap=91.9776n sapb=114.444n spba=115.715n spba1=117.043n dfm_flag=0          spmt=1.11111e+15 spomt=0 spomt1=1.11111e+60 spmb=1.11111e+15          spomb=0 spomb1=1.11111e+60
ends cmp_O4
subckt cmp_P4 CLK VINP VINN VDD GND DCMPP DCMPN
M13 (DCMPN LN VDD VDD) pch_mac l=30n w=100n multi=8 nf=1 sd=100n          ad=7.5e-15 as=7.5e-15 pd=350.0n ps=350.0n nrd=1.466664          nrs=1.466664 sa=75.0n sb=75.0n sa1=75.0n sa2=75.0n sa3=75.0n          sa4=75.0n sb1=75.0n sb2=75.0n sb3=75.0n spa=100n spa1=100n          spa2=100n spa3=100n sap=91.9776n sapb=114.444n spba=115.715n          spba1=117.043n dfm_flag=0 spmt=1.11111e+15 spomt=0          spomt1=1.11111e+60 spmb=1.11111e+15 spomb=0 spomb1=1.11111e+60
M11 (DCMPP LP VDD VDD) pch_mac l=30n w=100n multi=8 nf=1 sd=100n          ad=7.5e-15 as=7.5e-15 pd=350.0n ps=350.0n nrd=1.466664          nrs=1.466664 sa=75.0n sb=75.0n sa1=75.0n sa2=75.0n sa3=75.0n          sa4=75.0n sb1=75.0n sb2=75.0n sb3=75.0n spa=100n spa1=100n          spa2=100n spa3=100n sap=91.9776n sapb=114.444n spba=115.715n          spba1=117.043n dfm_flag=0 spmt=1.11111e+15 spomt=0          spomt1=1.11111e+60 spmb=1.11111e+15 spomb=0 spomb1=1.11111e+60
M5 (net2 CLK VDD VDD) pch_mac l=30n w=100n multi=4 nf=1 sd=100n ad=7.5e-15          as=7.5e-15 pd=350.0n ps=350.0n nrd=1.466664 nrs=1.466664 sa=75.0n          sb=75.0n sa1=75.0n sa2=75.0n sa3=75.0n sa4=75.0n sb1=75.0n          sb2=75.0n sb3=75.0n spa=100n spa1=100n spa2=100n spa3=100n          sap=91.9776n sapb=114.444n spba=115.715n spba1=117.043n dfm_flag=0          spmt=1.11111e+15 spomt=0 spomt1=1.11111e+60 spmb=1.11111e+15          spomb=0 spomb1=1.11111e+60
M4 (LN CLK VDD VDD) pch_mac l=30n w=100n multi=4 nf=1 sd=100n ad=7.5e-15          as=7.5e-15 pd=350.0n ps=350.0n nrd=1.466664 nrs=1.466664 sa=75.0n          sb=75.0n sa1=75.0n sa2=75.0n sa3=75.0n sa4=75.0n sb1=75.0n          sb2=75.0n sb3=75.0n spa=100n spa1=100n spa2=100n spa3=100n          sap=91.9776n sapb=114.444n spba=115.715n spba1=117.043n dfm_flag=0          spmt=1.11111e+15 spomt=0 spomt1=1.11111e+60 spmb=1.11111e+15          spomb=0 spomb1=1.11111e+60
M3 (net1 CLK VDD VDD) pch_mac l=30n w=100n multi=4 nf=1 sd=100n ad=7.5e-15          as=7.5e-15 pd=350.0n ps=350.0n nrd=1.466664 nrs=1.466664 sa=75.0n          sb=75.0n sa1=75.0n sa2=75.0n sa3=75.0n sa4=75.0n sb1=75.0n          sb2=75.0n sb3=75.0n spa=100n spa1=100n spa2=100n spa3=100n          sap=91.9776n sapb=114.444n spba=115.715n spba1=117.043n dfm_flag=0          spmt=1.11111e+15 spomt=0 spomt1=1.11111e+60 spmb=1.11111e+15          spomb=0 spomb1=1.11111e+60
M2 (LP CLK VDD VDD) pch_mac l=30n w=100n multi=4 nf=1 sd=100n ad=7.5e-15          as=7.5e-15 pd=350.0n ps=350.0n nrd=1.466664 nrs=1.466664 sa=75.0n          sb=75.0n sa1=75.0n sa2=75.0n sa3=75.0n sa4=75.0n sb1=75.0n          sb2=75.0n sb3=75.0n spa=100n spa1=100n spa2=100n spa3=100n          sap=91.9776n sapb=114.444n spba=115.715n spba1=117.043n dfm_flag=0          spmt=1.11111e+15 spomt=0 spomt1=1.11111e+60 spmb=1.11111e+15          spomb=0 spomb1=1.11111e+60
M0 (LP LN VDD VDD) pch_mac l=30n w=100n multi=2 nf=1 sd=100n ad=7.5e-15          as=7.5e-15 pd=350.0n ps=350.0n nrd=1.466664 nrs=1.466664 sa=75.0n          sb=75.0n sa1=75.0n sa2=75.0n sa3=75.0n sa4=75.0n sb1=75.0n          sb2=75.0n sb3=75.0n spa=100n spa1=100n spa2=100n spa3=100n          sap=91.9776n sapb=114.444n spba=115.715n spba1=117.043n dfm_flag=0          spmt=1.11111e+15 spomt=0 spomt1=1.11111e+60 spmb=1.11111e+15          spomb=0 spomb1=1.11111e+60
M1 (LN LP VDD VDD) pch_mac l=30n w=100n multi=2 nf=1 sd=100n ad=7.5e-15          as=7.5e-15 pd=350.0n ps=350.0n nrd=1.466664 nrs=1.466664 sa=75.0n          sb=75.0n sa1=75.0n sa2=75.0n sa3=75.0n sa4=75.0n sb1=75.0n          sb2=75.0n sb3=75.0n spa=100n spa1=100n spa2=100n spa3=100n          sap=91.9776n sapb=114.444n spba=115.715n spba1=117.043n dfm_flag=0          spmt=1.11111e+15 spomt=0 spomt1=1.11111e+60 spmb=1.11111e+15          spomb=0 spomb1=1.11111e+60
M14 (DCMPN LN GND GND) nch_mac l=30n w=100n multi=4 nf=1 sd=100n          ad=7.5e-15 as=7.5e-15 pd=350.0n ps=350.0n nrd=2.576626          nrs=2.576626 sa=75.0n sb=75.0n sa1=75.0n sa2=75.0n sa3=75.0n          sa4=75.0n sb1=75.0n sb2=75.0n sb3=75.0n spa=100n spa1=100n          spa2=100n spa3=100n sap=91.9776n sapb=114.444n spba=115.715n          spba1=117.043n dfm_flag=0 spmt=1.11111e+15 spomt=0          spomt1=1.11111e+60 spmb=1.11111e+15 spomb=0 spomb1=1.11111e+60
M12 (DCMPP LP GND GND) nch_mac l=30n w=100n multi=4 nf=1 sd=100n          ad=7.5e-15 as=7.5e-15 pd=350.0n ps=350.0n nrd=2.576626          nrs=2.576626 sa=75.0n sb=75.0n sa1=75.0n sa2=75.0n sa3=75.0n          sa4=75.0n sb1=75.0n sb2=75.0n sb3=75.0n spa=100n spa1=100n          spa2=100n spa3=100n sap=91.9776n sapb=114.444n spba=115.715n          spba1=117.043n dfm_flag=0 spmt=1.11111e+15 spomt=0          spomt1=1.11111e+60 spmb=1.11111e+15 spomb=0 spomb1=1.11111e+60
M10 (net3 CLK GND GND) nch_mac l=30n w=100n multi=4 nf=1 sd=100n          ad=7.5e-15 as=7.5e-15 pd=350.0n ps=350.0n nrd=2.576626          nrs=2.576626 sa=75.0n sb=75.0n sa1=75.0n sa2=75.0n sa3=75.0n          sa4=75.0n sb1=75.0n sb2=75.0n sb3=75.0n spa=100n spa1=100n          spa2=100n spa3=100n sap=91.9776n sapb=114.444n spba=115.715n          spba1=117.043n dfm_flag=0 spmt=1.11111e+15 spomt=0          spomt1=1.11111e+60 spmb=1.11111e+15 spomb=0 spomb1=1.11111e+60
M9 (net2 VINN net3 GND) nch_mac l=30n w=100n multi=4 nf=1 sd=100n          ad=7.5e-15 as=7.5e-15 pd=350.0n ps=350.0n nrd=2.576626          nrs=2.576626 sa=75.0n sb=75.0n sa1=75.0n sa2=75.0n sa3=75.0n          sa4=75.0n sb1=75.0n sb2=75.0n sb3=75.0n spa=100n spa1=100n          spa2=100n spa3=100n sap=91.9776n sapb=114.444n spba=115.715n          spba1=117.043n dfm_flag=0 spmt=1.11111e+15 spomt=0          spomt1=1.11111e+60 spmb=1.11111e+15 spomb=0 spomb1=1.11111e+60
M8 (net1 VINP net3 GND) nch_mac l=30n w=100n multi=4 nf=1 sd=100n          ad=7.5e-15 as=7.5e-15 pd=350.0n ps=350.0n nrd=2.576626          nrs=2.576626 sa=75.0n sb=75.0n sa1=75.0n sa2=75.0n sa3=75.0n          sa4=75.0n sb1=75.0n sb2=75.0n sb3=75.0n spa=100n spa1=100n          spa2=100n spa3=100n sap=91.9776n sapb=114.444n spba=115.715n          spba1=117.043n dfm_flag=0 spmt=1.11111e+15 spomt=0          spomt1=1.11111e+60 spmb=1.11111e+15 spomb=0 spomb1=1.11111e+60
M7 (LN LP net2 GND) nch_mac l=30n w=100n multi=2 nf=1 sd=100n ad=7.5e-15          as=7.5e-15 pd=350.0n ps=350.0n nrd=2.576626 nrs=2.576626 sa=75.0n          sb=75.0n sa1=75.0n sa2=75.0n sa3=75.0n sa4=75.0n sb1=75.0n          sb2=75.0n sb3=75.0n spa=100n spa1=100n spa2=100n spa3=100n          sap=91.9776n sapb=114.444n spba=115.715n spba1=117.043n dfm_flag=0          spmt=1.11111e+15 spomt=0 spomt1=1.11111e+60 spmb=1.11111e+15          spomb=0 spomb1=1.11111e+60
M6 (LP LN net1 GND) nch_mac l=30n w=100n multi=2 nf=1 sd=100n ad=7.5e-15          as=7.5e-15 pd=350.0n ps=350.0n nrd=2.576626 nrs=2.576626 sa=75.0n          sb=75.0n sa1=75.0n sa2=75.0n sa3=75.0n sa4=75.0n sb1=75.0n          sb2=75.0n sb3=75.0n spa=100n spa1=100n spa2=100n spa3=100n          sap=91.9776n sapb=114.444n spba=115.715n spba1=117.043n dfm_flag=0          spmt=1.11111e+15 spomt=0 spomt1=1.11111e+60 spmb=1.11111e+15          spomb=0 spomb1=1.11111e+60
ends cmp_P4
