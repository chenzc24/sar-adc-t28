simulator lang=spectre
include "models.scs"
include "dut.scs"
VCK (CK 0) vsource type=pwl wave=[0 0 5.4e-08 0 5.405e-08 0.99 5.55e-08 0.99 5.555e-08 0 5.8e-08 0 5.805e-08 0.99 5.95e-08 0.99 5.955e-08 0 6.2e-08 0 6.205e-08 0.99 6.35e-08 0.99 6.355e-08 0 6.6e-08 0 6.605e-08 0.99 6.75e-08 0.99 6.755e-08 0 7e-08 0 7.005e-08 0.99 7.15e-08 0.99 7.155e-08 0 7.4e-08 0 7.405e-08 0.99 7.55e-08 0.99 7.555e-08 0 7.8e-08 0 7.805e-08 0.99 7.95e-08 0.99 7.955e-08 0 8.2e-08 0 8.205e-08 0.99 8.35e-08 0.99 8.355e-08 0 1.54e-07 0 1.5405e-07 0.99 1.555e-07 0.99 1.5555e-07 0 1.58e-07 0 1.5805e-07 0.99 1.595e-07 0.99 1.5955e-07 0 1.62e-07 0 1.6205e-07 0.99 1.635e-07 0.99 1.6355e-07 0 1.66e-07 0 1.6605e-07 0.99 1.675e-07 0.99 1.6755e-07 0 1.7e-07 0 1.7005e-07 0.99 1.715e-07 0.99 1.7155e-07 0 1.74e-07 0 1.7405e-07 0.99 1.755e-07 0.99 1.7555e-07 0 1.78e-07 0 1.7805e-07 0.99 1.795e-07 0.99 1.7955e-07 0 1.82e-07 0 1.8205e-07 0.99 1.835e-07 0.99 1.8355e-07 0 2.54e-07 0 2.5405e-07 0.99 2.555e-07 0.99 2.5555e-07 0 2.58e-07 0 2.5805e-07 0.99 2.595e-07 0.99 2.5955e-07 0 2.62e-07 0 2.6205e-07 0.99 2.635e-07 0.99 2.6355e-07 0 2.66e-07 0 2.6605e-07 0.99 2.675e-07 0.99 2.6755e-07 0 2.7e-07 0 2.7005e-07 0.99 2.715e-07 0.99 2.7155e-07 0 2.74e-07 0 2.7405e-07 0.99 2.755e-07 0.99 2.7555e-07 0 2.78e-07 0 2.7805e-07 0.99 2.795e-07 0.99 2.7955e-07 0 2.82e-07 0 2.8205e-07 0.99 2.835e-07 0.99 2.8355e-07 0 3.54e-07 0 3.5405e-07 0.99 3.555e-07 0.99 3.5555e-07 0 3.58e-07 0 3.5805e-07 0.99 3.595e-07 0.99 3.5955e-07 0 3.62e-07 0 3.6205e-07 0.99 3.635e-07 0.99 3.6355e-07 0 3.66e-07 0 3.6605e-07 0.99 3.675e-07 0.99 3.6755e-07 0 3.7e-07 0 3.7005e-07 0.99 3.715e-07 0.99 3.7155e-07 0 3.74e-07 0 3.7405e-07 0.99 3.755e-07 0.99 3.7555e-07 0 3.78e-07 0 3.7805e-07 0.99 3.795e-07 0.99 3.7955e-07 0 3.82e-07 0 3.8205e-07 0.99 3.835e-07 0.99 3.8355e-07 0]
VTRACK (TRACK 0) vsource type=pwl wave=[0 1 5.2e-08 1 5.205e-08 1 5.345e-08 1 5.35e-08 0 5.6e-08 0 5.605e-08 1 5.745e-08 1 5.75e-08 0 6e-08 0 6.005e-08 1 6.145e-08 1 6.15e-08 0 6.4e-08 0 6.405e-08 1 6.545e-08 1 6.55e-08 0 6.8e-08 0 6.805e-08 1 6.945e-08 1 6.95e-08 0 7.2e-08 0 7.205e-08 1 7.345e-08 1 7.35e-08 0 7.6e-08 0 7.605e-08 1 7.745e-08 1 7.75e-08 0 8e-08 0 8.005e-08 1 8.145e-08 1 8.15e-08 0 1.52e-07 0 1.5205e-07 1 1.5345e-07 1 1.535e-07 0 1.56e-07 0 1.5605e-07 1 1.5745e-07 1 1.575e-07 0 1.6e-07 0 1.6005e-07 1 1.6145e-07 1 1.615e-07 0 1.64e-07 0 1.6405e-07 1 1.6545e-07 1 1.655e-07 0 1.68e-07 0 1.6805e-07 1 1.6945e-07 1 1.695e-07 0 1.72e-07 0 1.7205e-07 1 1.7345e-07 1 1.735e-07 0 1.76e-07 0 1.7605e-07 1 1.7745e-07 1 1.775e-07 0 1.8e-07 0 1.8005e-07 1 1.8145e-07 1 1.815e-07 0 2.52e-07 0 2.5205e-07 1 2.5345e-07 1 2.535e-07 0 2.56e-07 0 2.5605e-07 1 2.5745e-07 1 2.575e-07 0 2.6e-07 0 2.6005e-07 1 2.6145e-07 1 2.615e-07 0 2.64e-07 0 2.6405e-07 1 2.6545e-07 1 2.655e-07 0 2.68e-07 0 2.6805e-07 1 2.6945e-07 1 2.695e-07 0 2.72e-07 0 2.7205e-07 1 2.7345e-07 1 2.735e-07 0 2.76e-07 0 2.7605e-07 1 2.7745e-07 1 2.775e-07 0 2.8e-07 0 2.8005e-07 1 2.8145e-07 1 2.815e-07 0 3.52e-07 0 3.5205e-07 1 3.5345e-07 1 3.535e-07 0 3.56e-07 0 3.5605e-07 1 3.5745e-07 1 3.575e-07 0 3.6e-07 0 3.6005e-07 1 3.6145e-07 1 3.615e-07 0 3.64e-07 0 3.6405e-07 1 3.6545e-07 1 3.655e-07 0 3.68e-07 0 3.6805e-07 1 3.6945e-07 1 3.695e-07 0 3.72e-07 0 3.7205e-07 1 3.7345e-07 1 3.735e-07 0 3.76e-07 0 3.7605e-07 1 3.7745e-07 1 3.775e-07 0 3.8e-07 0 3.8005e-07 1 3.8145e-07 1 3.815e-07 0]
VIP (IP 0) vsource type=pwl wave=[0 0.45087890625 5.21e-08 0.45087890625 5.215e-08 0.45087890625 5.61e-08 0.45087890625 5.615e-08 0.44912109375 6.01e-08 0.44912109375 6.015e-08 0.4517578125 6.41e-08 0.4517578125 6.415e-08 0.4482421875 6.81e-08 0.4482421875 6.815e-08 0.453515625 7.21e-08 0.453515625 7.215e-08 0.446484375 7.61e-08 0.446484375 7.615e-08 0.875 8.01e-08 0.875 8.015e-08 0.025 1.521e-07 0.025 1.5215e-07 0.67587890625 1.561e-07 0.67587890625 1.5615e-07 0.67412109375 1.601e-07 0.67412109375 1.6015e-07 0.6767578125 1.641e-07 0.6767578125 1.6415e-07 0.6732421875 1.681e-07 0.6732421875 1.6815e-07 0.678515625 1.721e-07 0.678515625 1.7215e-07 0.671484375 1.761e-07 0.671484375 1.7615e-07 0.875 1.801e-07 0.875 1.8015e-07 0.475 2.521e-07 0.475 2.5215e-07 0.45439453125 2.561e-07 0.45439453125 2.5615e-07 0.45263671875 2.601e-07 0.45263671875 2.6015e-07 0.4552734375 2.641e-07 0.4552734375 2.6415e-07 0.4517578125 2.681e-07 0.4517578125 2.6815e-07 0.45703125 2.721e-07 0.45703125 2.7215e-07 0.45 2.761e-07 0.45 2.7615e-07 0.45439453125 2.801e-07 0.45439453125 2.8015e-07 0.45263671875 3.521e-07 0.45263671875 3.5215e-07 0.85 3.561e-07 0.85 3.5615e-07 0.45087890625 3.601e-07 0.45087890625 3.6015e-07 0.05 3.641e-07 0.05 3.6415e-07 0.45087890625 3.681e-07 0.45087890625 3.6815e-07 0.85 3.721e-07 0.85 3.7215e-07 0.44912109375 3.761e-07 0.44912109375 3.7615e-07 0.05 3.801e-07 0.05 3.8015e-07 0.44912109375]
VIN (IN 0) vsource type=pwl wave=[0 0.44912109375 5.21e-08 0.44912109375 5.215e-08 0.44912109375 5.61e-08 0.44912109375 5.615e-08 0.45087890625 6.01e-08 0.45087890625 6.015e-08 0.4482421875 6.41e-08 0.4482421875 6.415e-08 0.4517578125 6.81e-08 0.4517578125 6.815e-08 0.446484375 7.21e-08 0.446484375 7.215e-08 0.453515625 7.61e-08 0.453515625 7.615e-08 0.025 8.01e-08 0.025 8.015e-08 0.875 1.521e-07 0.875 1.5215e-07 0.67412109375 1.561e-07 0.67412109375 1.5615e-07 0.67587890625 1.601e-07 0.67587890625 1.6015e-07 0.6732421875 1.641e-07 0.6732421875 1.6415e-07 0.6767578125 1.681e-07 0.6767578125 1.6815e-07 0.671484375 1.721e-07 0.671484375 1.7215e-07 0.678515625 1.761e-07 0.678515625 1.7615e-07 0.475 1.801e-07 0.475 1.8015e-07 0.875 2.521e-07 0.875 2.5215e-07 0.45263671875 2.561e-07 0.45263671875 2.5615e-07 0.45439453125 2.601e-07 0.45439453125 2.6015e-07 0.4517578125 2.641e-07 0.4517578125 2.6415e-07 0.4552734375 2.681e-07 0.4552734375 2.6815e-07 0.45 2.721e-07 0.45 2.7215e-07 0.45703125 2.761e-07 0.45703125 2.7615e-07 0.45263671875 2.801e-07 0.45263671875 2.8015e-07 0.45439453125 3.521e-07 0.45439453125 3.5215e-07 0.05 3.561e-07 0.05 3.5615e-07 0.44912109375 3.601e-07 0.44912109375 3.6015e-07 0.85 3.641e-07 0.85 3.6415e-07 0.44912109375 3.681e-07 0.44912109375 3.6815e-07 0.05 3.721e-07 0.05 3.7215e-07 0.45087890625 3.761e-07 0.45087890625 3.7615e-07 0.85 3.801e-07 0.85 3.8015e-07 0.45087890625]
VSA2_driven (UA2_driven 0) vsource dc=0.99
XA2_driven (CK IP IN UA2_driven 0 OPA2_driven ONA2_driven) cmp_A2
CLPA2_driven (OPA2_driven 0) capacitor c=6.1e-15
CLNA2_driven (ONA2_driven 0) capacitor c=6.1e-15
VSA2_held (UA2_held 0) vsource dc=0.99
SPA2_held (IP PA2_held TRACK 0) relay rclosed=1 ropen=1e15 vt1=.4 vt2=.6
SNA2_held (IN NA2_held TRACK 0) relay rclosed=1 ropen=1e15 vt1=.4 vt2=.6
CPA2_held (PA2_held 0) capacitor c=1.28p
CNA2_held (NA2_held 0) capacitor c=1.28p
XA2_held (CK PA2_held NA2_held UA2_held 0 OPA2_held ONA2_held) cmp_A2
CLPA2_held (OPA2_held 0) capacitor c=6.1e-15
CLNA2_held (ONA2_held 0) capacitor c=6.1e-15
simulatorOptions options reltol=1e-6 vabstol=1e-8 iabstol=1e-14 temp=125 tnom=27
saveOptions options save=selected currents=selected
tran_test tran stop=400n maxstep=20p errpreset=conservative
save CK IN IP NA2_held ONA2_driven ONA2_held OPA2_driven OPA2_held PA2_held TRACK UA2_driven UA2_held VCK:1 VSA2_driven:1 VSA2_held:1 XA2_driven.LN XA2_driven.LP XA2_driven.net1 XA2_driven.net2 XA2_driven.net3 XA2_held.LN XA2_held.LP XA2_held.net1 XA2_held.net2 XA2_held.net3
save XA2_held.M6:2 XA2_held.M0:2 XA2_held.M7:1 XA2_held.M1:1 XA2_held.M4:1 XA2_held.M13:2 XA2_held.M14:2
